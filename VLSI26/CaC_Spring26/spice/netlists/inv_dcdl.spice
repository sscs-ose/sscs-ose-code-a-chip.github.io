* NGSPICE file created from inv_dcdl.ext - technology: sky130A

.subckt sky130_fd_sc_hd__decap_6 VPWR VGND VPB VNB
X0 VPWR VGND VPWR VPB sky130_fd_pr__pfet_01v8_hvt ad=0.2262 pd=2.26 as=0 ps=0 w=0.87 l=1.97
X1 VGND VPWR VGND VNB sky130_fd_pr__nfet_01v8 ad=0.143 pd=1.62 as=0 ps=0 w=0.55 l=1.97
.ends

.subckt sky130_ef_sc_hd__decap_12 VGND VPWR VPB VNB
X0 VPWR VGND VPWR VPB sky130_fd_pr__pfet_01v8_hvt ad=0.2262 pd=2.26 as=0 ps=0 w=0.87 l=4.73
X1 VGND VPWR VGND VNB sky130_fd_pr__nfet_01v8 ad=0.143 pd=1.62 as=0 ps=0 w=0.55 l=4.73
.ends

.subckt sky130_fd_sc_hd__inv_1 VPB VNB VGND VPWR A Y
X0 Y A VGND VNB sky130_fd_pr__nfet_01v8 ad=0.169 pd=1.82 as=0.169 ps=1.82 w=0.65 l=0.15
X1 Y A VPWR VPB sky130_fd_pr__pfet_01v8_hvt ad=0.26 pd=2.52 as=0.26 ps=2.52 w=1 l=0.15
.ends

.subckt sky130_fd_sc_hd__decap_4 VGND VPWR VPB VNB
X0 VPWR VGND VPWR VPB sky130_fd_pr__pfet_01v8_hvt ad=0.2262 pd=2.26 as=0 ps=0 w=0.87 l=1.05
X1 VGND VPWR VGND VNB sky130_fd_pr__nfet_01v8 ad=0.143 pd=1.62 as=0 ps=0 w=0.55 l=1.05
.ends

.subckt sky130_fd_sc_hd__mux4_2 VNB VPB VGND VPWR S0 A2 A3 S1 A1 A0 X
X0 a_600_345# S1 VPWR VPB sky130_fd_pr__pfet_01v8_hvt ad=0.1664 pd=1.8 as=0.0864 ps=0.91 w=0.64 l=0.15
X1 a_788_316# S1 a_288_47# VNB sky130_fd_pr__nfet_01v8 ad=0.05775 pd=0.695 as=0.1092 ps=1.36 w=0.42 l=0.15
X2 VPWR A3 a_372_413# VPB sky130_fd_pr__pfet_01v8_hvt ad=0.0864 pd=0.91 as=0.1645 ps=1.33 w=0.64 l=0.15
X3 a_872_316# a_600_345# a_788_316# VNB sky130_fd_pr__nfet_01v8 ad=0.1092 pd=1.36 as=0.05775 ps=0.695 w=0.42 l=0.15
X4 VPWR S0 a_27_47# VPB sky130_fd_pr__pfet_01v8_hvt ad=0.0864 pd=0.91 as=0.1664 ps=1.8 w=0.64 l=0.15
X5 a_1279_413# S0 a_872_316# VPB sky130_fd_pr__pfet_01v8_hvt ad=0.10535 pd=0.995 as=0.0567 ps=0.69 w=0.42 l=0.15
X6 VGND a_788_316# X VNB sky130_fd_pr__nfet_01v8 ad=0.221 pd=1.98 as=0.08775 ps=0.92 w=0.65 l=0.15
X7 a_1060_369# A1 VPWR VPB sky130_fd_pr__pfet_01v8_hvt ad=0.13775 pd=1.165 as=0.1664 ps=1.8 w=0.64 l=0.15
X8 a_872_316# a_27_47# a_1060_369# VPB sky130_fd_pr__pfet_01v8_hvt ad=0.0567 pd=0.69 as=0.13775 ps=1.165 w=0.42 l=0.15
X9 a_193_47# A2 VGND VNB sky130_fd_pr__nfet_01v8 ad=0.066 pd=0.745 as=0.0567 ps=0.69 w=0.42 l=0.15
X10 a_1064_47# A1 VGND VNB sky130_fd_pr__nfet_01v8 ad=0.0786 pd=0.805 as=0.1092 ps=1.36 w=0.42 l=0.15
X11 a_1281_47# a_27_47# a_872_316# VNB sky130_fd_pr__special_nfet_01v8 ad=0.066 pd=0.745 as=0.072 ps=0.76 w=0.36 l=0.15
X12 a_872_316# S1 a_788_316# VPB sky130_fd_pr__pfet_01v8_hvt ad=0.1404 pd=1.6 as=0.0729 ps=0.81 w=0.54 l=0.15
X13 a_872_316# S0 a_1064_47# VNB sky130_fd_pr__special_nfet_01v8 ad=0.072 pd=0.76 as=0.0786 ps=0.805 w=0.36 l=0.15
X14 X a_788_316# VGND VNB sky130_fd_pr__nfet_01v8 ad=0.08775 pd=0.92 as=0.10675 ps=1.005 w=0.65 l=0.15
X15 a_788_316# a_600_345# a_288_47# VPB sky130_fd_pr__pfet_01v8_hvt ad=0.0729 pd=0.81 as=0.1404 ps=1.6 w=0.54 l=0.15
X16 a_372_413# a_27_47# a_288_47# VPB sky130_fd_pr__pfet_01v8_hvt ad=0.1645 pd=1.33 as=0.0567 ps=0.69 w=0.42 l=0.15
X17 VGND A3 a_397_47# VNB sky130_fd_pr__nfet_01v8 ad=0.0819 pd=0.81 as=0.06705 ps=0.75 w=0.42 l=0.15
X18 a_600_345# S1 VGND VNB sky130_fd_pr__nfet_01v8 ad=0.1134 pd=1.38 as=0.0819 ps=0.81 w=0.42 l=0.15
X19 a_193_369# A2 VPWR VPB sky130_fd_pr__pfet_01v8_hvt ad=0.09575 pd=0.965 as=0.0864 ps=0.91 w=0.64 l=0.15
X20 VPWR a_788_316# X VPB sky130_fd_pr__pfet_01v8_hvt ad=0.34 pd=2.68 as=0.135 ps=1.27 w=1 l=0.15
X21 a_288_47# S0 a_193_369# VPB sky130_fd_pr__pfet_01v8_hvt ad=0.0567 pd=0.69 as=0.09575 ps=0.965 w=0.42 l=0.15
X22 VGND A0 a_1281_47# VNB sky130_fd_pr__nfet_01v8 ad=0.10675 pd=1.005 as=0.066 ps=0.745 w=0.42 l=0.15
X23 a_397_47# S0 a_288_47# VNB sky130_fd_pr__special_nfet_01v8 ad=0.06705 pd=0.75 as=0.0711 ps=0.755 w=0.36 l=0.15
X24 X a_788_316# VPWR VPB sky130_fd_pr__pfet_01v8_hvt ad=0.135 pd=1.27 as=0.154 ps=1.335 w=1 l=0.15
X25 a_288_47# a_27_47# a_193_47# VNB sky130_fd_pr__special_nfet_01v8 ad=0.0711 pd=0.755 as=0.066 ps=0.745 w=0.36 l=0.15
X26 VGND S0 a_27_47# VNB sky130_fd_pr__nfet_01v8 ad=0.0567 pd=0.69 as=0.1092 ps=1.36 w=0.42 l=0.15
X27 VPWR A0 a_1279_413# VPB sky130_fd_pr__pfet_01v8_hvt ad=0.154 pd=1.335 as=0.10535 ps=0.995 w=0.64 l=0.15
.ends

.subckt sky130_fd_sc_hd__a22o_2 VPWR VGND VPB VNB B2 B1 A1 A2 X
X0 VPWR a_27_297# X VPB sky130_fd_pr__pfet_01v8_hvt ad=0.27 pd=2.54 as=0.135 ps=1.27 w=1 l=0.15
X1 VGND A2 a_381_47# VNB sky130_fd_pr__nfet_01v8 ad=0.102375 pd=0.965 as=0.10725 ps=0.98 w=0.65 l=0.15
X2 X a_27_297# VGND VNB sky130_fd_pr__nfet_01v8 ad=0.08775 pd=0.92 as=0.102375 ps=0.965 w=0.65 l=0.15
X3 X a_27_297# VPWR VPB sky130_fd_pr__pfet_01v8_hvt ad=0.135 pd=1.27 as=0.1575 ps=1.315 w=1 l=0.15
X4 a_27_297# B1 a_109_47# VNB sky130_fd_pr__nfet_01v8 ad=0.169 pd=1.82 as=0.07475 ps=0.88 w=0.65 l=0.15
X5 a_27_297# B1 a_109_297# VPB sky130_fd_pr__pfet_01v8_hvt ad=0.26 pd=2.52 as=0.135 ps=1.27 w=1 l=0.15
X6 VGND a_27_297# X VNB sky130_fd_pr__nfet_01v8 ad=0.1755 pd=1.84 as=0.08775 ps=0.92 w=0.65 l=0.15
X7 a_109_297# A1 VPWR VPB sky130_fd_pr__pfet_01v8_hvt ad=0.165 pd=1.33 as=0.26 ps=2.52 w=1 l=0.15
X8 VPWR A2 a_109_297# VPB sky130_fd_pr__pfet_01v8_hvt ad=0.1575 pd=1.315 as=0.165 ps=1.33 w=1 l=0.15
X9 a_381_47# A1 a_27_297# VNB sky130_fd_pr__nfet_01v8 ad=0.10725 pd=0.98 as=0.169 ps=1.82 w=0.65 l=0.15
X10 a_109_297# B2 a_27_297# VPB sky130_fd_pr__pfet_01v8_hvt ad=0.135 pd=1.27 as=0.26 ps=2.52 w=1 l=0.15
X11 a_109_47# B2 VGND VNB sky130_fd_pr__nfet_01v8 ad=0.07475 pd=0.88 as=0.169 ps=1.82 w=0.65 l=0.15
.ends

.subckt sky130_fd_sc_hd__decap_8 VPWR VGND VPB VNB
X0 VPWR VGND VPWR VPB sky130_fd_pr__pfet_01v8_hvt ad=0.2262 pd=2.26 as=0 ps=0 w=0.87 l=2.89
X1 VGND VPWR VGND VNB sky130_fd_pr__nfet_01v8 ad=0.143 pd=1.62 as=0 ps=0 w=0.55 l=2.89
.ends

.subckt sky130_fd_sc_hd__decap_3 VPWR VGND VPB VNB
X0 VPWR VGND VPWR VPB sky130_fd_pr__pfet_01v8_hvt ad=0.2262 pd=2.26 as=0 ps=0 w=0.87 l=0.59
X1 VGND VPWR VGND VNB sky130_fd_pr__nfet_01v8 ad=0.143 pd=1.62 as=0 ps=0 w=0.55 l=0.59
.ends

.subckt sky130_fd_sc_hd__inv_2 VPB VNB VPWR VGND Y A
X0 Y A VPWR VPB sky130_fd_pr__pfet_01v8_hvt ad=0.135 pd=1.27 as=0.26 ps=2.52 w=1 l=0.15
X1 VGND A Y VNB sky130_fd_pr__nfet_01v8 ad=0.169 pd=1.82 as=0.08775 ps=0.92 w=0.65 l=0.15
X2 Y A VGND VNB sky130_fd_pr__nfet_01v8 ad=0.08775 pd=0.92 as=0.169 ps=1.82 w=0.65 l=0.15
X3 VPWR A Y VPB sky130_fd_pr__pfet_01v8_hvt ad=0.26 pd=2.52 as=0.135 ps=1.27 w=1 l=0.15
.ends

.subckt sky130_fd_sc_hd__o21a_2 VNB VPB VGND VPWR X B1 A2 A1
X0 VPWR A1 a_470_297# VPB sky130_fd_pr__pfet_01v8_hvt ad=0.265 pd=2.53 as=0.16 ps=1.32 w=1 l=0.15
X1 a_79_21# B1 VPWR VPB sky130_fd_pr__pfet_01v8_hvt ad=0.14 pd=1.28 as=0.4 ps=1.8 w=1 l=0.15
X2 VGND a_79_21# X VNB sky130_fd_pr__nfet_01v8 ad=0.17225 pd=1.83 as=0.089375 ps=0.925 w=0.65 l=0.15
X3 VGND A2 a_384_47# VNB sky130_fd_pr__nfet_01v8 ad=0.104 pd=0.97 as=0.091 ps=0.93 w=0.65 l=0.15
X4 a_470_297# A2 a_79_21# VPB sky130_fd_pr__pfet_01v8_hvt ad=0.16 pd=1.32 as=0.14 ps=1.28 w=1 l=0.15
X5 VPWR a_79_21# X VPB sky130_fd_pr__pfet_01v8_hvt ad=0.4 pd=1.8 as=0.1375 ps=1.275 w=1 l=0.15
X6 a_384_47# B1 a_79_21# VNB sky130_fd_pr__nfet_01v8 ad=0.091 pd=0.93 as=0.17225 ps=1.83 w=0.65 l=0.15
X7 a_384_47# A1 VGND VNB sky130_fd_pr__nfet_01v8 ad=0.17225 pd=1.83 as=0.104 ps=0.97 w=0.65 l=0.15
X8 X a_79_21# VPWR VPB sky130_fd_pr__pfet_01v8_hvt ad=0.1375 pd=1.275 as=0.26 ps=2.52 w=1 l=0.15
X9 X a_79_21# VGND VNB sky130_fd_pr__nfet_01v8 ad=0.089375 pd=0.925 as=0.169 ps=1.82 w=0.65 l=0.15
.ends

.subckt sky130_fd_sc_hd__mux2_1 VGND VPWR VPB VNB X A1 S A0
X0 VPWR a_505_21# a_535_374# VPB sky130_fd_pr__pfet_01v8_hvt ad=0.0693 pd=0.75 as=0.0441 ps=0.63 w=0.42 l=0.15
X1 a_505_21# S VPWR VPB sky130_fd_pr__pfet_01v8_hvt ad=0.1176 pd=1.4 as=0.0693 ps=0.75 w=0.42 l=0.15
X2 a_218_374# S VPWR VPB sky130_fd_pr__pfet_01v8_hvt ad=0.07665 pd=0.785 as=0.15835 ps=1.395 w=0.42 l=0.15
X3 VGND a_505_21# a_439_47# VNB sky130_fd_pr__nfet_01v8 ad=0.1449 pd=1.11 as=0.0693 ps=0.75 w=0.42 l=0.15
X4 a_76_199# A0 a_218_374# VPB sky130_fd_pr__pfet_01v8_hvt ad=0.1932 pd=1.34 as=0.07665 ps=0.785 w=0.42 l=0.15
X5 a_505_21# S VGND VNB sky130_fd_pr__nfet_01v8 ad=0.1092 pd=1.36 as=0.1449 ps=1.11 w=0.42 l=0.15
X6 a_439_47# A0 a_76_199# VNB sky130_fd_pr__nfet_01v8 ad=0.0693 pd=0.75 as=0.09975 ps=0.895 w=0.42 l=0.15
X7 a_535_374# A1 a_76_199# VPB sky130_fd_pr__pfet_01v8_hvt ad=0.0441 pd=0.63 as=0.1932 ps=1.34 w=0.42 l=0.15
X8 a_76_199# A1 a_218_47# VNB sky130_fd_pr__nfet_01v8 ad=0.09975 pd=0.895 as=0.0693 ps=0.75 w=0.42 l=0.15
X9 a_218_47# S VGND VNB sky130_fd_pr__nfet_01v8 ad=0.0693 pd=0.75 as=0.11285 ps=1.045 w=0.42 l=0.15
X10 VPWR a_76_199# X VPB sky130_fd_pr__pfet_01v8_hvt ad=0.15835 pd=1.395 as=0.26 ps=2.52 w=1 l=0.15
X11 VGND a_76_199# X VNB sky130_fd_pr__nfet_01v8 ad=0.11285 pd=1.045 as=0.169 ps=1.82 w=0.65 l=0.15
.ends

.subckt sky130_fd_sc_hd__or2_2 VPWR VGND VPB VNB X A B
X0 a_121_297# B a_39_297# VPB sky130_fd_pr__pfet_01v8_hvt ad=0.0441 pd=0.63 as=0.1092 ps=1.36 w=0.42 l=0.15
X1 X a_39_297# VGND VNB sky130_fd_pr__nfet_01v8 ad=0.08775 pd=0.92 as=0.10675 ps=1.005 w=0.65 l=0.15
X2 VPWR a_39_297# X VPB sky130_fd_pr__pfet_01v8_hvt ad=0.26 pd=2.52 as=0.135 ps=1.27 w=1 l=0.15
X3 X a_39_297# VPWR VPB sky130_fd_pr__pfet_01v8_hvt ad=0.135 pd=1.27 as=0.15575 ps=1.355 w=1 l=0.15
X4 VGND a_39_297# X VNB sky130_fd_pr__nfet_01v8 ad=0.169 pd=1.82 as=0.08775 ps=0.92 w=0.65 l=0.15
X5 VPWR A a_121_297# VPB sky130_fd_pr__pfet_01v8_hvt ad=0.15575 pd=1.355 as=0.0441 ps=0.63 w=0.42 l=0.15
X6 VGND A a_39_297# VNB sky130_fd_pr__nfet_01v8 ad=0.10675 pd=1.005 as=0.0567 ps=0.69 w=0.42 l=0.15
X7 a_39_297# B VGND VNB sky130_fd_pr__nfet_01v8 ad=0.0567 pd=0.69 as=0.1092 ps=1.36 w=0.42 l=0.15
.ends

.subckt sky130_fd_sc_hd__a21o_2 VNB VPB VGND VPWR A2 A1 B1 X
X0 VPWR a_80_199# X VPB sky130_fd_pr__pfet_01v8_hvt ad=0.265 pd=2.53 as=0.14 ps=1.28 w=1 l=0.15
X1 X a_80_199# VPWR VPB sky130_fd_pr__pfet_01v8_hvt ad=0.14 pd=1.28 as=0.265 ps=2.53 w=1 l=0.15
X2 VGND a_80_199# X VNB sky130_fd_pr__nfet_01v8 ad=0.1105 pd=0.99 as=0.091 ps=0.93 w=0.65 l=0.15
X3 a_386_297# A2 VPWR VPB sky130_fd_pr__pfet_01v8_hvt ad=0.26 pd=2.52 as=0.1575 ps=1.315 w=1 l=0.15
X4 X a_80_199# VGND VNB sky130_fd_pr__nfet_01v8 ad=0.091 pd=0.93 as=0.17225 ps=1.83 w=0.65 l=0.15
X5 a_80_199# B1 VGND VNB sky130_fd_pr__nfet_01v8 ad=0.1625 pd=1.15 as=0.1105 ps=0.99 w=0.65 l=0.15
X6 a_386_297# B1 a_80_199# VPB sky130_fd_pr__pfet_01v8_hvt ad=0.14 pd=1.28 as=0.265 ps=2.53 w=1 l=0.15
X7 a_458_47# A1 a_80_199# VNB sky130_fd_pr__nfet_01v8 ad=0.1235 pd=1.03 as=0.1625 ps=1.15 w=0.65 l=0.15
X8 VPWR A1 a_386_297# VPB sky130_fd_pr__pfet_01v8_hvt ad=0.1575 pd=1.315 as=0.14 ps=1.28 w=1 l=0.15
X9 VGND A2 a_458_47# VNB sky130_fd_pr__nfet_01v8 ad=0.17225 pd=1.83 as=0.1235 ps=1.03 w=0.65 l=0.15
.ends

.subckt sky130_fd_sc_hd__and2b_2 VNB VPB VPWR VGND A_N X B
X0 VPWR a_212_413# X VPB sky130_fd_pr__pfet_01v8_hvt ad=0.26 pd=2.52 as=0.135 ps=1.27 w=1 l=0.15
X1 a_297_47# a_27_413# a_212_413# VNB sky130_fd_pr__nfet_01v8 ad=0.0567 pd=0.69 as=0.1092 ps=1.36 w=0.42 l=0.15
X2 X a_212_413# VPWR VPB sky130_fd_pr__pfet_01v8_hvt ad=0.135 pd=1.27 as=0.22895 ps=1.745 w=1 l=0.15
X3 X a_212_413# VGND VNB sky130_fd_pr__nfet_01v8 ad=0.08775 pd=0.92 as=0.101875 ps=0.99 w=0.65 l=0.15
X4 a_212_413# a_27_413# VPWR VPB sky130_fd_pr__pfet_01v8_hvt ad=0.0609 pd=0.71 as=0.07665 ps=0.785 w=0.42 l=0.15
X5 VPWR A_N a_27_413# VPB sky130_fd_pr__pfet_01v8_hvt ad=0.07665 pd=0.785 as=0.1092 ps=1.36 w=0.42 l=0.15
X6 VPWR B a_212_413# VPB sky130_fd_pr__pfet_01v8_hvt ad=0.22895 pd=1.745 as=0.0609 ps=0.71 w=0.42 l=0.15
X7 VGND B a_297_47# VNB sky130_fd_pr__nfet_01v8 ad=0.101875 pd=0.99 as=0.0567 ps=0.69 w=0.42 l=0.15
X8 VGND a_212_413# X VNB sky130_fd_pr__nfet_01v8 ad=0.1755 pd=1.84 as=0.08775 ps=0.92 w=0.65 l=0.15
X9 a_27_413# A_N VGND VNB sky130_fd_pr__nfet_01v8 ad=0.1092 pd=1.36 as=0.1092 ps=1.36 w=0.42 l=0.15
.ends

.subckt sky130_fd_sc_hd__and2_2 VPWR VGND A X B VPB VNB
X0 X a_61_75# VPWR VPB sky130_fd_pr__pfet_01v8_hvt ad=0.195 pd=1.39 as=0.16655 ps=1.39 w=1 l=0.15
X1 VPWR a_61_75# X VPB sky130_fd_pr__pfet_01v8_hvt ad=0.38 pd=2.76 as=0.195 ps=1.39 w=1 l=0.15
X2 VPWR B a_61_75# VPB sky130_fd_pr__pfet_01v8_hvt ad=0.16655 pd=1.39 as=0.0567 ps=0.69 w=0.42 l=0.15
X3 VGND B a_147_75# VNB sky130_fd_pr__nfet_01v8 ad=0.1118 pd=1.04 as=0.0567 ps=0.69 w=0.42 l=0.15
X4 X a_61_75# VGND VNB sky130_fd_pr__nfet_01v8 ad=0.12675 pd=1.04 as=0.1118 ps=1.04 w=0.65 l=0.15
X5 VGND a_61_75# X VNB sky130_fd_pr__nfet_01v8 ad=0.247 pd=2.06 as=0.12675 ps=1.04 w=0.65 l=0.15
X6 a_61_75# A VPWR VPB sky130_fd_pr__pfet_01v8_hvt ad=0.0567 pd=0.69 as=0.1176 ps=1.4 w=0.42 l=0.15
X7 a_147_75# A a_61_75# VNB sky130_fd_pr__nfet_01v8 ad=0.0567 pd=0.69 as=0.1176 ps=1.4 w=0.42 l=0.15
.ends

.subckt sky130_fd_sc_hd__a211o_2 VNB VPB VGND VPWR X A2 A1 B1 C1
X0 a_79_21# A1 a_348_47# VNB sky130_fd_pr__nfet_01v8 ad=0.115375 pd=1.005 as=0.13325 ps=1.06 w=0.65 l=0.15
X1 a_79_21# C1 VGND VNB sky130_fd_pr__nfet_01v8 ad=0.169 pd=1.82 as=0.10725 ps=0.98 w=0.65 l=0.15
X2 VGND a_79_21# X VNB sky130_fd_pr__nfet_01v8 ad=0.199875 pd=1.265 as=0.091 ps=0.93 w=0.65 l=0.15
X3 VPWR a_79_21# X VPB sky130_fd_pr__pfet_01v8_hvt ad=0.26 pd=2.52 as=0.135 ps=1.27 w=1 l=0.15
X4 a_79_21# C1 a_585_297# VPB sky130_fd_pr__pfet_01v8_hvt ad=0.26 pd=2.52 as=0.105 ps=1.21 w=1 l=0.15
X5 VPWR A2 a_299_297# VPB sky130_fd_pr__pfet_01v8_hvt ad=0.195 pd=1.39 as=0.26 ps=2.52 w=1 l=0.15
X6 a_299_297# A1 VPWR VPB sky130_fd_pr__pfet_01v8_hvt ad=0.165 pd=1.33 as=0.195 ps=1.39 w=1 l=0.15
X7 a_585_297# B1 a_299_297# VPB sky130_fd_pr__pfet_01v8_hvt ad=0.105 pd=1.21 as=0.165 ps=1.33 w=1 l=0.15
X8 a_348_47# A2 VGND VNB sky130_fd_pr__nfet_01v8 ad=0.13325 pd=1.06 as=0.199875 ps=1.265 w=0.65 l=0.15
X9 X a_79_21# VPWR VPB sky130_fd_pr__pfet_01v8_hvt ad=0.135 pd=1.27 as=0.26 ps=2.52 w=1 l=0.15
X10 X a_79_21# VGND VNB sky130_fd_pr__nfet_01v8 ad=0.091 pd=0.93 as=0.169 ps=1.82 w=0.65 l=0.15
X11 VGND B1 a_79_21# VNB sky130_fd_pr__nfet_01v8 ad=0.10725 pd=0.98 as=0.115375 ps=1.005 w=0.65 l=0.15
.ends

.subckt sky130_fd_sc_hd__o21ba_2 VNB VPB VGND VPWR A2 A1 B1_N X
X0 VGND B1_N a_27_93# VNB sky130_fd_pr__nfet_01v8 ad=0.097 pd=0.975 as=0.1092 ps=1.36 w=0.42 l=0.15
X1 VGND A2 a_478_47# VNB sky130_fd_pr__nfet_01v8 ad=0.08775 pd=0.92 as=0.105625 ps=0.975 w=0.65 l=0.15
X2 a_478_47# a_27_93# a_174_21# VNB sky130_fd_pr__nfet_01v8 ad=0.105625 pd=0.975 as=0.169 ps=1.82 w=0.65 l=0.15
X3 a_478_47# A1 VGND VNB sky130_fd_pr__nfet_01v8 ad=0.169 pd=1.82 as=0.08775 ps=0.92 w=0.65 l=0.15
X4 X a_174_21# VGND VNB sky130_fd_pr__nfet_01v8 ad=0.08775 pd=0.92 as=0.097 ps=0.975 w=0.65 l=0.15
X5 VPWR a_174_21# X VPB sky130_fd_pr__pfet_01v8_hvt ad=0.395 pd=1.79 as=0.135 ps=1.27 w=1 l=0.15
X6 X a_174_21# VPWR VPB sky130_fd_pr__pfet_01v8_hvt ad=0.135 pd=1.27 as=0.14575 ps=1.335 w=1 l=0.15
X7 VPWR A1 a_574_297# VPB sky130_fd_pr__pfet_01v8_hvt ad=0.28 pd=2.56 as=0.105 ps=1.21 w=1 l=0.15
X8 VGND a_174_21# X VNB sky130_fd_pr__nfet_01v8 ad=0.169 pd=1.82 as=0.08775 ps=0.92 w=0.65 l=0.15
X9 VPWR B1_N a_27_93# VPB sky130_fd_pr__pfet_01v8_hvt ad=0.14575 pd=1.335 as=0.1092 ps=1.36 w=0.42 l=0.15
X10 a_574_297# A2 a_174_21# VPB sky130_fd_pr__pfet_01v8_hvt ad=0.105 pd=1.21 as=0.165 ps=1.33 w=1 l=0.15
X11 a_174_21# a_27_93# VPWR VPB sky130_fd_pr__pfet_01v8_hvt ad=0.165 pd=1.33 as=0.395 ps=1.79 w=1 l=0.15
.ends

.subckt sky130_fd_sc_hd__o31a_2 VGND VPWR VPB VNB X A1 A2 A3 B1
X0 a_108_21# B1 a_346_47# VNB sky130_fd_pr__nfet_01v8 ad=0.2015 pd=1.92 as=0.10725 ps=0.98 w=0.65 l=0.15
X1 a_346_47# A3 VGND VNB sky130_fd_pr__nfet_01v8 ad=0.10725 pd=0.98 as=0.10725 ps=0.98 w=0.65 l=0.15
X2 X a_108_21# VGND VNB sky130_fd_pr__nfet_01v8 ad=0.11375 pd=1 as=0.26325 ps=2.11 w=0.65 l=0.15
X3 a_108_21# A3 a_430_297# VPB sky130_fd_pr__pfet_01v8_hvt ad=0.2125 pd=1.425 as=0.165 ps=1.33 w=1 l=0.15
X4 a_430_297# A2 a_346_297# VPB sky130_fd_pr__pfet_01v8_hvt ad=0.165 pd=1.33 as=0.135 ps=1.27 w=1 l=0.15
X5 VPWR a_108_21# X VPB sky130_fd_pr__pfet_01v8_hvt ad=0.195 pd=1.39 as=0.175 ps=1.35 w=1 l=0.15
X6 a_346_297# A1 VPWR VPB sky130_fd_pr__pfet_01v8_hvt ad=0.135 pd=1.27 as=0.195 ps=1.39 w=1 l=0.15
X7 VGND A2 a_346_47# VNB sky130_fd_pr__nfet_01v8 ad=0.10725 pd=0.98 as=0.08775 ps=0.92 w=0.65 l=0.15
X8 X a_108_21# VPWR VPB sky130_fd_pr__pfet_01v8_hvt ad=0.175 pd=1.35 as=0.405 ps=2.81 w=1 l=0.15
X9 VPWR B1 a_108_21# VPB sky130_fd_pr__pfet_01v8_hvt ad=0.34 pd=2.68 as=0.2125 ps=1.425 w=1 l=0.15
X10 VGND a_108_21# X VNB sky130_fd_pr__nfet_01v8 ad=0.12675 pd=1.04 as=0.11375 ps=1 w=0.65 l=0.15
X11 a_346_47# A1 VGND VNB sky130_fd_pr__nfet_01v8 ad=0.08775 pd=0.92 as=0.12675 ps=1.04 w=0.65 l=0.15
.ends

.subckt sky130_fd_sc_hd__o221a_2 VPB VNB VGND VPWR B1 B2 A2 A1 X C1
X0 VPWR a_38_47# X VPB sky130_fd_pr__pfet_01v8_hvt ad=0.26 pd=2.52 as=0.135 ps=1.27 w=1 l=0.15
X1 VPWR A1 a_497_297# VPB sky130_fd_pr__pfet_01v8_hvt ad=0.165 pd=1.33 as=0.105 ps=1.21 w=1 l=0.15
X2 X a_38_47# VPWR VPB sky130_fd_pr__pfet_01v8_hvt ad=0.135 pd=1.27 as=0.165 ps=1.33 w=1 l=0.15
X3 a_141_47# B2 a_225_47# VNB sky130_fd_pr__nfet_01v8 ad=0.169 pd=1.82 as=0.08775 ps=0.92 w=0.65 l=0.15
X4 a_497_297# A2 a_38_47# VPB sky130_fd_pr__pfet_01v8_hvt ad=0.105 pd=1.21 as=0.3875 ps=1.775 w=1 l=0.15
X5 VGND A1 a_225_47# VNB sky130_fd_pr__nfet_01v8 ad=0.08775 pd=0.92 as=0.08775 ps=0.92 w=0.65 l=0.15
X6 VPWR C1 a_38_47# VPB sky130_fd_pr__pfet_01v8_hvt ad=0.165 pd=1.33 as=0.325 ps=2.65 w=1 l=0.15
X7 a_237_297# B1 VPWR VPB sky130_fd_pr__pfet_01v8_hvt ad=0.1125 pd=1.225 as=0.165 ps=1.33 w=1 l=0.15
X8 a_38_47# B2 a_237_297# VPB sky130_fd_pr__pfet_01v8_hvt ad=0.3875 pd=1.775 as=0.1125 ps=1.225 w=1 l=0.15
X9 a_225_47# A2 VGND VNB sky130_fd_pr__nfet_01v8 ad=0.08775 pd=0.92 as=0.169 ps=1.82 w=0.65 l=0.15
X10 X a_38_47# VGND VNB sky130_fd_pr__nfet_01v8 ad=0.08775 pd=0.92 as=0.08775 ps=0.92 w=0.65 l=0.15
X11 a_141_47# C1 a_38_47# VNB sky130_fd_pr__nfet_01v8 ad=0.08775 pd=0.92 as=0.23725 ps=2.03 w=0.65 l=0.15
X12 VGND a_38_47# X VNB sky130_fd_pr__nfet_01v8 ad=0.169 pd=1.82 as=0.08775 ps=0.92 w=0.65 l=0.15
X13 a_225_47# B1 a_141_47# VNB sky130_fd_pr__nfet_01v8 ad=0.08775 pd=0.92 as=0.08775 ps=0.92 w=0.65 l=0.15
.ends

.subckt inv_dcdl A Q[0] Q[1] Q[2] Q[3] Q[4] Q[5] VGND VPWR Y
XFILLER_22_133 VPWR VGND VPWR VGND sky130_fd_sc_hd__decap_6
XFILLER_22_177 VGND VPWR VPWR VGND sky130_ef_sc_hd__decap_12
Xdelay_chain\[28\].genblk1.inv_a.core_inv VPWR VGND VGND VPWR tap\[27\] d\[28\] sky130_fd_sc_hd__inv_1
XFILLER_45_225 VGND VPWR VPWR VGND sky130_ef_sc_hd__decap_12
XFILLER_26_41 VGND VPWR VPWR VGND sky130_ef_sc_hd__decap_12
XFILLER_26_85 VGND VPWR VPWR VGND sky130_ef_sc_hd__decap_12
XFILLER_9_137 VGND VPWR VPWR VGND sky130_ef_sc_hd__decap_12
Xdelay_chain\[37\].genblk1.inv_a.core_inv VPWR VGND VGND VPWR tap\[36\] d\[37\] sky130_fd_sc_hd__inv_1
Xdelay_chain\[46\].genblk1.inv_a.core_inv VPWR VGND VGND VPWR tap\[45\] d\[46\] sky130_fd_sc_hd__inv_1
XFILLER_27_225 VGND VPWR VPWR VGND sky130_ef_sc_hd__decap_12
XFILLER_12_65 VGND VPWR VPWR VGND sky130_ef_sc_hd__decap_12
Xdelay_chain\[55\].genblk1.inv_a.core_inv VPWR VGND VGND VPWR tap\[54\] d\[55\] sky130_fd_sc_hd__inv_1
XFILLER_37_51 VGND VPWR VPWR VGND sky130_fd_sc_hd__decap_4
XFILLER_41_261 VGND VPWR VPWR VGND sky130_ef_sc_hd__decap_12
XFILLER_33_217 VPWR VGND VPWR VGND sky130_fd_sc_hd__decap_6
XFILLER_30_209 VGND VPWR VPWR VGND sky130_ef_sc_hd__decap_12
X_062_ VGND VPWR VGND VPWR Q[0] tap\[46\] tap\[47\] Q[1] tap\[45\] tap\[44\] _034_
+ sky130_fd_sc_hd__mux4_2
XFILLER_2_121 VGND VPWR VPWR VGND sky130_ef_sc_hd__decap_12
XFILLER_0_57 VGND VPWR VPWR VGND sky130_ef_sc_hd__decap_12
XFILLER_14_272 VGND VPWR VPWR VGND sky130_ef_sc_hd__decap_12
XFILLER_12_209 VGND VPWR VPWR VGND sky130_ef_sc_hd__decap_12
XFILLER_20_253 VGND VPWR VPWR VGND sky130_ef_sc_hd__decap_12
XFILLER_18_53 VGND VPWR VPWR VGND sky130_ef_sc_hd__decap_12
XFILLER_18_97 VGND VPWR VPWR VGND sky130_ef_sc_hd__decap_12
XFILLER_34_41 VGND VPWR VPWR VGND sky130_ef_sc_hd__decap_12
XFILLER_34_85 VGND VPWR VPWR VGND sky130_ef_sc_hd__decap_12
X_114_ VPWR VGND VPWR VGND _031_ _027_ _024_ _026_ _028_ sky130_fd_sc_hd__a22o_2
Xdelay_chain\[2\].genblk1.inv_a.core_inv VPWR VGND VGND VPWR tap\[1\] d\[2\] sky130_fd_sc_hd__inv_1
XFILLER_44_109 VGND VPWR VPWR VGND sky130_ef_sc_hd__decap_12
XFILLER_37_161 VPWR VGND VPWR VGND sky130_fd_sc_hd__decap_6
XFILLER_20_65 VGND VPWR VPWR VGND sky130_ef_sc_hd__decap_12
XFILLER_45_51 VGND VPWR VPWR VGND sky130_fd_sc_hd__decap_4
XFILLER_3_293 VPWR VGND VPWR VGND sky130_fd_sc_hd__decap_6
XFILLER_13_3 VGND VPWR VPWR VGND sky130_ef_sc_hd__decap_12
XFILLER_19_161 VPWR VGND VPWR VGND sky130_fd_sc_hd__decap_6
XFILLER_26_109 VGND VPWR VPWR VGND sky130_ef_sc_hd__decap_12
XFILLER_34_153 VGND VPWR VPWR VGND sky130_ef_sc_hd__decap_12
XFILLER_34_197 VGND VPWR VPWR VGND sky130_ef_sc_hd__decap_12
XFILLER_40_189 VPWR VGND VPWR VGND sky130_fd_sc_hd__decap_6
XFILLER_16_153 VPWR VGND VPWR VGND sky130_fd_sc_hd__decap_8
XFILLER_16_175 VPWR VGND VPWR VGND sky130_fd_sc_hd__decap_8
XFILLER_16_197 VGND VPWR VPWR VGND sky130_fd_sc_hd__decap_4
XFILLER_22_189 VPWR VGND VPWR VGND sky130_fd_sc_hd__decap_6
XFILLER_45_237 VGND VPWR VPWR VGND sky130_ef_sc_hd__decap_12
XFILLER_9_105 VPWR VGND VPWR VGND sky130_fd_sc_hd__decap_6
XFILLER_26_53 VGND VPWR VPWR VGND sky130_ef_sc_hd__decap_12
XFILLER_26_97 VGND VPWR VPWR VGND sky130_ef_sc_hd__decap_12
XFILLER_42_85 VGND VPWR VPWR VGND sky130_ef_sc_hd__decap_12
XFILLER_42_41 VGND VPWR VPWR VGND sky130_ef_sc_hd__decap_12
XFILLER_9_149 VGND VPWR VPWR VGND sky130_ef_sc_hd__decap_12
XFILLER_3_57 VGND VPWR VPWR VGND sky130_ef_sc_hd__decap_12
XFILLER_35_281 VGND VPWR VPWR VGND sky130_ef_sc_hd__decap_12
XFILLER_27_237 VPWR VGND VPWR VGND sky130_fd_sc_hd__decap_3
XFILLER_12_77 VPWR VGND VPWR VGND sky130_fd_sc_hd__decap_6
XFILLER_41_273 VPWR VGND VPWR VGND sky130_fd_sc_hd__decap_6
XFILLER_17_281 VGND VPWR VPWR VGND sky130_fd_sc_hd__decap_4
XPHY_EDGE_ROW_12_Right_12 VPWR VGND VPWR VGND sky130_fd_sc_hd__decap_3
XPHY_EDGE_ROW_21_Right_21 VPWR VGND VPWR VGND sky130_fd_sc_hd__decap_3
X_061_ VPWR VGND VPWR VGND _033_ Q[5] sky130_fd_sc_hd__inv_2
XPHY_EDGE_ROW_30_Right_30 VPWR VGND VPWR VGND sky130_fd_sc_hd__decap_3
XFILLER_2_133 VPWR VGND VPWR VGND sky130_fd_sc_hd__decap_6
XFILLER_0_69 VGND VPWR VPWR VGND sky130_ef_sc_hd__decap_12
XFILLER_14_284 VGND VPWR VPWR VGND sky130_ef_sc_hd__decap_12
XFILLER_43_3 VGND VPWR VPWR VGND sky130_ef_sc_hd__decap_12
XFILLER_20_210 VGND VPWR VPWR VGND sky130_ef_sc_hd__decap_12
XFILLER_20_265 VPWR VGND VPWR VGND sky130_fd_sc_hd__decap_8
XFILLER_18_65 VGND VPWR VPWR VGND sky130_ef_sc_hd__decap_12
XFILLER_7_225 VGND VPWR VPWR VGND sky130_ef_sc_hd__decap_12
X_113_ VGND VPWR VGND VPWR Q[0] tap\[18\] tap\[19\] Q[1] tap\[17\] tap\[16\] _027_
+ sky130_fd_sc_hd__mux4_2
XFILLER_34_53 VGND VPWR VPWR VGND sky130_ef_sc_hd__decap_12
XFILLER_34_97 VGND VPWR VPWR VGND sky130_ef_sc_hd__decap_12
XPHY_EDGE_ROW_28_Left_75 VPWR VGND VPWR VGND sky130_fd_sc_hd__decap_3
XPHY_EDGE_ROW_12_Left_59 VPWR VGND VPWR VGND sky130_fd_sc_hd__decap_3
XFILLER_20_77 VPWR VGND VPWR VGND sky130_fd_sc_hd__decap_6
XFILLER_3_261 VGND VPWR VPWR VGND sky130_ef_sc_hd__decap_12
XFILLER_34_121 VGND VPWR VPWR VGND sky130_ef_sc_hd__decap_12
XFILLER_34_165 VGND VPWR VPWR VGND sky130_ef_sc_hd__decap_12
XPHY_EDGE_ROW_6_Right_6 VPWR VGND VPWR VGND sky130_fd_sc_hd__decap_3
XFILLER_0_253 VGND VPWR VPWR VGND sky130_ef_sc_hd__decap_12
XFILLER_16_121 VGND VPWR VPWR VGND sky130_ef_sc_hd__decap_12
Xdelay_chain\[3\].inv_b.core_inv VPWR VGND VGND VPWR d\[3\] tap\[3\] sky130_fd_sc_hd__inv_1
XFILLER_31_113 VGND VPWR VPWR VGND sky130_ef_sc_hd__decap_12
XPHY_EDGE_ROW_15_Left_62 VPWR VGND VPWR VGND sky130_fd_sc_hd__decap_3
XFILLER_45_249 VGND VPWR VPWR VGND sky130_ef_sc_hd__decap_12
XFILLER_45_205 VGND VPWR VPWR VGND sky130_ef_sc_hd__decap_12
XFILLER_42_53 VGND VPWR VPWR VGND sky130_ef_sc_hd__decap_12
XFILLER_13_113 VGND VPWR VPWR VGND sky130_ef_sc_hd__decap_12
XFILLER_26_65 VGND VPWR VPWR VGND sky130_ef_sc_hd__decap_12
XFILLER_42_97 VGND VPWR VPWR VGND sky130_ef_sc_hd__decap_12
XFILLER_3_69 VGND VPWR VPWR VGND sky130_ef_sc_hd__decap_12
XFILLER_35_293 VPWR VGND VPWR VGND sky130_fd_sc_hd__decap_6
XFILLER_6_109 VGND VPWR VPWR VGND sky130_ef_sc_hd__decap_12
XPHY_EDGE_ROW_0_Left_47 VPWR VGND VPWR VGND sky130_fd_sc_hd__decap_3
XFILLER_17_260 VGND VPWR VPWR VGND sky130_ef_sc_hd__decap_12
XPHY_EDGE_ROW_42_Left_89 VPWR VGND VPWR VGND sky130_fd_sc_hd__decap_3
XFILLER_3_3 VGND VPWR VPWR VGND sky130_ef_sc_hd__decap_12
X_060_ VPWR VGND VPWR VGND _032_ Q[4] sky130_fd_sc_hd__inv_2
XFILLER_0_15 VGND VPWR VPWR VGND sky130_ef_sc_hd__decap_12
Xdelay_chain\[8\].inv_b.core_inv VPWR VGND VGND VPWR d\[8\] tap\[8\] sky130_fd_sc_hd__inv_1
XFILLER_9_57 VGND VPWR VPWR VGND sky130_ef_sc_hd__decap_12
XFILLER_14_296 VPWR VGND VPWR VGND sky130_fd_sc_hd__decap_3
XFILLER_36_3 VGND VPWR VPWR VGND sky130_ef_sc_hd__decap_12
XFILLER_20_200 VGND VPWR VPWR VGND sky130_fd_sc_hd__decap_4
XFILLER_20_222 VPWR VGND VPWR VGND sky130_fd_sc_hd__decap_6
XFILLER_18_77 VPWR VGND VPWR VGND sky130_fd_sc_hd__decap_6
XFILLER_7_237 VGND VPWR VPWR VGND sky130_ef_sc_hd__decap_12
X_112_ VGND VPWR VGND VPWR _026_ Q[2] _025_ _030_ sky130_fd_sc_hd__o21a_2
XFILLER_34_65 VGND VPWR VPWR VGND sky130_ef_sc_hd__decap_12
XFILLER_46_141 VGND VPWR VPWR VGND sky130_ef_sc_hd__decap_12
XPHY_EDGE_ROW_3_Left_50 VPWR VGND VPWR VGND sky130_fd_sc_hd__decap_3
XPHY_EDGE_ROW_45_Left_92 VPWR VGND VPWR VGND sky130_fd_sc_hd__decap_3
XFILLER_28_141 VGND VPWR VPWR VGND sky130_ef_sc_hd__decap_12
XFILLER_3_273 VPWR VGND VPWR VGND sky130_fd_sc_hd__decap_6
Xdelay_chain\[12\].genblk1.inv_a.core_inv VPWR VGND VGND VPWR tap\[11\] d\[12\] sky130_fd_sc_hd__inv_1
XFILLER_34_133 VPWR VGND VPWR VGND sky130_fd_sc_hd__decap_6
XFILLER_34_177 VGND VPWR VPWR VGND sky130_ef_sc_hd__decap_12
Xdelay_chain\[21\].genblk1.inv_a.core_inv VPWR VGND VGND VPWR tap\[20\] d\[21\] sky130_fd_sc_hd__inv_1
XFILLER_0_221 VPWR VGND VPWR VGND sky130_fd_sc_hd__decap_3
XFILLER_0_265 VGND VPWR VPWR VGND sky130_ef_sc_hd__decap_12
XFILLER_16_133 VPWR VGND VPWR VGND sky130_fd_sc_hd__decap_6
Xdelay_chain\[30\].genblk1.inv_a.core_inv VPWR VGND VGND VPWR tap\[29\] d\[30\] sky130_fd_sc_hd__inv_1
XFILLER_16_188 VPWR VGND VPWR VGND sky130_fd_sc_hd__decap_8
XFILLER_31_125 VGND VPWR VPWR VGND sky130_ef_sc_hd__decap_12
XFILLER_31_169 VGND VPWR VPWR VGND sky130_ef_sc_hd__decap_12
XFILLER_39_225 VGND VPWR VPWR VGND sky130_ef_sc_hd__decap_12
Xdelay_chain\[61\].inv_b.core_inv VPWR VGND VGND VPWR d\[61\] tap\[61\] sky130_fd_sc_hd__inv_1
XFILLER_45_217 VPWR VGND VPWR VGND sky130_fd_sc_hd__decap_6
XFILLER_42_65 VGND VPWR VPWR VGND sky130_ef_sc_hd__decap_12
XFILLER_13_125 VGND VPWR VPWR VGND sky130_ef_sc_hd__decap_12
XFILLER_13_169 VGND VPWR VPWR VGND sky130_ef_sc_hd__decap_12
XFILLER_26_77 VPWR VGND VPWR VGND sky130_fd_sc_hd__decap_6
XFILLER_3_15 VGND VPWR VPWR VGND sky130_ef_sc_hd__decap_12
XFILLER_42_209 VGND VPWR VPWR VGND sky130_ef_sc_hd__decap_12
XFILLER_35_261 VGND VPWR VPWR VGND sky130_ef_sc_hd__decap_12
XFILLER_18_228 VGND VPWR VPWR VGND sky130_ef_sc_hd__decap_12
XFILLER_17_272 VGND VPWR VPWR VGND sky130_fd_sc_hd__decap_4
XFILLER_32_253 VGND VPWR VPWR VGND sky130_ef_sc_hd__decap_12
XFILLER_23_253 VPWR VGND VPWR VGND sky130_fd_sc_hd__decap_8
XFILLER_9_69 VGND VPWR VPWR VGND sky130_ef_sc_hd__decap_12
XFILLER_29_3 VGND VPWR VPWR VGND sky130_ef_sc_hd__decap_12
XFILLER_34_77 VPWR VGND VPWR VGND sky130_fd_sc_hd__decap_6
XFILLER_7_249 VGND VPWR VPWR VGND sky130_ef_sc_hd__decap_12
XFILLER_7_205 VGND VPWR VPWR VGND sky130_ef_sc_hd__decap_12
X_111_ VGND VPWR VPWR VGND _025_ tap\[23\] Q[0] tap\[22\] sky130_fd_sc_hd__mux2_1
XFILLER_38_109 VGND VPWR VPWR VGND sky130_ef_sc_hd__decap_12
XFILLER_46_197 VGND VPWR VPWR VGND sky130_ef_sc_hd__decap_12
XFILLER_46_153 VGND VPWR VPWR VGND sky130_ef_sc_hd__decap_12
XFILLER_1_81 VGND VPWR VPWR VGND sky130_ef_sc_hd__decap_12
Xdelay_chain\[52\].inv_b.core_inv VPWR VGND VGND VPWR d\[52\] tap\[52\] sky130_fd_sc_hd__inv_1
XFILLER_28_153 VGND VPWR VPWR VGND sky130_ef_sc_hd__decap_12
XFILLER_28_197 VGND VPWR VPWR VGND sky130_ef_sc_hd__decap_12
XFILLER_6_15 VGND VPWR VPWR VGND sky130_ef_sc_hd__decap_12
XFILLER_34_189 VPWR VGND VPWR VGND sky130_fd_sc_hd__decap_6
XFILLER_15_57 VGND VPWR VPWR VGND sky130_ef_sc_hd__decap_12
XFILLER_0_277 VPWR VGND VPWR VGND sky130_fd_sc_hd__decap_3
XFILLER_31_137 VGND VPWR VPWR VGND sky130_ef_sc_hd__decap_12
XFILLER_39_237 VGND VPWR VPWR VGND sky130_ef_sc_hd__decap_12
XFILLER_11_3 VGND VPWR VPWR VGND sky130_ef_sc_hd__decap_12
XFILLER_42_77 VPWR VGND VPWR VGND sky130_fd_sc_hd__decap_6
XFILLER_13_137 VGND VPWR VPWR VGND sky130_ef_sc_hd__decap_12
Xdelay_chain\[49\].genblk1.inv_a.core_inv VPWR VGND VGND VPWR tap\[48\] d\[49\] sky130_fd_sc_hd__inv_1
XFILLER_3_27 VGND VPWR VPWR VGND sky130_ef_sc_hd__decap_12
XFILLER_29_281 VGND VPWR VPWR VGND sky130_ef_sc_hd__decap_12
XFILLER_8_141 VGND VPWR VPWR VGND sky130_ef_sc_hd__decap_12
Xdelay_chain\[58\].genblk1.inv_a.core_inv VPWR VGND VGND VPWR tap\[57\] d\[58\] sky130_fd_sc_hd__inv_1
XFILLER_35_273 VPWR VGND VPWR VGND sky130_fd_sc_hd__decap_6
Xdelay_chain\[57\].inv_b.core_inv VPWR VGND VGND VPWR d\[57\] tap\[57\] sky130_fd_sc_hd__inv_1
XFILLER_32_221 VGND VPWR VPWR VGND sky130_ef_sc_hd__decap_12
XFILLER_32_265 VGND VPWR VPWR VGND sky130_ef_sc_hd__decap_12
XFILLER_23_57 VGND VPWR VPWR VGND sky130_ef_sc_hd__decap_12
XFILLER_9_15 VGND VPWR VPWR VGND sky130_ef_sc_hd__decap_12
XFILLER_14_221 VGND VPWR VPWR VGND sky130_ef_sc_hd__decap_12
Xdelay_chain\[43\].inv_b.core_inv VPWR VGND VGND VPWR d\[43\] tap\[43\] sky130_fd_sc_hd__inv_1
XFILLER_20_235 VPWR VGND VPWR VGND sky130_fd_sc_hd__decap_8
Xdelay_chain\[5\].genblk1.inv_a.core_inv VPWR VGND VGND VPWR tap\[4\] d\[5\] sky130_fd_sc_hd__inv_1
X_110_ VPWR VGND VPWR VGND _024_ Q[1] _023_ sky130_fd_sc_hd__or2_2
XFILLER_7_217 VPWR VGND VPWR VGND sky130_fd_sc_hd__decap_6
XFILLER_46_165 VPWR VGND VPWR VGND sky130_fd_sc_hd__decap_3
XFILLER_41_3 VGND VPWR VPWR VGND sky130_ef_sc_hd__decap_12
XFILLER_1_93 VGND VPWR VPWR VGND sky130_ef_sc_hd__decap_12
XFILLER_4_209 VGND VPWR VPWR VGND sky130_ef_sc_hd__decap_12
XFILLER_43_113 VGND VPWR VPWR VGND sky130_ef_sc_hd__decap_12
XFILLER_28_121 VGND VPWR VPWR VGND sky130_ef_sc_hd__decap_12
XFILLER_28_165 VGND VPWR VPWR VGND sky130_ef_sc_hd__decap_12
XFILLER_25_113 VGND VPWR VPWR VGND sky130_ef_sc_hd__decap_12
XFILLER_15_69 VGND VPWR VPWR VGND sky130_ef_sc_hd__decap_12
XFILLER_31_57 VGND VPWR VPWR VGND sky130_ef_sc_hd__decap_12
XPHY_EDGE_ROW_19_Right_19 VPWR VGND VPWR VGND sky130_fd_sc_hd__decap_3
XFILLER_31_105 VPWR VGND VPWR VGND sky130_fd_sc_hd__decap_6
XFILLER_31_149 VGND VPWR VPWR VGND sky130_ef_sc_hd__decap_12
XFILLER_39_205 VGND VPWR VPWR VGND sky130_ef_sc_hd__decap_12
Xdelay_chain\[48\].inv_b.core_inv VPWR VGND VGND VPWR d\[48\] tap\[48\] sky130_fd_sc_hd__inv_1
XPHY_EDGE_ROW_28_Right_28 VPWR VGND VPWR VGND sky130_fd_sc_hd__decap_3
XFILLER_39_249 VGND VPWR VPWR VGND sky130_ef_sc_hd__decap_12
XPHY_EDGE_ROW_37_Right_37 VPWR VGND VPWR VGND sky130_fd_sc_hd__decap_3
XPHY_EDGE_ROW_46_Right_46 VPWR VGND VPWR VGND sky130_fd_sc_hd__decap_3
XFILLER_7_81 VGND VPWR VPWR VGND sky130_ef_sc_hd__decap_12
XFILLER_13_105 VPWR VGND VPWR VGND sky130_fd_sc_hd__decap_6
XFILLER_13_149 VGND VPWR VPWR VGND sky130_ef_sc_hd__decap_12
XFILLER_3_39 VGND VPWR VPWR VGND sky130_ef_sc_hd__decap_12
XFILLER_29_293 VPWR VGND VPWR VGND sky130_fd_sc_hd__decap_6
XFILLER_8_197 VGND VPWR VPWR VGND sky130_ef_sc_hd__decap_12
XFILLER_8_153 VGND VPWR VPWR VGND sky130_ef_sc_hd__decap_12
XPHY_EDGE_ROW_19_Left_66 VPWR VGND VPWR VGND sky130_fd_sc_hd__decap_3
XFILLER_12_15 VGND VPWR VPWR VGND sky130_ef_sc_hd__decap_12
Xdelay_chain\[34\].inv_b.core_inv VPWR VGND VGND VPWR d\[34\] tap\[34\] sky130_fd_sc_hd__inv_1
XFILLER_17_296 VPWR VGND VPWR VGND sky130_fd_sc_hd__decap_3
XFILLER_32_233 VGND VPWR VPWR VGND sky130_ef_sc_hd__decap_12
XFILLER_32_277 VGND VPWR VPWR VGND sky130_ef_sc_hd__decap_12
XFILLER_23_69 VGND VPWR VPWR VGND sky130_ef_sc_hd__decap_12
XFILLER_0_29 VGND VPWR VPWR VGND sky130_ef_sc_hd__decap_12
XFILLER_9_27 VGND VPWR VPWR VGND sky130_ef_sc_hd__decap_12
XFILLER_1_181 VGND VPWR VPWR VGND sky130_ef_sc_hd__decap_12
XFILLER_9_281 VGND VPWR VPWR VGND sky130_ef_sc_hd__decap_12
XFILLER_20_247 VGND VPWR VPWR VGND sky130_fd_sc_hd__decap_4
Xdelay_chain\[20\].inv_b.core_inv VPWR VGND VGND VPWR d\[20\] tap\[20\] sky130_fd_sc_hd__inv_1
XFILLER_11_225 VGND VPWR VPWR VGND sky130_ef_sc_hd__decap_12
XFILLER_1_3 VGND VPWR VPWR VGND sky130_ef_sc_hd__decap_12
XFILLER_34_3 VGND VPWR VPWR VGND sky130_ef_sc_hd__decap_12
XFILLER_20_15 VGND VPWR VPWR VGND sky130_ef_sc_hd__decap_12
Xdelay_chain\[39\].inv_b.core_inv VPWR VGND VGND VPWR d\[39\] tap\[39\] sky130_fd_sc_hd__inv_1
XFILLER_29_57 VGND VPWR VPWR VGND sky130_ef_sc_hd__decap_12
XFILLER_43_169 VGND VPWR VPWR VGND sky130_ef_sc_hd__decap_12
XFILLER_43_125 VGND VPWR VPWR VGND sky130_ef_sc_hd__decap_12
XFILLER_28_133 VPWR VGND VPWR VGND sky130_fd_sc_hd__decap_6
XFILLER_28_177 VGND VPWR VPWR VGND sky130_ef_sc_hd__decap_12
XPHY_EDGE_ROW_7_Left_54 VPWR VGND VPWR VGND sky130_fd_sc_hd__decap_3
XFILLER_15_15 VGND VPWR VPWR VGND sky130_ef_sc_hd__decap_12
XFILLER_25_125 VGND VPWR VPWR VGND sky130_ef_sc_hd__decap_12
XFILLER_25_169 VGND VPWR VPWR VGND sky130_ef_sc_hd__decap_12
XFILLER_31_69 VGND VPWR VPWR VGND sky130_ef_sc_hd__decap_12
XFILLER_24_180 VGND VPWR VPWR VGND sky130_fd_sc_hd__decap_4
XFILLER_39_217 VPWR VGND VPWR VGND sky130_fd_sc_hd__decap_6
Xdelay_chain\[25\].inv_b.core_inv VPWR VGND VGND VPWR d\[25\] tap\[25\] sky130_fd_sc_hd__inv_1
XFILLER_7_93 VGND VPWR VPWR VGND sky130_ef_sc_hd__decap_12
XFILLER_44_253 VGND VPWR VPWR VGND sky130_ef_sc_hd__decap_12
XFILLER_36_209 VGND VPWR VPWR VGND sky130_ef_sc_hd__decap_12
XFILLER_29_261 VGND VPWR VPWR VGND sky130_ef_sc_hd__decap_12
XFILLER_8_121 VGND VPWR VPWR VGND sky130_ef_sc_hd__decap_12
XFILLER_8_165 VGND VPWR VPWR VGND sky130_ef_sc_hd__decap_12
XFILLER_10_109 VGND VPWR VPWR VGND sky130_ef_sc_hd__decap_12
XFILLER_37_57 VGND VPWR VPWR VGND sky130_ef_sc_hd__decap_12
XFILLER_26_253 VPWR VGND VPWR VGND sky130_fd_sc_hd__decap_8
XFILLER_5_113 VGND VPWR VPWR VGND sky130_ef_sc_hd__decap_12
XPHY_EDGE_ROW_36_Left_83 VPWR VGND VPWR VGND sky130_fd_sc_hd__decap_3
Xdelay_chain\[11\].inv_b.core_inv VPWR VGND VGND VPWR d\[11\] tap\[11\] sky130_fd_sc_hd__inv_1
XPHY_EDGE_ROW_20_Left_67 VPWR VGND VPWR VGND sky130_fd_sc_hd__decap_3
XFILLER_32_245 VPWR VGND VPWR VGND sky130_fd_sc_hd__decap_6
XFILLER_32_289 VPWR VGND VPWR VGND sky130_fd_sc_hd__decap_8
XFILLER_23_15 VGND VPWR VPWR VGND sky130_ef_sc_hd__decap_12
XFILLER_14_245 VGND VPWR VPWR VGND sky130_fd_sc_hd__decap_4
XFILLER_9_39 VGND VPWR VPWR VGND sky130_ef_sc_hd__decap_12
XFILLER_13_81 VGND VPWR VPWR VGND sky130_ef_sc_hd__decap_12
XFILLER_1_193 VGND VPWR VPWR VGND sky130_ef_sc_hd__decap_12
XFILLER_9_293 VPWR VGND VPWR VGND sky130_fd_sc_hd__decap_6
XFILLER_18_15 VGND VPWR VPWR VGND sky130_ef_sc_hd__decap_12
XFILLER_11_237 VGND VPWR VPWR VGND sky130_ef_sc_hd__decap_12
X_099_ VGND VPWR VPWR VGND _013_ tap\[7\] Q[0] tap\[6\] sky130_fd_sc_hd__mux2_1
XFILLER_27_3 VGND VPWR VPWR VGND sky130_ef_sc_hd__decap_12
XFILLER_1_51 VGND VPWR VPWR VGND sky130_fd_sc_hd__decap_4
XPHY_EDGE_ROW_23_Left_70 VPWR VGND VPWR VGND sky130_fd_sc_hd__decap_3
Xdelay_chain\[15\].genblk1.inv_a.core_inv VPWR VGND VGND VPWR tap\[14\] d\[15\] sky130_fd_sc_hd__inv_1
XFILLER_29_69 VGND VPWR VPWR VGND sky130_ef_sc_hd__decap_12
XFILLER_45_57 VGND VPWR VPWR VGND sky130_ef_sc_hd__decap_12
XFILLER_43_137 VGND VPWR VPWR VGND sky130_ef_sc_hd__decap_12
XFILLER_28_189 VPWR VGND VPWR VGND sky130_fd_sc_hd__decap_6
XFILLER_6_29 VGND VPWR VPWR VGND sky130_ef_sc_hd__decap_12
Xdelay_chain\[16\].inv_b.core_inv VPWR VGND VGND VPWR d\[16\] tap\[16\] sky130_fd_sc_hd__inv_1
Xdelay_chain\[24\].genblk1.inv_a.core_inv VPWR VGND VGND VPWR tap\[23\] d\[24\] sky130_fd_sc_hd__inv_1
Xdelay_chain\[33\].genblk1.inv_a.core_inv VPWR VGND VGND VPWR tap\[32\] d\[33\] sky130_fd_sc_hd__inv_1
XFILLER_15_27 VGND VPWR VPWR VGND sky130_ef_sc_hd__decap_12
XFILLER_25_137 VGND VPWR VPWR VGND sky130_ef_sc_hd__decap_12
XFILLER_33_181 VGND VPWR VPWR VGND sky130_ef_sc_hd__decap_12
XFILLER_31_15 VGND VPWR VPWR VGND sky130_ef_sc_hd__decap_12
XFILLER_0_225 VGND VPWR VPWR VGND sky130_ef_sc_hd__decap_12
XPHY_EDGE_ROW_1_Right_1 VPWR VGND VPWR VGND sky130_fd_sc_hd__decap_3
Xdelay_chain\[42\].genblk1.inv_a.core_inv VPWR VGND VGND VPWR tap\[41\] d\[42\] sky130_fd_sc_hd__inv_1
XFILLER_24_192 VGND VPWR VPWR VGND sky130_fd_sc_hd__decap_4
XFILLER_21_81 VGND VPWR VPWR VGND sky130_ef_sc_hd__decap_12
Xdelay_chain\[51\].genblk1.inv_a.core_inv VPWR VGND VGND VPWR tap\[50\] d\[51\] sky130_fd_sc_hd__inv_1
XFILLER_26_15 VGND VPWR VPWR VGND sky130_ef_sc_hd__decap_12
Xdelay_chain\[60\].genblk1.inv_a.core_inv VPWR VGND VGND VPWR tap\[59\] d\[60\] sky130_fd_sc_hd__inv_1
XFILLER_44_265 VGND VPWR VPWR VGND sky130_ef_sc_hd__decap_12
XFILLER_44_221 VGND VPWR VPWR VGND sky130_ef_sc_hd__decap_12
XFILLER_29_273 VPWR VGND VPWR VGND sky130_fd_sc_hd__decap_6
XFILLER_8_177 VGND VPWR VPWR VGND sky130_ef_sc_hd__decap_12
XFILLER_8_133 VPWR VGND VPWR VGND sky130_fd_sc_hd__decap_6
XFILLER_37_69 VGND VPWR VPWR VGND sky130_ef_sc_hd__decap_12
XFILLER_5_169 VGND VPWR VPWR VGND sky130_ef_sc_hd__decap_12
XFILLER_5_125 VGND VPWR VPWR VGND sky130_ef_sc_hd__decap_12
XFILLER_23_202 VGND VPWR VPWR VGND sky130_ef_sc_hd__decap_12
XFILLER_23_27 VGND VPWR VPWR VGND sky130_ef_sc_hd__decap_12
XFILLER_23_268 VGND VPWR VPWR VGND sky130_fd_sc_hd__decap_4
XFILLER_13_93 VGND VPWR VPWR VGND sky130_ef_sc_hd__decap_12
XFILLER_1_161 VPWR VGND VPWR VGND sky130_fd_sc_hd__decap_6
XFILLER_9_261 VGND VPWR VPWR VGND sky130_ef_sc_hd__decap_12
XFILLER_11_205 VGND VPWR VPWR VGND sky130_ef_sc_hd__decap_12
XFILLER_34_15 VGND VPWR VPWR VGND sky130_ef_sc_hd__decap_12
XFILLER_11_249 VGND VPWR VPWR VGND sky130_ef_sc_hd__decap_12
XFILLER_46_113 VGND VPWR VPWR VGND sky130_ef_sc_hd__decap_12
XFILLER_6_253 VGND VPWR VPWR VGND sky130_ef_sc_hd__decap_12
X_098_ VPWR VGND VPWR VGND _012_ Q[1] _011_ sky130_fd_sc_hd__or2_2
XFILLER_37_113 VGND VPWR VPWR VGND sky130_ef_sc_hd__decap_12
XFILLER_29_15 VGND VPWR VPWR VGND sky130_ef_sc_hd__decap_12
XFILLER_43_105 VPWR VGND VPWR VGND sky130_fd_sc_hd__decap_6
XFILLER_45_69 VGND VPWR VPWR VGND sky130_ef_sc_hd__decap_12
XFILLER_43_149 VGND VPWR VPWR VGND sky130_ef_sc_hd__decap_12
XFILLER_19_113 VGND VPWR VPWR VGND sky130_ef_sc_hd__decap_12
XFILLER_19_81 VGND VPWR VPWR VGND sky130_ef_sc_hd__decap_12
XFILLER_25_105 VPWR VGND VPWR VGND sky130_fd_sc_hd__decap_6
XFILLER_15_39 VGND VPWR VPWR VGND sky130_ef_sc_hd__decap_12
XFILLER_25_149 VGND VPWR VPWR VGND sky130_ef_sc_hd__decap_12
XFILLER_33_193 VGND VPWR VPWR VGND sky130_ef_sc_hd__decap_12
XFILLER_31_27 VGND VPWR VPWR VGND sky130_ef_sc_hd__decap_12
XFILLER_0_237 VGND VPWR VPWR VGND sky130_ef_sc_hd__decap_12
XFILLER_21_93 VGND VPWR VPWR VGND sky130_ef_sc_hd__decap_12
XFILLER_7_51 VGND VPWR VPWR VGND sky130_fd_sc_hd__decap_4
XFILLER_30_141 VGND VPWR VPWR VGND sky130_ef_sc_hd__decap_12
XPHY_EDGE_ROW_15_Right_15 VPWR VGND VPWR VGND sky130_fd_sc_hd__decap_3
XPHY_EDGE_ROW_24_Right_24 VPWR VGND VPWR VGND sky130_fd_sc_hd__decap_3
XFILLER_42_15 VGND VPWR VPWR VGND sky130_ef_sc_hd__decap_12
XPHY_EDGE_ROW_33_Right_33 VPWR VGND VPWR VGND sky130_fd_sc_hd__decap_3
XFILLER_44_277 VGND VPWR VPWR VGND sky130_ef_sc_hd__decap_12
XFILLER_44_233 VGND VPWR VPWR VGND sky130_ef_sc_hd__decap_12
XPHY_EDGE_ROW_42_Right_42 VPWR VGND VPWR VGND sky130_fd_sc_hd__decap_3
XFILLER_8_189 VPWR VGND VPWR VGND sky130_fd_sc_hd__decap_6
XFILLER_12_141 VGND VPWR VPWR VGND sky130_ef_sc_hd__decap_12
XFILLER_12_29 VGND VPWR VPWR VGND sky130_ef_sc_hd__decap_12
XFILLER_37_15 VGND VPWR VPWR VGND sky130_ef_sc_hd__decap_12
XFILLER_41_225 VGND VPWR VPWR VGND sky130_ef_sc_hd__decap_12
XFILLER_26_222 VPWR VGND VPWR VGND sky130_fd_sc_hd__decap_8
XFILLER_5_137 VGND VPWR VPWR VGND sky130_ef_sc_hd__decap_12
XFILLER_17_211 VPWR VGND VPWR VGND sky130_fd_sc_hd__decap_8
XFILLER_27_81 VGND VPWR VPWR VGND sky130_ef_sc_hd__decap_12
XFILLER_17_288 VPWR VGND VPWR VGND sky130_fd_sc_hd__decap_8
XFILLER_4_85 VGND VPWR VPWR VGND sky130_ef_sc_hd__decap_12
XFILLER_4_41 VGND VPWR VPWR VGND sky130_ef_sc_hd__decap_12
XFILLER_23_214 VPWR VGND VPWR VGND sky130_fd_sc_hd__decap_8
XFILLER_23_39 VGND VPWR VPWR VGND sky130_ef_sc_hd__decap_12
Xdelay_chain\[8\].genblk1.inv_a.core_inv VPWR VGND VGND VPWR tap\[7\] d\[8\] sky130_fd_sc_hd__inv_1
XFILLER_9_273 VPWR VGND VPWR VGND sky130_fd_sc_hd__decap_6
XFILLER_11_217 VPWR VGND VPWR VGND sky130_fd_sc_hd__decap_6
XFILLER_46_169 VGND VPWR VPWR VGND sky130_ef_sc_hd__decap_12
XFILLER_46_125 VGND VPWR VPWR VGND sky130_ef_sc_hd__decap_12
XFILLER_6_265 VGND VPWR VPWR VGND sky130_ef_sc_hd__decap_12
XFILLER_6_221 VGND VPWR VPWR VGND sky130_ef_sc_hd__decap_12
X_097_ VGND VPWR VPWR VGND _011_ tap\[5\] Q[0] tap\[4\] sky130_fd_sc_hd__mux2_1
XFILLER_37_125 VGND VPWR VPWR VGND sky130_ef_sc_hd__decap_12
XFILLER_37_169 VGND VPWR VPWR VGND sky130_ef_sc_hd__decap_12
XFILLER_20_29 VGND VPWR VPWR VGND sky130_ef_sc_hd__decap_12
XFILLER_29_27 VGND VPWR VPWR VGND sky130_ef_sc_hd__decap_12
XFILLER_45_15 VGND VPWR VPWR VGND sky130_ef_sc_hd__decap_12
XFILLER_19_125 VGND VPWR VPWR VGND sky130_ef_sc_hd__decap_12
XFILLER_35_81 VGND VPWR VPWR VGND sky130_ef_sc_hd__decap_12
XFILLER_19_93 VGND VPWR VPWR VGND sky130_ef_sc_hd__decap_12
XFILLER_32_3 VGND VPWR VPWR VGND sky130_ef_sc_hd__decap_12
XFILLER_40_109 VGND VPWR VPWR VGND sky130_ef_sc_hd__decap_12
XFILLER_33_161 VPWR VGND VPWR VGND sky130_fd_sc_hd__decap_6
XFILLER_31_39 VGND VPWR VPWR VGND sky130_ef_sc_hd__decap_12
XFILLER_0_249 VPWR VGND VPWR VGND sky130_fd_sc_hd__decap_3
Xdelay_chain\[1\].inv_b.core_inv VPWR VGND VGND VPWR d\[1\] tap\[1\] sky130_fd_sc_hd__inv_1
XFILLER_15_161 VPWR VGND VPWR VGND sky130_fd_sc_hd__decap_6
XFILLER_22_109 VGND VPWR VPWR VGND sky130_ef_sc_hd__decap_12
XFILLER_30_153 VGND VPWR VPWR VGND sky130_ef_sc_hd__decap_12
XFILLER_30_197 VGND VPWR VPWR VGND sky130_ef_sc_hd__decap_12
XFILLER_38_253 VGND VPWR VPWR VGND sky130_ef_sc_hd__decap_12
XFILLER_44_289 VPWR VGND VPWR VGND sky130_fd_sc_hd__decap_8
XFILLER_44_245 VPWR VGND VPWR VGND sky130_fd_sc_hd__decap_6
XFILLER_12_153 VGND VPWR VPWR VGND sky130_ef_sc_hd__decap_12
XFILLER_12_197 VGND VPWR VPWR VGND sky130_ef_sc_hd__decap_12
XFILLER_37_27 VGND VPWR VPWR VGND sky130_ef_sc_hd__decap_12
XFILLER_41_237 VGND VPWR VPWR VGND sky130_ef_sc_hd__decap_12
XFILLER_5_149 VGND VPWR VPWR VGND sky130_ef_sc_hd__decap_12
XFILLER_5_105 VPWR VGND VPWR VGND sky130_fd_sc_hd__decap_6
XFILLER_27_93 VGND VPWR VPWR VGND sky130_ef_sc_hd__decap_12
XFILLER_43_81 VGND VPWR VPWR VGND sky130_ef_sc_hd__decap_12
XFILLER_4_97 VGND VPWR VPWR VGND sky130_ef_sc_hd__decap_12
XFILLER_4_53 VGND VPWR VPWR VGND sky130_ef_sc_hd__decap_12
XFILLER_31_281 VGND VPWR VPWR VGND sky130_ef_sc_hd__decap_12
XFILLER_13_51 VGND VPWR VPWR VGND sky130_fd_sc_hd__decap_4
Xdelay_chain\[6\].inv_b.core_inv VPWR VGND VGND VPWR d\[6\] tap\[6\] sky130_fd_sc_hd__inv_1
XFILLER_13_281 VGND VPWR VPWR VGND sky130_ef_sc_hd__decap_12
XFILLER_18_29 VGND VPWR VPWR VGND sky130_ef_sc_hd__decap_12
XFILLER_46_137 VPWR VGND VPWR VGND sky130_fd_sc_hd__decap_3
XFILLER_6_233 VGND VPWR VPWR VGND sky130_ef_sc_hd__decap_12
XFILLER_6_277 VGND VPWR VPWR VGND sky130_ef_sc_hd__decap_12
X_096_ VPWR VGND VPWR VGND _009_ _007_ Q[2] _005_ _010_ sky130_fd_sc_hd__a22o_2
XFILLER_37_137 VGND VPWR VPWR VGND sky130_ef_sc_hd__decap_12
XFILLER_45_181 VGND VPWR VPWR VGND sky130_ef_sc_hd__decap_12
XFILLER_29_39 VGND VPWR VPWR VGND sky130_ef_sc_hd__decap_12
XFILLER_45_27 VGND VPWR VPWR VGND sky130_ef_sc_hd__decap_12
XFILLER_3_225 VGND VPWR VPWR VGND sky130_ef_sc_hd__decap_12
XFILLER_10_41 VGND VPWR VPWR VGND sky130_ef_sc_hd__decap_12
XFILLER_10_85 VGND VPWR VPWR VGND sky130_ef_sc_hd__decap_12
XFILLER_19_137 VGND VPWR VPWR VGND sky130_ef_sc_hd__decap_12
XFILLER_35_93 VGND VPWR VPWR VGND sky130_ef_sc_hd__decap_12
X_079_ VGND VPWR VGND VPWR tap\[49\] Q[0] Q[1] _051_ sky130_fd_sc_hd__a21o_2
XFILLER_25_3 VGND VPWR VPWR VGND sky130_ef_sc_hd__decap_12
XPHY_EDGE_ROW_27_Left_74 VPWR VGND VPWR VGND sky130_fd_sc_hd__decap_3
XPHY_EDGE_ROW_11_Left_58 VPWR VGND VPWR VGND sky130_fd_sc_hd__decap_3
XFILLER_18_192 VGND VPWR VPWR VGND sky130_fd_sc_hd__decap_4
XFILLER_21_51 VGND VPWR VPWR VGND sky130_fd_sc_hd__decap_4
XFILLER_46_81 VPWR VGND VPWR VGND sky130_fd_sc_hd__decap_3
XFILLER_30_121 VGND VPWR VPWR VGND sky130_ef_sc_hd__decap_12
XFILLER_30_165 VGND VPWR VPWR VGND sky130_ef_sc_hd__decap_12
XFILLER_38_221 VGND VPWR VPWR VGND sky130_ef_sc_hd__decap_12
XFILLER_38_265 VGND VPWR VPWR VGND sky130_ef_sc_hd__decap_12
XPHY_EDGE_ROW_5_Right_5 VPWR VGND VPWR VGND sky130_fd_sc_hd__decap_3
XFILLER_26_29 VGND VPWR VPWR VGND sky130_ef_sc_hd__decap_12
XFILLER_21_187 VGND VPWR VPWR VGND sky130_fd_sc_hd__decap_4
XFILLER_12_121 VGND VPWR VPWR VGND sky130_ef_sc_hd__decap_12
XFILLER_12_165 VGND VPWR VPWR VGND sky130_ef_sc_hd__decap_12
XFILLER_37_39 VGND VPWR VPWR VGND sky130_ef_sc_hd__decap_12
XFILLER_41_249 VGND VPWR VPWR VGND sky130_ef_sc_hd__decap_12
XFILLER_41_205 VGND VPWR VPWR VGND sky130_ef_sc_hd__decap_12
XPHY_EDGE_ROW_14_Left_61 VPWR VGND VPWR VGND sky130_fd_sc_hd__decap_3
XFILLER_43_93 VGND VPWR VPWR VGND sky130_ef_sc_hd__decap_12
XFILLER_4_65 VGND VPWR VPWR VGND sky130_ef_sc_hd__decap_12
XFILLER_2_109 VGND VPWR VPWR VGND sky130_ef_sc_hd__decap_12
XFILLER_31_293 VPWR VGND VPWR VGND sky130_fd_sc_hd__decap_6
XFILLER_13_293 VPWR VGND VPWR VGND sky130_fd_sc_hd__decap_6
XPHY_EDGE_ROW_41_Left_88 VPWR VGND VPWR VGND sky130_fd_sc_hd__decap_3
XFILLER_34_29 VGND VPWR VPWR VGND sky130_ef_sc_hd__decap_12
XFILLER_6_245 VPWR VGND VPWR VGND sky130_fd_sc_hd__decap_6
X_095_ VGND VPWR VGND VPWR _009_ _031_ _008_ _030_ sky130_fd_sc_hd__o21a_2
Xdelay_chain\[18\].genblk1.inv_a.core_inv VPWR VGND VGND VPWR tap\[17\] d\[18\] sky130_fd_sc_hd__inv_1
XFILLER_6_289 VPWR VGND VPWR VGND sky130_fd_sc_hd__decap_8
XFILLER_37_149 VGND VPWR VPWR VGND sky130_ef_sc_hd__decap_12
XFILLER_37_105 VPWR VGND VPWR VGND sky130_fd_sc_hd__decap_6
XFILLER_45_193 VGND VPWR VPWR VGND sky130_ef_sc_hd__decap_12
Xdelay_chain\[27\].genblk1.inv_a.core_inv VPWR VGND VGND VPWR tap\[26\] d\[27\] sky130_fd_sc_hd__inv_1
XFILLER_45_39 VGND VPWR VPWR VGND sky130_ef_sc_hd__decap_12
Xdelay_chain\[50\].inv_b.core_inv VPWR VGND VGND VPWR d\[50\] tap\[50\] sky130_fd_sc_hd__inv_1
XFILLER_3_237 VGND VPWR VPWR VGND sky130_ef_sc_hd__decap_12
XFILLER_10_53 VGND VPWR VPWR VGND sky130_ef_sc_hd__decap_12
XFILLER_10_97 VGND VPWR VPWR VGND sky130_ef_sc_hd__decap_12
Xdelay_chain\[36\].genblk1.inv_a.core_inv VPWR VGND VGND VPWR tap\[35\] d\[36\] sky130_fd_sc_hd__inv_1
XFILLER_19_51 VGND VPWR VPWR VGND sky130_fd_sc_hd__decap_4
XFILLER_19_105 VPWR VGND VPWR VGND sky130_fd_sc_hd__decap_6
XFILLER_19_149 VGND VPWR VPWR VGND sky130_ef_sc_hd__decap_12
XFILLER_42_141 VGND VPWR VPWR VGND sky130_ef_sc_hd__decap_12
X_078_ VGND VPWR VPWR VGND Q[0] _050_ tap\[48\] sky130_fd_sc_hd__and2b_2
Xdelay_chain\[45\].genblk1.inv_a.core_inv VPWR VGND VGND VPWR tap\[44\] d\[45\] sky130_fd_sc_hd__inv_1
XFILLER_18_3 VGND VPWR VPWR VGND sky130_ef_sc_hd__decap_12
Xdelay_chain\[54\].genblk1.inv_a.core_inv VPWR VGND VGND VPWR tap\[53\] d\[54\] sky130_fd_sc_hd__inv_1
XPHY_EDGE_ROW_44_Left_91 VPWR VGND VPWR VGND sky130_fd_sc_hd__decap_3
XFILLER_24_141 VPWR VGND VPWR VGND sky130_fd_sc_hd__decap_8
Xdelay_chain\[63\].genblk1.inv_a.core_inv VPWR VGND VGND VPWR tap\[62\] d\[63\] sky130_fd_sc_hd__inv_1
XFILLER_30_133 VPWR VGND VPWR VGND sky130_fd_sc_hd__decap_6
XFILLER_30_177 VGND VPWR VPWR VGND sky130_ef_sc_hd__decap_12
XFILLER_38_277 VGND VPWR VPWR VGND sky130_ef_sc_hd__decap_12
XFILLER_38_233 VGND VPWR VPWR VGND sky130_ef_sc_hd__decap_12
XFILLER_42_29 VGND VPWR VPWR VGND sky130_ef_sc_hd__decap_12
XFILLER_16_41 VGND VPWR VPWR VGND sky130_ef_sc_hd__decap_12
XPHY_EDGE_ROW_11_Right_11 VPWR VGND VPWR VGND sky130_fd_sc_hd__decap_3
XFILLER_12_133 VPWR VGND VPWR VGND sky130_fd_sc_hd__decap_6
XFILLER_12_177 VGND VPWR VPWR VGND sky130_ef_sc_hd__decap_12
XFILLER_16_85 VGND VPWR VPWR VGND sky130_ef_sc_hd__decap_12
XPHY_EDGE_ROW_20_Right_20 VPWR VGND VPWR VGND sky130_fd_sc_hd__decap_3
XFILLER_35_225 VGND VPWR VPWR VGND sky130_ef_sc_hd__decap_12
XFILLER_7_181 VGND VPWR VPWR VGND sky130_ef_sc_hd__decap_12
Xdelay_chain\[55\].inv_b.core_inv VPWR VGND VGND VPWR d\[55\] tap\[55\] sky130_fd_sc_hd__inv_1
XFILLER_41_217 VPWR VGND VPWR VGND sky130_fd_sc_hd__decap_6
XFILLER_17_247 VPWR VGND VPWR VGND sky130_fd_sc_hd__decap_8
XFILLER_27_51 VGND VPWR VPWR VGND sky130_fd_sc_hd__decap_4
Xdelay_chain\[1\].genblk1.inv_a.core_inv VPWR VGND VGND VPWR tap\[0\] d\[1\] sky130_fd_sc_hd__inv_1
XFILLER_4_77 VPWR VGND VPWR VGND sky130_fd_sc_hd__decap_6
XFILLER_23_239 VGND VPWR VPWR VGND sky130_fd_sc_hd__decap_4
XFILLER_31_261 VGND VPWR VPWR VGND sky130_ef_sc_hd__decap_12
XFILLER_22_272 VGND VPWR VPWR VGND sky130_ef_sc_hd__decap_12
XFILLER_13_250 VGND VPWR VPWR VGND sky130_ef_sc_hd__decap_12
Xdelay_chain\[41\].inv_b.core_inv VPWR VGND VGND VPWR d\[41\] tap\[41\] sky130_fd_sc_hd__inv_1
XFILLER_24_41 VGND VPWR VPWR VGND sky130_ef_sc_hd__decap_12
XFILLER_24_85 VGND VPWR VPWR VGND sky130_ef_sc_hd__decap_12
XFILLER_10_253 VGND VPWR VPWR VGND sky130_ef_sc_hd__decap_12
X_094_ VGND VPWR VPWR VGND _008_ tap\[11\] Q[0] tap\[10\] sky130_fd_sc_hd__mux2_1
XFILLER_45_161 VPWR VGND VPWR VGND sky130_fd_sc_hd__decap_6
XFILLER_3_205 VGND VPWR VPWR VGND sky130_ef_sc_hd__decap_12
XFILLER_3_249 VGND VPWR VPWR VGND sky130_ef_sc_hd__decap_12
XFILLER_10_65 VGND VPWR VPWR VGND sky130_ef_sc_hd__decap_12
XFILLER_35_51 VGND VPWR VPWR VGND sky130_fd_sc_hd__decap_4
XFILLER_27_161 VPWR VGND VPWR VGND sky130_fd_sc_hd__decap_6
XFILLER_34_109 VGND VPWR VPWR VGND sky130_ef_sc_hd__decap_12
XFILLER_42_197 VGND VPWR VPWR VGND sky130_ef_sc_hd__decap_12
XFILLER_42_153 VGND VPWR VPWR VGND sky130_ef_sc_hd__decap_12
X_077_ VPWR VGND Q[2] _049_ _048_ VPWR VGND sky130_fd_sc_hd__and2_2
XFILLER_16_109 VGND VPWR VPWR VGND sky130_ef_sc_hd__decap_12
Xdelay_chain\[46\].inv_b.core_inv VPWR VGND VGND VPWR d\[46\] tap\[46\] sky130_fd_sc_hd__inv_1
XFILLER_30_189 VPWR VGND VPWR VGND sky130_fd_sc_hd__decap_6
XFILLER_30_3 VGND VPWR VPWR VGND sky130_ef_sc_hd__decap_12
XFILLER_38_289 VPWR VGND VPWR VGND sky130_fd_sc_hd__decap_8
XFILLER_38_245 VPWR VGND VPWR VGND sky130_fd_sc_hd__decap_6
XFILLER_16_53 VGND VPWR VPWR VGND sky130_ef_sc_hd__decap_12
XFILLER_12_189 VPWR VGND VPWR VGND sky130_fd_sc_hd__decap_6
XFILLER_16_97 VGND VPWR VPWR VGND sky130_ef_sc_hd__decap_12
XFILLER_32_41 VGND VPWR VPWR VGND sky130_ef_sc_hd__decap_12
XFILLER_32_85 VGND VPWR VPWR VGND sky130_ef_sc_hd__decap_12
XFILLER_35_237 VGND VPWR VPWR VGND sky130_ef_sc_hd__decap_12
XFILLER_43_281 VGND VPWR VPWR VGND sky130_ef_sc_hd__decap_12
XFILLER_7_193 VGND VPWR VPWR VGND sky130_ef_sc_hd__decap_12
Xdelay_chain\[32\].inv_b.core_inv VPWR VGND VGND VPWR d\[32\] tap\[32\] sky130_fd_sc_hd__inv_1
XFILLER_43_51 VGND VPWR VPWR VGND sky130_fd_sc_hd__decap_4
XFILLER_4_141 VGND VPWR VPWR VGND sky130_ef_sc_hd__decap_12
XFILLER_31_273 VPWR VGND VPWR VGND sky130_fd_sc_hd__decap_6
XFILLER_22_284 VGND VPWR VPWR VGND sky130_ef_sc_hd__decap_12
XFILLER_8_3 VGND VPWR VPWR VGND sky130_ef_sc_hd__decap_12
XFILLER_13_262 VGND VPWR VPWR VGND sky130_ef_sc_hd__decap_12
XFILLER_39_181 VGND VPWR VPWR VGND sky130_ef_sc_hd__decap_12
XFILLER_10_221 VGND VPWR VPWR VGND sky130_ef_sc_hd__decap_12
XFILLER_24_53 VGND VPWR VPWR VGND sky130_ef_sc_hd__decap_12
XFILLER_24_97 VGND VPWR VPWR VGND sky130_ef_sc_hd__decap_12
XFILLER_40_85 VGND VPWR VPWR VGND sky130_ef_sc_hd__decap_12
XFILLER_40_41 VGND VPWR VPWR VGND sky130_ef_sc_hd__decap_12
XFILLER_10_265 VGND VPWR VPWR VGND sky130_ef_sc_hd__decap_12
X_093_ VPWR VGND VPWR VGND _007_ Q[1] _006_ sky130_fd_sc_hd__or2_2
XFILLER_1_57 VGND VPWR VPWR VGND sky130_ef_sc_hd__decap_12
Xdelay_chain\[37\].inv_b.core_inv VPWR VGND VGND VPWR d\[37\] tap\[37\] sky130_fd_sc_hd__inv_1
XFILLER_3_217 VPWR VGND VPWR VGND sky130_fd_sc_hd__decap_6
XFILLER_10_77 VPWR VGND VPWR VGND sky130_fd_sc_hd__decap_6
XFILLER_42_121 VGND VPWR VPWR VGND sky130_ef_sc_hd__decap_12
XFILLER_27_184 VGND VPWR VPWR VGND sky130_ef_sc_hd__decap_12
XFILLER_42_165 VGND VPWR VPWR VGND sky130_ef_sc_hd__decap_12
X_076_ VGND VPWR VGND VPWR Q[0] tap\[54\] tap\[55\] Q[1] tap\[53\] tap\[52\] _048_
+ sky130_fd_sc_hd__mux4_2
XFILLER_0_209 VGND VPWR VPWR VGND sky130_ef_sc_hd__decap_12
XFILLER_24_121 VGND VPWR VPWR VGND sky130_ef_sc_hd__decap_12
XFILLER_23_3 VGND VPWR VPWR VGND sky130_ef_sc_hd__decap_12
X_059_ VPWR VGND VPWR VGND _031_ Q[2] sky130_fd_sc_hd__inv_2
Xdelay_chain\[23\].inv_b.core_inv VPWR VGND VGND VPWR d\[23\] tap\[23\] sky130_fd_sc_hd__inv_1
XFILLER_21_113 VGND VPWR VPWR VGND sky130_ef_sc_hd__decap_12
XFILLER_21_157 VPWR VGND VPWR VGND sky130_fd_sc_hd__decap_3
XFILLER_16_65 VGND VPWR VPWR VGND sky130_ef_sc_hd__decap_12
XFILLER_32_53 VGND VPWR VPWR VGND sky130_ef_sc_hd__decap_12
XFILLER_32_97 VGND VPWR VPWR VGND sky130_ef_sc_hd__decap_12
XFILLER_35_249 VGND VPWR VPWR VGND sky130_ef_sc_hd__decap_12
XFILLER_35_205 VGND VPWR VPWR VGND sky130_ef_sc_hd__decap_12
XFILLER_43_293 VPWR VGND VPWR VGND sky130_fd_sc_hd__decap_6
XFILLER_7_161 VPWR VGND VPWR VGND sky130_fd_sc_hd__decap_6
XPHY_EDGE_ROW_9_Right_9 VPWR VGND VPWR VGND sky130_fd_sc_hd__decap_3
XFILLER_26_238 VPWR VGND VPWR VGND sky130_fd_sc_hd__decap_6
XFILLER_4_153 VGND VPWR VPWR VGND sky130_ef_sc_hd__decap_12
XFILLER_4_197 VGND VPWR VPWR VGND sky130_ef_sc_hd__decap_12
XPHY_EDGE_ROW_18_Left_65 VPWR VGND VPWR VGND sky130_fd_sc_hd__decap_3
XFILLER_22_296 VPWR VGND VPWR VGND sky130_fd_sc_hd__decap_3
XFILLER_38_41 VGND VPWR VPWR VGND sky130_ef_sc_hd__decap_12
XFILLER_38_85 VGND VPWR VPWR VGND sky130_ef_sc_hd__decap_12
XFILLER_13_274 VPWR VGND VPWR VGND sky130_fd_sc_hd__decap_6
Xdelay_chain\[11\].genblk1.inv_a.core_inv VPWR VGND VGND VPWR tap\[10\] d\[11\] sky130_fd_sc_hd__inv_1
Xdelay_chain\[28\].inv_b.core_inv VPWR VGND VGND VPWR d\[28\] tap\[28\] sky130_fd_sc_hd__inv_1
Xdelay_chain\[20\].genblk1.inv_a.core_inv VPWR VGND VGND VPWR tap\[19\] d\[20\] sky130_fd_sc_hd__inv_1
XFILLER_39_193 VGND VPWR VPWR VGND sky130_ef_sc_hd__decap_12
XFILLER_10_233 VGND VPWR VPWR VGND sky130_ef_sc_hd__decap_12
XFILLER_10_277 VGND VPWR VPWR VGND sky130_ef_sc_hd__decap_12
XFILLER_24_65 VGND VPWR VPWR VGND sky130_ef_sc_hd__decap_12
XFILLER_40_97 VGND VPWR VPWR VGND sky130_ef_sc_hd__decap_12
XFILLER_40_53 VGND VPWR VPWR VGND sky130_ef_sc_hd__decap_12
X_092_ VGND VPWR VPWR VGND _006_ tap\[9\] Q[0] tap\[8\] sky130_fd_sc_hd__mux2_1
XFILLER_1_69 VGND VPWR VPWR VGND sky130_ef_sc_hd__decap_12
XFILLER_5_281 VGND VPWR VPWR VGND sky130_ef_sc_hd__decap_12
XFILLER_36_141 VGND VPWR VPWR VGND sky130_ef_sc_hd__decap_12
Xdelay_chain\[14\].inv_b.core_inv VPWR VGND VGND VPWR d\[14\] tap\[14\] sky130_fd_sc_hd__inv_1
XFILLER_42_177 VGND VPWR VPWR VGND sky130_ef_sc_hd__decap_12
XFILLER_42_133 VPWR VGND VPWR VGND sky130_fd_sc_hd__decap_6
XFILLER_27_196 VPWR VGND VPWR VGND sky130_fd_sc_hd__decap_6
X_075_ VGND VPWR VGND VPWR _047_ _039_ Q[3] _046_ Q[4] sky130_fd_sc_hd__a211o_2
XFILLER_18_141 VGND VPWR VPWR VGND sky130_ef_sc_hd__decap_12
XFILLER_24_133 VPWR VGND VPWR VGND sky130_fd_sc_hd__decap_6
XFILLER_46_85 VGND VPWR VPWR VGND sky130_ef_sc_hd__decap_12
XFILLER_46_41 VGND VPWR VPWR VGND sky130_ef_sc_hd__decap_12
XPHY_EDGE_ROW_6_Left_53 VPWR VGND VPWR VGND sky130_fd_sc_hd__decap_3
XFILLER_7_57 VGND VPWR VPWR VGND sky130_ef_sc_hd__decap_12
X_058_ VPWR VGND VPWR VGND _030_ Q[1] sky130_fd_sc_hd__inv_2
XFILLER_16_3 VGND VPWR VPWR VGND sky130_ef_sc_hd__decap_12
XFILLER_21_125 VGND VPWR VPWR VGND sky130_ef_sc_hd__decap_12
XFILLER_16_77 VPWR VGND VPWR VGND sky130_fd_sc_hd__decap_6
XPHY_EDGE_ROW_32_Left_79 VPWR VGND VPWR VGND sky130_fd_sc_hd__decap_3
XFILLER_32_65 VGND VPWR VPWR VGND sky130_ef_sc_hd__decap_12
XFILLER_43_261 VGND VPWR VPWR VGND sky130_ef_sc_hd__decap_12
XFILLER_35_217 VPWR VGND VPWR VGND sky130_fd_sc_hd__decap_6
Xdelay_chain\[19\].inv_b.core_inv VPWR VGND VGND VPWR d\[19\] tap\[19\] sky130_fd_sc_hd__inv_1
XFILLER_17_228 VPWR VGND VPWR VGND sky130_fd_sc_hd__decap_8
XFILLER_25_250 VGND VPWR VPWR VGND sky130_ef_sc_hd__decap_12
XFILLER_32_209 VGND VPWR VPWR VGND sky130_ef_sc_hd__decap_12
XFILLER_40_253 VGND VPWR VPWR VGND sky130_ef_sc_hd__decap_12
XFILLER_4_165 VGND VPWR VPWR VGND sky130_ef_sc_hd__decap_12
XFILLER_4_121 VGND VPWR VPWR VGND sky130_ef_sc_hd__decap_12
XFILLER_14_209 VGND VPWR VPWR VGND sky130_ef_sc_hd__decap_12
XFILLER_22_242 VPWR VGND VPWR VGND sky130_fd_sc_hd__decap_8
XFILLER_22_253 VPWR VGND VPWR VGND sky130_fd_sc_hd__decap_8
XFILLER_1_113 VGND VPWR VPWR VGND sky130_ef_sc_hd__decap_12
XFILLER_38_97 VGND VPWR VPWR VGND sky130_ef_sc_hd__decap_12
XFILLER_38_53 VGND VPWR VPWR VGND sky130_ef_sc_hd__decap_12
XPHY_EDGE_ROW_35_Left_82 VPWR VGND VPWR VGND sky130_fd_sc_hd__decap_3
XFILLER_46_109 VPWR VGND VPWR VGND sky130_fd_sc_hd__decap_3
XFILLER_39_161 VPWR VGND VPWR VGND sky130_fd_sc_hd__decap_6
XFILLER_10_245 VPWR VGND VPWR VGND sky130_fd_sc_hd__decap_6
XFILLER_10_289 VPWR VGND VPWR VGND sky130_fd_sc_hd__decap_8
X_091_ VGND VPWR VGND VPWR Q[0] tap\[14\] tap\[15\] Q[1] tap\[13\] tap\[12\] _005_
+ sky130_fd_sc_hd__mux4_2
XFILLER_24_77 VPWR VGND VPWR VGND sky130_fd_sc_hd__decap_6
XFILLER_40_65 VGND VPWR VPWR VGND sky130_ef_sc_hd__decap_12
XFILLER_1_15 VGND VPWR VPWR VGND sky130_ef_sc_hd__decap_12
Xdelay_chain\[39\].genblk1.inv_a.core_inv VPWR VGND VGND VPWR tap\[38\] d\[39\] sky130_fd_sc_hd__inv_1
XFILLER_46_3 VGND VPWR VPWR VGND sky130_ef_sc_hd__decap_12
XFILLER_5_293 VPWR VGND VPWR VGND sky130_fd_sc_hd__decap_6
XPHY_EDGE_ROW_18_Right_18 VPWR VGND VPWR VGND sky130_fd_sc_hd__decap_3
XFILLER_28_109 VGND VPWR VPWR VGND sky130_ef_sc_hd__decap_12
XFILLER_36_197 VGND VPWR VPWR VGND sky130_ef_sc_hd__decap_12
XFILLER_36_153 VGND VPWR VPWR VGND sky130_ef_sc_hd__decap_12
XPHY_EDGE_ROW_27_Right_27 VPWR VGND VPWR VGND sky130_fd_sc_hd__decap_3
XPHY_EDGE_ROW_36_Right_36 VPWR VGND VPWR VGND sky130_fd_sc_hd__decap_3
Xdelay_chain\[48\].genblk1.inv_a.core_inv VPWR VGND VGND VPWR tap\[47\] d\[48\] sky130_fd_sc_hd__inv_1
XPHY_EDGE_ROW_45_Right_45 VPWR VGND VPWR VGND sky130_fd_sc_hd__decap_3
XFILLER_42_189 VPWR VGND VPWR VGND sky130_fd_sc_hd__decap_6
X_074_ VGND VPWR VGND VPWR _045_ _043_ Q[3] _046_ sky130_fd_sc_hd__o21ba_2
Xdelay_chain\[57\].genblk1.inv_a.core_inv VPWR VGND VGND VPWR tap\[56\] d\[57\] sky130_fd_sc_hd__inv_1
XFILLER_18_153 VGND VPWR VPWR VGND sky130_ef_sc_hd__decap_12
XFILLER_18_197 VPWR VGND VPWR VGND sky130_fd_sc_hd__decap_8
XFILLER_46_97 VGND VPWR VPWR VGND sky130_ef_sc_hd__decap_12
XFILLER_46_53 VPWR VGND VPWR VGND sky130_fd_sc_hd__decap_3
XFILLER_7_69 VGND VPWR VPWR VGND sky130_ef_sc_hd__decap_12
XFILLER_46_281 VGND VPWR VPWR VGND sky130_ef_sc_hd__decap_12
XFILLER_21_137 VGND VPWR VPWR VGND sky130_ef_sc_hd__decap_12
XFILLER_37_281 VGND VPWR VPWR VGND sky130_ef_sc_hd__decap_12
XFILLER_29_237 VGND VPWR VPWR VGND sky130_ef_sc_hd__decap_12
XPHY_EDGE_ROW_0_Right_0 VPWR VGND VPWR VGND sky130_fd_sc_hd__decap_3
XFILLER_32_77 VPWR VGND VPWR VGND sky130_fd_sc_hd__decap_6
XFILLER_43_273 VPWR VGND VPWR VGND sky130_fd_sc_hd__decap_6
XFILLER_11_181 VGND VPWR VPWR VGND sky130_ef_sc_hd__decap_12
X_109_ VGND VPWR VPWR VGND _023_ tap\[21\] Q[0] tap\[20\] sky130_fd_sc_hd__mux2_1
Xdelay_chain\[4\].genblk1.inv_a.core_inv VPWR VGND VGND VPWR tap\[3\] d\[4\] sky130_fd_sc_hd__inv_1
XFILLER_25_262 VGND VPWR VPWR VGND sky130_ef_sc_hd__decap_12
XFILLER_40_265 VGND VPWR VPWR VGND sky130_ef_sc_hd__decap_12
XFILLER_40_221 VGND VPWR VPWR VGND sky130_ef_sc_hd__decap_12
XFILLER_4_177 VGND VPWR VPWR VGND sky130_ef_sc_hd__decap_12
XFILLER_4_133 VPWR VGND VPWR VGND sky130_fd_sc_hd__decap_6
XFILLER_4_15 VGND VPWR VPWR VGND sky130_ef_sc_hd__decap_12
XFILLER_16_295 VGND VPWR VPWR VGND sky130_fd_sc_hd__decap_4
XFILLER_13_57 VGND VPWR VPWR VGND sky130_ef_sc_hd__decap_12
XFILLER_1_125 VGND VPWR VPWR VGND sky130_ef_sc_hd__decap_12
XFILLER_38_65 VGND VPWR VPWR VGND sky130_ef_sc_hd__decap_12
XFILLER_1_169 VGND VPWR VPWR VGND sky130_ef_sc_hd__decap_12
XFILLER_9_225 VGND VPWR VPWR VGND sky130_ef_sc_hd__decap_12
XFILLER_40_77 VPWR VGND VPWR VGND sky130_fd_sc_hd__decap_6
X_090_ VGND VPWR VPWR VGND _004_ _032_ _054_ _003_ Q[5] sky130_fd_sc_hd__o31a_2
XFILLER_6_3 VGND VPWR VPWR VGND sky130_ef_sc_hd__decap_12
XFILLER_1_27 VGND VPWR VPWR VGND sky130_ef_sc_hd__decap_12
XFILLER_5_261 VGND VPWR VPWR VGND sky130_ef_sc_hd__decap_12
XFILLER_39_3 VGND VPWR VPWR VGND sky130_ef_sc_hd__decap_12
XFILLER_36_165 VGND VPWR VPWR VGND sky130_ef_sc_hd__decap_12
XFILLER_36_121 VGND VPWR VPWR VGND sky130_ef_sc_hd__decap_12
X_073_ VPWR VGND _031_ _045_ _044_ VPWR VGND sky130_fd_sc_hd__and2_2
XFILLER_2_253 VGND VPWR VPWR VGND sky130_ef_sc_hd__decap_12
XFILLER_18_121 VGND VPWR VPWR VGND sky130_ef_sc_hd__decap_12
XFILLER_18_165 VGND VPWR VPWR VGND sky130_ef_sc_hd__decap_12
XFILLER_33_113 VGND VPWR VPWR VGND sky130_ef_sc_hd__decap_12
XFILLER_21_57 VGND VPWR VPWR VGND sky130_ef_sc_hd__decap_12
XFILLER_15_113 VGND VPWR VPWR VGND sky130_ef_sc_hd__decap_12
XFILLER_7_15 VGND VPWR VPWR VGND sky130_ef_sc_hd__decap_12
XFILLER_46_293 VPWR VGND VPWR VGND sky130_fd_sc_hd__decap_6
XFILLER_21_105 VPWR VGND VPWR VGND sky130_fd_sc_hd__decap_6
XFILLER_21_149 VPWR VGND VPWR VGND sky130_fd_sc_hd__decap_8
XFILLER_29_205 VGND VPWR VPWR VGND sky130_ef_sc_hd__decap_12
XFILLER_37_293 VPWR VGND VPWR VGND sky130_fd_sc_hd__decap_6
XFILLER_29_249 VGND VPWR VPWR VGND sky130_ef_sc_hd__decap_12
XFILLER_8_109 VGND VPWR VPWR VGND sky130_ef_sc_hd__decap_12
XFILLER_11_193 VGND VPWR VPWR VGND sky130_ef_sc_hd__decap_12
X_108_ VPWR VGND VPWR VGND _021_ _019_ Q[2] _017_ _022_ sky130_fd_sc_hd__a22o_2
XFILLER_21_3 VGND VPWR VPWR VGND sky130_ef_sc_hd__decap_12
XFILLER_40_233 VGND VPWR VPWR VGND sky130_ef_sc_hd__decap_12
XFILLER_40_277 VGND VPWR VPWR VGND sky130_ef_sc_hd__decap_12
XFILLER_4_189 VPWR VGND VPWR VGND sky130_fd_sc_hd__decap_6
XFILLER_13_69 VGND VPWR VPWR VGND sky130_ef_sc_hd__decap_12
XFILLER_1_137 VGND VPWR VPWR VGND sky130_ef_sc_hd__decap_12
Xdelay_chain\[4\].inv_b.core_inv VPWR VGND VGND VPWR d\[4\] tap\[4\] sky130_fd_sc_hd__inv_1
XFILLER_38_77 VPWR VGND VPWR VGND sky130_fd_sc_hd__decap_6
XFILLER_9_237 VGND VPWR VPWR VGND sky130_ef_sc_hd__decap_12
XFILLER_0_181 VGND VPWR VPWR VGND sky130_ef_sc_hd__decap_12
XFILLER_5_81 VGND VPWR VPWR VGND sky130_ef_sc_hd__decap_12
XFILLER_1_39 VGND VPWR VPWR VGND sky130_ef_sc_hd__decap_12
XFILLER_5_273 VPWR VGND VPWR VGND sky130_fd_sc_hd__decap_6
XFILLER_36_133 VPWR VGND VPWR VGND sky130_fd_sc_hd__decap_6
XFILLER_36_177 VGND VPWR VPWR VGND sky130_ef_sc_hd__decap_12
XFILLER_10_15 VGND VPWR VPWR VGND sky130_ef_sc_hd__decap_12
XFILLER_19_57 VGND VPWR VPWR VGND sky130_ef_sc_hd__decap_12
XFILLER_2_265 VGND VPWR VPWR VGND sky130_ef_sc_hd__decap_12
XFILLER_2_221 VGND VPWR VPWR VGND sky130_ef_sc_hd__decap_12
X_072_ VGND VPWR VGND VPWR Q[0] tap\[34\] tap\[35\] Q[1] tap\[33\] tap\[32\] _044_
+ sky130_fd_sc_hd__mux4_2
XFILLER_18_133 VPWR VGND VPWR VGND sky130_fd_sc_hd__decap_6
XFILLER_18_177 VPWR VGND VPWR VGND sky130_fd_sc_hd__decap_6
XFILLER_33_125 VGND VPWR VPWR VGND sky130_ef_sc_hd__decap_12
XFILLER_33_169 VGND VPWR VPWR VGND sky130_ef_sc_hd__decap_12
Xdelay_chain\[9\].inv_b.core_inv VPWR VGND VGND VPWR d\[9\] tap\[9\] sky130_fd_sc_hd__inv_1
XFILLER_21_69 VGND VPWR VPWR VGND sky130_ef_sc_hd__decap_12
XFILLER_15_125 VGND VPWR VPWR VGND sky130_ef_sc_hd__decap_12
XFILLER_7_27 VGND VPWR VPWR VGND sky130_ef_sc_hd__decap_12
XFILLER_44_209 VGND VPWR VPWR VGND sky130_ef_sc_hd__decap_12
XFILLER_37_261 VGND VPWR VPWR VGND sky130_ef_sc_hd__decap_12
XFILLER_11_161 VPWR VGND VPWR VGND sky130_fd_sc_hd__decap_6
X_107_ VGND VPWR VGND VPWR _021_ _031_ _020_ _030_ sky130_fd_sc_hd__o21a_2
XFILLER_14_3 VGND VPWR VPWR VGND sky130_ef_sc_hd__decap_12
XFILLER_26_209 VGND VPWR VPWR VGND sky130_fd_sc_hd__decap_4
XFILLER_34_253 VGND VPWR VPWR VGND sky130_ef_sc_hd__decap_12
XFILLER_27_57 VGND VPWR VPWR VGND sky130_ef_sc_hd__decap_12
XFILLER_40_245 VPWR VGND VPWR VGND sky130_fd_sc_hd__decap_6
XFILLER_25_220 VGND VPWR VPWR VGND sky130_fd_sc_hd__decap_4
XFILLER_40_289 VPWR VGND VPWR VGND sky130_fd_sc_hd__decap_8
XFILLER_16_253 VPWR VGND VPWR VGND sky130_fd_sc_hd__decap_3
XFILLER_13_15 VGND VPWR VPWR VGND sky130_ef_sc_hd__decap_12
Xdelay_chain\[14\].genblk1.inv_a.core_inv VPWR VGND VGND VPWR tap\[13\] d\[14\] sky130_fd_sc_hd__inv_1
XFILLER_1_105 VPWR VGND VPWR VGND sky130_fd_sc_hd__decap_6
XFILLER_1_149 VGND VPWR VPWR VGND sky130_ef_sc_hd__decap_12
XFILLER_9_205 VGND VPWR VPWR VGND sky130_ef_sc_hd__decap_12
XFILLER_9_249 VGND VPWR VPWR VGND sky130_ef_sc_hd__decap_12
Xdelay_chain\[62\].inv_b.core_inv VPWR VGND VGND VPWR d\[62\] tap\[62\] sky130_fd_sc_hd__inv_1
Xdelay_chain\[23\].genblk1.inv_a.core_inv VPWR VGND VGND VPWR tap\[22\] d\[23\] sky130_fd_sc_hd__inv_1
XFILLER_0_193 VPWR VGND VPWR VGND sky130_fd_sc_hd__decap_3
Xdelay_chain\[32\].genblk1.inv_a.core_inv VPWR VGND VGND VPWR tap\[31\] d\[32\] sky130_fd_sc_hd__inv_1
XFILLER_5_93 VGND VPWR VPWR VGND sky130_ef_sc_hd__decap_12
Xdelay_chain\[41\].genblk1.inv_a.core_inv VPWR VGND VGND VPWR tap\[40\] d\[41\] sky130_fd_sc_hd__inv_1
XPHY_EDGE_ROW_39_Left_86 VPWR VGND VPWR VGND sky130_fd_sc_hd__decap_3
Xdelay_chain\[50\].genblk1.inv_a.core_inv VPWR VGND VGND VPWR tap\[49\] d\[50\] sky130_fd_sc_hd__inv_1
XFILLER_36_189 VPWR VGND VPWR VGND sky130_fd_sc_hd__decap_6
XFILLER_19_69 VGND VPWR VPWR VGND sky130_ef_sc_hd__decap_12
XFILLER_35_57 VGND VPWR VPWR VGND sky130_ef_sc_hd__decap_12
XPHY_EDGE_ROW_14_Right_14 VPWR VGND VPWR VGND sky130_fd_sc_hd__decap_3
X_071_ VPWR VGND VGND VPWR _042_ _030_ _041_ _040_ _043_ Q[2] sky130_fd_sc_hd__o221a_2
XFILLER_2_277 VGND VPWR VPWR VGND sky130_ef_sc_hd__decap_12
XFILLER_2_233 VGND VPWR VPWR VGND sky130_ef_sc_hd__decap_12
XPHY_EDGE_ROW_23_Right_23 VPWR VGND VPWR VGND sky130_fd_sc_hd__decap_3
XFILLER_41_181 VGND VPWR VPWR VGND sky130_ef_sc_hd__decap_12
XPHY_EDGE_ROW_32_Right_32 VPWR VGND VPWR VGND sky130_fd_sc_hd__decap_3
XFILLER_33_137 VGND VPWR VPWR VGND sky130_ef_sc_hd__decap_12
XFILLER_44_3 VGND VPWR VPWR VGND sky130_ef_sc_hd__decap_12
XPHY_EDGE_ROW_41_Right_41 VPWR VGND VPWR VGND sky130_fd_sc_hd__decap_3
XFILLER_21_15 VGND VPWR VPWR VGND sky130_ef_sc_hd__decap_12
XFILLER_15_137 VGND VPWR VPWR VGND sky130_ef_sc_hd__decap_12
XFILLER_7_39 VGND VPWR VPWR VGND sky130_ef_sc_hd__decap_12
XFILLER_11_81 VGND VPWR VPWR VGND sky130_ef_sc_hd__decap_12
XFILLER_14_181 VGND VPWR VPWR VGND sky130_ef_sc_hd__decap_12
XPHY_EDGE_ROW_26_Left_73 VPWR VGND VPWR VGND sky130_fd_sc_hd__decap_3
XPHY_EDGE_ROW_10_Left_57 VPWR VGND VPWR VGND sky130_fd_sc_hd__decap_3
XFILLER_37_273 VPWR VGND VPWR VGND sky130_fd_sc_hd__decap_6
XFILLER_16_15 VGND VPWR VPWR VGND sky130_ef_sc_hd__decap_12
X_106_ VGND VPWR VPWR VGND _020_ tap\[27\] Q[0] tap\[26\] sky130_fd_sc_hd__mux2_1
XFILLER_34_265 VGND VPWR VPWR VGND sky130_ef_sc_hd__decap_12
XFILLER_19_251 VPWR VGND VPWR VGND sky130_fd_sc_hd__decap_3
XFILLER_19_262 VGND VPWR VPWR VGND sky130_ef_sc_hd__decap_12
XFILLER_19_295 VGND VPWR VPWR VGND sky130_fd_sc_hd__decap_4
XFILLER_34_221 VGND VPWR VPWR VGND sky130_ef_sc_hd__decap_12
Xdelay_chain\[53\].inv_b.core_inv VPWR VGND VGND VPWR d\[53\] tap\[53\] sky130_fd_sc_hd__inv_1
XPHY_EDGE_ROW_4_Right_4 VPWR VGND VPWR VGND sky130_fd_sc_hd__decap_3
XFILLER_27_69 VGND VPWR VPWR VGND sky130_ef_sc_hd__decap_12
XFILLER_43_57 VGND VPWR VPWR VGND sky130_ef_sc_hd__decap_12
XFILLER_4_29 VGND VPWR VPWR VGND sky130_ef_sc_hd__decap_12
XFILLER_16_243 VPWR VGND VPWR VGND sky130_fd_sc_hd__decap_8
XFILLER_16_265 VGND VPWR VPWR VGND sky130_ef_sc_hd__decap_12
XFILLER_13_27 VGND VPWR VPWR VGND sky130_ef_sc_hd__decap_12
XPHY_EDGE_ROW_13_Left_60 VPWR VGND VPWR VGND sky130_fd_sc_hd__decap_3
XFILLER_9_217 VPWR VGND VPWR VGND sky130_fd_sc_hd__decap_6
XFILLER_24_15 VGND VPWR VPWR VGND sky130_ef_sc_hd__decap_12
XFILLER_6_209 VGND VPWR VPWR VGND sky130_ef_sc_hd__decap_12
XFILLER_45_113 VGND VPWR VPWR VGND sky130_ef_sc_hd__decap_12
Xdelay_chain\[58\].inv_b.core_inv VPWR VGND VGND VPWR d\[58\] tap\[58\] sky130_fd_sc_hd__inv_1
XPHY_EDGE_ROW_40_Left_87 VPWR VGND VPWR VGND sky130_fd_sc_hd__decap_3
XFILLER_19_15 VGND VPWR VPWR VGND sky130_ef_sc_hd__decap_12
XFILLER_27_113 VGND VPWR VPWR VGND sky130_ef_sc_hd__decap_12
XFILLER_35_69 VGND VPWR VPWR VGND sky130_ef_sc_hd__decap_12
X_070_ VGND VPWR VPWR VGND _042_ tap\[39\] Q[0] tap\[38\] sky130_fd_sc_hd__mux2_1
XFILLER_4_3 VGND VPWR VPWR VGND sky130_ef_sc_hd__decap_12
XFILLER_2_289 VPWR VGND VPWR VGND sky130_fd_sc_hd__decap_8
XFILLER_2_245 VPWR VGND VPWR VGND sky130_fd_sc_hd__decap_6
XFILLER_33_105 VPWR VGND VPWR VGND sky130_fd_sc_hd__decap_6
XFILLER_41_193 VGND VPWR VPWR VGND sky130_ef_sc_hd__decap_12
XFILLER_33_149 VGND VPWR VPWR VGND sky130_ef_sc_hd__decap_12
XFILLER_37_3 VGND VPWR VPWR VGND sky130_ef_sc_hd__decap_12
XFILLER_24_149 VPWR VGND VPWR VGND sky130_fd_sc_hd__decap_3
XFILLER_21_27 VGND VPWR VPWR VGND sky130_ef_sc_hd__decap_12
XFILLER_46_57 VGND VPWR VPWR VGND sky130_ef_sc_hd__decap_12
XFILLER_15_105 VPWR VGND VPWR VGND sky130_fd_sc_hd__decap_6
XFILLER_15_149 VGND VPWR VPWR VGND sky130_ef_sc_hd__decap_12
XFILLER_23_182 VGND VPWR VPWR VGND sky130_ef_sc_hd__decap_12
XFILLER_11_93 VGND VPWR VPWR VGND sky130_ef_sc_hd__decap_12
Xdelay_chain\[44\].inv_b.core_inv VPWR VGND VGND VPWR d\[44\] tap\[44\] sky130_fd_sc_hd__inv_1
XFILLER_14_193 VPWR VGND VPWR VGND sky130_fd_sc_hd__decap_3
XFILLER_20_141 VGND VPWR VPWR VGND sky130_ef_sc_hd__decap_12
XFILLER_32_15 VGND VPWR VPWR VGND sky130_ef_sc_hd__decap_12
XPHY_EDGE_ROW_43_Left_90 VPWR VGND VPWR VGND sky130_fd_sc_hd__decap_3
Xdelay_chain\[7\].genblk1.inv_a.core_inv VPWR VGND VGND VPWR tap\[6\] d\[7\] sky130_fd_sc_hd__inv_1
XFILLER_28_241 VPWR VGND VPWR VGND sky130_fd_sc_hd__decap_8
X_105_ VPWR VGND VPWR VGND _019_ Q[1] _018_ sky130_fd_sc_hd__or2_2
XFILLER_19_274 VPWR VGND VPWR VGND sky130_fd_sc_hd__decap_6
XFILLER_34_277 VGND VPWR VPWR VGND sky130_ef_sc_hd__decap_12
XFILLER_34_233 VGND VPWR VPWR VGND sky130_ef_sc_hd__decap_12
Xdelay_chain\[30\].inv_b.core_inv VPWR VGND VGND VPWR d\[30\] tap\[30\] sky130_fd_sc_hd__inv_1
XFILLER_27_15 VGND VPWR VPWR VGND sky130_ef_sc_hd__decap_12
XFILLER_43_69 VGND VPWR VPWR VGND sky130_ef_sc_hd__decap_12
XFILLER_25_288 VPWR VGND VPWR VGND sky130_fd_sc_hd__decap_3
XFILLER_16_277 VGND VPWR VPWR VGND sky130_ef_sc_hd__decap_12
XFILLER_17_81 VGND VPWR VPWR VGND sky130_ef_sc_hd__decap_12
XFILLER_31_225 VGND VPWR VPWR VGND sky130_ef_sc_hd__decap_12
XFILLER_3_181 VGND VPWR VPWR VGND sky130_ef_sc_hd__decap_12
XFILLER_13_39 VGND VPWR VPWR VGND sky130_ef_sc_hd__decap_12
XFILLER_13_225 VGND VPWR VPWR VGND sky130_ef_sc_hd__decap_12
Xdelay_chain\[49\].inv_b.core_inv VPWR VGND VGND VPWR d\[49\] tap\[49\] sky130_fd_sc_hd__inv_1
XFILLER_5_51 VGND VPWR VPWR VGND sky130_fd_sc_hd__decap_4
XFILLER_40_15 VGND VPWR VPWR VGND sky130_ef_sc_hd__decap_12
XFILLER_45_169 VGND VPWR VPWR VGND sky130_ef_sc_hd__decap_12
XFILLER_45_125 VGND VPWR VPWR VGND sky130_ef_sc_hd__decap_12
XFILLER_10_29 VGND VPWR VPWR VGND sky130_ef_sc_hd__decap_12
Xdelay_chain\[35\].inv_b.core_inv VPWR VGND VGND VPWR d\[35\] tap\[35\] sky130_fd_sc_hd__inv_1
XFILLER_35_15 VGND VPWR VPWR VGND sky130_ef_sc_hd__decap_12
XFILLER_19_27 VGND VPWR VPWR VGND sky130_ef_sc_hd__decap_12
XFILLER_27_125 VGND VPWR VPWR VGND sky130_ef_sc_hd__decap_12
XFILLER_27_169 VPWR VGND VPWR VGND sky130_fd_sc_hd__decap_3
XFILLER_41_161 VPWR VGND VPWR VGND sky130_fd_sc_hd__decap_6
XFILLER_25_81 VGND VPWR VPWR VGND sky130_ef_sc_hd__decap_12
XFILLER_2_41 VGND VPWR VPWR VGND sky130_ef_sc_hd__decap_12
XFILLER_2_85 VGND VPWR VPWR VGND sky130_ef_sc_hd__decap_12
XFILLER_21_39 VGND VPWR VPWR VGND sky130_ef_sc_hd__decap_12
XFILLER_46_69 VGND VPWR VPWR VGND sky130_ef_sc_hd__decap_12
XFILLER_23_161 VPWR VGND VPWR VGND sky130_fd_sc_hd__decap_6
XFILLER_23_194 VGND VPWR VPWR VGND sky130_fd_sc_hd__decap_4
XFILLER_30_109 VGND VPWR VPWR VGND sky130_ef_sc_hd__decap_12
XFILLER_38_209 VGND VPWR VPWR VGND sky130_ef_sc_hd__decap_12
Xdelay_chain\[21\].inv_b.core_inv VPWR VGND VGND VPWR d\[21\] tap\[21\] sky130_fd_sc_hd__inv_1
XFILLER_46_253 VGND VPWR VPWR VGND sky130_ef_sc_hd__decap_12
XFILLER_12_109 VGND VPWR VPWR VGND sky130_ef_sc_hd__decap_12
XFILLER_20_153 VGND VPWR VPWR VGND sky130_ef_sc_hd__decap_12
XFILLER_28_253 VGND VPWR VPWR VGND sky130_ef_sc_hd__decap_12
XFILLER_7_113 VGND VPWR VPWR VGND sky130_ef_sc_hd__decap_12
X_104_ VGND VPWR VPWR VGND _018_ tap\[25\] Q[0] tap\[24\] sky130_fd_sc_hd__mux2_1
XFILLER_34_289 VPWR VGND VPWR VGND sky130_fd_sc_hd__decap_8
XFILLER_34_245 VPWR VGND VPWR VGND sky130_fd_sc_hd__decap_6
XFILLER_27_27 VGND VPWR VPWR VGND sky130_ef_sc_hd__decap_12
XFILLER_43_15 VGND VPWR VPWR VGND sky130_ef_sc_hd__decap_12
XFILLER_17_93 VGND VPWR VPWR VGND sky130_ef_sc_hd__decap_12
XFILLER_31_237 VGND VPWR VPWR VGND sky130_ef_sc_hd__decap_12
XFILLER_33_81 VGND VPWR VPWR VGND sky130_ef_sc_hd__decap_12
XFILLER_3_193 VGND VPWR VPWR VGND sky130_ef_sc_hd__decap_12
XFILLER_12_3 VGND VPWR VPWR VGND sky130_ef_sc_hd__decap_12
XFILLER_22_204 VPWR VGND VPWR VGND sky130_fd_sc_hd__decap_6
XFILLER_38_15 VGND VPWR VPWR VGND sky130_ef_sc_hd__decap_12
XFILLER_13_237 VPWR VGND VPWR VGND sky130_fd_sc_hd__decap_8
XFILLER_21_281 VPWR VGND VPWR VGND sky130_fd_sc_hd__decap_8
XFILLER_0_141 VGND VPWR VPWR VGND sky130_ef_sc_hd__decap_12
Xdelay_chain\[26\].inv_b.core_inv VPWR VGND VGND VPWR d\[26\] tap\[26\] sky130_fd_sc_hd__inv_1
XFILLER_45_137 VGND VPWR VPWR VGND sky130_ef_sc_hd__decap_12
XFILLER_35_27 VGND VPWR VPWR VGND sky130_ef_sc_hd__decap_12
XFILLER_19_39 VGND VPWR VPWR VGND sky130_ef_sc_hd__decap_12
Xdelay_chain\[12\].inv_b.core_inv VPWR VGND VGND VPWR d\[12\] tap\[12\] sky130_fd_sc_hd__inv_1
XFILLER_27_137 VGND VPWR VPWR VGND sky130_ef_sc_hd__decap_12
XFILLER_35_181 VGND VPWR VPWR VGND sky130_ef_sc_hd__decap_12
XFILLER_41_81 VGND VPWR VPWR VGND sky130_ef_sc_hd__decap_12
XFILLER_25_93 VGND VPWR VPWR VGND sky130_ef_sc_hd__decap_12
XFILLER_2_97 VGND VPWR VPWR VGND sky130_ef_sc_hd__decap_12
XFILLER_2_53 VGND VPWR VPWR VGND sky130_ef_sc_hd__decap_12
XPHY_EDGE_ROW_10_Right_10 VPWR VGND VPWR VGND sky130_fd_sc_hd__decap_3
XFILLER_46_15 VGND VPWR VPWR VGND sky130_ef_sc_hd__decap_12
XFILLER_11_51 VGND VPWR VPWR VGND sky130_fd_sc_hd__decap_4
XFILLER_46_265 VGND VPWR VPWR VGND sky130_ef_sc_hd__decap_12
XFILLER_46_221 VPWR VGND VPWR VGND sky130_fd_sc_hd__decap_3
XFILLER_42_3 VGND VPWR VPWR VGND sky130_ef_sc_hd__decap_12
XFILLER_16_29 VGND VPWR VPWR VGND sky130_ef_sc_hd__decap_12
XFILLER_20_121 VGND VPWR VPWR VGND sky130_ef_sc_hd__decap_12
XFILLER_20_165 VGND VPWR VPWR VGND sky130_ef_sc_hd__decap_12
XFILLER_28_265 VGND VPWR VPWR VGND sky130_ef_sc_hd__decap_12
XFILLER_7_169 VGND VPWR VPWR VGND sky130_ef_sc_hd__decap_12
XFILLER_7_125 VGND VPWR VPWR VGND sky130_ef_sc_hd__decap_12
X_103_ VGND VPWR VGND VPWR Q[0] tap\[30\] tap\[31\] Q[1] tap\[29\] tap\[28\] _017_
+ sky130_fd_sc_hd__mux4_2
XFILLER_19_221 VPWR VGND VPWR VGND sky130_fd_sc_hd__decap_3
XFILLER_19_287 VGND VPWR VPWR VGND sky130_fd_sc_hd__decap_4
XFILLER_8_85 VGND VPWR VPWR VGND sky130_ef_sc_hd__decap_12
XFILLER_8_41 VGND VPWR VPWR VGND sky130_ef_sc_hd__decap_12
Xdelay_chain\[17\].inv_b.core_inv VPWR VGND VGND VPWR d\[17\] tap\[17\] sky130_fd_sc_hd__inv_1
XFILLER_27_39 VGND VPWR VPWR VGND sky130_ef_sc_hd__decap_12
XFILLER_43_27 VGND VPWR VPWR VGND sky130_ef_sc_hd__decap_12
XFILLER_16_213 VPWR VGND VPWR VGND sky130_fd_sc_hd__decap_8
XFILLER_16_224 VGND VPWR VPWR VGND sky130_ef_sc_hd__decap_12
Xdelay_chain\[17\].genblk1.inv_a.core_inv VPWR VGND VGND VPWR tap\[16\] d\[17\] sky130_fd_sc_hd__inv_1
XFILLER_31_205 VGND VPWR VPWR VGND sky130_ef_sc_hd__decap_12
XFILLER_31_249 VGND VPWR VPWR VGND sky130_ef_sc_hd__decap_12
XFILLER_33_93 VGND VPWR VPWR VGND sky130_ef_sc_hd__decap_12
XFILLER_3_161 VPWR VGND VPWR VGND sky130_fd_sc_hd__decap_6
XPHY_EDGE_ROW_8_Right_8 VPWR VGND VPWR VGND sky130_fd_sc_hd__decap_3
Xdelay_chain\[26\].genblk1.inv_a.core_inv VPWR VGND VGND VPWR tap\[25\] d\[26\] sky130_fd_sc_hd__inv_1
XPHY_EDGE_ROW_39_Right_39 VPWR VGND VPWR VGND sky130_fd_sc_hd__decap_3
XFILLER_13_205 VGND VPWR VPWR VGND sky130_ef_sc_hd__decap_12
Xdelay_chain\[35\].genblk1.inv_a.core_inv VPWR VGND VGND VPWR tap\[34\] d\[35\] sky130_fd_sc_hd__inv_1
XFILLER_0_153 VGND VPWR VPWR VGND sky130_ef_sc_hd__decap_12
XFILLER_0_197 VGND VPWR VPWR VGND sky130_ef_sc_hd__decap_12
Xdelay_chain\[44\].genblk1.inv_a.core_inv VPWR VGND VGND VPWR tap\[43\] d\[44\] sky130_fd_sc_hd__inv_1
XFILLER_8_253 VGND VPWR VPWR VGND sky130_ef_sc_hd__decap_12
XFILLER_39_113 VGND VPWR VPWR VGND sky130_ef_sc_hd__decap_12
XPHY_EDGE_ROW_17_Left_64 VPWR VGND VPWR VGND sky130_fd_sc_hd__decap_3
XFILLER_24_29 VGND VPWR VPWR VGND sky130_ef_sc_hd__decap_12
Xdelay_chain\[53\].genblk1.inv_a.core_inv VPWR VGND VGND VPWR tap\[52\] d\[53\] sky130_fd_sc_hd__inv_1
XFILLER_45_149 VGND VPWR VPWR VGND sky130_ef_sc_hd__decap_12
XFILLER_45_105 VPWR VGND VPWR VGND sky130_fd_sc_hd__decap_6
Xdelay_chain\[62\].genblk1.inv_a.core_inv VPWR VGND VGND VPWR tap\[61\] d\[62\] sky130_fd_sc_hd__inv_1
XFILLER_39_81 VGND VPWR VPWR VGND sky130_ef_sc_hd__decap_12
XFILLER_35_39 VGND VPWR VPWR VGND sky130_ef_sc_hd__decap_12
XFILLER_27_105 VPWR VGND VPWR VGND sky130_fd_sc_hd__decap_6
XFILLER_27_149 VGND VPWR VPWR VGND sky130_ef_sc_hd__decap_12
XFILLER_35_193 VGND VPWR VPWR VGND sky130_ef_sc_hd__decap_12
XPHY_EDGE_ROW_2_Left_49 VPWR VGND VPWR VGND sky130_fd_sc_hd__decap_3
XFILLER_41_93 VGND VPWR VPWR VGND sky130_ef_sc_hd__decap_12
XFILLER_1_281 VGND VPWR VPWR VGND sky130_ef_sc_hd__decap_12
XFILLER_2_65 VGND VPWR VPWR VGND sky130_ef_sc_hd__decap_12
XFILLER_32_141 VGND VPWR VPWR VGND sky130_ef_sc_hd__decap_12
Xdelay_chain\[0\].genblk1.inv_a.core_inv VPWR VGND VGND VPWR A d\[0\] sky130_fd_sc_hd__inv_1
XFILLER_2_3 VGND VPWR VPWR VGND sky130_ef_sc_hd__decap_12
XFILLER_46_277 VPWR VGND VPWR VGND sky130_fd_sc_hd__decap_3
XFILLER_14_141 VGND VPWR VPWR VGND sky130_ef_sc_hd__decap_12
XFILLER_35_3 VGND VPWR VPWR VGND sky130_ef_sc_hd__decap_12
XFILLER_20_133 VPWR VGND VPWR VGND sky130_fd_sc_hd__decap_6
XFILLER_20_177 VGND VPWR VPWR VGND sky130_fd_sc_hd__decap_4
XFILLER_20_188 VPWR VGND VPWR VGND sky130_fd_sc_hd__decap_3
XFILLER_32_29 VGND VPWR VPWR VGND sky130_ef_sc_hd__decap_12
XFILLER_43_225 VGND VPWR VPWR VGND sky130_ef_sc_hd__decap_12
XFILLER_28_277 VGND VPWR VPWR VGND sky130_ef_sc_hd__decap_12
XFILLER_7_137 VGND VPWR VPWR VGND sky130_ef_sc_hd__decap_12
XPHY_EDGE_ROW_5_Left_52 VPWR VGND VPWR VGND sky130_fd_sc_hd__decap_3
X_102_ VPWR VGND VPWR VGND _031_ _015_ _012_ _014_ _016_ sky130_fd_sc_hd__a22o_2
XFILLER_8_97 VGND VPWR VPWR VGND sky130_ef_sc_hd__decap_12
XFILLER_8_53 VGND VPWR VPWR VGND sky130_ef_sc_hd__decap_12
XFILLER_43_39 VGND VPWR VPWR VGND sky130_ef_sc_hd__decap_12
XPHY_EDGE_ROW_31_Left_78 VPWR VGND VPWR VGND sky130_fd_sc_hd__decap_3
XFILLER_17_51 VGND VPWR VPWR VGND sky130_fd_sc_hd__decap_4
XFILLER_31_217 VPWR VGND VPWR VGND sky130_fd_sc_hd__decap_6
XFILLER_13_217 VPWR VGND VPWR VGND sky130_fd_sc_hd__decap_6
XFILLER_0_165 VPWR VGND VPWR VGND sky130_fd_sc_hd__decap_3
XFILLER_8_265 VGND VPWR VPWR VGND sky130_ef_sc_hd__decap_12
XFILLER_8_221 VGND VPWR VPWR VGND sky130_ef_sc_hd__decap_12
XFILLER_39_125 VGND VPWR VPWR VGND sky130_ef_sc_hd__decap_12
XFILLER_39_169 VGND VPWR VPWR VGND sky130_ef_sc_hd__decap_12
XFILLER_10_209 VGND VPWR VPWR VGND sky130_ef_sc_hd__decap_12
XFILLER_40_29 VGND VPWR VPWR VGND sky130_ef_sc_hd__decap_12
XFILLER_14_41 VGND VPWR VPWR VGND sky130_ef_sc_hd__decap_12
XFILLER_14_85 VGND VPWR VPWR VGND sky130_ef_sc_hd__decap_12
XFILLER_39_93 VGND VPWR VPWR VGND sky130_ef_sc_hd__decap_12
XPHY_EDGE_ROW_34_Left_81 VPWR VGND VPWR VGND sky130_fd_sc_hd__decap_3
XFILLER_42_109 VGND VPWR VPWR VGND sky130_ef_sc_hd__decap_12
XFILLER_35_161 VPWR VGND VPWR VGND sky130_fd_sc_hd__decap_6
XFILLER_25_51 VGND VPWR VPWR VGND sky130_fd_sc_hd__decap_4
XFILLER_1_293 VPWR VGND VPWR VGND sky130_fd_sc_hd__decap_6
XFILLER_2_77 VPWR VGND VPWR VGND sky130_fd_sc_hd__decap_6
XFILLER_17_161 VPWR VGND VPWR VGND sky130_fd_sc_hd__decap_6
XFILLER_24_109 VGND VPWR VPWR VGND sky130_ef_sc_hd__decap_12
XFILLER_32_153 VGND VPWR VPWR VGND sky130_ef_sc_hd__decap_12
XFILLER_32_197 VGND VPWR VPWR VGND sky130_ef_sc_hd__decap_12
XFILLER_14_153 VGND VPWR VPWR VGND sky130_ef_sc_hd__decap_12
XFILLER_14_197 VGND VPWR VPWR VGND sky130_ef_sc_hd__decap_12
XFILLER_28_3 VGND VPWR VPWR VGND sky130_ef_sc_hd__decap_12
XFILLER_43_237 VGND VPWR VPWR VGND sky130_ef_sc_hd__decap_12
XFILLER_28_289 VPWR VGND VPWR VGND sky130_fd_sc_hd__decap_8
XFILLER_7_105 VPWR VGND VPWR VGND sky130_fd_sc_hd__decap_6
X_101_ VGND VPWR VGND VPWR Q[0] tap\[2\] tap\[3\] Q[1] tap\[1\] tap\[0\] _015_ sky130_fd_sc_hd__mux4_2
XFILLER_22_41 VGND VPWR VPWR VGND sky130_ef_sc_hd__decap_12
XFILLER_7_149 VGND VPWR VPWR VGND sky130_ef_sc_hd__decap_12
XFILLER_22_85 VGND VPWR VPWR VGND sky130_ef_sc_hd__decap_12
XFILLER_8_65 VGND VPWR VPWR VGND sky130_ef_sc_hd__decap_12
XFILLER_25_237 VPWR VGND VPWR VGND sky130_fd_sc_hd__decap_6
XFILLER_33_281 VGND VPWR VPWR VGND sky130_ef_sc_hd__decap_12
XFILLER_33_51 VGND VPWR VPWR VGND sky130_fd_sc_hd__decap_4
XFILLER_22_229 VPWR VGND VPWR VGND sky130_fd_sc_hd__decap_8
XFILLER_38_29 VGND VPWR VPWR VGND sky130_ef_sc_hd__decap_12
Xdelay_chain\[2\].inv_b.core_inv VPWR VGND VGND VPWR d\[2\] tap\[2\] sky130_fd_sc_hd__inv_1
XFILLER_8_277 VGND VPWR VPWR VGND sky130_ef_sc_hd__decap_12
XFILLER_8_233 VGND VPWR VPWR VGND sky130_ef_sc_hd__decap_12
XFILLER_39_137 VGND VPWR VPWR VGND sky130_ef_sc_hd__decap_12
XFILLER_10_3 VGND VPWR VPWR VGND sky130_ef_sc_hd__decap_12
XFILLER_14_53 VGND VPWR VPWR VGND sky130_ef_sc_hd__decap_12
XFILLER_5_225 VGND VPWR VPWR VGND sky130_ef_sc_hd__decap_12
XFILLER_14_97 VGND VPWR VPWR VGND sky130_ef_sc_hd__decap_12
XFILLER_30_41 VGND VPWR VPWR VGND sky130_ef_sc_hd__decap_12
XFILLER_30_85 VGND VPWR VPWR VGND sky130_ef_sc_hd__decap_12
XFILLER_29_181 VGND VPWR VPWR VGND sky130_ef_sc_hd__decap_12
XFILLER_41_51 VGND VPWR VPWR VGND sky130_fd_sc_hd__decap_4
XFILLER_1_261 VGND VPWR VPWR VGND sky130_ef_sc_hd__decap_12
XFILLER_32_121 VGND VPWR VPWR VGND sky130_ef_sc_hd__decap_12
XFILLER_32_165 VGND VPWR VPWR VGND sky130_ef_sc_hd__decap_12
Xdelay_chain\[7\].inv_b.core_inv VPWR VGND VGND VPWR d\[7\] tap\[7\] sky130_fd_sc_hd__inv_1
XFILLER_46_29 VGND VPWR VPWR VGND sky130_ef_sc_hd__decap_12
XFILLER_14_121 VGND VPWR VPWR VGND sky130_ef_sc_hd__decap_12
XFILLER_43_249 VGND VPWR VPWR VGND sky130_ef_sc_hd__decap_12
XFILLER_43_205 VGND VPWR VPWR VGND sky130_ef_sc_hd__decap_12
XFILLER_11_113 VGND VPWR VPWR VGND sky130_ef_sc_hd__decap_12
X_100_ VGND VPWR VGND VPWR _014_ Q[2] _013_ _030_ sky130_fd_sc_hd__o21a_2
XFILLER_22_53 VGND VPWR VPWR VGND sky130_ef_sc_hd__decap_12
Xdelay_chain\[10\].genblk1.inv_a.core_inv VPWR VGND VGND VPWR tap\[9\] d\[10\] sky130_fd_sc_hd__inv_1
XFILLER_22_97 VGND VPWR VPWR VGND sky130_ef_sc_hd__decap_12
XFILLER_19_213 VPWR VGND VPWR VGND sky130_fd_sc_hd__decap_8
XFILLER_8_77 VPWR VGND VPWR VGND sky130_fd_sc_hd__decap_6
XFILLER_40_3 VGND VPWR VPWR VGND sky130_ef_sc_hd__decap_12
XFILLER_33_293 VPWR VGND VPWR VGND sky130_fd_sc_hd__decap_6
XFILLER_4_109 VGND VPWR VPWR VGND sky130_ef_sc_hd__decap_12
XPHY_EDGE_ROW_17_Right_17 VPWR VGND VPWR VGND sky130_fd_sc_hd__decap_3
Xdelay_chain\[60\].inv_b.core_inv VPWR VGND VGND VPWR d\[60\] tap\[60\] sky130_fd_sc_hd__inv_1
XPHY_EDGE_ROW_26_Right_26 VPWR VGND VPWR VGND sky130_fd_sc_hd__decap_3
XFILLER_28_41 VGND VPWR VPWR VGND sky130_ef_sc_hd__decap_12
XFILLER_28_85 VGND VPWR VPWR VGND sky130_ef_sc_hd__decap_12
XPHY_EDGE_ROW_35_Right_35 VPWR VGND VPWR VGND sky130_fd_sc_hd__decap_3
XFILLER_8_245 VPWR VGND VPWR VGND sky130_fd_sc_hd__decap_6
XFILLER_8_289 VPWR VGND VPWR VGND sky130_fd_sc_hd__decap_8
XPHY_EDGE_ROW_44_Right_44 VPWR VGND VPWR VGND sky130_fd_sc_hd__decap_3
XFILLER_39_149 VGND VPWR VPWR VGND sky130_ef_sc_hd__decap_12
XFILLER_39_105 VPWR VGND VPWR VGND sky130_fd_sc_hd__decap_6
XFILLER_14_65 VGND VPWR VPWR VGND sky130_ef_sc_hd__decap_12
XFILLER_5_237 VGND VPWR VPWR VGND sky130_ef_sc_hd__decap_12
XFILLER_30_53 VGND VPWR VPWR VGND sky130_ef_sc_hd__decap_12
XFILLER_30_97 VGND VPWR VPWR VGND sky130_ef_sc_hd__decap_12
XFILLER_39_51 VGND VPWR VPWR VGND sky130_fd_sc_hd__decap_4
XFILLER_44_141 VGND VPWR VPWR VGND sky130_ef_sc_hd__decap_12
XFILLER_29_193 VGND VPWR VPWR VGND sky130_ef_sc_hd__decap_12
XFILLER_26_141 VGND VPWR VPWR VGND sky130_ef_sc_hd__decap_12
XFILLER_26_174 VGND VPWR VPWR VGND sky130_fd_sc_hd__decap_4
XFILLER_1_273 VPWR VGND VPWR VGND sky130_fd_sc_hd__decap_6
XFILLER_32_133 VPWR VGND VPWR VGND sky130_fd_sc_hd__decap_6
XFILLER_32_177 VGND VPWR VPWR VGND sky130_ef_sc_hd__decap_12
XFILLER_46_225 VGND VPWR VPWR VGND sky130_ef_sc_hd__decap_12
XFILLER_36_85 VGND VPWR VPWR VGND sky130_ef_sc_hd__decap_12
XFILLER_36_41 VGND VPWR VPWR VGND sky130_ef_sc_hd__decap_12
XFILLER_14_133 VPWR VGND VPWR VGND sky130_fd_sc_hd__decap_6
XFILLER_37_225 VGND VPWR VPWR VGND sky130_ef_sc_hd__decap_12
XFILLER_9_181 VGND VPWR VPWR VGND sky130_ef_sc_hd__decap_12
XFILLER_43_217 VPWR VGND VPWR VGND sky130_fd_sc_hd__decap_6
XFILLER_11_125 VGND VPWR VPWR VGND sky130_ef_sc_hd__decap_12
XFILLER_11_169 VGND VPWR VPWR VGND sky130_ef_sc_hd__decap_12
XFILLER_22_65 VGND VPWR VPWR VGND sky130_ef_sc_hd__decap_12
XFILLER_0_3 VGND VPWR VPWR VGND sky130_ef_sc_hd__decap_12
Xdelay_chain\[51\].inv_b.core_inv VPWR VGND VGND VPWR d\[51\] tap\[51\] sky130_fd_sc_hd__inv_1
XFILLER_33_3 VGND VPWR VPWR VGND sky130_ef_sc_hd__decap_12
XFILLER_40_209 VGND VPWR VPWR VGND sky130_ef_sc_hd__decap_12
XFILLER_33_261 VGND VPWR VPWR VGND sky130_ef_sc_hd__decap_12
XPHY_EDGE_ROW_9_Left_56 VPWR VGND VPWR VGND sky130_fd_sc_hd__decap_3
Xdelay_chain\[29\].genblk1.inv_a.core_inv VPWR VGND VGND VPWR tap\[28\] d\[29\] sky130_fd_sc_hd__inv_1
Xdelay_chain\[38\].genblk1.inv_a.core_inv VPWR VGND VGND VPWR tap\[37\] d\[38\] sky130_fd_sc_hd__inv_1
XFILLER_30_253 VGND VPWR VPWR VGND sky130_ef_sc_hd__decap_12
Xdelay_chain\[47\].genblk1.inv_a.core_inv VPWR VGND VGND VPWR tap\[46\] d\[47\] sky130_fd_sc_hd__inv_1
XFILLER_21_231 VPWR VGND VPWR VGND sky130_fd_sc_hd__decap_8
XFILLER_0_113 VGND VPWR VPWR VGND sky130_ef_sc_hd__decap_12
XFILLER_44_41 VGND VPWR VPWR VGND sky130_ef_sc_hd__decap_12
Xdelay_chain\[56\].genblk1.inv_a.core_inv VPWR VGND VGND VPWR tap\[55\] d\[56\] sky130_fd_sc_hd__inv_1
XFILLER_28_53 VGND VPWR VPWR VGND sky130_ef_sc_hd__decap_12
XFILLER_28_97 VGND VPWR VPWR VGND sky130_ef_sc_hd__decap_12
XFILLER_44_85 VGND VPWR VPWR VGND sky130_ef_sc_hd__decap_12
XFILLER_12_253 VGND VPWR VPWR VGND sky130_ef_sc_hd__decap_12
XFILLER_5_57 VGND VPWR VPWR VGND sky130_ef_sc_hd__decap_12
XFILLER_14_77 VPWR VGND VPWR VGND sky130_fd_sc_hd__decap_6
XFILLER_5_249 VGND VPWR VPWR VGND sky130_ef_sc_hd__decap_12
XFILLER_5_205 VGND VPWR VPWR VGND sky130_ef_sc_hd__decap_12
XFILLER_30_65 VGND VPWR VPWR VGND sky130_ef_sc_hd__decap_12
XFILLER_36_109 VGND VPWR VPWR VGND sky130_ef_sc_hd__decap_12
XFILLER_29_161 VPWR VGND VPWR VGND sky130_fd_sc_hd__decap_6
XFILLER_44_197 VGND VPWR VPWR VGND sky130_ef_sc_hd__decap_12
XFILLER_44_153 VGND VPWR VPWR VGND sky130_ef_sc_hd__decap_12
Xdelay_chain\[56\].inv_b.core_inv VPWR VGND VGND VPWR d\[56\] tap\[56\] sky130_fd_sc_hd__inv_1
XFILLER_18_109 VGND VPWR VPWR VGND sky130_ef_sc_hd__decap_12
XFILLER_26_153 VPWR VGND VPWR VGND sky130_fd_sc_hd__decap_8
XPHY_EDGE_ROW_38_Left_85 VPWR VGND VPWR VGND sky130_fd_sc_hd__decap_3
XPHY_EDGE_ROW_22_Left_69 VPWR VGND VPWR VGND sky130_fd_sc_hd__decap_3
XFILLER_32_189 VPWR VGND VPWR VGND sky130_fd_sc_hd__decap_6
Xdelay_chain\[3\].genblk1.inv_a.core_inv VPWR VGND VGND VPWR tap\[2\] d\[3\] sky130_fd_sc_hd__inv_1
Xdelay_chain\[42\].inv_b.core_inv VPWR VGND VGND VPWR d\[42\] tap\[42\] sky130_fd_sc_hd__inv_1
XFILLER_46_237 VGND VPWR VPWR VGND sky130_ef_sc_hd__decap_12
XFILLER_36_53 VGND VPWR VPWR VGND sky130_ef_sc_hd__decap_12
XFILLER_36_97 VGND VPWR VPWR VGND sky130_ef_sc_hd__decap_12
XFILLER_45_281 VGND VPWR VPWR VGND sky130_ef_sc_hd__decap_12
XFILLER_37_237 VGND VPWR VPWR VGND sky130_ef_sc_hd__decap_12
XFILLER_9_193 VGND VPWR VPWR VGND sky130_ef_sc_hd__decap_12
XFILLER_11_137 VGND VPWR VPWR VGND sky130_ef_sc_hd__decap_12
XFILLER_22_77 VPWR VGND VPWR VGND sky130_fd_sc_hd__decap_6
XFILLER_27_281 VGND VPWR VPWR VGND sky130_ef_sc_hd__decap_12
XFILLER_6_141 VGND VPWR VPWR VGND sky130_ef_sc_hd__decap_12
X_089_ VGND VPWR VGND VPWR _003_ Q[3] _002_ _000_ sky130_fd_sc_hd__o21a_2
XPHY_EDGE_ROW_25_Left_72 VPWR VGND VPWR VGND sky130_fd_sc_hd__decap_3
XFILLER_26_3 VGND VPWR VPWR VGND sky130_ef_sc_hd__decap_12
XFILLER_33_273 VPWR VGND VPWR VGND sky130_fd_sc_hd__decap_6
XFILLER_24_295 VGND VPWR VPWR VGND sky130_fd_sc_hd__decap_4
XFILLER_30_221 VGND VPWR VPWR VGND sky130_ef_sc_hd__decap_12
XFILLER_30_265 VGND VPWR VPWR VGND sky130_ef_sc_hd__decap_12
XPHY_EDGE_ROW_3_Right_3 VPWR VGND VPWR VGND sky130_fd_sc_hd__decap_3
XFILLER_21_254 VGND VPWR VPWR VGND sky130_fd_sc_hd__decap_4
Xdelay_chain\[47\].inv_b.core_inv VPWR VGND VGND VPWR d\[47\] tap\[47\] sky130_fd_sc_hd__inv_1
XFILLER_0_125 VGND VPWR VPWR VGND sky130_ef_sc_hd__decap_12
XFILLER_0_169 VGND VPWR VPWR VGND sky130_ef_sc_hd__decap_12
XFILLER_28_65 VGND VPWR VPWR VGND sky130_ef_sc_hd__decap_12
XFILLER_44_53 VGND VPWR VPWR VGND sky130_ef_sc_hd__decap_12
XFILLER_12_221 VGND VPWR VPWR VGND sky130_ef_sc_hd__decap_12
XFILLER_44_97 VGND VPWR VPWR VGND sky130_ef_sc_hd__decap_12
XFILLER_12_265 VGND VPWR VPWR VGND sky130_ef_sc_hd__decap_12
XFILLER_5_69 VGND VPWR VPWR VGND sky130_ef_sc_hd__decap_12
XFILLER_5_217 VPWR VGND VPWR VGND sky130_fd_sc_hd__decap_6
XFILLER_30_77 VPWR VGND VPWR VGND sky130_fd_sc_hd__decap_6
XFILLER_44_121 VGND VPWR VPWR VGND sky130_ef_sc_hd__decap_12
XFILLER_44_165 VGND VPWR VPWR VGND sky130_ef_sc_hd__decap_12
Xdelay_chain\[33\].inv_b.core_inv VPWR VGND VGND VPWR d\[33\] tap\[33\] sky130_fd_sc_hd__inv_1
XFILLER_2_209 VGND VPWR VPWR VGND sky130_ef_sc_hd__decap_12
XFILLER_26_121 VGND VPWR VPWR VGND sky130_ef_sc_hd__decap_12
XFILLER_41_113 VGND VPWR VPWR VGND sky130_ef_sc_hd__decap_12
XFILLER_2_15 VGND VPWR VPWR VGND sky130_ef_sc_hd__decap_12
XFILLER_17_187 VGND VPWR VPWR VGND sky130_fd_sc_hd__decap_4
XFILLER_17_198 VPWR VGND VPWR VGND sky130_fd_sc_hd__decap_8
XFILLER_23_113 VGND VPWR VPWR VGND sky130_ef_sc_hd__decap_12
XFILLER_11_57 VGND VPWR VPWR VGND sky130_ef_sc_hd__decap_12
XFILLER_46_249 VPWR VGND VPWR VGND sky130_fd_sc_hd__decap_3
XFILLER_36_65 VGND VPWR VPWR VGND sky130_ef_sc_hd__decap_12
XFILLER_37_205 VGND VPWR VPWR VGND sky130_ef_sc_hd__decap_12
XFILLER_45_293 VPWR VGND VPWR VGND sky130_fd_sc_hd__decap_6
XFILLER_37_249 VGND VPWR VPWR VGND sky130_ef_sc_hd__decap_12
XFILLER_9_161 VPWR VGND VPWR VGND sky130_fd_sc_hd__decap_6
XFILLER_28_249 VPWR VGND VPWR VGND sky130_fd_sc_hd__decap_3
XFILLER_11_105 VPWR VGND VPWR VGND sky130_fd_sc_hd__decap_6
XFILLER_11_149 VGND VPWR VPWR VGND sky130_ef_sc_hd__decap_12
XFILLER_27_293 VPWR VGND VPWR VGND sky130_fd_sc_hd__decap_6
XFILLER_6_153 VGND VPWR VPWR VGND sky130_ef_sc_hd__decap_12
XFILLER_6_197 VGND VPWR VPWR VGND sky130_ef_sc_hd__decap_12
Xdelay_chain\[38\].inv_b.core_inv VPWR VGND VGND VPWR d\[38\] tap\[38\] sky130_fd_sc_hd__inv_1
X_088_ VPWR VGND _031_ _002_ _001_ VPWR VGND sky130_fd_sc_hd__and2_2
XFILLER_19_3 VGND VPWR VPWR VGND sky130_ef_sc_hd__decap_12
XFILLER_25_208 VGND VPWR VPWR VGND sky130_ef_sc_hd__decap_12
XFILLER_24_230 VPWR VGND VPWR VGND sky130_fd_sc_hd__decap_8
XFILLER_24_285 VPWR VGND VPWR VGND sky130_fd_sc_hd__decap_6
XFILLER_15_252 VPWR VGND VPWR VGND sky130_fd_sc_hd__decap_6
XFILLER_30_233 VGND VPWR VPWR VGND sky130_ef_sc_hd__decap_12
XFILLER_30_277 VGND VPWR VPWR VGND sky130_ef_sc_hd__decap_12
XFILLER_0_81 VPWR VGND VPWR VGND sky130_fd_sc_hd__decap_3
XFILLER_21_200 VGND VPWR VPWR VGND sky130_fd_sc_hd__decap_4
XFILLER_0_137 VPWR VGND VPWR VGND sky130_fd_sc_hd__decap_3
Xdelay_chain\[24\].inv_b.core_inv VPWR VGND VGND VPWR d\[24\] tap\[24\] sky130_fd_sc_hd__inv_1
XFILLER_28_77 VPWR VGND VPWR VGND sky130_fd_sc_hd__decap_6
XFILLER_44_65 VGND VPWR VPWR VGND sky130_ef_sc_hd__decap_12
XFILLER_12_233 VGND VPWR VPWR VGND sky130_ef_sc_hd__decap_12
XFILLER_5_15 VGND VPWR VPWR VGND sky130_ef_sc_hd__decap_12
XFILLER_12_277 VGND VPWR VPWR VGND sky130_ef_sc_hd__decap_12
XPHY_EDGE_ROW_13_Right_13 VPWR VGND VPWR VGND sky130_fd_sc_hd__decap_3
XPHY_EDGE_ROW_22_Right_22 VPWR VGND VPWR VGND sky130_fd_sc_hd__decap_3
XFILLER_7_281 VGND VPWR VPWR VGND sky130_ef_sc_hd__decap_12
XFILLER_38_141 VGND VPWR VPWR VGND sky130_ef_sc_hd__decap_12
XPHY_EDGE_ROW_31_Right_31 VPWR VGND VPWR VGND sky130_fd_sc_hd__decap_3
XPHY_EDGE_ROW_40_Right_40 VPWR VGND VPWR VGND sky130_fd_sc_hd__decap_3
XFILLER_44_133 VPWR VGND VPWR VGND sky130_fd_sc_hd__decap_6
XFILLER_44_177 VGND VPWR VPWR VGND sky130_ef_sc_hd__decap_12
Xdelay_chain\[10\].inv_b.core_inv VPWR VGND VGND VPWR d\[10\] tap\[10\] sky130_fd_sc_hd__inv_1
XFILLER_26_133 VPWR VGND VPWR VGND sky130_fd_sc_hd__decap_6
XFILLER_41_169 VGND VPWR VPWR VGND sky130_ef_sc_hd__decap_12
XFILLER_41_125 VGND VPWR VPWR VGND sky130_ef_sc_hd__decap_12
XFILLER_23_125 VGND VPWR VPWR VGND sky130_ef_sc_hd__decap_12
XFILLER_23_169 VPWR VGND VPWR VGND sky130_fd_sc_hd__decap_6
XFILLER_11_69 VGND VPWR VPWR VGND sky130_ef_sc_hd__decap_12
Xdelay_chain\[29\].inv_b.core_inv VPWR VGND VGND VPWR d\[29\] tap\[29\] sky130_fd_sc_hd__inv_1
XFILLER_36_77 VPWR VGND VPWR VGND sky130_fd_sc_hd__decap_6
XFILLER_14_169 VGND VPWR VPWR VGND sky130_ef_sc_hd__decap_12
XFILLER_37_217 VPWR VGND VPWR VGND sky130_fd_sc_hd__decap_6
XFILLER_45_261 VGND VPWR VPWR VGND sky130_ef_sc_hd__decap_12
Xdelay_chain\[13\].genblk1.inv_a.core_inv VPWR VGND VGND VPWR tap\[12\] d\[13\] sky130_fd_sc_hd__inv_1
XFILLER_3_81 VGND VPWR VPWR VGND sky130_ef_sc_hd__decap_12
XFILLER_28_217 VPWR VGND VPWR VGND sky130_fd_sc_hd__decap_3
Xdelay_chain\[22\].genblk1.inv_a.core_inv VPWR VGND VGND VPWR tap\[21\] d\[22\] sky130_fd_sc_hd__inv_1
XFILLER_42_253 VGND VPWR VPWR VGND sky130_ef_sc_hd__decap_12
XFILLER_8_15 VGND VPWR VPWR VGND sky130_ef_sc_hd__decap_12
XFILLER_27_272 VPWR VGND VPWR VGND sky130_fd_sc_hd__decap_8
XFILLER_34_209 VGND VPWR VPWR VGND sky130_ef_sc_hd__decap_12
XFILLER_6_165 VGND VPWR VPWR VGND sky130_ef_sc_hd__decap_12
XFILLER_6_121 VGND VPWR VPWR VGND sky130_ef_sc_hd__decap_12
X_087_ VGND VPWR VGND VPWR Q[0] tap\[58\] tap\[59\] Q[1] tap\[57\] tap\[56\] _001_
+ sky130_fd_sc_hd__mux4_2
Xdelay_chain\[31\].genblk1.inv_a.core_inv VPWR VGND VGND VPWR tap\[30\] d\[31\] sky130_fd_sc_hd__inv_1
Xdelay_chain\[15\].inv_b.core_inv VPWR VGND VGND VPWR d\[15\] tap\[15\] sky130_fd_sc_hd__inv_1
Xdelay_chain\[40\].genblk1.inv_a.core_inv VPWR VGND VGND VPWR tap\[39\] d\[40\] sky130_fd_sc_hd__inv_1
XFILLER_17_57 VGND VPWR VPWR VGND sky130_ef_sc_hd__decap_12
XFILLER_24_253 VPWR VGND VPWR VGND sky130_fd_sc_hd__decap_8
XFILLER_3_113 VGND VPWR VPWR VGND sky130_ef_sc_hd__decap_12
XFILLER_30_245 VPWR VGND VPWR VGND sky130_fd_sc_hd__decap_6
XFILLER_30_289 VPWR VGND VPWR VGND sky130_fd_sc_hd__decap_8
XFILLER_31_3 VGND VPWR VPWR VGND sky130_ef_sc_hd__decap_12
XFILLER_21_212 VGND VPWR VPWR VGND sky130_ef_sc_hd__decap_12
XFILLER_44_77 VPWR VGND VPWR VGND sky130_fd_sc_hd__decap_6
XFILLER_12_245 VPWR VGND VPWR VGND sky130_fd_sc_hd__decap_6
XFILLER_5_27 VGND VPWR VPWR VGND sky130_ef_sc_hd__decap_12
XFILLER_12_289 VPWR VGND VPWR VGND sky130_fd_sc_hd__decap_8
XFILLER_7_293 VPWR VGND VPWR VGND sky130_fd_sc_hd__decap_6
XFILLER_38_197 VGND VPWR VPWR VGND sky130_ef_sc_hd__decap_12
XFILLER_38_153 VGND VPWR VPWR VGND sky130_ef_sc_hd__decap_12
XFILLER_44_189 VPWR VGND VPWR VGND sky130_fd_sc_hd__decap_6
XFILLER_41_137 VGND VPWR VPWR VGND sky130_ef_sc_hd__decap_12
XFILLER_25_57 VGND VPWR VPWR VGND sky130_ef_sc_hd__decap_12
XFILLER_9_3 VGND VPWR VPWR VGND sky130_ef_sc_hd__decap_12
XFILLER_23_137 VGND VPWR VPWR VGND sky130_ef_sc_hd__decap_12
XFILLER_31_181 VGND VPWR VPWR VGND sky130_ef_sc_hd__decap_12
XFILLER_11_15 VGND VPWR VPWR VGND sky130_ef_sc_hd__decap_12
XFILLER_39_281 VGND VPWR VPWR VGND sky130_ef_sc_hd__decap_12
XFILLER_45_273 VPWR VGND VPWR VGND sky130_fd_sc_hd__decap_6
XFILLER_13_181 VGND VPWR VPWR VGND sky130_ef_sc_hd__decap_12
XFILLER_3_93 VGND VPWR VPWR VGND sky130_ef_sc_hd__decap_12
XFILLER_42_265 VGND VPWR VPWR VGND sky130_ef_sc_hd__decap_12
XFILLER_42_221 VGND VPWR VPWR VGND sky130_ef_sc_hd__decap_12
XFILLER_6_177 VGND VPWR VPWR VGND sky130_ef_sc_hd__decap_12
XFILLER_6_133 VPWR VGND VPWR VGND sky130_fd_sc_hd__decap_6
X_086_ VPWR VGND VGND VPWR _057_ _030_ _056_ _055_ _000_ Q[2] sky130_fd_sc_hd__o221a_2
XFILLER_17_69 VGND VPWR VPWR VGND sky130_ef_sc_hd__decap_12
XFILLER_24_276 VPWR VGND VPWR VGND sky130_fd_sc_hd__decap_3
XFILLER_33_57 VGND VPWR VPWR VGND sky130_ef_sc_hd__decap_12
XFILLER_3_125 VGND VPWR VPWR VGND sky130_ef_sc_hd__decap_12
XFILLER_3_169 VGND VPWR VPWR VGND sky130_ef_sc_hd__decap_12
XPHY_EDGE_ROW_29_Left_76 VPWR VGND VPWR VGND sky130_fd_sc_hd__decap_3
X_069_ VGND VPWR VGND VPWR tap\[37\] Q[0] Q[1] _041_ sky130_fd_sc_hd__a21o_2
XFILLER_24_3 VGND VPWR VPWR VGND sky130_ef_sc_hd__decap_12
Xdelay_chain\[59\].genblk1.inv_a.core_inv VPWR VGND VGND VPWR tap\[58\] d\[59\] sky130_fd_sc_hd__inv_1
XFILLER_9_81 VGND VPWR VPWR VGND sky130_ef_sc_hd__decap_12
XFILLER_5_39 VGND VPWR VPWR VGND sky130_ef_sc_hd__decap_12
XFILLER_7_261 VGND VPWR VPWR VGND sky130_ef_sc_hd__decap_12
XPHY_EDGE_ROW_7_Right_7 VPWR VGND VPWR VGND sky130_fd_sc_hd__decap_3
XFILLER_38_165 VGND VPWR VPWR VGND sky130_ef_sc_hd__decap_12
XFILLER_38_121 VGND VPWR VPWR VGND sky130_ef_sc_hd__decap_12
XFILLER_14_15 VGND VPWR VPWR VGND sky130_ef_sc_hd__decap_12
XFILLER_4_253 VGND VPWR VPWR VGND sky130_ef_sc_hd__decap_12
XFILLER_35_113 VGND VPWR VPWR VGND sky130_ef_sc_hd__decap_12
XPHY_EDGE_ROW_16_Left_63 VPWR VGND VPWR VGND sky130_fd_sc_hd__decap_3
XFILLER_41_105 VPWR VGND VPWR VGND sky130_fd_sc_hd__decap_6
XFILLER_25_69 VGND VPWR VPWR VGND sky130_ef_sc_hd__decap_12
XFILLER_26_168 VPWR VGND VPWR VGND sky130_fd_sc_hd__decap_3
XFILLER_41_149 VGND VPWR VPWR VGND sky130_ef_sc_hd__decap_12
XFILLER_41_57 VGND VPWR VPWR VGND sky130_ef_sc_hd__decap_12
Xdelay_chain\[6\].genblk1.inv_a.core_inv VPWR VGND VGND VPWR tap\[5\] d\[6\] sky130_fd_sc_hd__inv_1
XFILLER_2_29 VGND VPWR VPWR VGND sky130_ef_sc_hd__decap_12
XFILLER_17_113 VGND VPWR VPWR VGND sky130_ef_sc_hd__decap_12
XFILLER_23_105 VPWR VGND VPWR VGND sky130_fd_sc_hd__decap_6
XFILLER_23_149 VPWR VGND VPWR VGND sky130_fd_sc_hd__decap_8
XFILLER_31_193 VGND VPWR VPWR VGND sky130_ef_sc_hd__decap_12
XFILLER_11_27 VGND VPWR VPWR VGND sky130_ef_sc_hd__decap_12
XFILLER_39_293 VPWR VGND VPWR VGND sky130_fd_sc_hd__decap_6
XPHY_EDGE_ROW_1_Left_48 VPWR VGND VPWR VGND sky130_fd_sc_hd__decap_3
XFILLER_13_193 VGND VPWR VPWR VGND sky130_ef_sc_hd__decap_12
XFILLER_22_15 VGND VPWR VPWR VGND sky130_ef_sc_hd__decap_12
XFILLER_42_277 VGND VPWR VPWR VGND sky130_ef_sc_hd__decap_12
XFILLER_42_233 VGND VPWR VPWR VGND sky130_ef_sc_hd__decap_12
XFILLER_10_141 VGND VPWR VPWR VGND sky130_ef_sc_hd__decap_12
XFILLER_6_189 VPWR VGND VPWR VGND sky130_fd_sc_hd__decap_6
X_085_ VGND VPWR VPWR VGND _057_ tap\[63\] Q[0] tap\[62\] sky130_fd_sc_hd__mux2_1
XFILLER_18_274 VPWR VGND VPWR VGND sky130_fd_sc_hd__decap_3
XFILLER_17_15 VGND VPWR VPWR VGND sky130_ef_sc_hd__decap_12
XFILLER_33_69 VGND VPWR VPWR VGND sky130_ef_sc_hd__decap_12
XFILLER_3_137 VGND VPWR VPWR VGND sky130_ef_sc_hd__decap_12
XPHY_EDGE_ROW_4_Left_51 VPWR VGND VPWR VGND sky130_fd_sc_hd__decap_3
XFILLER_15_211 VPWR VGND VPWR VGND sky130_fd_sc_hd__decap_8
X_068_ VGND VPWR VPWR VGND Q[0] _040_ tap\[36\] sky130_fd_sc_hd__and2b_2
XFILLER_17_3 VGND VPWR VPWR VGND sky130_ef_sc_hd__decap_12
Xdelay_chain\[0\].inv_b.core_inv VPWR VGND VGND VPWR d\[0\] tap\[0\] sky130_fd_sc_hd__inv_1
XFILLER_21_225 VPWR VGND VPWR VGND sky130_fd_sc_hd__decap_3
XFILLER_9_93 VGND VPWR VPWR VGND sky130_ef_sc_hd__decap_12
XPHY_EDGE_ROW_46_Left_93 VPWR VGND VPWR VGND sky130_fd_sc_hd__decap_3
XFILLER_20_280 VPWR VGND VPWR VGND sky130_fd_sc_hd__decap_6
XPHY_EDGE_ROW_30_Left_77 VPWR VGND VPWR VGND sky130_fd_sc_hd__decap_3
XFILLER_7_273 VPWR VGND VPWR VGND sky130_fd_sc_hd__decap_6
XFILLER_38_177 VGND VPWR VPWR VGND sky130_ef_sc_hd__decap_12
XFILLER_38_133 VPWR VGND VPWR VGND sky130_fd_sc_hd__decap_6
XFILLER_30_15 VGND VPWR VPWR VGND sky130_ef_sc_hd__decap_12
XFILLER_39_57 VGND VPWR VPWR VGND sky130_ef_sc_hd__decap_12
XFILLER_4_221 VGND VPWR VPWR VGND sky130_ef_sc_hd__decap_12
XFILLER_4_265 VGND VPWR VPWR VGND sky130_ef_sc_hd__decap_12
XFILLER_35_169 VGND VPWR VPWR VGND sky130_ef_sc_hd__decap_12
XFILLER_35_125 VGND VPWR VPWR VGND sky130_ef_sc_hd__decap_12
XFILLER_25_15 VGND VPWR VPWR VGND sky130_ef_sc_hd__decap_12
XFILLER_41_69 VGND VPWR VPWR VGND sky130_ef_sc_hd__decap_12
XFILLER_17_125 VGND VPWR VPWR VGND sky130_ef_sc_hd__decap_12
XFILLER_15_81 VGND VPWR VPWR VGND sky130_ef_sc_hd__decap_12
XPHY_EDGE_ROW_33_Left_80 VPWR VGND VPWR VGND sky130_fd_sc_hd__decap_3
Xdelay_chain\[5\].inv_b.core_inv VPWR VGND VGND VPWR d\[5\] tap\[5\] sky130_fd_sc_hd__inv_1
XFILLER_11_39 VGND VPWR VPWR VGND sky130_ef_sc_hd__decap_12
XFILLER_31_161 VPWR VGND VPWR VGND sky130_fd_sc_hd__decap_6
XFILLER_46_209 VGND VPWR VPWR VGND sky130_ef_sc_hd__decap_12
XFILLER_39_261 VGND VPWR VPWR VGND sky130_ef_sc_hd__decap_12
XFILLER_20_109 VGND VPWR VPWR VGND sky130_ef_sc_hd__decap_12
XFILLER_36_253 VGND VPWR VPWR VGND sky130_ef_sc_hd__decap_12
XFILLER_3_51 VGND VPWR VPWR VGND sky130_fd_sc_hd__decap_4
XFILLER_28_209 VPWR VGND VPWR VGND sky130_fd_sc_hd__decap_8
XFILLER_42_245 VPWR VGND VPWR VGND sky130_fd_sc_hd__decap_6
XFILLER_27_220 VGND VPWR VPWR VGND sky130_fd_sc_hd__decap_4
XPHY_EDGE_ROW_29_Right_29 VPWR VGND VPWR VGND sky130_fd_sc_hd__decap_3
XFILLER_42_289 VPWR VGND VPWR VGND sky130_fd_sc_hd__decap_8
XPHY_EDGE_ROW_38_Right_38 VPWR VGND VPWR VGND sky130_fd_sc_hd__decap_3
XFILLER_8_29 VGND VPWR VPWR VGND sky130_ef_sc_hd__decap_12
XFILLER_10_153 VGND VPWR VPWR VGND sky130_ef_sc_hd__decap_12
XFILLER_10_197 VGND VPWR VPWR VGND sky130_ef_sc_hd__decap_12
X_084_ VGND VPWR VGND VPWR tap\[61\] Q[0] Q[1] _056_ sky130_fd_sc_hd__a21o_2
XFILLER_18_253 VPWR VGND VPWR VGND sky130_fd_sc_hd__decap_6
XFILLER_17_27 VGND VPWR VPWR VGND sky130_ef_sc_hd__decap_12
XFILLER_33_15 VGND VPWR VPWR VGND sky130_ef_sc_hd__decap_12
XFILLER_3_149 VGND VPWR VPWR VGND sky130_ef_sc_hd__decap_12
XFILLER_3_105 VPWR VGND VPWR VGND sky130_fd_sc_hd__decap_6
XFILLER_23_81 VGND VPWR VPWR VGND sky130_ef_sc_hd__decap_12
X_067_ VPWR VGND VPWR VGND _038_ _036_ Q[2] _034_ _039_ sky130_fd_sc_hd__a22o_2
XFILLER_0_41 VGND VPWR VPWR VGND sky130_ef_sc_hd__decap_12
XFILLER_0_85 VGND VPWR VPWR VGND sky130_ef_sc_hd__decap_12
XFILLER_28_15 VGND VPWR VPWR VGND sky130_ef_sc_hd__decap_12
XFILLER_11_281 VGND VPWR VPWR VGND sky130_ef_sc_hd__decap_12
XFILLER_38_189 VPWR VGND VPWR VGND sky130_fd_sc_hd__decap_6
XFILLER_39_69 VGND VPWR VPWR VGND sky130_ef_sc_hd__decap_12
XFILLER_4_233 VGND VPWR VPWR VGND sky130_ef_sc_hd__decap_12
XFILLER_4_277 VGND VPWR VPWR VGND sky130_ef_sc_hd__decap_12
XFILLER_35_137 VGND VPWR VPWR VGND sky130_ef_sc_hd__decap_12
XFILLER_43_181 VGND VPWR VPWR VGND sky130_ef_sc_hd__decap_12
XFILLER_25_27 VGND VPWR VPWR VGND sky130_ef_sc_hd__decap_12
XFILLER_41_15 VGND VPWR VPWR VGND sky130_ef_sc_hd__decap_12
XFILLER_1_225 VGND VPWR VPWR VGND sky130_ef_sc_hd__decap_12
XFILLER_17_137 VGND VPWR VPWR VGND sky130_ef_sc_hd__decap_12
XFILLER_15_93 VGND VPWR VPWR VGND sky130_ef_sc_hd__decap_12
XFILLER_25_181 VGND VPWR VPWR VGND sky130_ef_sc_hd__decap_12
XFILLER_31_81 VGND VPWR VPWR VGND sky130_ef_sc_hd__decap_12
Xdelay_chain\[63\].inv_b.core_inv VPWR VGND VGND VPWR d\[63\] tap\[63\] sky130_fd_sc_hd__inv_1
XFILLER_39_273 VPWR VGND VPWR VGND sky130_fd_sc_hd__decap_6
XFILLER_36_15 VGND VPWR VPWR VGND sky130_ef_sc_hd__decap_12
Xdelay_chain\[16\].genblk1.inv_a.core_inv VPWR VGND VGND VPWR tap\[15\] d\[16\] sky130_fd_sc_hd__inv_1
XFILLER_7_3 VGND VPWR VPWR VGND sky130_ef_sc_hd__decap_12
Xdelay_chain\[25\].genblk1.inv_a.core_inv VPWR VGND VGND VPWR tap\[24\] d\[25\] sky130_fd_sc_hd__inv_1
XFILLER_36_265 VGND VPWR VPWR VGND sky130_ef_sc_hd__decap_12
XFILLER_36_221 VGND VPWR VPWR VGND sky130_ef_sc_hd__decap_12
Xdelay_chain\[34\].genblk1.inv_a.core_inv VPWR VGND VGND VPWR tap\[33\] d\[34\] sky130_fd_sc_hd__inv_1
XFILLER_10_121 VGND VPWR VPWR VGND sky130_ef_sc_hd__decap_12
XFILLER_10_165 VGND VPWR VPWR VGND sky130_ef_sc_hd__decap_12
X_083_ VGND VPWR VPWR VGND Q[0] _055_ tap\[60\] sky130_fd_sc_hd__and2b_2
Xdelay_chain\[43\].genblk1.inv_a.core_inv VPWR VGND VGND VPWR tap\[42\] d\[43\] sky130_fd_sc_hd__inv_1
Xdelay_chain\[52\].genblk1.inv_a.core_inv VPWR VGND VGND VPWR tap\[51\] d\[52\] sky130_fd_sc_hd__inv_1
XFILLER_17_39 VGND VPWR VPWR VGND sky130_ef_sc_hd__decap_12
XFILLER_24_224 VPWR VGND VPWR VGND sky130_fd_sc_hd__decap_3
XFILLER_24_268 VPWR VGND VPWR VGND sky130_fd_sc_hd__decap_8
XFILLER_33_27 VGND VPWR VPWR VGND sky130_ef_sc_hd__decap_12
Xdelay_chain\[61\].genblk1.inv_a.core_inv VPWR VGND VGND VPWR tap\[60\] d\[61\] sky130_fd_sc_hd__inv_1
X_066_ VGND VPWR VGND VPWR _038_ _031_ _037_ _030_ sky130_fd_sc_hd__o21a_2
XFILLER_23_93 VGND VPWR VPWR VGND sky130_ef_sc_hd__decap_12
XFILLER_0_53 VPWR VGND VPWR VGND sky130_fd_sc_hd__decap_3
XFILLER_0_97 VGND VPWR VPWR VGND sky130_ef_sc_hd__decap_12
XFILLER_9_51 VGND VPWR VPWR VGND sky130_fd_sc_hd__decap_4
XFILLER_0_109 VPWR VGND VPWR VGND sky130_fd_sc_hd__decap_3
XFILLER_44_15 VGND VPWR VPWR VGND sky130_ef_sc_hd__decap_12
XFILLER_8_209 VGND VPWR VPWR VGND sky130_ef_sc_hd__decap_12
XFILLER_11_293 VPWR VGND VPWR VGND sky130_fd_sc_hd__decap_6
XFILLER_22_3 VGND VPWR VPWR VGND sky130_ef_sc_hd__decap_12
XFILLER_14_29 VGND VPWR VPWR VGND sky130_ef_sc_hd__decap_12
XFILLER_39_15 VGND VPWR VPWR VGND sky130_ef_sc_hd__decap_12
XFILLER_29_113 VGND VPWR VPWR VGND sky130_ef_sc_hd__decap_12
XFILLER_4_289 VPWR VGND VPWR VGND sky130_fd_sc_hd__decap_8
XFILLER_4_245 VPWR VGND VPWR VGND sky130_fd_sc_hd__decap_6
Xdelay_chain\[54\].inv_b.core_inv VPWR VGND VGND VPWR d\[54\] tap\[54\] sky130_fd_sc_hd__inv_1
XFILLER_29_81 VGND VPWR VPWR VGND sky130_ef_sc_hd__decap_12
XFILLER_43_193 VGND VPWR VPWR VGND sky130_ef_sc_hd__decap_12
XFILLER_35_149 VGND VPWR VPWR VGND sky130_ef_sc_hd__decap_12
XFILLER_35_105 VPWR VGND VPWR VGND sky130_fd_sc_hd__decap_6
XFILLER_6_41 VGND VPWR VPWR VGND sky130_ef_sc_hd__decap_12
XFILLER_6_85 VGND VPWR VPWR VGND sky130_ef_sc_hd__decap_12
XFILLER_41_27 VGND VPWR VPWR VGND sky130_ef_sc_hd__decap_12
XFILLER_25_39 VGND VPWR VPWR VGND sky130_ef_sc_hd__decap_12
XFILLER_1_237 VGND VPWR VPWR VGND sky130_ef_sc_hd__decap_12
XFILLER_17_105 VPWR VGND VPWR VGND sky130_fd_sc_hd__decap_6
XFILLER_17_149 VGND VPWR VPWR VGND sky130_ef_sc_hd__decap_12
XFILLER_40_141 VGND VPWR VPWR VGND sky130_ef_sc_hd__decap_12
XFILLER_31_93 VGND VPWR VPWR VGND sky130_ef_sc_hd__decap_12
XFILLER_0_281 VGND VPWR VPWR VGND sky130_ef_sc_hd__decap_12
Xdelay_chain\[40\].inv_b.core_inv VPWR VGND VGND VPWR d\[40\] tap\[40\] sky130_fd_sc_hd__inv_1
XFILLER_22_141 VGND VPWR VPWR VGND sky130_ef_sc_hd__decap_12
XFILLER_36_277 VGND VPWR VPWR VGND sky130_ef_sc_hd__decap_12
XFILLER_36_233 VGND VPWR VPWR VGND sky130_ef_sc_hd__decap_12
XFILLER_22_29 VGND VPWR VPWR VGND sky130_ef_sc_hd__decap_12
XFILLER_10_133 VPWR VGND VPWR VGND sky130_fd_sc_hd__decap_6
XFILLER_10_177 VGND VPWR VPWR VGND sky130_ef_sc_hd__decap_12
X_082_ VGND VPWR VGND VPWR _053_ _049_ Q[3] _054_ sky130_fd_sc_hd__o21ba_2
Xdelay_chain\[59\].inv_b.core_inv VPWR VGND VGND VPWR d\[59\] tap\[59\] sky130_fd_sc_hd__inv_1
XFILLER_37_81 VGND VPWR VPWR VGND sky130_ef_sc_hd__decap_12
XFILLER_33_225 VGND VPWR VPWR VGND sky130_ef_sc_hd__decap_12
XFILLER_5_181 VGND VPWR VPWR VGND sky130_ef_sc_hd__decap_12
XFILLER_33_39 VGND VPWR VPWR VGND sky130_ef_sc_hd__decap_12
XFILLER_15_236 VPWR VGND VPWR VGND sky130_fd_sc_hd__decap_6
X_065_ VGND VPWR VPWR VGND _037_ tap\[43\] Q[0] tap\[42\] sky130_fd_sc_hd__mux2_1
XFILLER_2_162 VGND VPWR VPWR VGND sky130_ef_sc_hd__decap_12
Xdelay_chain\[45\].inv_b.core_inv VPWR VGND VGND VPWR d\[45\] tap\[45\] sky130_fd_sc_hd__inv_1
XPHY_EDGE_ROW_8_Left_55 VPWR VGND VPWR VGND sky130_fd_sc_hd__decap_3
XFILLER_11_261 VGND VPWR VPWR VGND sky130_ef_sc_hd__decap_12
XFILLER_15_3 VGND VPWR VPWR VGND sky130_ef_sc_hd__decap_12
XFILLER_30_29 VGND VPWR VPWR VGND sky130_ef_sc_hd__decap_12
XFILLER_39_27 VGND VPWR VPWR VGND sky130_ef_sc_hd__decap_12
XFILLER_29_125 VGND VPWR VPWR VGND sky130_ef_sc_hd__decap_12
XFILLER_29_169 VGND VPWR VPWR VGND sky130_ef_sc_hd__decap_12
XFILLER_29_93 VGND VPWR VPWR VGND sky130_ef_sc_hd__decap_12
XFILLER_45_81 VGND VPWR VPWR VGND sky130_ef_sc_hd__decap_12
XFILLER_43_161 VPWR VGND VPWR VGND sky130_fd_sc_hd__decap_6
Xdelay_chain\[9\].genblk1.inv_a.core_inv VPWR VGND VGND VPWR tap\[8\] d\[9\] sky130_fd_sc_hd__inv_1
Xdelay_chain\[31\].inv_b.core_inv VPWR VGND VGND VPWR d\[31\] tap\[31\] sky130_fd_sc_hd__inv_1
XFILLER_6_53 VGND VPWR VPWR VGND sky130_ef_sc_hd__decap_12
XFILLER_6_97 VGND VPWR VPWR VGND sky130_ef_sc_hd__decap_12
XFILLER_41_39 VGND VPWR VPWR VGND sky130_ef_sc_hd__decap_12
XFILLER_1_205 VGND VPWR VPWR VGND sky130_ef_sc_hd__decap_12
XFILLER_1_249 VGND VPWR VPWR VGND sky130_ef_sc_hd__decap_12
XFILLER_40_153 VGND VPWR VPWR VGND sky130_ef_sc_hd__decap_12
XFILLER_15_51 VGND VPWR VPWR VGND sky130_fd_sc_hd__decap_4
XFILLER_25_161 VPWR VGND VPWR VGND sky130_fd_sc_hd__decap_6
XFILLER_32_109 VGND VPWR VPWR VGND sky130_ef_sc_hd__decap_12
XFILLER_40_197 VGND VPWR VPWR VGND sky130_ef_sc_hd__decap_12
XFILLER_0_293 VPWR VGND VPWR VGND sky130_fd_sc_hd__decap_6
XFILLER_14_109 VGND VPWR VPWR VGND sky130_ef_sc_hd__decap_12
XFILLER_22_153 VGND VPWR VPWR VGND sky130_ef_sc_hd__decap_12
XPHY_EDGE_ROW_37_Left_84 VPWR VGND VPWR VGND sky130_fd_sc_hd__decap_3
XFILLER_9_113 VGND VPWR VPWR VGND sky130_ef_sc_hd__decap_12
XPHY_EDGE_ROW_21_Left_68 VPWR VGND VPWR VGND sky130_fd_sc_hd__decap_3
XFILLER_36_289 VPWR VGND VPWR VGND sky130_fd_sc_hd__decap_8
XFILLER_36_245 VPWR VGND VPWR VGND sky130_fd_sc_hd__decap_6
XFILLER_10_189 VPWR VGND VPWR VGND sky130_fd_sc_hd__decap_6
XFILLER_12_41 VGND VPWR VPWR VGND sky130_ef_sc_hd__decap_12
XFILLER_12_85 VGND VPWR VPWR VGND sky130_ef_sc_hd__decap_12
X_081_ VPWR VGND VGND VPWR _052_ _030_ _051_ _050_ _053_ _031_ sky130_fd_sc_hd__o221a_2
Xdelay_chain\[36\].inv_b.core_inv VPWR VGND VGND VPWR d\[36\] tap\[36\] sky130_fd_sc_hd__inv_1
XFILLER_37_93 VGND VPWR VPWR VGND sky130_ef_sc_hd__decap_12
XPHY_EDGE_ROW_16_Right_16 VPWR VGND VPWR VGND sky130_fd_sc_hd__decap_3
XFILLER_18_212 VPWR VGND VPWR VGND sky130_fd_sc_hd__decap_8
XFILLER_33_237 VGND VPWR VPWR VGND sky130_ef_sc_hd__decap_12
XFILLER_41_281 VGND VPWR VPWR VGND sky130_ef_sc_hd__decap_12
XPHY_EDGE_ROW_25_Right_25 VPWR VGND VPWR VGND sky130_fd_sc_hd__decap_3
XFILLER_45_3 VGND VPWR VPWR VGND sky130_ef_sc_hd__decap_12
XFILLER_5_193 VGND VPWR VPWR VGND sky130_ef_sc_hd__decap_12
XPHY_EDGE_ROW_34_Right_34 VPWR VGND VPWR VGND sky130_fd_sc_hd__decap_3
XPHY_EDGE_ROW_43_Right_43 VPWR VGND VPWR VGND sky130_fd_sc_hd__decap_3
XFILLER_23_51 VGND VPWR VPWR VGND sky130_fd_sc_hd__decap_4
XFILLER_23_281 VPWR VGND VPWR VGND sky130_fd_sc_hd__decap_3
XFILLER_2_174 VGND VPWR VPWR VGND sky130_ef_sc_hd__decap_12
XFILLER_2_141 VGND VPWR VPWR VGND sky130_ef_sc_hd__decap_12
X_064_ VPWR VGND VPWR VGND _036_ Q[1] _035_ sky130_fd_sc_hd__or2_2
XPHY_EDGE_ROW_24_Left_71 VPWR VGND VPWR VGND sky130_fd_sc_hd__decap_3
XFILLER_28_29 VGND VPWR VPWR VGND sky130_ef_sc_hd__decap_12
Xdelay_chain\[22\].inv_b.core_inv VPWR VGND VGND VPWR d\[22\] tap\[22\] sky130_fd_sc_hd__inv_1
XFILLER_11_273 VPWR VGND VPWR VGND sky130_fd_sc_hd__decap_6
X_116_ VPWR VGND VPWR VGND _033_ _029_ _047_ _004_ Y sky130_fd_sc_hd__a22o_2
XFILLER_46_181 VGND VPWR VPWR VGND sky130_ef_sc_hd__decap_12
XFILLER_39_39 VGND VPWR VPWR VGND sky130_ef_sc_hd__decap_12
XPHY_EDGE_ROW_2_Right_2 VPWR VGND VPWR VGND sky130_fd_sc_hd__decap_3
XFILLER_29_137 VGND VPWR VPWR VGND sky130_ef_sc_hd__decap_12
XFILLER_37_181 VGND VPWR VPWR VGND sky130_ef_sc_hd__decap_12
XFILLER_20_41 VGND VPWR VPWR VGND sky130_ef_sc_hd__decap_12
XFILLER_20_85 VGND VPWR VPWR VGND sky130_ef_sc_hd__decap_12
XFILLER_45_93 VGND VPWR VPWR VGND sky130_ef_sc_hd__decap_12
XFILLER_6_65 VGND VPWR VPWR VGND sky130_ef_sc_hd__decap_12
XFILLER_19_181 VGND VPWR VPWR VGND sky130_ef_sc_hd__decap_12
XFILLER_1_217 VPWR VGND VPWR VGND sky130_fd_sc_hd__decap_6
XFILLER_40_165 VGND VPWR VPWR VGND sky130_ef_sc_hd__decap_12
XFILLER_40_121 VGND VPWR VPWR VGND sky130_ef_sc_hd__decap_12
XFILLER_31_51 VGND VPWR VPWR VGND sky130_fd_sc_hd__decap_4
XFILLER_36_29 VGND VPWR VPWR VGND sky130_ef_sc_hd__decap_12
Xdelay_chain\[27\].inv_b.core_inv VPWR VGND VGND VPWR d\[27\] tap\[27\] sky130_fd_sc_hd__inv_1
XFILLER_22_121 VGND VPWR VPWR VGND sky130_ef_sc_hd__decap_12
XFILLER_22_165 VGND VPWR VPWR VGND sky130_fd_sc_hd__decap_4
XFILLER_9_169 VGND VPWR VPWR VGND sky130_ef_sc_hd__decap_12
XFILLER_9_125 VGND VPWR VPWR VGND sky130_ef_sc_hd__decap_12
XFILLER_13_165 VPWR VGND VPWR VGND sky130_fd_sc_hd__decap_3
X_080_ VGND VPWR VPWR VGND _052_ tap\[51\] Q[0] tap\[50\] sky130_fd_sc_hd__mux2_1
XFILLER_5_3 VGND VPWR VPWR VGND sky130_ef_sc_hd__decap_12
XFILLER_12_53 VGND VPWR VPWR VGND sky130_ef_sc_hd__decap_12
XFILLER_12_97 VGND VPWR VPWR VGND sky130_ef_sc_hd__decap_12
XFILLER_18_246 VPWR VGND VPWR VGND sky130_fd_sc_hd__decap_6
XFILLER_33_205 VGND VPWR VPWR VGND sky130_ef_sc_hd__decap_12
XFILLER_33_249 VGND VPWR VPWR VGND sky130_ef_sc_hd__decap_12
XFILLER_41_293 VPWR VGND VPWR VGND sky130_fd_sc_hd__decap_6
Xdelay_chain\[13\].inv_b.core_inv VPWR VGND VGND VPWR d\[13\] tap\[13\] sky130_fd_sc_hd__inv_1
XFILLER_38_3 VGND VPWR VPWR VGND sky130_ef_sc_hd__decap_12
XFILLER_5_161 VPWR VGND VPWR VGND sky130_fd_sc_hd__decap_6
X_063_ VGND VPWR VPWR VGND _035_ tap\[41\] Q[0] tap\[40\] sky130_fd_sc_hd__mux2_1
XFILLER_2_197 VGND VPWR VPWR VGND sky130_ef_sc_hd__decap_12
XFILLER_2_186 VPWR VGND VPWR VGND sky130_fd_sc_hd__decap_8
XFILLER_2_153 VPWR VGND VPWR VGND sky130_fd_sc_hd__decap_6
XFILLER_14_260 VGND VPWR VPWR VGND sky130_ef_sc_hd__decap_12
XFILLER_44_29 VGND VPWR VPWR VGND sky130_ef_sc_hd__decap_12
XFILLER_18_41 VGND VPWR VPWR VGND sky130_ef_sc_hd__decap_12
XFILLER_18_85 VGND VPWR VPWR VGND sky130_ef_sc_hd__decap_12
X_115_ VGND VPWR VGND VPWR Q[4] _010_ _022_ Q[3] _028_ _016_ _029_ sky130_fd_sc_hd__mux4_2
XFILLER_46_193 VPWR VGND VPWR VGND sky130_fd_sc_hd__decap_3
XFILLER_29_105 VPWR VGND VPWR VGND sky130_fd_sc_hd__decap_6
XFILLER_29_149 VGND VPWR VPWR VGND sky130_ef_sc_hd__decap_12
XFILLER_37_193 VGND VPWR VPWR VGND sky130_ef_sc_hd__decap_12
XFILLER_20_53 VGND VPWR VPWR VGND sky130_ef_sc_hd__decap_12
XFILLER_20_97 VGND VPWR VPWR VGND sky130_ef_sc_hd__decap_12
XFILLER_29_51 VGND VPWR VPWR VGND sky130_fd_sc_hd__decap_4
Xdelay_chain\[18\].inv_b.core_inv VPWR VGND VGND VPWR d\[18\] tap\[18\] sky130_fd_sc_hd__inv_1
XFILLER_6_77 VPWR VGND VPWR VGND sky130_fd_sc_hd__decap_6
XFILLER_3_281 VGND VPWR VPWR VGND sky130_ef_sc_hd__decap_12
XFILLER_20_3 VGND VPWR VPWR VGND sky130_ef_sc_hd__decap_12
XFILLER_19_193 VGND VPWR VPWR VGND sky130_fd_sc_hd__decap_4
XFILLER_34_141 VGND VPWR VPWR VGND sky130_ef_sc_hd__decap_12
XFILLER_40_177 VGND VPWR VPWR VGND sky130_ef_sc_hd__decap_12
XFILLER_40_133 VPWR VGND VPWR VGND sky130_fd_sc_hd__decap_6
XFILLER_25_196 VGND VPWR VPWR VGND sky130_ef_sc_hd__decap_12
XFILLER_16_141 VGND VPWR VPWR VGND sky130_ef_sc_hd__decap_12
Xdelay_chain\[19\].genblk1.inv_a.core_inv VPWR VGND VGND VPWR tap\[18\] d\[19\] sky130_fd_sc_hd__inv_1
.ends
