.param VDD=1.8 VIN=0.9 Ton=5n Tperiod=10n NFT=10 WT=4.2 LT=0.15 NF1=10 W1=4.2 L1=0.15 NF2=10 W2=4.2 L2=0.15 NF3=4 W3=1.68 L3=0.15 NF4=6 W4=2.52 L4=0.15 NF5=12 W5=5.04 L5=0.15 NF6=4 W6=1.68 L6=0.15 NF7=10 W7=4.2 L7=0.15
