* NGSPICE file created from inv_dcdl_glitchless.ext - technology: sky130A

.subckt sky130_fd_sc_hd__inv_1 VPB VNB VGND VPWR A Y
X0 Y A VGND VNB sky130_fd_pr__nfet_01v8 ad=0.169 pd=1.82 as=0.169 ps=1.82 w=0.65 l=0.15
X1 Y A VPWR VPB sky130_fd_pr__pfet_01v8_hvt ad=0.26 pd=2.52 as=0.26 ps=2.52 w=1 l=0.15
.ends

.subckt sky130_ef_sc_hd__decap_12 VGND VPWR VPB VNB
X0 VPWR VGND VPWR VPB sky130_fd_pr__pfet_01v8_hvt ad=0.2262 pd=2.26 as=0 ps=0 w=0.87 l=4.73
X1 VGND VPWR VGND VNB sky130_fd_pr__nfet_01v8 ad=0.143 pd=1.62 as=0 ps=0 w=0.55 l=4.73
.ends

.subckt sky130_fd_sc_hd__decap_3 VPWR VGND VPB VNB
X0 VPWR VGND VPWR VPB sky130_fd_pr__pfet_01v8_hvt ad=0.2262 pd=2.26 as=0 ps=0 w=0.87 l=0.59
X1 VGND VPWR VGND VNB sky130_fd_pr__nfet_01v8 ad=0.143 pd=1.62 as=0 ps=0 w=0.55 l=0.59
.ends

.subckt sky130_fd_sc_hd__inv_2 VPB VNB VPWR VGND Y A
X0 Y A VPWR VPB sky130_fd_pr__pfet_01v8_hvt ad=0.135 pd=1.27 as=0.26 ps=2.52 w=1 l=0.15
X1 VGND A Y VNB sky130_fd_pr__nfet_01v8 ad=0.169 pd=1.82 as=0.08775 ps=0.92 w=0.65 l=0.15
X2 Y A VGND VNB sky130_fd_pr__nfet_01v8 ad=0.08775 pd=0.92 as=0.169 ps=1.82 w=0.65 l=0.15
X3 VPWR A Y VPB sky130_fd_pr__pfet_01v8_hvt ad=0.26 pd=2.52 as=0.135 ps=1.27 w=1 l=0.15
.ends

.subckt sky130_fd_sc_hd__dfrtp_2 VGND VPWR VPB VNB CLK D RESET_B Q
X0 a_805_47# a_761_289# a_639_47# VNB sky130_fd_pr__nfet_01v8 ad=0.0441 pd=0.63 as=0.1401 ps=1.1 w=0.42 l=0.15
X1 a_1217_47# a_27_47# a_1108_47# VNB sky130_fd_pr__special_nfet_01v8 ad=0.0669 pd=0.75 as=0.0711 ps=0.755 w=0.36 l=0.15
X2 VGND a_1283_21# Q VNB sky130_fd_pr__nfet_01v8 ad=0.169 pd=1.82 as=0.08775 ps=0.92 w=0.65 l=0.15
X3 a_1283_21# a_1108_47# a_1462_47# VNB sky130_fd_pr__nfet_01v8 ad=0.1092 pd=1.36 as=0.06405 ps=0.725 w=0.42 l=0.15
X4 a_651_413# a_27_47# a_543_47# VPB sky130_fd_pr__pfet_01v8_hvt ad=0.1155 pd=0.97 as=0.07245 ps=0.765 w=0.42 l=0.15
X5 VPWR a_1283_21# Q VPB sky130_fd_pr__pfet_01v8_hvt ad=0.26 pd=2.52 as=0.135 ps=1.27 w=1 l=0.15
X6 a_1108_47# a_193_47# a_761_289# VNB sky130_fd_pr__special_nfet_01v8 ad=0.0711 pd=0.755 as=0.0999 ps=0.985 w=0.36 l=0.15
X7 VGND RESET_B a_805_47# VNB sky130_fd_pr__nfet_01v8 ad=0.1346 pd=1.15 as=0.0441 ps=0.63 w=0.42 l=0.15
X8 Q a_1283_21# VPWR VPB sky130_fd_pr__pfet_01v8_hvt ad=0.135 pd=1.27 as=0.3012 ps=2.66 w=1 l=0.15
X9 VPWR CLK a_27_47# VPB sky130_fd_pr__pfet_01v8_hvt ad=0.0864 pd=0.91 as=0.1664 ps=1.8 w=0.64 l=0.15
X10 a_448_47# D VPWR VPB sky130_fd_pr__pfet_01v8_hvt ad=0.0651 pd=0.73 as=0.1092 ps=1.36 w=0.42 l=0.15
X11 a_761_289# a_543_47# VGND VNB sky130_fd_pr__nfet_01v8 ad=0.0999 pd=0.985 as=0.1346 ps=1.15 w=0.64 l=0.15
X12 a_193_47# a_27_47# VGND VNB sky130_fd_pr__nfet_01v8 ad=0.1092 pd=1.36 as=0.0567 ps=0.69 w=0.42 l=0.15
X13 a_1108_47# a_27_47# a_761_289# VPB sky130_fd_pr__pfet_01v8_hvt ad=0.0588 pd=0.7 as=0.12915 ps=1.185 w=0.42 l=0.15
X14 a_1462_47# RESET_B VGND VNB sky130_fd_pr__nfet_01v8 ad=0.06405 pd=0.725 as=0.12495 ps=1.015 w=0.42 l=0.15
X15 a_543_47# a_27_47# a_448_47# VNB sky130_fd_pr__special_nfet_01v8 ad=0.0594 pd=0.69 as=0.066 ps=0.745 w=0.36 l=0.15
X16 a_543_47# a_193_47# a_448_47# VPB sky130_fd_pr__pfet_01v8_hvt ad=0.07245 pd=0.765 as=0.0651 ps=0.73 w=0.42 l=0.15
X17 a_448_47# D VGND VNB sky130_fd_pr__nfet_01v8 ad=0.066 pd=0.745 as=0.2205 ps=1.89 w=0.42 l=0.15
X18 VPWR a_1283_21# a_1270_413# VPB sky130_fd_pr__pfet_01v8_hvt ad=0.0819 pd=0.81 as=0.0567 ps=0.69 w=0.42 l=0.15
X19 VPWR a_1108_47# a_1283_21# VPB sky130_fd_pr__pfet_01v8_hvt ad=0.1134 pd=1.38 as=0.0567 ps=0.69 w=0.42 l=0.15
X20 a_1270_413# a_193_47# a_1108_47# VPB sky130_fd_pr__pfet_01v8_hvt ad=0.0567 pd=0.69 as=0.0588 ps=0.7 w=0.42 l=0.15
X21 a_193_47# a_27_47# VPWR VPB sky130_fd_pr__pfet_01v8_hvt ad=0.1664 pd=1.8 as=0.0864 ps=0.91 w=0.64 l=0.15
X22 a_1283_21# RESET_B VPWR VPB sky130_fd_pr__pfet_01v8_hvt ad=0.0567 pd=0.69 as=0.0819 ps=0.81 w=0.42 l=0.15
X23 VPWR a_761_289# a_651_413# VPB sky130_fd_pr__pfet_01v8_hvt ad=0.07035 pd=0.755 as=0.1155 ps=0.97 w=0.42 l=0.15
X24 Q a_1283_21# VGND VNB sky130_fd_pr__nfet_01v8 ad=0.08775 pd=0.92 as=0.2087 ps=2.02 w=0.65 l=0.15
X25 a_639_47# a_193_47# a_543_47# VNB sky130_fd_pr__special_nfet_01v8 ad=0.1401 pd=1.1 as=0.0594 ps=0.69 w=0.36 l=0.15
X26 VGND a_1283_21# a_1217_47# VNB sky130_fd_pr__nfet_01v8 ad=0.12495 pd=1.015 as=0.0669 ps=0.75 w=0.42 l=0.15
X27 a_651_413# RESET_B VPWR VPB sky130_fd_pr__pfet_01v8_hvt ad=0.1092 pd=1.36 as=0.07035 ps=0.755 w=0.42 l=0.15
X28 VGND CLK a_27_47# VNB sky130_fd_pr__nfet_01v8 ad=0.0567 pd=0.69 as=0.1092 ps=1.36 w=0.42 l=0.15
X29 a_761_289# a_543_47# VPWR VPB sky130_fd_pr__pfet_01v8_hvt ad=0.12915 pd=1.185 as=0.2184 ps=2.2 w=0.84 l=0.15
.ends

.subckt sky130_fd_sc_hd__decap_6 VPWR VGND VPB VNB
X0 VPWR VGND VPWR VPB sky130_fd_pr__pfet_01v8_hvt ad=0.2262 pd=2.26 as=0 ps=0 w=0.87 l=1.97
X1 VGND VPWR VGND VNB sky130_fd_pr__nfet_01v8 ad=0.143 pd=1.62 as=0 ps=0 w=0.55 l=1.97
.ends

.subckt sky130_fd_sc_hd__and3b_2 VGND VPWR VNB VPB X C B A_N
X0 a_109_53# A_N VPWR VPB sky130_fd_pr__pfet_01v8_hvt ad=0.1092 pd=1.36 as=0.1092 ps=1.36 w=0.42 l=0.15
X1 X a_215_311# VGND VNB sky130_fd_pr__nfet_01v8 ad=0.08775 pd=0.92 as=0.12715 ps=1.095 w=0.65 l=0.15
X2 a_109_53# A_N VGND VNB sky130_fd_pr__nfet_01v8 ad=0.1176 pd=1.4 as=0.1092 ps=1.36 w=0.42 l=0.15
X3 VGND C a_373_53# VNB sky130_fd_pr__nfet_01v8 ad=0.12715 pd=1.095 as=0.05355 ps=0.675 w=0.42 l=0.15
X4 VGND a_215_311# X VNB sky130_fd_pr__nfet_01v8 ad=0.169 pd=1.82 as=0.08775 ps=0.92 w=0.65 l=0.15
X5 VPWR C a_215_311# VPB sky130_fd_pr__pfet_01v8_hvt ad=0.14575 pd=1.335 as=0.074375 ps=0.815 w=0.42 l=0.15
X6 VPWR a_215_311# X VPB sky130_fd_pr__pfet_01v8_hvt ad=0.26 pd=2.52 as=0.135 ps=1.27 w=1 l=0.15
X7 X a_215_311# VPWR VPB sky130_fd_pr__pfet_01v8_hvt ad=0.135 pd=1.27 as=0.14575 ps=1.335 w=1 l=0.15
X8 a_301_53# a_109_53# a_215_311# VNB sky130_fd_pr__nfet_01v8 ad=0.0441 pd=0.63 as=0.1092 ps=1.36 w=0.42 l=0.15
X9 a_215_311# B VPWR VPB sky130_fd_pr__pfet_01v8_hvt ad=0.074375 pd=0.815 as=0.0567 ps=0.69 w=0.42 l=0.15
X10 a_373_53# B a_301_53# VNB sky130_fd_pr__nfet_01v8 ad=0.05355 pd=0.675 as=0.0441 ps=0.63 w=0.42 l=0.15
X11 VPWR a_109_53# a_215_311# VPB sky130_fd_pr__pfet_01v8_hvt ad=0.0567 pd=0.69 as=0.1092 ps=1.36 w=0.42 l=0.15
.ends

.subckt sky130_fd_sc_hd__decap_4 VGND VPWR VPB VNB
X0 VPWR VGND VPWR VPB sky130_fd_pr__pfet_01v8_hvt ad=0.2262 pd=2.26 as=0 ps=0 w=0.87 l=1.05
X1 VGND VPWR VGND VNB sky130_fd_pr__nfet_01v8 ad=0.143 pd=1.62 as=0 ps=0 w=0.55 l=1.05
.ends

.subckt sky130_fd_sc_hd__and2_2 VPWR VGND A X B VPB VNB
X0 X a_61_75# VPWR VPB sky130_fd_pr__pfet_01v8_hvt ad=0.195 pd=1.39 as=0.16655 ps=1.39 w=1 l=0.15
X1 VPWR a_61_75# X VPB sky130_fd_pr__pfet_01v8_hvt ad=0.38 pd=2.76 as=0.195 ps=1.39 w=1 l=0.15
X2 VPWR B a_61_75# VPB sky130_fd_pr__pfet_01v8_hvt ad=0.16655 pd=1.39 as=0.0567 ps=0.69 w=0.42 l=0.15
X3 VGND B a_147_75# VNB sky130_fd_pr__nfet_01v8 ad=0.1118 pd=1.04 as=0.0567 ps=0.69 w=0.42 l=0.15
X4 X a_61_75# VGND VNB sky130_fd_pr__nfet_01v8 ad=0.12675 pd=1.04 as=0.1118 ps=1.04 w=0.65 l=0.15
X5 VGND a_61_75# X VNB sky130_fd_pr__nfet_01v8 ad=0.247 pd=2.06 as=0.12675 ps=1.04 w=0.65 l=0.15
X6 a_61_75# A VPWR VPB sky130_fd_pr__pfet_01v8_hvt ad=0.0567 pd=0.69 as=0.1176 ps=1.4 w=0.42 l=0.15
X7 a_147_75# A a_61_75# VNB sky130_fd_pr__nfet_01v8 ad=0.0567 pd=0.69 as=0.1176 ps=1.4 w=0.42 l=0.15
.ends

.subckt sky130_fd_sc_hd__nand2b_2 VNB VPB VGND VPWR A_N Y B
X0 Y B VPWR VPB sky130_fd_pr__pfet_01v8_hvt ad=0.135 pd=1.27 as=0.335 ps=1.67 w=1 l=0.15
X1 VGND A_N a_27_93# VNB sky130_fd_pr__nfet_01v8 ad=0.194 pd=1.95 as=0.1092 ps=1.36 w=0.42 l=0.15
X2 VGND B a_229_47# VNB sky130_fd_pr__nfet_01v8 ad=0.08775 pd=0.92 as=0.08775 ps=0.92 w=0.65 l=0.15
X3 Y a_27_93# a_229_47# VNB sky130_fd_pr__nfet_01v8 ad=0.08775 pd=0.92 as=0.169 ps=1.82 w=0.65 l=0.15
X4 a_229_47# a_27_93# Y VNB sky130_fd_pr__nfet_01v8 ad=0.08775 pd=0.92 as=0.08775 ps=0.92 w=0.65 l=0.15
X5 Y a_27_93# VPWR VPB sky130_fd_pr__pfet_01v8_hvt ad=0.165 pd=1.33 as=0.1468 ps=1.34 w=1 l=0.15
X6 VPWR a_27_93# Y VPB sky130_fd_pr__pfet_01v8_hvt ad=0.335 pd=1.67 as=0.165 ps=1.33 w=1 l=0.15
X7 VPWR B Y VPB sky130_fd_pr__pfet_01v8_hvt ad=0.275 pd=2.55 as=0.135 ps=1.27 w=1 l=0.15
X8 a_229_47# B VGND VNB sky130_fd_pr__nfet_01v8 ad=0.169 pd=1.82 as=0.08775 ps=0.92 w=0.65 l=0.15
X9 VPWR A_N a_27_93# VPB sky130_fd_pr__pfet_01v8_hvt ad=0.1468 pd=1.34 as=0.1092 ps=1.36 w=0.42 l=0.15
.ends

.subckt sky130_fd_sc_hd__decap_8 VPWR VGND VPB VNB
X0 VPWR VGND VPWR VPB sky130_fd_pr__pfet_01v8_hvt ad=0.2262 pd=2.26 as=0 ps=0 w=0.87 l=2.89
X1 VGND VPWR VGND VNB sky130_fd_pr__nfet_01v8 ad=0.143 pd=1.62 as=0 ps=0 w=0.55 l=2.89
.ends

.subckt sky130_fd_sc_hd__and3_2 B X A C VPWR VGND VPB VNB
X0 VPWR a_29_311# X VPB sky130_fd_pr__pfet_01v8_hvt ad=0.26 pd=2.52 as=0.135 ps=1.27 w=1 l=0.15
X1 X a_29_311# VPWR VPB sky130_fd_pr__pfet_01v8_hvt ad=0.135 pd=1.27 as=0.15075 ps=1.345 w=1 l=0.15
X2 VPWR A a_29_311# VPB sky130_fd_pr__pfet_01v8_hvt ad=0.0567 pd=0.69 as=0.1092 ps=1.36 w=0.42 l=0.15
X3 VGND a_29_311# X VNB sky130_fd_pr__nfet_01v8 ad=0.17875 pd=1.85 as=0.08775 ps=0.92 w=0.65 l=0.15
X4 a_184_53# B a_112_53# VNB sky130_fd_pr__nfet_01v8 ad=0.05355 pd=0.675 as=0.0441 ps=0.63 w=0.42 l=0.15
X5 VPWR C a_29_311# VPB sky130_fd_pr__pfet_01v8_hvt ad=0.15075 pd=1.345 as=0.074375 ps=0.815 w=0.42 l=0.15
X6 X a_29_311# VGND VNB sky130_fd_pr__nfet_01v8 ad=0.08775 pd=0.92 as=0.1304 ps=1.105 w=0.65 l=0.15
X7 a_112_53# A a_29_311# VNB sky130_fd_pr__nfet_01v8 ad=0.0441 pd=0.63 as=0.1092 ps=1.36 w=0.42 l=0.15
X8 a_29_311# B VPWR VPB sky130_fd_pr__pfet_01v8_hvt ad=0.074375 pd=0.815 as=0.0567 ps=0.69 w=0.42 l=0.15
X9 VGND C a_184_53# VNB sky130_fd_pr__nfet_01v8 ad=0.1304 pd=1.105 as=0.05355 ps=0.675 w=0.42 l=0.15
.ends

.subckt sky130_fd_sc_hd__and2b_2 VNB VPB VPWR VGND A_N X B
X0 VPWR a_212_413# X VPB sky130_fd_pr__pfet_01v8_hvt ad=0.26 pd=2.52 as=0.135 ps=1.27 w=1 l=0.15
X1 a_297_47# a_27_413# a_212_413# VNB sky130_fd_pr__nfet_01v8 ad=0.0567 pd=0.69 as=0.1092 ps=1.36 w=0.42 l=0.15
X2 X a_212_413# VPWR VPB sky130_fd_pr__pfet_01v8_hvt ad=0.135 pd=1.27 as=0.22895 ps=1.745 w=1 l=0.15
X3 X a_212_413# VGND VNB sky130_fd_pr__nfet_01v8 ad=0.08775 pd=0.92 as=0.101875 ps=0.99 w=0.65 l=0.15
X4 a_212_413# a_27_413# VPWR VPB sky130_fd_pr__pfet_01v8_hvt ad=0.0609 pd=0.71 as=0.07665 ps=0.785 w=0.42 l=0.15
X5 VPWR A_N a_27_413# VPB sky130_fd_pr__pfet_01v8_hvt ad=0.07665 pd=0.785 as=0.1092 ps=1.36 w=0.42 l=0.15
X6 VPWR B a_212_413# VPB sky130_fd_pr__pfet_01v8_hvt ad=0.22895 pd=1.745 as=0.0609 ps=0.71 w=0.42 l=0.15
X7 VGND B a_297_47# VNB sky130_fd_pr__nfet_01v8 ad=0.101875 pd=0.99 as=0.0567 ps=0.69 w=0.42 l=0.15
X8 VGND a_212_413# X VNB sky130_fd_pr__nfet_01v8 ad=0.1755 pd=1.84 as=0.08775 ps=0.92 w=0.65 l=0.15
X9 a_27_413# A_N VGND VNB sky130_fd_pr__nfet_01v8 ad=0.1092 pd=1.36 as=0.1092 ps=1.36 w=0.42 l=0.15
.ends

.subckt sky130_fd_sc_hd__nor2_2 VPB VNB VGND VPWR B Y A
X0 Y B a_27_297# VPB sky130_fd_pr__pfet_01v8_hvt ad=0.135 pd=1.27 as=0.135 ps=1.27 w=1 l=0.15
X1 Y B VGND VNB sky130_fd_pr__nfet_01v8 ad=0.08775 pd=0.92 as=0.08775 ps=0.92 w=0.65 l=0.15
X2 a_27_297# A VPWR VPB sky130_fd_pr__pfet_01v8_hvt ad=0.135 pd=1.27 as=0.135 ps=1.27 w=1 l=0.15
X3 VGND A Y VNB sky130_fd_pr__nfet_01v8 ad=0.08775 pd=0.92 as=0.08775 ps=0.92 w=0.65 l=0.15
X4 Y A VGND VNB sky130_fd_pr__nfet_01v8 ad=0.08775 pd=0.92 as=0.182 ps=1.86 w=0.65 l=0.15
X5 VGND B Y VNB sky130_fd_pr__nfet_01v8 ad=0.169 pd=1.82 as=0.08775 ps=0.92 w=0.65 l=0.15
X6 VPWR A a_27_297# VPB sky130_fd_pr__pfet_01v8_hvt ad=0.135 pd=1.27 as=0.28 ps=2.56 w=1 l=0.15
X7 a_27_297# B Y VPB sky130_fd_pr__pfet_01v8_hvt ad=0.26 pd=2.52 as=0.135 ps=1.27 w=1 l=0.15
.ends

.subckt sky130_fd_sc_hd__or3b_2 VPWR VGND VPB VNB C_N X A B
X0 a_388_297# A VPWR VPB sky130_fd_pr__pfet_01v8_hvt ad=0.0567 pd=0.69 as=0.14825 ps=1.34 w=0.42 l=0.15
X1 VPWR C_N a_27_47# VPB sky130_fd_pr__pfet_01v8_hvt ad=0.14575 pd=1.335 as=0.1092 ps=1.36 w=0.42 l=0.15
X2 VGND a_176_21# X VNB sky130_fd_pr__nfet_01v8 ad=0.101875 pd=0.99 as=0.08775 ps=0.92 w=0.65 l=0.15
X3 X a_176_21# VGND VNB sky130_fd_pr__nfet_01v8 ad=0.08775 pd=0.92 as=0.10025 ps=0.985 w=0.65 l=0.15
X4 VPWR a_176_21# X VPB sky130_fd_pr__pfet_01v8_hvt ad=0.14825 pd=1.34 as=0.135 ps=1.27 w=1 l=0.15
X5 VGND B a_176_21# VNB sky130_fd_pr__nfet_01v8 ad=0.0567 pd=0.69 as=0.0567 ps=0.69 w=0.42 l=0.15
X6 X a_176_21# VPWR VPB sky130_fd_pr__pfet_01v8_hvt ad=0.135 pd=1.27 as=0.14575 ps=1.335 w=1 l=0.15
X7 a_176_21# a_27_47# a_472_297# VPB sky130_fd_pr__pfet_01v8_hvt ad=0.1092 pd=1.36 as=0.0567 ps=0.69 w=0.42 l=0.15
X8 a_472_297# B a_388_297# VPB sky130_fd_pr__pfet_01v8_hvt ad=0.0567 pd=0.69 as=0.0567 ps=0.69 w=0.42 l=0.15
X9 a_176_21# A VGND VNB sky130_fd_pr__nfet_01v8 ad=0.0567 pd=0.69 as=0.101875 ps=0.99 w=0.42 l=0.15
X10 a_176_21# a_27_47# VGND VNB sky130_fd_pr__nfet_01v8 ad=0.1092 pd=1.36 as=0.0567 ps=0.69 w=0.42 l=0.15
X11 VGND C_N a_27_47# VNB sky130_fd_pr__nfet_01v8 ad=0.10025 pd=0.985 as=0.1092 ps=1.36 w=0.42 l=0.15
.ends

.subckt sky130_fd_sc_hd__nand2_2 VPB VNB VGND VPWR Y A B
X0 VPWR A Y VPB sky130_fd_pr__pfet_01v8_hvt ad=0.26 pd=2.52 as=0.135 ps=1.27 w=1 l=0.15
X1 Y A VPWR VPB sky130_fd_pr__pfet_01v8_hvt ad=0.135 pd=1.27 as=0.135 ps=1.27 w=1 l=0.15
X2 VPWR B Y VPB sky130_fd_pr__pfet_01v8_hvt ad=0.135 pd=1.27 as=0.135 ps=1.27 w=1 l=0.15
X3 a_27_47# B VGND VNB sky130_fd_pr__nfet_01v8 ad=0.08775 pd=0.92 as=0.08775 ps=0.92 w=0.65 l=0.15
X4 a_27_47# A Y VNB sky130_fd_pr__nfet_01v8 ad=0.169 pd=1.82 as=0.08775 ps=0.92 w=0.65 l=0.15
X5 Y A a_27_47# VNB sky130_fd_pr__nfet_01v8 ad=0.08775 pd=0.92 as=0.08775 ps=0.92 w=0.65 l=0.15
X6 Y B VPWR VPB sky130_fd_pr__pfet_01v8_hvt ad=0.135 pd=1.27 as=0.26 ps=2.52 w=1 l=0.15
X7 VGND B a_27_47# VNB sky130_fd_pr__nfet_01v8 ad=0.08775 pd=0.92 as=0.169 ps=1.82 w=0.65 l=0.15
.ends

.subckt sky130_fd_sc_hd__and4b_2 VPWR VGND VNB VPB A_N B C D X
X0 VPWR a_193_413# X VPB sky130_fd_pr__pfet_01v8_hvt ad=0.26 pd=2.52 as=0.1525 ps=1.305 w=1 l=0.15
X1 a_297_47# a_27_413# a_193_413# VNB sky130_fd_pr__nfet_01v8 ad=0.0441 pd=0.63 as=0.1092 ps=1.36 w=0.42 l=0.15
X2 a_369_47# B a_297_47# VNB sky130_fd_pr__nfet_01v8 ad=0.0735 pd=0.77 as=0.0441 ps=0.63 w=0.42 l=0.15
X3 X a_193_413# VGND VNB sky130_fd_pr__nfet_01v8 ad=0.099125 pd=0.955 as=0.103975 ps=1 w=0.65 l=0.15
X4 VPWR D a_193_413# VPB sky130_fd_pr__pfet_01v8_hvt ad=0.14325 pd=1.33 as=0.06615 ps=0.735 w=0.42 l=0.15
X5 VPWR A_N a_27_413# VPB sky130_fd_pr__pfet_01v8_hvt ad=0.0567 pd=0.69 as=0.1092 ps=1.36 w=0.42 l=0.15
X6 VGND D a_469_47# VNB sky130_fd_pr__nfet_01v8 ad=0.103975 pd=1 as=0.06195 ps=0.715 w=0.42 l=0.15
X7 VGND a_193_413# X VNB sky130_fd_pr__nfet_01v8 ad=0.169 pd=1.82 as=0.099125 ps=0.955 w=0.65 l=0.15
X8 VPWR B a_193_413# VPB sky130_fd_pr__pfet_01v8_hvt ad=0.1281 pd=1.03 as=0.0987 ps=0.89 w=0.42 l=0.15
X9 a_193_413# C VPWR VPB sky130_fd_pr__pfet_01v8_hvt ad=0.06615 pd=0.735 as=0.1281 ps=1.03 w=0.42 l=0.15
X10 X a_193_413# VPWR VPB sky130_fd_pr__pfet_01v8_hvt ad=0.1525 pd=1.305 as=0.14325 ps=1.33 w=1 l=0.15
X11 a_193_413# a_27_413# VPWR VPB sky130_fd_pr__pfet_01v8_hvt ad=0.0987 pd=0.89 as=0.0567 ps=0.69 w=0.42 l=0.15
X12 a_469_47# C a_369_47# VNB sky130_fd_pr__nfet_01v8 ad=0.06195 pd=0.715 as=0.0735 ps=0.77 w=0.42 l=0.15
X13 a_27_413# A_N VGND VNB sky130_fd_pr__nfet_01v8 ad=0.1092 pd=1.36 as=0.1092 ps=1.36 w=0.42 l=0.15
.ends

.subckt sky130_fd_sc_hd__a221o_2 VPWR VGND VPB VNB C1 B2 B1 A1 A2 X
X0 VPWR a_27_47# X VPB sky130_fd_pr__pfet_01v8_hvt ad=0.285 pd=2.57 as=0.135 ps=1.27 w=1 l=0.15
X1 a_465_47# A1 a_27_47# VNB sky130_fd_pr__nfet_01v8 ad=0.10725 pd=0.98 as=0.169 ps=1.82 w=0.65 l=0.15
X2 X a_27_47# VPWR VPB sky130_fd_pr__pfet_01v8_hvt ad=0.135 pd=1.27 as=0.1575 ps=1.315 w=1 l=0.15
X3 a_109_297# B1 a_193_297# VPB sky130_fd_pr__pfet_01v8_hvt ad=0.26 pd=2.52 as=0.135 ps=1.27 w=1 l=0.15
X4 a_193_297# B2 a_109_297# VPB sky130_fd_pr__pfet_01v8_hvt ad=0.135 pd=1.27 as=0.135 ps=1.27 w=1 l=0.15
X5 X a_27_47# VGND VNB sky130_fd_pr__nfet_01v8 ad=0.08775 pd=0.92 as=0.102375 ps=0.965 w=0.65 l=0.15
X6 a_205_47# B2 VGND VNB sky130_fd_pr__nfet_01v8 ad=0.06825 pd=0.86 as=0.10725 ps=0.98 w=0.65 l=0.15
X7 VPWR A2 a_193_297# VPB sky130_fd_pr__pfet_01v8_hvt ad=0.1575 pd=1.315 as=0.165 ps=1.33 w=1 l=0.15
X8 a_193_297# A1 VPWR VPB sky130_fd_pr__pfet_01v8_hvt ad=0.165 pd=1.33 as=0.26 ps=2.52 w=1 l=0.15
X9 a_27_47# B1 a_205_47# VNB sky130_fd_pr__nfet_01v8 ad=0.169 pd=1.82 as=0.06825 ps=0.86 w=0.65 l=0.15
X10 VGND a_27_47# X VNB sky130_fd_pr__nfet_01v8 ad=0.18525 pd=1.87 as=0.08775 ps=0.92 w=0.65 l=0.15
X11 a_109_297# C1 a_27_47# VPB sky130_fd_pr__pfet_01v8_hvt ad=0.135 pd=1.27 as=0.26 ps=2.52 w=1 l=0.15
X12 VGND C1 a_27_47# VNB sky130_fd_pr__nfet_01v8 ad=0.10725 pd=0.98 as=0.169 ps=1.82 w=0.65 l=0.15
X13 VGND A2 a_465_47# VNB sky130_fd_pr__nfet_01v8 ad=0.102375 pd=0.965 as=0.10725 ps=0.98 w=0.65 l=0.15
.ends

.subckt sky130_fd_sc_hd__and4_2 VNB VPB VGND VPWR X D C B A
X0 VGND a_27_47# X VNB sky130_fd_pr__nfet_01v8 ad=0.195 pd=1.9 as=0.10725 ps=0.98 w=0.65 l=0.15
X1 VGND D a_304_47# VNB sky130_fd_pr__nfet_01v8 ad=0.17515 pd=1.265 as=0.0693 ps=0.75 w=0.42 l=0.15
X2 X a_27_47# VPWR VPB sky130_fd_pr__pfet_01v8_hvt ad=0.165 pd=1.33 as=0.27995 ps=1.615 w=1 l=0.15
X3 a_198_47# B a_109_47# VNB sky130_fd_pr__nfet_01v8 ad=0.0798 pd=0.8 as=0.06195 ps=0.715 w=0.42 l=0.15
X4 a_27_47# C VPWR VPB sky130_fd_pr__pfet_01v8_hvt ad=0.0588 pd=0.7 as=0.0777 ps=0.79 w=0.42 l=0.15
X5 VPWR a_27_47# X VPB sky130_fd_pr__pfet_01v8_hvt ad=0.3 pd=2.6 as=0.165 ps=1.33 w=1 l=0.15
X6 a_304_47# C a_198_47# VNB sky130_fd_pr__nfet_01v8 ad=0.0693 pd=0.75 as=0.0798 ps=0.8 w=0.42 l=0.15
X7 a_27_47# A VPWR VPB sky130_fd_pr__pfet_01v8_hvt ad=0.07455 pd=0.775 as=0.1092 ps=1.36 w=0.42 l=0.15
X8 VPWR D a_27_47# VPB sky130_fd_pr__pfet_01v8_hvt ad=0.27995 pd=1.615 as=0.0588 ps=0.7 w=0.42 l=0.15
X9 X a_27_47# VGND VNB sky130_fd_pr__nfet_01v8 ad=0.10725 pd=0.98 as=0.17515 ps=1.265 w=0.65 l=0.15
X10 VPWR B a_27_47# VPB sky130_fd_pr__pfet_01v8_hvt ad=0.0777 pd=0.79 as=0.07455 ps=0.775 w=0.42 l=0.15
X11 a_109_47# A a_27_47# VNB sky130_fd_pr__nfet_01v8 ad=0.06195 pd=0.715 as=0.1092 ps=1.36 w=0.42 l=0.15
.ends

.subckt sky130_fd_sc_hd__a22o_2 VPWR VGND VPB VNB B2 B1 A1 A2 X
X0 VPWR a_27_297# X VPB sky130_fd_pr__pfet_01v8_hvt ad=0.27 pd=2.54 as=0.135 ps=1.27 w=1 l=0.15
X1 VGND A2 a_381_47# VNB sky130_fd_pr__nfet_01v8 ad=0.102375 pd=0.965 as=0.10725 ps=0.98 w=0.65 l=0.15
X2 X a_27_297# VGND VNB sky130_fd_pr__nfet_01v8 ad=0.08775 pd=0.92 as=0.102375 ps=0.965 w=0.65 l=0.15
X3 X a_27_297# VPWR VPB sky130_fd_pr__pfet_01v8_hvt ad=0.135 pd=1.27 as=0.1575 ps=1.315 w=1 l=0.15
X4 a_27_297# B1 a_109_47# VNB sky130_fd_pr__nfet_01v8 ad=0.169 pd=1.82 as=0.07475 ps=0.88 w=0.65 l=0.15
X5 a_27_297# B1 a_109_297# VPB sky130_fd_pr__pfet_01v8_hvt ad=0.26 pd=2.52 as=0.135 ps=1.27 w=1 l=0.15
X6 VGND a_27_297# X VNB sky130_fd_pr__nfet_01v8 ad=0.1755 pd=1.84 as=0.08775 ps=0.92 w=0.65 l=0.15
X7 a_109_297# A1 VPWR VPB sky130_fd_pr__pfet_01v8_hvt ad=0.165 pd=1.33 as=0.26 ps=2.52 w=1 l=0.15
X8 VPWR A2 a_109_297# VPB sky130_fd_pr__pfet_01v8_hvt ad=0.1575 pd=1.315 as=0.165 ps=1.33 w=1 l=0.15
X9 a_381_47# A1 a_27_297# VNB sky130_fd_pr__nfet_01v8 ad=0.10725 pd=0.98 as=0.169 ps=1.82 w=0.65 l=0.15
X10 a_109_297# B2 a_27_297# VPB sky130_fd_pr__pfet_01v8_hvt ad=0.135 pd=1.27 as=0.26 ps=2.52 w=1 l=0.15
X11 a_109_47# B2 VGND VNB sky130_fd_pr__nfet_01v8 ad=0.07475 pd=0.88 as=0.169 ps=1.82 w=0.65 l=0.15
.ends

.subckt sky130_fd_sc_hd__xor2_2 VPWR VGND X B A VPB VNB
X0 a_27_297# A VPWR VPB sky130_fd_pr__pfet_01v8_hvt ad=0.135 pd=1.27 as=0.135 ps=1.27 w=1 l=0.15
X1 a_470_47# A VGND VNB sky130_fd_pr__nfet_01v8 ad=0.08775 pd=0.92 as=0.08775 ps=0.92 w=0.65 l=0.15
X2 a_470_297# A VPWR VPB sky130_fd_pr__pfet_01v8_hvt ad=0.135 pd=1.27 as=0.135 ps=1.27 w=1 l=0.15
X3 VPWR A a_470_297# VPB sky130_fd_pr__pfet_01v8_hvt ad=0.135 pd=1.27 as=0.26 ps=2.52 w=1 l=0.15
X4 a_112_47# B VGND VNB sky130_fd_pr__nfet_01v8 ad=0.08775 pd=0.92 as=0.08775 ps=0.92 w=0.65 l=0.15
X5 a_470_47# B X VNB sky130_fd_pr__nfet_01v8 ad=0.169 pd=1.82 as=0.105625 ps=0.975 w=0.65 l=0.15
X6 VGND A a_112_47# VNB sky130_fd_pr__nfet_01v8 ad=0.08775 pd=0.92 as=0.08775 ps=0.92 w=0.65 l=0.15
X7 a_112_47# A VGND VNB sky130_fd_pr__nfet_01v8 ad=0.08775 pd=0.92 as=0.17875 ps=1.85 w=0.65 l=0.15
X8 VGND B a_112_47# VNB sky130_fd_pr__nfet_01v8 ad=0.169 pd=1.82 as=0.08775 ps=0.92 w=0.65 l=0.15
X9 VPWR A a_27_297# VPB sky130_fd_pr__pfet_01v8_hvt ad=0.135 pd=1.27 as=0.275 ps=2.55 w=1 l=0.15
X10 a_470_297# B VPWR VPB sky130_fd_pr__pfet_01v8_hvt ad=0.26 pd=2.52 as=0.1625 ps=1.325 w=1 l=0.15
X11 X a_112_47# VGND VNB sky130_fd_pr__nfet_01v8 ad=0.08775 pd=0.92 as=0.169 ps=1.82 w=0.65 l=0.15
X12 VPWR B a_470_297# VPB sky130_fd_pr__pfet_01v8_hvt ad=0.1625 pd=1.325 as=0.135 ps=1.27 w=1 l=0.15
X13 VGND a_112_47# X VNB sky130_fd_pr__nfet_01v8 ad=0.169 pd=1.82 as=0.08775 ps=0.92 w=0.65 l=0.15
X14 VGND A a_470_47# VNB sky130_fd_pr__nfet_01v8 ad=0.08775 pd=0.92 as=0.169 ps=1.82 w=0.65 l=0.15
X15 a_27_297# B a_112_47# VPB sky130_fd_pr__pfet_01v8_hvt ad=0.26 pd=2.52 as=0.135 ps=1.27 w=1 l=0.15
X16 X a_112_47# a_470_297# VPB sky130_fd_pr__pfet_01v8_hvt ad=0.135 pd=1.27 as=0.26 ps=2.52 w=1 l=0.15
X17 a_470_297# a_112_47# X VPB sky130_fd_pr__pfet_01v8_hvt ad=0.28 pd=2.56 as=0.135 ps=1.27 w=1 l=0.15
X18 X B a_470_47# VNB sky130_fd_pr__nfet_01v8 ad=0.105625 pd=0.975 as=0.08775 ps=0.92 w=0.65 l=0.15
X19 a_112_47# B a_27_297# VPB sky130_fd_pr__pfet_01v8_hvt ad=0.135 pd=1.27 as=0.135 ps=1.27 w=1 l=0.15
.ends

.subckt sky130_fd_sc_hd__xnor2_2 VGND VPWR Y A B VPB VNB
X0 a_27_297# B VPWR VPB sky130_fd_pr__pfet_01v8_hvt ad=0.135 pd=1.27 as=0.135 ps=1.27 w=1 l=0.15
X1 a_560_47# A VGND VNB sky130_fd_pr__nfet_01v8 ad=0.08775 pd=0.92 as=0.182 ps=1.86 w=0.65 l=0.15
X2 VGND B a_560_47# VNB sky130_fd_pr__nfet_01v8 ad=0.169 pd=1.82 as=0.099125 ps=0.955 w=0.65 l=0.15
X3 Y B a_474_297# VPB sky130_fd_pr__pfet_01v8_hvt ad=0.1525 pd=1.305 as=0.135 ps=1.27 w=1 l=0.15
X4 VGND A a_27_47# VNB sky130_fd_pr__nfet_01v8 ad=0.08775 pd=0.92 as=0.08775 ps=0.92 w=0.65 l=0.15
X5 Y a_27_297# a_560_47# VNB sky130_fd_pr__nfet_01v8 ad=0.169 pd=1.82 as=0.08775 ps=0.92 w=0.65 l=0.15
X6 a_474_297# B Y VPB sky130_fd_pr__pfet_01v8_hvt ad=0.26 pd=2.52 as=0.1525 ps=1.305 w=1 l=0.15
X7 VGND A a_560_47# VNB sky130_fd_pr__nfet_01v8 ad=0.08775 pd=0.92 as=0.08775 ps=0.92 w=0.65 l=0.15
X8 a_27_47# B a_27_297# VNB sky130_fd_pr__nfet_01v8 ad=0.08775 pd=0.92 as=0.08775 ps=0.92 w=0.65 l=0.15
X9 a_27_297# B a_27_47# VNB sky130_fd_pr__nfet_01v8 ad=0.08775 pd=0.92 as=0.17875 ps=1.85 w=0.65 l=0.15
X10 a_27_47# A VGND VNB sky130_fd_pr__nfet_01v8 ad=0.182 pd=1.86 as=0.08775 ps=0.92 w=0.65 l=0.15
X11 VPWR B a_27_297# VPB sky130_fd_pr__pfet_01v8_hvt ad=0.135 pd=1.27 as=0.275 ps=2.55 w=1 l=0.15
X12 a_474_297# A VPWR VPB sky130_fd_pr__pfet_01v8_hvt ad=0.135 pd=1.27 as=0.135 ps=1.27 w=1 l=0.15
X13 a_560_47# a_27_297# Y VNB sky130_fd_pr__nfet_01v8 ad=0.08775 pd=0.92 as=0.169 ps=1.82 w=0.65 l=0.15
X14 VPWR A a_474_297# VPB sky130_fd_pr__pfet_01v8_hvt ad=0.135 pd=1.27 as=0.28 ps=2.56 w=1 l=0.15
X15 Y a_27_297# VPWR VPB sky130_fd_pr__pfet_01v8_hvt ad=0.135 pd=1.27 as=0.26 ps=2.52 w=1 l=0.15
X16 VPWR a_27_297# Y VPB sky130_fd_pr__pfet_01v8_hvt ad=0.28 pd=2.56 as=0.135 ps=1.27 w=1 l=0.15
X17 a_560_47# B VGND VNB sky130_fd_pr__nfet_01v8 ad=0.099125 pd=0.955 as=0.08775 ps=0.92 w=0.65 l=0.15
X18 a_27_297# A VPWR VPB sky130_fd_pr__pfet_01v8_hvt ad=0.28 pd=2.56 as=0.135 ps=1.27 w=1 l=0.15
X19 VPWR A a_27_297# VPB sky130_fd_pr__pfet_01v8_hvt ad=0.135 pd=1.27 as=0.135 ps=1.27 w=1 l=0.15
.ends

.subckt sky130_fd_sc_hd__or4b_2 VPWR VGND VPB VNB C D_N X A B
X0 a_176_21# C VGND VNB sky130_fd_pr__nfet_01v8 ad=0.0567 pd=0.69 as=0.0567 ps=0.69 w=0.42 l=0.15
X1 VGND D_N a_27_53# VNB sky130_fd_pr__nfet_01v8 ad=0.10025 pd=0.985 as=0.1092 ps=1.36 w=0.42 l=0.15
X2 VGND a_176_21# X VNB sky130_fd_pr__nfet_01v8 ad=0.10025 pd=0.985 as=0.08775 ps=0.92 w=0.65 l=0.15
X3 X a_176_21# VGND VNB sky130_fd_pr__nfet_01v8 ad=0.08775 pd=0.92 as=0.10025 ps=0.985 w=0.65 l=0.15
X4 VPWR a_176_21# X VPB sky130_fd_pr__pfet_01v8_hvt ad=0.16835 pd=1.495 as=0.135 ps=1.27 w=1 l=0.15
X5 a_555_297# C a_483_297# VPB sky130_fd_pr__pfet_01v8_hvt ad=0.0693 pd=0.75 as=0.0441 ps=0.63 w=0.42 l=0.15
X6 a_176_21# a_27_53# a_555_297# VPB sky130_fd_pr__pfet_01v8_hvt ad=0.1092 pd=1.36 as=0.0693 ps=0.75 w=0.42 l=0.15
X7 X a_176_21# VPWR VPB sky130_fd_pr__pfet_01v8_hvt ad=0.135 pd=1.27 as=0.1693 ps=1.5 w=1 l=0.15
X8 a_387_297# A VPWR VPB sky130_fd_pr__pfet_01v8_hvt ad=0.0693 pd=0.75 as=0.16835 ps=1.495 w=0.42 l=0.15
X9 a_483_297# B a_387_297# VPB sky130_fd_pr__pfet_01v8_hvt ad=0.0441 pd=0.63 as=0.0693 ps=0.75 w=0.42 l=0.15
X10 VGND B a_176_21# VNB sky130_fd_pr__nfet_01v8 ad=0.0567 pd=0.69 as=0.0693 ps=0.75 w=0.42 l=0.15
X11 VGND a_27_53# a_176_21# VNB sky130_fd_pr__nfet_01v8 ad=0.1092 pd=1.36 as=0.0567 ps=0.69 w=0.42 l=0.15
X12 VPWR D_N a_27_53# VPB sky130_fd_pr__pfet_01v8_hvt ad=0.1693 pd=1.5 as=0.1092 ps=1.36 w=0.42 l=0.15
X13 a_176_21# A VGND VNB sky130_fd_pr__nfet_01v8 ad=0.0693 pd=0.75 as=0.10025 ps=0.985 w=0.42 l=0.15
.ends

.subckt sky130_fd_sc_hd__or4_2 VPWR VGND VPB VNB B D C A X
X0 a_27_297# B VGND VNB sky130_fd_pr__nfet_01v8 ad=0.0567 pd=0.69 as=0.0567 ps=0.69 w=0.42 l=0.15
X1 a_27_297# D VGND VNB sky130_fd_pr__nfet_01v8 ad=0.0693 pd=0.75 as=0.1092 ps=1.36 w=0.42 l=0.15
X2 a_277_297# B a_205_297# VPB sky130_fd_pr__pfet_01v8_hvt ad=0.0693 pd=0.75 as=0.0441 ps=0.63 w=0.42 l=0.15
X3 VPWR A a_277_297# VPB sky130_fd_pr__pfet_01v8_hvt ad=0.14825 pd=1.34 as=0.0693 ps=0.75 w=0.42 l=0.15
X4 X a_27_297# VGND VNB sky130_fd_pr__nfet_01v8 ad=0.08775 pd=0.92 as=0.101875 ps=0.99 w=0.65 l=0.15
X5 a_205_297# C a_109_297# VPB sky130_fd_pr__pfet_01v8_hvt ad=0.0441 pd=0.63 as=0.0693 ps=0.75 w=0.42 l=0.15
X6 VPWR a_27_297# X VPB sky130_fd_pr__pfet_01v8_hvt ad=0.305 pd=2.61 as=0.135 ps=1.27 w=1 l=0.15
X7 VGND a_27_297# X VNB sky130_fd_pr__nfet_01v8 ad=0.19825 pd=1.91 as=0.08775 ps=0.92 w=0.65 l=0.15
X8 X a_27_297# VPWR VPB sky130_fd_pr__pfet_01v8_hvt ad=0.135 pd=1.27 as=0.14825 ps=1.34 w=1 l=0.15
X9 VGND C a_27_297# VNB sky130_fd_pr__nfet_01v8 ad=0.0567 pd=0.69 as=0.0693 ps=0.75 w=0.42 l=0.15
X10 a_109_297# D a_27_297# VPB sky130_fd_pr__pfet_01v8_hvt ad=0.0693 pd=0.75 as=0.1092 ps=1.36 w=0.42 l=0.15
X11 VGND A a_27_297# VNB sky130_fd_pr__nfet_01v8 ad=0.101875 pd=0.99 as=0.0567 ps=0.69 w=0.42 l=0.15
.ends

.subckt sky130_fd_sc_hd__and4bb_2 VNB VPB VGND VPWR A_N X C D B_N
X0 a_174_21# C VPWR VPB sky130_fd_pr__pfet_01v8_hvt ad=0.0567 pd=0.69 as=0.0588 ps=0.7 w=0.42 l=0.15
X1 a_174_21# a_27_47# VPWR VPB sky130_fd_pr__pfet_01v8_hvt ad=0.0672 pd=0.74 as=0.33075 ps=1.705 w=0.42 l=0.15
X2 a_476_47# a_27_47# a_174_21# VNB sky130_fd_pr__nfet_01v8 ad=0.0441 pd=0.63 as=0.1092 ps=1.36 w=0.42 l=0.15
X3 VPWR a_174_21# X VPB sky130_fd_pr__pfet_01v8_hvt ad=0.33075 pd=1.705 as=0.135 ps=1.27 w=1 l=0.15
X4 X a_174_21# VPWR VPB sky130_fd_pr__pfet_01v8_hvt ad=0.135 pd=1.27 as=0.14075 ps=1.325 w=1 l=0.15
X5 a_548_47# a_505_280# a_476_47# VNB sky130_fd_pr__nfet_01v8 ad=0.06405 pd=0.725 as=0.0441 ps=0.63 w=0.42 l=0.15
X6 VPWR A_N a_27_47# VPB sky130_fd_pr__pfet_01v8_hvt ad=0.14075 pd=1.325 as=0.1092 ps=1.36 w=0.42 l=0.15
X7 X a_174_21# VGND VNB sky130_fd_pr__nfet_01v8 ad=0.08775 pd=0.92 as=0.097 ps=0.975 w=0.65 l=0.15
X8 VPWR D a_174_21# VPB sky130_fd_pr__pfet_01v8_hvt ad=0.0924 pd=0.86 as=0.0567 ps=0.69 w=0.42 l=0.15
X9 VGND D a_639_47# VNB sky130_fd_pr__nfet_01v8 ad=0.0924 pd=0.86 as=0.0567 ps=0.69 w=0.42 l=0.15
X10 VPWR a_505_280# a_174_21# VPB sky130_fd_pr__pfet_01v8_hvt ad=0.0588 pd=0.7 as=0.0672 ps=0.74 w=0.42 l=0.15
X11 a_505_280# B_N VPWR VPB sky130_fd_pr__pfet_01v8_hvt ad=0.1092 pd=1.36 as=0.0924 ps=0.86 w=0.42 l=0.15
X12 VGND a_174_21# X VNB sky130_fd_pr__nfet_01v8 ad=0.169 pd=1.82 as=0.08775 ps=0.92 w=0.65 l=0.15
X13 a_505_280# B_N VGND VNB sky130_fd_pr__nfet_01v8 ad=0.1092 pd=1.36 as=0.0924 ps=0.86 w=0.42 l=0.15
X14 a_639_47# C a_548_47# VNB sky130_fd_pr__nfet_01v8 ad=0.0567 pd=0.69 as=0.06405 ps=0.725 w=0.42 l=0.15
X15 VGND A_N a_27_47# VNB sky130_fd_pr__nfet_01v8 ad=0.097 pd=0.975 as=0.1092 ps=1.36 w=0.42 l=0.15
.ends

.subckt sky130_fd_sc_hd__or2_2 VPWR VGND VPB VNB X A B
X0 a_121_297# B a_39_297# VPB sky130_fd_pr__pfet_01v8_hvt ad=0.0441 pd=0.63 as=0.1092 ps=1.36 w=0.42 l=0.15
X1 X a_39_297# VGND VNB sky130_fd_pr__nfet_01v8 ad=0.08775 pd=0.92 as=0.10675 ps=1.005 w=0.65 l=0.15
X2 VPWR a_39_297# X VPB sky130_fd_pr__pfet_01v8_hvt ad=0.26 pd=2.52 as=0.135 ps=1.27 w=1 l=0.15
X3 X a_39_297# VPWR VPB sky130_fd_pr__pfet_01v8_hvt ad=0.135 pd=1.27 as=0.15575 ps=1.355 w=1 l=0.15
X4 VGND a_39_297# X VNB sky130_fd_pr__nfet_01v8 ad=0.169 pd=1.82 as=0.08775 ps=0.92 w=0.65 l=0.15
X5 VPWR A a_121_297# VPB sky130_fd_pr__pfet_01v8_hvt ad=0.15575 pd=1.355 as=0.0441 ps=0.63 w=0.42 l=0.15
X6 VGND A a_39_297# VNB sky130_fd_pr__nfet_01v8 ad=0.10675 pd=1.005 as=0.0567 ps=0.69 w=0.42 l=0.15
X7 a_39_297# B VGND VNB sky130_fd_pr__nfet_01v8 ad=0.0567 pd=0.69 as=0.1092 ps=1.36 w=0.42 l=0.15
.ends

.subckt sky130_fd_sc_hd__o21a_2 VNB VPB VGND VPWR X B1 A2 A1
X0 VPWR A1 a_470_297# VPB sky130_fd_pr__pfet_01v8_hvt ad=0.265 pd=2.53 as=0.16 ps=1.32 w=1 l=0.15
X1 a_79_21# B1 VPWR VPB sky130_fd_pr__pfet_01v8_hvt ad=0.14 pd=1.28 as=0.4 ps=1.8 w=1 l=0.15
X2 VGND a_79_21# X VNB sky130_fd_pr__nfet_01v8 ad=0.17225 pd=1.83 as=0.089375 ps=0.925 w=0.65 l=0.15
X3 VGND A2 a_384_47# VNB sky130_fd_pr__nfet_01v8 ad=0.104 pd=0.97 as=0.091 ps=0.93 w=0.65 l=0.15
X4 a_470_297# A2 a_79_21# VPB sky130_fd_pr__pfet_01v8_hvt ad=0.16 pd=1.32 as=0.14 ps=1.28 w=1 l=0.15
X5 VPWR a_79_21# X VPB sky130_fd_pr__pfet_01v8_hvt ad=0.4 pd=1.8 as=0.1375 ps=1.275 w=1 l=0.15
X6 a_384_47# B1 a_79_21# VNB sky130_fd_pr__nfet_01v8 ad=0.091 pd=0.93 as=0.17225 ps=1.83 w=0.65 l=0.15
X7 a_384_47# A1 VGND VNB sky130_fd_pr__nfet_01v8 ad=0.17225 pd=1.83 as=0.104 ps=0.97 w=0.65 l=0.15
X8 X a_79_21# VPWR VPB sky130_fd_pr__pfet_01v8_hvt ad=0.1375 pd=1.275 as=0.26 ps=2.52 w=1 l=0.15
X9 X a_79_21# VGND VNB sky130_fd_pr__nfet_01v8 ad=0.089375 pd=0.925 as=0.169 ps=1.82 w=0.65 l=0.15
.ends

.subckt sky130_fd_sc_hd__or3_2 VGND VPWR VPB VNB B C A X
X0 VPWR a_30_53# X VPB sky130_fd_pr__pfet_01v8_hvt ad=0.315 pd=2.63 as=0.135 ps=1.27 w=1 l=0.15
X1 VGND a_30_53# X VNB sky130_fd_pr__nfet_01v8 ad=0.18525 pd=1.87 as=0.08775 ps=0.92 w=0.65 l=0.15
X2 X a_30_53# VPWR VPB sky130_fd_pr__pfet_01v8_hvt ad=0.135 pd=1.27 as=0.14825 ps=1.34 w=1 l=0.15
X3 a_112_297# C a_30_53# VPB sky130_fd_pr__pfet_01v8_hvt ad=0.0441 pd=0.63 as=0.1092 ps=1.36 w=0.42 l=0.15
X4 X a_30_53# VGND VNB sky130_fd_pr__nfet_01v8 ad=0.08775 pd=0.92 as=0.101875 ps=0.99 w=0.65 l=0.15
X5 VGND A a_30_53# VNB sky130_fd_pr__nfet_01v8 ad=0.101875 pd=0.99 as=0.0567 ps=0.69 w=0.42 l=0.15
X6 a_30_53# B VGND VNB sky130_fd_pr__nfet_01v8 ad=0.0567 pd=0.69 as=0.0567 ps=0.69 w=0.42 l=0.15
X7 VGND C a_30_53# VNB sky130_fd_pr__nfet_01v8 ad=0.0567 pd=0.69 as=0.1092 ps=1.36 w=0.42 l=0.15
X8 a_184_297# B a_112_297# VPB sky130_fd_pr__pfet_01v8_hvt ad=0.0693 pd=0.75 as=0.0441 ps=0.63 w=0.42 l=0.15
X9 VPWR A a_184_297# VPB sky130_fd_pr__pfet_01v8_hvt ad=0.14825 pd=1.34 as=0.0693 ps=0.75 w=0.42 l=0.15
.ends

.subckt sky130_fd_sc_hd__dfstp_2 VPB VNB VPWR VGND Q SET_B D CLK
X0 VGND a_652_21# a_586_47# VNB sky130_fd_pr__nfet_01v8 ad=0.0882 pd=0.84 as=0.06705 ps=0.75 w=0.42 l=0.15
X1 a_956_413# a_476_47# VPWR VPB sky130_fd_pr__pfet_01v8_hvt ad=0.0441 pd=0.63 as=0.0567 ps=0.69 w=0.42 l=0.15
X2 a_1136_413# a_193_47# a_1028_413# VPB sky130_fd_pr__pfet_01v8_hvt ad=0.0441 pd=0.63 as=0.0819 ps=0.81 w=0.42 l=0.15
X3 VPWR a_476_47# a_652_21# VPB sky130_fd_pr__pfet_01v8_hvt ad=0.0567 pd=0.69 as=0.0567 ps=0.69 w=0.42 l=0.15
X4 a_1228_47# a_27_47# a_1028_413# VNB sky130_fd_pr__nfet_01v8 ad=0.0441 pd=0.63 as=0.0735 ps=0.77 w=0.42 l=0.15
X5 VPWR CLK a_27_47# VPB sky130_fd_pr__pfet_01v8_hvt ad=0.0864 pd=0.91 as=0.1664 ps=1.8 w=0.64 l=0.15
X6 a_586_47# a_193_47# a_476_47# VNB sky130_fd_pr__special_nfet_01v8 ad=0.06705 pd=0.75 as=0.072 ps=0.76 w=0.36 l=0.15
X7 a_1056_47# a_476_47# VGND VNB sky130_fd_pr__nfet_01v8 ad=0.0441 pd=0.63 as=0.1092 ps=1.36 w=0.42 l=0.15
X8 a_476_47# a_27_47# a_381_47# VNB sky130_fd_pr__special_nfet_01v8 ad=0.072 pd=0.76 as=0.0935 ps=0.965 w=0.36 l=0.15
X9 a_381_47# D VPWR VPB sky130_fd_pr__pfet_01v8_hvt ad=0.12495 pd=1.175 as=0.2184 ps=2.2 w=0.84 l=0.15
X10 a_652_21# SET_B VPWR VPB sky130_fd_pr__pfet_01v8_hvt ad=0.0567 pd=0.69 as=0.0798 ps=0.8 w=0.42 l=0.15
X11 VPWR a_1602_47# Q VPB sky130_fd_pr__pfet_01v8_hvt ad=0.26 pd=2.52 as=0.135 ps=1.27 w=1 l=0.15
X12 a_562_413# a_27_47# a_476_47# VPB sky130_fd_pr__pfet_01v8_hvt ad=0.0945 pd=0.87 as=0.0567 ps=0.69 w=0.42 l=0.15
X13 VGND a_1028_413# a_1602_47# VNB sky130_fd_pr__nfet_01v8 ad=0.08775 pd=0.92 as=0.169 ps=1.82 w=0.65 l=0.15
X14 VGND a_1602_47# Q VNB sky130_fd_pr__nfet_01v8 ad=0.169 pd=1.82 as=0.08775 ps=0.92 w=0.65 l=0.15
X15 Q a_1602_47# VPWR VPB sky130_fd_pr__pfet_01v8_hvt ad=0.135 pd=1.27 as=0.135 ps=1.27 w=1 l=0.15
X16 a_1028_413# a_193_47# a_1056_47# VNB sky130_fd_pr__nfet_01v8 ad=0.0735 pd=0.77 as=0.0441 ps=0.63 w=0.42 l=0.15
X17 a_476_47# a_193_47# a_381_47# VPB sky130_fd_pr__pfet_01v8_hvt ad=0.0567 pd=0.69 as=0.12495 ps=1.175 w=0.42 l=0.15
X18 a_193_47# a_27_47# VGND VNB sky130_fd_pr__nfet_01v8 ad=0.1092 pd=1.36 as=0.0567 ps=0.69 w=0.42 l=0.15
X19 VPWR a_1028_413# a_1602_47# VPB sky130_fd_pr__pfet_01v8_hvt ad=0.135 pd=1.27 as=0.26 ps=2.52 w=1 l=0.15
X20 VPWR a_652_21# a_562_413# VPB sky130_fd_pr__pfet_01v8_hvt ad=0.0798 pd=0.8 as=0.0945 ps=0.87 w=0.42 l=0.15
X21 Q a_1602_47# VGND VNB sky130_fd_pr__nfet_01v8 ad=0.08775 pd=0.92 as=0.08775 ps=0.92 w=0.65 l=0.15
X22 a_1028_413# a_27_47# a_956_413# VPB sky130_fd_pr__pfet_01v8_hvt ad=0.0819 pd=0.81 as=0.0441 ps=0.63 w=0.42 l=0.15
X23 VPWR a_1178_261# a_1136_413# VPB sky130_fd_pr__pfet_01v8_hvt ad=0.1092 pd=1.36 as=0.0441 ps=0.63 w=0.42 l=0.15
X24 a_193_47# a_27_47# VPWR VPB sky130_fd_pr__pfet_01v8_hvt ad=0.1664 pd=1.8 as=0.0864 ps=0.91 w=0.64 l=0.15
X25 a_1178_261# a_1028_413# VPWR VPB sky130_fd_pr__pfet_01v8_hvt ad=0.2226 pd=2.21 as=0.12075 ps=1.165 w=0.84 l=0.15
X26 a_796_47# SET_B VGND VNB sky130_fd_pr__nfet_01v8 ad=0.0441 pd=0.63 as=0.0882 ps=0.84 w=0.42 l=0.15
X27 a_1300_47# a_1178_261# a_1228_47# VNB sky130_fd_pr__nfet_01v8 ad=0.0441 pd=0.63 as=0.0441 ps=0.63 w=0.42 l=0.15
X28 a_381_47# D VGND VNB sky130_fd_pr__nfet_01v8 ad=0.0935 pd=0.965 as=0.1664 ps=1.8 w=0.64 l=0.15
X29 a_1178_261# a_1028_413# VGND VNB sky130_fd_pr__nfet_01v8 ad=0.1404 pd=1.6 as=0.1137 ps=1.01 w=0.54 l=0.15
X30 a_652_21# a_476_47# a_796_47# VNB sky130_fd_pr__nfet_01v8 ad=0.1092 pd=1.36 as=0.0441 ps=0.63 w=0.42 l=0.15
X31 VPWR SET_B a_1028_413# VPB sky130_fd_pr__pfet_01v8_hvt ad=0.12075 pd=1.165 as=0.1092 ps=1.36 w=0.42 l=0.15
X32 VGND CLK a_27_47# VNB sky130_fd_pr__nfet_01v8 ad=0.0567 pd=0.69 as=0.1092 ps=1.36 w=0.42 l=0.15
X33 VGND SET_B a_1300_47# VNB sky130_fd_pr__nfet_01v8 ad=0.1137 pd=1.01 as=0.0441 ps=0.63 w=0.42 l=0.15
.ends

.subckt sky130_fd_sc_hd__nand3_2 VNB VPB VGND VPWR C A Y B
X0 VGND C a_277_47# VNB sky130_fd_pr__nfet_01v8 ad=0.2015 pd=1.92 as=0.08775 ps=0.92 w=0.65 l=0.15
X1 VPWR B Y VPB sky130_fd_pr__pfet_01v8_hvt ad=0.26 pd=2.52 as=0.135 ps=1.27 w=1 l=0.15
X2 a_277_47# C VGND VNB sky130_fd_pr__nfet_01v8 ad=0.08775 pd=0.92 as=0.169 ps=1.82 w=0.65 l=0.15
X3 Y B VPWR VPB sky130_fd_pr__pfet_01v8_hvt ad=0.135 pd=1.27 as=0.135 ps=1.27 w=1 l=0.15
X4 VPWR A Y VPB sky130_fd_pr__pfet_01v8_hvt ad=0.135 pd=1.27 as=0.135 ps=1.27 w=1 l=0.15
X5 a_27_47# A Y VNB sky130_fd_pr__nfet_01v8 ad=0.08775 pd=0.92 as=0.08775 ps=0.92 w=0.65 l=0.15
X6 a_27_47# B a_277_47# VNB sky130_fd_pr__nfet_01v8 ad=0.169 pd=1.82 as=0.08775 ps=0.92 w=0.65 l=0.15
X7 VPWR C Y VPB sky130_fd_pr__pfet_01v8_hvt ad=0.31 pd=2.62 as=0.135 ps=1.27 w=1 l=0.15
X8 Y C VPWR VPB sky130_fd_pr__pfet_01v8_hvt ad=0.135 pd=1.27 as=0.26 ps=2.52 w=1 l=0.15
X9 a_277_47# B a_27_47# VNB sky130_fd_pr__nfet_01v8 ad=0.08775 pd=0.92 as=0.08775 ps=0.92 w=0.65 l=0.15
X10 Y A VPWR VPB sky130_fd_pr__pfet_01v8_hvt ad=0.135 pd=1.27 as=0.26 ps=2.52 w=1 l=0.15
X11 Y A a_27_47# VNB sky130_fd_pr__nfet_01v8 ad=0.08775 pd=0.92 as=0.169 ps=1.82 w=0.65 l=0.15
.ends

.subckt inv_dcdl_glitchless A Q[0] Q[1] Q[2] Q[3] Q[4] Q[5] VGND VPWR Y clk rst
Xdelay_chain\[36\].genblk1.inv_b.core_inv VPWR VGND VGND VPWR delay_chain\[36\].genblk1.inv_a.out
+ delay_chain\[36\].genblk1.inv_b.out sky130_fd_sc_hd__inv_1
Xdelay_chain\[28\].genblk1.inv_a.core_inv VPWR VGND VGND VPWR delay_chain\[27\].genblk1.inv_b.out
+ delay_chain\[28\].genblk1.inv_a.out sky130_fd_sc_hd__inv_1
XFILLER_22_155 VGND VPWR VPWR VGND sky130_ef_sc_hd__decap_12
XFILLER_22_111 VGND VPWR VPWR VGND sky130_ef_sc_hd__decap_12
XPHY_EDGE_ROW_15_Left_60 VPWR VGND VPWR VGND sky130_fd_sc_hd__decap_3
X_432_ VPWR VGND VPWR VGND _043_ clk sky130_fd_sc_hd__inv_2
X_501_ VGND VPWR VPWR VGND _053_ sel_one_hot\[26\] _052_ sel_reg\[26\] sky130_fd_sc_hd__dfrtp_2
Xdelay_chain\[45\].genblk1.inv_b.core_inv VPWR VGND VGND VPWR delay_chain\[45\].genblk1.inv_a.out
+ delay_chain\[45\].genblk1.inv_b.out sky130_fd_sc_hd__inv_1
XFILLER_26_41 VPWR VGND VPWR VGND sky130_fd_sc_hd__decap_6
XFILLER_9_137 VGND VPWR VPWR VGND sky130_ef_sc_hd__decap_12
X_294_ VGND VPWR VGND VPWR sel_one_hot\[14\] _198_ _179_ Q[5] sky130_fd_sc_hd__and3b_2
X_363_ VPWR VGND VPWR VGND _096_ rst sky130_fd_sc_hd__inv_2
Xdelay_chain\[37\].genblk1.inv_a.core_inv VPWR VGND VGND VPWR delay_chain\[36\].genblk1.inv_b.out
+ delay_chain\[37\].genblk1.inv_a.out sky130_fd_sc_hd__inv_1
Xdelay_chain\[54\].genblk1.inv_b.core_inv VPWR VGND VGND VPWR delay_chain\[54\].genblk1.inv_a.out
+ delay_chain\[54\].genblk1.inv_b.out sky130_fd_sc_hd__inv_1
Xdelay_chain\[46\].genblk1.inv_a.core_inv VPWR VGND VGND VPWR delay_chain\[45\].genblk1.inv_b.out
+ delay_chain\[46\].genblk1.inv_a.out sky130_fd_sc_hd__inv_1
XFILLER_27_225 VGND VPWR VPWR VGND sky130_ef_sc_hd__decap_12
Xdelay_chain\[63\].genblk1.inv_b.core_inv VPWR VGND VGND VPWR delay_chain\[63\].genblk1.inv_a.out
+ delay_chain\[63\].genblk1.inv_b.out sky130_fd_sc_hd__inv_1
XFILLER_10_147 VGND VPWR VPWR VGND sky130_ef_sc_hd__decap_12
XPHY_EDGE_ROW_0_Left_45 VPWR VGND VPWR VGND sky130_fd_sc_hd__decap_3
Xdelay_chain\[55\].genblk1.inv_a.core_inv VPWR VGND VGND VPWR delay_chain\[54\].genblk1.inv_b.out
+ delay_chain\[55\].genblk1.inv_a.out sky130_fd_sc_hd__inv_1
XFILLER_37_51 VGND VPWR VPWR VGND sky130_fd_sc_hd__decap_4
X_415_ VPWR VGND VPWR VGND _009_ clk sky130_fd_sc_hd__inv_2
X_346_ VPWR VGND _171_ sel_one_hot\[61\] _203_ VPWR VGND sky130_fd_sc_hd__and2_2
XFILLER_41_261 VPWR VGND VPWR VGND sky130_fd_sc_hd__decap_6
XFILLER_33_217 VPWR VGND VPWR VGND sky130_fd_sc_hd__decap_6
X_277_ VGND VPWR VGND VPWR Q[2] _188_ Q[3] sky130_fd_sc_hd__nand2b_2
XPHY_EDGE_ROW_42_Left_87 VPWR VGND VPWR VGND sky130_fd_sc_hd__decap_3
XFILLER_2_121 VGND VPWR VPWR VGND sky130_ef_sc_hd__decap_12
XFILLER_2_165 VGND VPWR VPWR VGND sky130_ef_sc_hd__decap_12
XFILLER_0_57 VGND VPWR VPWR VGND sky130_ef_sc_hd__decap_12
X_329_ VPWR VGND _171_ sel_one_hot\[44\] _196_ VPWR VGND sky130_fd_sc_hd__and2_2
XFILLER_20_253 VGND VPWR VPWR VGND sky130_ef_sc_hd__decap_12
Xdelay_chain\[1\].genblk1.inv_b.core_inv VPWR VGND VGND VPWR delay_chain\[1\].genblk1.inv_a.out
+ delay_chain\[1\].genblk1.inv_b.out sky130_fd_sc_hd__inv_1
XFILLER_18_75 VPWR VGND VPWR VGND sky130_fd_sc_hd__decap_8
XFILLER_18_53 VGND VPWR VPWR VGND sky130_ef_sc_hd__decap_12
XFILLER_34_85 VPWR VGND VPWR VGND sky130_fd_sc_hd__decap_8
XFILLER_34_41 VGND VPWR VPWR VGND sky130_ef_sc_hd__decap_12
Xdelay_chain\[2\].genblk1.inv_a.core_inv VPWR VGND VGND VPWR delay_chain\[1\].genblk1.inv_b.out
+ delay_chain\[2\].genblk1.inv_a.out sky130_fd_sc_hd__inv_1
XFILLER_44_109 VPWR VGND VPWR VGND sky130_fd_sc_hd__decap_3
XFILLER_13_3 VGND VPWR VPWR VGND sky130_ef_sc_hd__decap_12
XFILLER_40_189 VPWR VGND VPWR VGND sky130_fd_sc_hd__decap_6
XFILLER_16_197 VGND VPWR VPWR VGND sky130_ef_sc_hd__decap_12
XFILLER_16_153 VGND VPWR VPWR VGND sky130_ef_sc_hd__decap_12
XFILLER_22_167 VGND VPWR VPWR VGND sky130_ef_sc_hd__decap_12
XFILLER_22_123 VPWR VGND VPWR VGND sky130_fd_sc_hd__decap_3
X_500_ VGND VPWR VPWR VGND _051_ sel_one_hot\[25\] _050_ sel_reg\[25\] sky130_fd_sc_hd__dfrtp_2
X_362_ VPWR VGND VPWR VGND _098_ rst sky130_fd_sc_hd__inv_2
X_431_ VPWR VGND VPWR VGND _041_ clk sky130_fd_sc_hd__inv_2
XFILLER_42_41 VGND VPWR VPWR VGND sky130_ef_sc_hd__decap_12
XFILLER_42_85 VGND VPWR VPWR VGND sky130_ef_sc_hd__decap_12
X_293_ Q[2] _198_ Q[3] _172_ VPWR VGND VPWR VGND sky130_fd_sc_hd__and3_2
XFILLER_9_149 VGND VPWR VPWR VGND sky130_ef_sc_hd__decap_12
XFILLER_3_57 VGND VPWR VPWR VGND sky130_ef_sc_hd__decap_12
XFILLER_10_159 VPWR VGND VPWR VGND sky130_fd_sc_hd__decap_6
XFILLER_10_137 VPWR VGND VPWR VGND sky130_fd_sc_hd__decap_3
X_414_ VPWR VGND VPWR VGND _007_ clk sky130_fd_sc_hd__inv_2
XFILLER_33_229 VGND VPWR VPWR VGND sky130_ef_sc_hd__decap_12
X_345_ Q[4] sel_one_hot\[60\] Q[5] _195_ VPWR VGND VPWR VGND sky130_fd_sc_hd__and3_2
X_276_ VGND VPWR VPWR VGND Q[2] _187_ Q[3] sky130_fd_sc_hd__and2b_2
XFILLER_5_185 VGND VPWR VPWR VGND sky130_ef_sc_hd__decap_12
XPHY_EDGE_ROW_12_Right_12 VPWR VGND VPWR VGND sky130_fd_sc_hd__decap_3
XPHY_EDGE_ROW_21_Right_21 VPWR VGND VPWR VGND sky130_fd_sc_hd__decap_3
XPHY_EDGE_ROW_30_Right_30 VPWR VGND VPWR VGND sky130_fd_sc_hd__decap_3
XFILLER_2_133 VPWR VGND VPWR VGND sky130_fd_sc_hd__decap_6
XFILLER_2_177 VGND VPWR VPWR VGND sky130_ef_sc_hd__decap_12
XFILLER_0_69 VGND VPWR VPWR VGND sky130_ef_sc_hd__decap_12
X_328_ VPWR VGND VGND VPWR _194_ sel_one_hot\[43\] _170_ sky130_fd_sc_hd__nor2_2
X_259_ VPWR VGND VPWR VGND _166_ _175_ _173_ Q[4] sky130_fd_sc_hd__or3b_2
XFILLER_43_3 VGND VPWR VPWR VGND sky130_ef_sc_hd__decap_12
XFILLER_20_243 VPWR VGND VPWR VGND sky130_fd_sc_hd__decap_8
XFILLER_7_225 VGND VPWR VPWR VGND sky130_ef_sc_hd__decap_12
XFILLER_34_53 VGND VPWR VPWR VGND sky130_ef_sc_hd__decap_12
XFILLER_3_261 VPWR VGND VPWR VGND sky130_fd_sc_hd__decap_6
XPHY_EDGE_ROW_6_Right_6 VPWR VGND VPWR VGND sky130_fd_sc_hd__decap_3
XFILLER_0_253 VGND VPWR VPWR VGND sky130_ef_sc_hd__decap_12
XFILLER_16_165 VPWR VGND VPWR VGND sky130_fd_sc_hd__decap_6
XFILLER_22_179 VGND VPWR VPWR VGND sky130_ef_sc_hd__decap_12
XFILLER_42_53 VGND VPWR VPWR VGND sky130_ef_sc_hd__decap_12
X_292_ VGND VPWR VGND VPWR sel_one_hot\[13\] _197_ _179_ Q[5] sky130_fd_sc_hd__and3b_2
X_361_ VPWR VGND VPWR VGND _100_ rst sky130_fd_sc_hd__inv_2
X_430_ VPWR VGND VPWR VGND _039_ clk sky130_fd_sc_hd__inv_2
XFILLER_42_97 VGND VPWR VPWR VGND sky130_ef_sc_hd__decap_12
XFILLER_3_69 VGND VPWR VPWR VGND sky130_ef_sc_hd__decap_12
XFILLER_10_105 VPWR VGND VPWR VGND sky130_fd_sc_hd__decap_3
XFILLER_6_109 VGND VPWR VPWR VGND sky130_ef_sc_hd__decap_12
X_413_ VPWR VGND VPWR VGND _005_ clk sky130_fd_sc_hd__inv_2
X_344_ VPWR VGND _171_ sel_one_hot\[59\] _202_ VPWR VGND sky130_fd_sc_hd__and2_2
X_275_ VPWR VGND VGND VPWR _186_ sel_one_hot\[7\] Q[5] sky130_fd_sc_hd__nor2_2
XFILLER_5_197 VGND VPWR VPWR VGND sky130_ef_sc_hd__decap_12
XFILLER_3_3 VGND VPWR VPWR VGND sky130_ef_sc_hd__decap_12
XFILLER_0_15 VGND VPWR VPWR VGND sky130_ef_sc_hd__decap_12
XFILLER_2_189 VPWR VGND VPWR VGND sky130_fd_sc_hd__decap_6
XFILLER_9_57 VGND VPWR VPWR VGND sky130_ef_sc_hd__decap_12
X_327_ VPWR VGND VGND VPWR _193_ sel_one_hot\[42\] _170_ sky130_fd_sc_hd__nor2_2
X_258_ VPWR VGND VPWR VGND _174_ _173_ sky130_fd_sc_hd__inv_2
XFILLER_36_3 VGND VPWR VPWR VGND sky130_ef_sc_hd__decap_12
XFILLER_7_237 VGND VPWR VPWR VGND sky130_ef_sc_hd__decap_12
XFILLER_34_65 VGND VPWR VPWR VGND sky130_ef_sc_hd__decap_12
Xdelay_chain\[11\].genblk1.inv_b.core_inv VPWR VGND VGND VPWR delay_chain\[11\].genblk1.inv_a.out
+ delay_chain\[11\].genblk1.inv_b.out sky130_fd_sc_hd__inv_1
XFILLER_28_141 VGND VPWR VPWR VGND sky130_fd_sc_hd__decap_4
Xdelay_chain\[12\].genblk1.inv_a.core_inv VPWR VGND VGND VPWR delay_chain\[11\].genblk1.inv_b.out
+ delay_chain\[12\].genblk1.inv_a.out sky130_fd_sc_hd__inv_1
Xdelay_chain\[20\].genblk1.inv_b.core_inv VPWR VGND VGND VPWR delay_chain\[20\].genblk1.inv_a.out
+ delay_chain\[20\].genblk1.inv_b.out sky130_fd_sc_hd__inv_1
Xdelay_chain\[21\].genblk1.inv_a.core_inv VPWR VGND VGND VPWR delay_chain\[20\].genblk1.inv_b.out
+ delay_chain\[21\].genblk1.inv_a.out sky130_fd_sc_hd__inv_1
XFILLER_0_221 VPWR VGND VPWR VGND sky130_fd_sc_hd__decap_3
Xdelay_chain\[30\].genblk1.inv_a.core_inv VPWR VGND VGND VPWR delay_chain\[29\].genblk1.inv_b.out
+ delay_chain\[30\].genblk1.inv_a.out sky130_fd_sc_hd__inv_1
XFILLER_31_169 VGND VPWR VPWR VGND sky130_ef_sc_hd__decap_12
XFILLER_39_225 VGND VPWR VPWR VGND sky130_ef_sc_hd__decap_12
XFILLER_42_65 VGND VPWR VPWR VGND sky130_ef_sc_hd__decap_12
X_291_ Q[2] _197_ Q[3] _169_ VPWR VGND VPWR VGND sky130_fd_sc_hd__and3_2
XFILLER_26_77 VPWR VGND VPWR VGND sky130_fd_sc_hd__decap_6
X_360_ VPWR VGND VPWR VGND _102_ rst sky130_fd_sc_hd__inv_2
XFILLER_13_169 VGND VPWR VPWR VGND sky130_ef_sc_hd__decap_12
XFILLER_3_15 VGND VPWR VPWR VGND sky130_ef_sc_hd__decap_12
XFILLER_36_206 VPWR VGND VPWR VGND sky130_fd_sc_hd__decap_3
X_489_ VGND VPWR VPWR VGND _029_ sel_one_hot\[14\] _028_ sel_reg\[14\] sky130_fd_sc_hd__dfrtp_2
XFILLER_12_180 VGND VPWR VPWR VGND sky130_ef_sc_hd__decap_12
XFILLER_42_209 VGND VPWR VPWR VGND sky130_ef_sc_hd__decap_12
XFILLER_27_217 VPWR VGND VPWR VGND sky130_fd_sc_hd__decap_6
XPHY_EDGE_ROW_19_Left_64 VPWR VGND VPWR VGND sky130_fd_sc_hd__decap_3
XFILLER_18_239 VGND VPWR VPWR VGND sky130_ef_sc_hd__decap_12
X_412_ VPWR VGND VPWR VGND _003_ clk sky130_fd_sc_hd__inv_2
X_343_ _180_ sel_one_hot\[58\] _171_ _192_ VPWR VGND VPWR VGND sky130_fd_sc_hd__and3_2
X_274_ VPWR VGND VPWR VGND _185_ _186_ _168_ _178_ sky130_fd_sc_hd__or3b_2
XFILLER_32_253 VGND VPWR VPWR VGND sky130_ef_sc_hd__decap_12
XFILLER_17_261 VPWR VGND VPWR VGND sky130_fd_sc_hd__decap_6
XPHY_EDGE_ROW_4_Left_49 VPWR VGND VPWR VGND sky130_fd_sc_hd__decap_3
XFILLER_23_220 VGND VPWR VPWR VGND sky130_fd_sc_hd__decap_4
XFILLER_23_264 VPWR VGND VPWR VGND sky130_fd_sc_hd__decap_3
XFILLER_9_69 VGND VPWR VPWR VGND sky130_ef_sc_hd__decap_12
X_326_ VPWR VGND VGND VPWR _191_ sel_one_hot\[41\] _170_ sky130_fd_sc_hd__nor2_2
XFILLER_14_253 VGND VPWR VPWR VGND sky130_ef_sc_hd__decap_12
X_257_ VPWR VGND VGND VPWR _173_ Q[1] Q[0] sky130_fd_sc_hd__nand2_2
XFILLER_29_3 VGND VPWR VPWR VGND sky130_ef_sc_hd__decap_12
XFILLER_34_77 VPWR VGND VPWR VGND sky130_fd_sc_hd__decap_6
XFILLER_7_205 VGND VPWR VPWR VGND sky130_ef_sc_hd__decap_12
XFILLER_7_249 VGND VPWR VPWR VGND sky130_ef_sc_hd__decap_12
XFILLER_38_109 VGND VPWR VPWR VGND sky130_ef_sc_hd__decap_12
X_309_ _180_ sel_one_hot\[26\] _170_ _192_ VPWR VGND VPWR VGND sky130_fd_sc_hd__and3_2
XFILLER_1_81 VGND VPWR VPWR VGND sky130_ef_sc_hd__decap_12
XPHY_EDGE_ROW_7_Left_52 VPWR VGND VPWR VGND sky130_fd_sc_hd__decap_3
XFILLER_6_15 VGND VPWR VPWR VGND sky130_ef_sc_hd__decap_12
XFILLER_15_57 VGND VPWR VPWR VGND sky130_fd_sc_hd__decap_4
XPHY_EDGE_ROW_33_Left_78 VPWR VGND VPWR VGND sky130_fd_sc_hd__decap_3
Xdelay_chain\[39\].genblk1.inv_b.core_inv VPWR VGND VGND VPWR delay_chain\[39\].genblk1.inv_a.out
+ delay_chain\[39\].genblk1.inv_b.out sky130_fd_sc_hd__inv_1
XFILLER_39_237 VGND VPWR VPWR VGND sky130_ef_sc_hd__decap_12
Xdelay_chain\[48\].genblk1.inv_b.core_inv VPWR VGND VGND VPWR delay_chain\[48\].genblk1.inv_a.out
+ delay_chain\[48\].genblk1.inv_b.out sky130_fd_sc_hd__inv_1
XFILLER_11_3 VGND VPWR VPWR VGND sky130_ef_sc_hd__decap_12
Xdelay_chain\[57\].genblk1.inv_b.core_inv VPWR VGND VGND VPWR delay_chain\[57\].genblk1.inv_a.out
+ delay_chain\[57\].genblk1.inv_b.out sky130_fd_sc_hd__inv_1
X_290_ VPWR VGND _170_ sel_one_hot\[12\] _196_ VPWR VGND sky130_fd_sc_hd__and2_2
XFILLER_42_77 VPWR VGND VPWR VGND sky130_fd_sc_hd__decap_6
Xdelay_chain\[49\].genblk1.inv_a.core_inv VPWR VGND VGND VPWR delay_chain\[48\].genblk1.inv_b.out
+ delay_chain\[49\].genblk1.inv_a.out sky130_fd_sc_hd__inv_1
XFILLER_21_181 VGND VPWR VPWR VGND sky130_ef_sc_hd__decap_12
XFILLER_3_27 VGND VPWR VPWR VGND sky130_ef_sc_hd__decap_12
X_488_ VGND VPWR VPWR VGND _027_ sel_one_hot\[13\] _026_ sel_reg\[13\] sky130_fd_sc_hd__dfrtp_2
Xdelay_chain\[58\].genblk1.inv_a.core_inv VPWR VGND VGND VPWR delay_chain\[57\].genblk1.inv_b.out
+ delay_chain\[58\].genblk1.inv_a.out sky130_fd_sc_hd__inv_1
XFILLER_12_192 VGND VPWR VPWR VGND sky130_fd_sc_hd__decap_4
XFILLER_35_240 VGND VPWR VPWR VGND sky130_ef_sc_hd__decap_12
X_411_ VPWR VGND VPWR VGND _000_ rst sky130_fd_sc_hd__inv_2
X_342_ _180_ sel_one_hot\[57\] _171_ _190_ VPWR VGND VPWR VGND sky130_fd_sc_hd__and3_2
X_273_ VGND VPWR VGND VPWR _185_ _174_ Q[2] Q[3] sky130_fd_sc_hd__and3b_2
XPHY_EDGE_ROW_36_Left_81 VPWR VGND VPWR VGND sky130_fd_sc_hd__decap_3
XPHY_EDGE_ROW_20_Left_65 VPWR VGND VPWR VGND sky130_fd_sc_hd__decap_3
XFILLER_23_57 VGND VPWR VPWR VGND sky130_ef_sc_hd__decap_12
XFILLER_9_15 VGND VPWR VPWR VGND sky130_ef_sc_hd__decap_12
X_325_ VPWR VGND VGND VPWR _189_ sel_one_hot\[40\] _170_ sky130_fd_sc_hd__nor2_2
Xdelay_chain\[4\].genblk1.inv_b.core_inv VPWR VGND VGND VPWR delay_chain\[4\].genblk1.inv_a.out
+ delay_chain\[4\].genblk1.inv_b.out sky130_fd_sc_hd__inv_1
X_256_ VPWR VGND VGND VPWR Q[4] _166_ _170_ _172_ sel_one_hot\[2\] sky130_fd_sc_hd__and4b_2
Xdelay_chain\[5\].genblk1.inv_a.core_inv VPWR VGND VGND VPWR delay_chain\[4\].genblk1.inv_b.out
+ delay_chain\[5\].genblk1.inv_a.out sky130_fd_sc_hd__inv_1
XFILLER_18_68 VGND VPWR VPWR VGND sky130_fd_sc_hd__decap_4
XFILLER_7_217 VPWR VGND VPWR VGND sky130_fd_sc_hd__decap_6
X_308_ _180_ sel_one_hot\[25\] _170_ _190_ VPWR VGND VPWR VGND sky130_fd_sc_hd__and3_2
X_239_ VPWR VGND VPWR VGND _159_ delay_chain\[27\].genblk1.inv_b.out sel_reg\[27\]
+ sel_reg\[24\] delay_chain\[24\].genblk1.inv_b.out _160_ sky130_fd_sc_hd__a221o_2
XFILLER_41_3 VGND VPWR VPWR VGND sky130_ef_sc_hd__decap_12
XFILLER_1_93 VGND VPWR VPWR VGND sky130_ef_sc_hd__decap_12
XFILLER_4_209 VGND VPWR VPWR VGND sky130_ef_sc_hd__decap_12
XFILLER_43_113 VGND VPWR VPWR VGND sky130_ef_sc_hd__decap_12
XFILLER_28_176 VGND VPWR VPWR VGND sky130_ef_sc_hd__decap_12
XFILLER_28_110 VGND VPWR VPWR VGND sky130_ef_sc_hd__decap_12
XFILLER_19_165 VPWR VGND VPWR VGND sky130_fd_sc_hd__decap_3
XFILLER_19_121 VPWR VGND VPWR VGND sky130_fd_sc_hd__decap_3
XFILLER_31_57 VGND VPWR VPWR VGND sky130_ef_sc_hd__decap_12
XPHY_EDGE_ROW_19_Right_19 VPWR VGND VPWR VGND sky130_fd_sc_hd__decap_3
XFILLER_16_124 VGND VPWR VPWR VGND sky130_ef_sc_hd__decap_12
XFILLER_39_205 VGND VPWR VPWR VGND sky130_ef_sc_hd__decap_12
XPHY_EDGE_ROW_28_Right_28 VPWR VGND VPWR VGND sky130_fd_sc_hd__decap_3
XPHY_EDGE_ROW_37_Right_37 VPWR VGND VPWR VGND sky130_fd_sc_hd__decap_3
XFILLER_39_249 VGND VPWR VPWR VGND sky130_ef_sc_hd__decap_12
XFILLER_22_149 VPWR VGND VPWR VGND sky130_fd_sc_hd__decap_3
XFILLER_7_81 VGND VPWR VPWR VGND sky130_ef_sc_hd__decap_12
XFILLER_21_193 VGND VPWR VPWR VGND sky130_ef_sc_hd__decap_12
XFILLER_3_39 VGND VPWR VPWR VGND sky130_ef_sc_hd__decap_12
X_487_ VGND VPWR VPWR VGND _025_ sel_one_hot\[12\] _024_ sel_reg\[12\] sky130_fd_sc_hd__dfrtp_2
XFILLER_35_252 VGND VPWR VPWR VGND sky130_ef_sc_hd__decap_12
XFILLER_12_15 VGND VPWR VPWR VGND sky130_ef_sc_hd__decap_12
X_341_ VGND VPWR VGND VPWR sel_one_hot\[56\] _187_ _165_ Q[4] Q[5] sky130_fd_sc_hd__and4_2
X_410_ VPWR VGND VPWR VGND _002_ rst sky130_fd_sc_hd__inv_2
X_272_ VPWR VGND VGND VPWR _184_ sel_one_hot\[6\] Q[5] sky130_fd_sc_hd__nor2_2
XFILLER_23_244 VGND VPWR VPWR VGND sky130_ef_sc_hd__decap_12
XFILLER_23_69 VPWR VGND VPWR VGND sky130_fd_sc_hd__decap_3
XFILLER_0_29 VGND VPWR VPWR VGND sky130_ef_sc_hd__decap_12
XFILLER_9_27 VGND VPWR VPWR VGND sky130_ef_sc_hd__decap_12
X_255_ VGND VPWR VPWR VGND Q[0] _172_ Q[1] sky130_fd_sc_hd__and2b_2
X_324_ VPWR VGND VGND VPWR _186_ sel_one_hot\[39\] _170_ sky130_fd_sc_hd__nor2_2
XFILLER_1_181 VGND VPWR VPWR VGND sky130_ef_sc_hd__decap_12
XFILLER_11_225 VGND VPWR VPWR VGND sky130_ef_sc_hd__decap_12
XFILLER_11_203 VGND VPWR VPWR VGND sky130_ef_sc_hd__decap_12
XFILLER_1_3 VGND VPWR VPWR VGND sky130_ef_sc_hd__decap_12
X_238_ VPWR VGND VPWR VGND delay_chain\[30\].genblk1.inv_b.out sel_reg\[30\] sel_reg\[29\]
+ delay_chain\[29\].genblk1.inv_b.out _159_ sky130_fd_sc_hd__a22o_2
X_307_ VPWR VGND VGND VPWR Q[5] Q[4] _165_ _187_ sel_one_hot\[24\] sky130_fd_sc_hd__and4b_2
XFILLER_34_3 VGND VPWR VPWR VGND sky130_ef_sc_hd__decap_12
XFILLER_20_15 VGND VPWR VPWR VGND sky130_ef_sc_hd__decap_12
XFILLER_29_57 VGND VPWR VPWR VGND sky130_ef_sc_hd__decap_12
XFILLER_43_169 VGND VPWR VPWR VGND sky130_ef_sc_hd__decap_12
XFILLER_43_125 VGND VPWR VPWR VGND sky130_ef_sc_hd__decap_12
XFILLER_28_188 VPWR VGND VPWR VGND sky130_fd_sc_hd__decap_8
XFILLER_25_169 VGND VPWR VPWR VGND sky130_ef_sc_hd__decap_12
XFILLER_15_15 VGND VPWR VPWR VGND sky130_ef_sc_hd__decap_12
XFILLER_31_69 VGND VPWR VPWR VGND sky130_fd_sc_hd__decap_4
XFILLER_16_136 VGND VPWR VPWR VGND sky130_fd_sc_hd__decap_4
XFILLER_39_217 VPWR VGND VPWR VGND sky130_fd_sc_hd__decap_6
XFILLER_7_93 VPWR VGND VPWR VGND sky130_fd_sc_hd__decap_8
XFILLER_44_253 VGND VPWR VPWR VGND sky130_ef_sc_hd__decap_12
X_486_ VGND VPWR VPWR VGND _023_ sel_one_hot\[11\] _022_ sel_reg\[11\] sky130_fd_sc_hd__dfrtp_2
XFILLER_8_165 VGND VPWR VPWR VGND sky130_fd_sc_hd__decap_4
XFILLER_35_264 VPWR VGND VPWR VGND sky130_fd_sc_hd__decap_3
XFILLER_37_57 VGND VPWR VPWR VGND sky130_ef_sc_hd__decap_12
XFILLER_26_253 VGND VPWR VPWR VGND sky130_ef_sc_hd__decap_12
XFILLER_26_231 VPWR VGND VPWR VGND sky130_fd_sc_hd__decap_3
X_340_ _180_ sel_one_hot\[55\] _171_ _185_ VPWR VGND VPWR VGND sky130_fd_sc_hd__and3_2
X_271_ VPWR VGND VPWR VGND _183_ _184_ _168_ _178_ sky130_fd_sc_hd__or3b_2
XFILLER_5_113 VGND VPWR VPWR VGND sky130_ef_sc_hd__decap_12
X_538_ VGND VPWR VPWR VGND _127_ sel_one_hot\[63\] _126_ sel_reg\[63\] sky130_fd_sc_hd__dfrtp_2
X_469_ VPWR VGND VPWR VGND _117_ clk sky130_fd_sc_hd__inv_2
XFILLER_23_256 VPWR VGND VPWR VGND sky130_fd_sc_hd__decap_8
XFILLER_23_15 VGND VPWR VPWR VGND sky130_ef_sc_hd__decap_12
XFILLER_9_39 VGND VPWR VPWR VGND sky130_ef_sc_hd__decap_12
X_254_ VPWR VGND VGND VPWR Q[4] _166_ _169_ _170_ sel_one_hot\[1\] sky130_fd_sc_hd__and4b_2
X_323_ VPWR VGND VGND VPWR _184_ sel_one_hot\[38\] _170_ sky130_fd_sc_hd__nor2_2
XFILLER_1_193 VGND VPWR VPWR VGND sky130_ef_sc_hd__decap_12
XFILLER_18_15 VGND VPWR VPWR VGND sky130_ef_sc_hd__decap_12
XFILLER_11_237 VGND VPWR VPWR VGND sky130_ef_sc_hd__decap_12
XFILLER_11_215 VPWR VGND VPWR VGND sky130_fd_sc_hd__decap_8
X_306_ _180_ sel_one_hot\[23\] _170_ _185_ VPWR VGND VPWR VGND sky130_fd_sc_hd__and3_2
Xdelay_chain\[14\].genblk1.inv_b.core_inv VPWR VGND VGND VPWR delay_chain\[14\].genblk1.inv_a.out
+ delay_chain\[14\].genblk1.inv_b.out sky130_fd_sc_hd__inv_1
X_237_ VPWR VGND VPWR VGND _157_ delay_chain\[10\].genblk1.inv_b.out sel_reg\[10\]
+ sel_reg\[9\] delay_chain\[10\].genblk1.inv_a.in _158_ sky130_fd_sc_hd__a221o_2
XFILLER_24_80 VGND VPWR VPWR VGND sky130_fd_sc_hd__decap_4
XFILLER_27_3 VGND VPWR VPWR VGND sky130_ef_sc_hd__decap_12
XFILLER_1_51 VGND VPWR VPWR VGND sky130_fd_sc_hd__decap_4
Xdelay_chain\[15\].genblk1.inv_a.core_inv VPWR VGND VGND VPWR delay_chain\[14\].genblk1.inv_b.out
+ delay_chain\[15\].genblk1.inv_a.out sky130_fd_sc_hd__inv_1
Xdelay_chain\[23\].genblk1.inv_b.core_inv VPWR VGND VGND VPWR delay_chain\[23\].genblk1.inv_a.out
+ delay_chain\[23\].genblk1.inv_b.out sky130_fd_sc_hd__inv_1
XFILLER_29_69 VGND VPWR VPWR VGND sky130_ef_sc_hd__decap_12
XFILLER_43_137 VGND VPWR VPWR VGND sky130_ef_sc_hd__decap_12
XFILLER_6_29 VGND VPWR VPWR VGND sky130_ef_sc_hd__decap_12
Xdelay_chain\[32\].genblk1.inv_b.core_inv VPWR VGND VGND VPWR delay_chain\[32\].genblk1.inv_a.out
+ delay_chain\[32\].genblk1.inv_b.out sky130_fd_sc_hd__inv_1
Xdelay_chain\[24\].genblk1.inv_a.core_inv VPWR VGND VGND VPWR delay_chain\[23\].genblk1.inv_b.out
+ delay_chain\[24\].genblk1.inv_a.out sky130_fd_sc_hd__inv_1
XFILLER_34_115 VGND VPWR VPWR VGND sky130_ef_sc_hd__decap_12
XFILLER_19_145 VGND VPWR VPWR VGND sky130_ef_sc_hd__decap_12
Xdelay_chain\[41\].genblk1.inv_b.core_inv VPWR VGND VGND VPWR delay_chain\[41\].genblk1.inv_a.out
+ delay_chain\[41\].genblk1.inv_b.out sky130_fd_sc_hd__inv_1
Xdelay_chain\[33\].genblk1.inv_a.core_inv VPWR VGND VGND VPWR delay_chain\[32\].genblk1.inv_b.out
+ delay_chain\[33\].genblk1.inv_a.out sky130_fd_sc_hd__inv_1
XFILLER_15_27 VGND VPWR VPWR VGND sky130_ef_sc_hd__decap_12
XFILLER_31_15 VGND VPWR VPWR VGND sky130_ef_sc_hd__decap_12
XFILLER_0_225 VGND VPWR VPWR VGND sky130_ef_sc_hd__decap_12
XPHY_EDGE_ROW_1_Right_1 VPWR VGND VPWR VGND sky130_fd_sc_hd__decap_3
Xdelay_chain\[50\].genblk1.inv_b.core_inv VPWR VGND VGND VPWR delay_chain\[50\].genblk1.inv_a.out
+ delay_chain\[50\].genblk1.inv_b.out sky130_fd_sc_hd__inv_1
Xdelay_chain\[42\].genblk1.inv_a.core_inv VPWR VGND VGND VPWR delay_chain\[41\].genblk1.inv_b.out
+ delay_chain\[42\].genblk1.inv_a.out sky130_fd_sc_hd__inv_1
XFILLER_24_181 VPWR VGND VPWR VGND sky130_fd_sc_hd__decap_3
Xdelay_chain\[51\].genblk1.inv_a.core_inv VPWR VGND VGND VPWR delay_chain\[50\].genblk1.inv_b.out
+ delay_chain\[51\].genblk1.inv_a.out sky130_fd_sc_hd__inv_1
XFILLER_26_15 VGND VPWR VPWR VGND sky130_ef_sc_hd__decap_12
Xdelay_chain\[60\].genblk1.inv_a.core_inv VPWR VGND VGND VPWR delay_chain\[59\].genblk1.inv_b.out
+ delay_chain\[60\].genblk1.inv_a.out sky130_fd_sc_hd__inv_1
XFILLER_44_221 VPWR VGND VPWR VGND sky130_fd_sc_hd__decap_3
X_485_ VGND VPWR VPWR VGND _021_ sel_one_hot\[10\] _020_ sel_reg\[10\] sky130_fd_sc_hd__dfrtp_2
XFILLER_12_162 VPWR VGND VPWR VGND sky130_fd_sc_hd__decap_8
XFILLER_37_69 VGND VPWR VPWR VGND sky130_ef_sc_hd__decap_12
X_270_ VGND VPWR VGND VPWR _183_ _172_ Q[2] Q[3] sky130_fd_sc_hd__and3b_2
XFILLER_5_147 VGND VPWR VPWR VGND sky130_ef_sc_hd__decap_12
XFILLER_5_169 VGND VPWR VPWR VGND sky130_ef_sc_hd__decap_12
X_537_ VGND VPWR VPWR VGND _125_ sel_one_hot\[62\] _124_ sel_reg\[62\] sky130_fd_sc_hd__dfrtp_2
X_468_ VPWR VGND VPWR VGND _115_ clk sky130_fd_sc_hd__inv_2
X_399_ VPWR VGND VPWR VGND _024_ rst sky130_fd_sc_hd__inv_2
XFILLER_23_27 VGND VPWR VPWR VGND sky130_ef_sc_hd__decap_12
X_322_ VPWR VGND VGND VPWR _182_ sel_one_hot\[37\] _170_ sky130_fd_sc_hd__nor2_2
XPHY_EDGE_ROW_24_Left_69 VPWR VGND VPWR VGND sky130_fd_sc_hd__decap_3
X_253_ VPWR VGND _171_ _168_ Q[5] VPWR VGND sky130_fd_sc_hd__xor2_2
XFILLER_1_161 VPWR VGND VPWR VGND sky130_fd_sc_hd__decap_6
XFILLER_9_261 VPWR VGND VPWR VGND sky130_fd_sc_hd__decap_6
XFILLER_34_15 VGND VPWR VPWR VGND sky130_ef_sc_hd__decap_12
XFILLER_11_249 VGND VPWR VPWR VGND sky130_ef_sc_hd__decap_12
XFILLER_24_70 VGND VPWR VPWR VGND sky130_fd_sc_hd__decap_4
X_305_ _180_ sel_one_hot\[22\] _170_ _183_ VPWR VGND VPWR VGND sky130_fd_sc_hd__and3_2
XFILLER_6_253 VGND VPWR VPWR VGND sky130_ef_sc_hd__decap_12
X_236_ VPWR VGND VPWR VGND delay_chain\[15\].genblk1.inv_b.out sel_reg\[15\] sel_reg\[12\]
+ delay_chain\[12\].genblk1.inv_b.out _157_ sky130_fd_sc_hd__a22o_2
XFILLER_37_113 VGND VPWR VPWR VGND sky130_ef_sc_hd__decap_12
XFILLER_29_15 VGND VPWR VPWR VGND sky130_ef_sc_hd__decap_12
XFILLER_43_105 VPWR VGND VPWR VGND sky130_fd_sc_hd__decap_6
XFILLER_43_149 VGND VPWR VPWR VGND sky130_ef_sc_hd__decap_12
XFILLER_19_113 VPWR VGND VPWR VGND sky130_fd_sc_hd__decap_8
XFILLER_34_127 VGND VPWR VPWR VGND sky130_ef_sc_hd__decap_12
XFILLER_19_157 VPWR VGND VPWR VGND sky130_fd_sc_hd__decap_8
X_219_ VPWR VGND VPWR VGND _139_ delay_chain\[42\].genblk1.inv_b.out sel_reg\[42\]
+ sel_reg\[41\] delay_chain\[41\].genblk1.inv_b.out _140_ sky130_fd_sc_hd__a221o_2
XPHY_EDGE_ROW_27_Left_72 VPWR VGND VPWR VGND sky130_fd_sc_hd__decap_3
XPHY_EDGE_ROW_11_Left_56 VPWR VGND VPWR VGND sky130_fd_sc_hd__decap_3
XFILLER_15_39 VGND VPWR VPWR VGND sky130_ef_sc_hd__decap_12
XFILLER_31_27 VGND VPWR VPWR VGND sky130_ef_sc_hd__decap_12
XFILLER_0_237 VGND VPWR VPWR VGND sky130_ef_sc_hd__decap_12
XFILLER_31_108 VGND VPWR VPWR VGND sky130_fd_sc_hd__decap_4
XFILLER_15_160 VGND VPWR VPWR VGND sky130_fd_sc_hd__decap_4
XFILLER_7_51 VGND VPWR VPWR VGND sky130_fd_sc_hd__decap_4
XFILLER_30_174 VGND VPWR VPWR VGND sky130_ef_sc_hd__decap_12
XPHY_EDGE_ROW_15_Right_15 VPWR VGND VPWR VGND sky130_fd_sc_hd__decap_3
XPHY_EDGE_ROW_24_Right_24 VPWR VGND VPWR VGND sky130_fd_sc_hd__decap_3
XFILLER_42_15 VGND VPWR VPWR VGND sky130_ef_sc_hd__decap_12
XPHY_EDGE_ROW_33_Right_33 VPWR VGND VPWR VGND sky130_fd_sc_hd__decap_3
XPHY_EDGE_ROW_42_Right_42 VPWR VGND VPWR VGND sky130_fd_sc_hd__decap_3
X_484_ VGND VPWR VPWR VGND _019_ sel_one_hot\[9\] _018_ sel_reg\[9\] sky130_fd_sc_hd__dfrtp_2
XFILLER_12_29 VGND VPWR VPWR VGND sky130_ef_sc_hd__decap_12
XFILLER_37_15 VGND VPWR VPWR VGND sky130_ef_sc_hd__decap_12
XFILLER_41_225 VGND VPWR VPWR VGND sky130_ef_sc_hd__decap_12
XFILLER_26_211 VPWR VGND VPWR VGND sky130_fd_sc_hd__decap_8
XFILLER_5_159 VPWR VGND VPWR VGND sky130_fd_sc_hd__decap_8
XFILLER_27_81 VGND VPWR VPWR VGND sky130_fd_sc_hd__decap_4
XFILLER_17_211 VPWR VGND VPWR VGND sky130_fd_sc_hd__decap_3
X_398_ VPWR VGND VPWR VGND _026_ rst sky130_fd_sc_hd__inv_2
X_536_ VGND VPWR VPWR VGND _123_ sel_one_hot\[61\] _122_ sel_reg\[61\] sky130_fd_sc_hd__dfrtp_2
X_467_ VPWR VGND VPWR VGND _113_ clk sky130_fd_sc_hd__inv_2
XFILLER_4_41 VGND VPWR VPWR VGND sky130_ef_sc_hd__decap_12
XFILLER_4_85 VGND VPWR VPWR VGND sky130_ef_sc_hd__decap_12
XFILLER_23_225 VGND VPWR VPWR VGND sky130_ef_sc_hd__decap_12
Xdelay_chain\[7\].genblk1.inv_b.core_inv VPWR VGND VGND VPWR delay_chain\[7\].genblk1.inv_a.out
+ delay_chain\[7\].genblk1.inv_b.out sky130_fd_sc_hd__inv_1
XFILLER_23_39 VGND VPWR VPWR VGND sky130_ef_sc_hd__decap_12
X_321_ VPWR VGND VGND VPWR _177_ sel_one_hot\[36\] _170_ sky130_fd_sc_hd__nor2_2
XFILLER_14_225 VGND VPWR VPWR VGND sky130_ef_sc_hd__decap_12
X_252_ VGND VPWR _170_ Q[5] _168_ VPWR VGND sky130_fd_sc_hd__xnor2_2
Xdelay_chain\[8\].genblk1.inv_a.core_inv VPWR VGND VGND VPWR delay_chain\[7\].genblk1.inv_b.out
+ delay_chain\[8\].genblk1.inv_a.out sky130_fd_sc_hd__inv_1
X_519_ VGND VPWR VPWR VGND _089_ sel_one_hot\[44\] _088_ sel_reg\[44\] sky130_fd_sc_hd__dfrtp_2
XPHY_EDGE_ROW_41_Left_86 VPWR VGND VPWR VGND sky130_fd_sc_hd__decap_3
X_235_ VPWR VGND VPWR VGND _155_ delay_chain\[3\].genblk1.inv_b.out sel_reg\[3\] sel_reg\[0\]
+ delay_chain\[0\].genblk1.inv_b.out _156_ sky130_fd_sc_hd__a221o_2
X_304_ _180_ sel_one_hot\[21\] _170_ _181_ VPWR VGND VPWR VGND sky130_fd_sc_hd__and3_2
XFILLER_6_221 VGND VPWR VPWR VGND sky130_ef_sc_hd__decap_12
XFILLER_37_147 VGND VPWR VPWR VGND sky130_ef_sc_hd__decap_12
XFILLER_37_169 VGND VPWR VPWR VGND sky130_ef_sc_hd__decap_12
XFILLER_20_29 VPWR VGND VPWR VGND sky130_fd_sc_hd__decap_6
XFILLER_29_27 VGND VPWR VPWR VGND sky130_ef_sc_hd__decap_12
XFILLER_19_60 VPWR VGND VPWR VGND sky130_fd_sc_hd__decap_8
XFILLER_35_81 VGND VPWR VPWR VGND sky130_fd_sc_hd__decap_4
XFILLER_19_169 VPWR VGND VPWR VGND sky130_fd_sc_hd__decap_8
X_218_ VPWR VGND VPWR VGND delay_chain\[47\].genblk1.inv_b.out sel_reg\[47\] sel_reg\[44\]
+ delay_chain\[44\].genblk1.inv_b.out _139_ sky130_fd_sc_hd__a22o_2
XFILLER_32_3 VGND VPWR VPWR VGND sky130_ef_sc_hd__decap_12
XFILLER_40_109 VGND VPWR VPWR VGND sky130_ef_sc_hd__decap_12
XFILLER_31_39 VGND VPWR VPWR VGND sky130_ef_sc_hd__decap_12
XFILLER_0_249 VPWR VGND VPWR VGND sky130_fd_sc_hd__decap_3
XFILLER_30_197 VPWR VGND VPWR VGND sky130_fd_sc_hd__decap_6
XFILLER_38_253 VGND VPWR VPWR VGND sky130_ef_sc_hd__decap_12
XFILLER_21_175 VPWR VGND VPWR VGND sky130_fd_sc_hd__decap_3
XFILLER_29_242 VGND VPWR VPWR VGND sky130_ef_sc_hd__decap_12
X_483_ VGND VPWR VPWR VGND _017_ sel_one_hot\[8\] _016_ sel_reg\[8\] sky130_fd_sc_hd__dfrtp_2
XFILLER_12_120 VPWR VGND VPWR VGND sky130_fd_sc_hd__decap_6
XFILLER_37_27 VGND VPWR VPWR VGND sky130_ef_sc_hd__decap_12
XFILLER_41_237 VGND VPWR VPWR VGND sky130_ef_sc_hd__decap_12
XFILLER_5_105 VPWR VGND VPWR VGND sky130_fd_sc_hd__decap_6
X_535_ VGND VPWR VPWR VGND _121_ sel_one_hot\[60\] _120_ sel_reg\[60\] sky130_fd_sc_hd__dfrtp_2
XFILLER_43_81 VGND VPWR VPWR VGND sky130_ef_sc_hd__decap_12
X_397_ VPWR VGND VPWR VGND _028_ rst sky130_fd_sc_hd__inv_2
X_466_ VPWR VGND VPWR VGND _111_ clk sky130_fd_sc_hd__inv_2
XFILLER_4_182 VGND VPWR VPWR VGND sky130_ef_sc_hd__decap_12
XFILLER_4_53 VGND VPWR VPWR VGND sky130_ef_sc_hd__decap_12
XFILLER_4_97 VGND VPWR VPWR VGND sky130_ef_sc_hd__decap_12
XFILLER_23_237 VGND VPWR VPWR VGND sky130_fd_sc_hd__decap_4
X_320_ VPWR VGND VGND VPWR _175_ sel_one_hot\[35\] _170_ sky130_fd_sc_hd__nor2_2
XFILLER_14_237 VGND VPWR VPWR VGND sky130_ef_sc_hd__decap_12
X_251_ VPWR VGND Q[5] sel_one_hot\[32\] _168_ VPWR VGND sky130_fd_sc_hd__and2_2
X_518_ VGND VPWR VPWR VGND _087_ sel_one_hot\[43\] _086_ sel_reg\[43\] sky130_fd_sc_hd__dfrtp_2
X_449_ VPWR VGND VPWR VGND _077_ clk sky130_fd_sc_hd__inv_2
XFILLER_18_29 VGND VPWR VPWR VGND sky130_ef_sc_hd__decap_12
X_234_ VPWR VGND VPWR VGND delay_chain\[6\].genblk1.inv_b.out sel_reg\[6\] sel_reg\[5\]
+ delay_chain\[5\].genblk1.inv_b.out _155_ sky130_fd_sc_hd__a22o_2
XFILLER_6_233 VGND VPWR VPWR VGND sky130_ef_sc_hd__decap_12
X_303_ VPWR VGND VPWR VGND sel_one_hot\[20\] _201_ sky130_fd_sc_hd__inv_2
XFILLER_37_159 VPWR VGND VPWR VGND sky130_fd_sc_hd__decap_8
XFILLER_29_39 VGND VPWR VPWR VGND sky130_ef_sc_hd__decap_12
XFILLER_3_225 VGND VPWR VPWR VGND sky130_ef_sc_hd__decap_12
XFILLER_10_85 VGND VPWR VPWR VGND sky130_ef_sc_hd__decap_12
XFILLER_10_41 VGND VPWR VPWR VGND sky130_ef_sc_hd__decap_12
XFILLER_19_94 VPWR VGND VPWR VGND sky130_fd_sc_hd__decap_8
X_217_ VPWR VGND VPWR VGND _137_ delay_chain\[35\].genblk1.inv_b.out sel_reg\[35\]
+ sel_reg\[32\] delay_chain\[32\].genblk1.inv_b.out _138_ sky130_fd_sc_hd__a221o_2
XFILLER_25_3 VGND VPWR VPWR VGND sky130_ef_sc_hd__decap_12
XFILLER_33_140 VPWR VGND VPWR VGND sky130_fd_sc_hd__decap_6
XFILLER_21_51 VGND VPWR VPWR VGND sky130_fd_sc_hd__decap_4
XFILLER_21_95 VPWR VGND VPWR VGND sky130_fd_sc_hd__decap_3
XFILLER_38_221 VGND VPWR VPWR VGND sky130_ef_sc_hd__decap_12
XPHY_EDGE_ROW_5_Right_5 VPWR VGND VPWR VGND sky130_fd_sc_hd__decap_3
XFILLER_26_29 VGND VPWR VPWR VGND sky130_ef_sc_hd__decap_12
XFILLER_29_254 VGND VPWR VPWR VGND sky130_ef_sc_hd__decap_12
XFILLER_29_221 VPWR VGND VPWR VGND sky130_fd_sc_hd__decap_3
X_482_ VGND VPWR VPWR VGND _015_ sel_one_hot\[7\] _014_ sel_reg\[7\] sky130_fd_sc_hd__dfrtp_2
XFILLER_37_39 VGND VPWR VPWR VGND sky130_ef_sc_hd__decap_12
XFILLER_41_205 VGND VPWR VPWR VGND sky130_ef_sc_hd__decap_12
XFILLER_41_249 VGND VPWR VPWR VGND sky130_ef_sc_hd__decap_12
X_534_ VGND VPWR VPWR VGND _119_ sel_one_hot\[59\] _118_ sel_reg\[59\] sky130_fd_sc_hd__dfrtp_2
X_465_ VPWR VGND VPWR VGND _109_ clk sky130_fd_sc_hd__inv_2
XFILLER_43_93 VGND VPWR VPWR VGND sky130_ef_sc_hd__decap_12
X_396_ VPWR VGND VPWR VGND _030_ rst sky130_fd_sc_hd__inv_2
XFILLER_4_65 VGND VPWR VPWR VGND sky130_ef_sc_hd__decap_12
XFILLER_2_109 VGND VPWR VPWR VGND sky130_ef_sc_hd__decap_12
X_250_ VGND VPWR VPWR VGND Q[1] _169_ Q[0] sky130_fd_sc_hd__and2b_2
XFILLER_14_249 VPWR VGND VPWR VGND sky130_fd_sc_hd__decap_3
X_517_ VGND VPWR VPWR VGND _085_ sel_one_hot\[42\] _084_ sel_reg\[42\] sky130_fd_sc_hd__dfrtp_2
X_448_ VPWR VGND VPWR VGND _075_ clk sky130_fd_sc_hd__inv_2
X_379_ VPWR VGND VPWR VGND _064_ rst sky130_fd_sc_hd__inv_2
XFILLER_34_29 VGND VPWR VPWR VGND sky130_ef_sc_hd__decap_12
Xdelay_chain\[17\].genblk1.inv_b.core_inv VPWR VGND VGND VPWR delay_chain\[17\].genblk1.inv_a.out
+ delay_chain\[17\].genblk1.inv_b.out sky130_fd_sc_hd__inv_1
X_302_ VPWR VGND VPWR VGND _176_ Q[4] _201_ Q[5] Q[3] sky130_fd_sc_hd__or4b_2
XFILLER_6_245 VPWR VGND VPWR VGND sky130_fd_sc_hd__decap_6
Xdelay_chain\[26\].genblk1.inv_b.core_inv VPWR VGND VGND VPWR delay_chain\[26\].genblk1.inv_a.out
+ delay_chain\[26\].genblk1.inv_b.out sky130_fd_sc_hd__inv_1
X_233_ VPWR VGND VPWR VGND _149_ _153_ _151_ _147_ _154_ sky130_fd_sc_hd__or4_2
Xdelay_chain\[18\].genblk1.inv_a.core_inv VPWR VGND VGND VPWR delay_chain\[17\].genblk1.inv_b.out
+ delay_chain\[18\].genblk1.inv_a.out sky130_fd_sc_hd__inv_1
Xdelay_chain\[27\].genblk1.inv_a.core_inv VPWR VGND VGND VPWR delay_chain\[26\].genblk1.inv_b.out
+ delay_chain\[27\].genblk1.inv_a.out sky130_fd_sc_hd__inv_1
Xdelay_chain\[35\].genblk1.inv_b.core_inv VPWR VGND VGND VPWR delay_chain\[35\].genblk1.inv_a.out
+ delay_chain\[35\].genblk1.inv_b.out sky130_fd_sc_hd__inv_1
XFILLER_36_193 VPWR VGND VPWR VGND sky130_fd_sc_hd__decap_3
XFILLER_3_237 VGND VPWR VPWR VGND sky130_ef_sc_hd__decap_12
Xdelay_chain\[44\].genblk1.inv_b.core_inv VPWR VGND VGND VPWR delay_chain\[44\].genblk1.inv_a.out
+ delay_chain\[44\].genblk1.inv_b.out sky130_fd_sc_hd__inv_1
Xdelay_chain\[36\].genblk1.inv_a.core_inv VPWR VGND VGND VPWR delay_chain\[35\].genblk1.inv_b.out
+ delay_chain\[36\].genblk1.inv_a.out sky130_fd_sc_hd__inv_1
XFILLER_10_97 VPWR VGND VPWR VGND sky130_fd_sc_hd__decap_8
XFILLER_10_53 VGND VPWR VPWR VGND sky130_ef_sc_hd__decap_12
XFILLER_19_105 VPWR VGND VPWR VGND sky130_fd_sc_hd__decap_6
XFILLER_42_141 VGND VPWR VPWR VGND sky130_ef_sc_hd__decap_12
X_216_ VPWR VGND VPWR VGND delay_chain\[38\].genblk1.inv_b.out sel_reg\[38\] sel_reg\[37\]
+ delay_chain\[37\].genblk1.inv_b.out _137_ sky130_fd_sc_hd__a22o_2
Xdelay_chain\[45\].genblk1.inv_a.core_inv VPWR VGND VGND VPWR delay_chain\[44\].genblk1.inv_b.out
+ delay_chain\[45\].genblk1.inv_a.out sky130_fd_sc_hd__inv_1
Xdelay_chain\[53\].genblk1.inv_b.core_inv VPWR VGND VGND VPWR delay_chain\[53\].genblk1.inv_a.out
+ delay_chain\[53\].genblk1.inv_b.out sky130_fd_sc_hd__inv_1
XFILLER_18_3 VGND VPWR VPWR VGND sky130_ef_sc_hd__decap_12
XFILLER_18_160 VGND VPWR VPWR VGND sky130_ef_sc_hd__decap_12
Xdelay_chain\[62\].genblk1.inv_b.core_inv VPWR VGND VGND VPWR delay_chain\[62\].genblk1.inv_a.out
+ delay_chain\[62\].genblk1.inv_b.out sky130_fd_sc_hd__inv_1
Xdelay_chain\[54\].genblk1.inv_a.core_inv VPWR VGND VGND VPWR delay_chain\[53\].genblk1.inv_b.out
+ delay_chain\[54\].genblk1.inv_a.out sky130_fd_sc_hd__inv_1
XFILLER_24_141 VPWR VGND VPWR VGND sky130_fd_sc_hd__decap_6
Xdelay_chain\[63\].genblk1.inv_a.core_inv VPWR VGND VGND VPWR delay_chain\[62\].genblk1.inv_b.out
+ delay_chain\[63\].genblk1.inv_a.out sky130_fd_sc_hd__inv_1
XFILLER_30_144 VPWR VGND VPWR VGND sky130_fd_sc_hd__decap_3
XFILLER_38_233 VGND VPWR VPWR VGND sky130_ef_sc_hd__decap_12
XFILLER_42_29 VGND VPWR VPWR VGND sky130_ef_sc_hd__decap_12
X_481_ VGND VPWR VPWR VGND _013_ sel_one_hot\[6\] _012_ sel_reg\[6\] sky130_fd_sc_hd__dfrtp_2
XFILLER_44_225 VGND VPWR VPWR VGND sky130_ef_sc_hd__decap_12
XFILLER_16_41 VPWR VGND VPWR VGND sky130_fd_sc_hd__decap_6
XFILLER_16_96 VGND VPWR VPWR VGND sky130_fd_sc_hd__decap_4
XFILLER_16_85 VGND VPWR VPWR VGND sky130_fd_sc_hd__decap_4
XPHY_EDGE_ROW_11_Right_11 VPWR VGND VPWR VGND sky130_fd_sc_hd__decap_3
XPHY_EDGE_ROW_20_Right_20 VPWR VGND VPWR VGND sky130_fd_sc_hd__decap_3
Xdelay_chain\[0\].genblk1.inv_b.core_inv VPWR VGND VGND VPWR delay_chain\[0\].genblk1.inv_a.out
+ delay_chain\[0\].genblk1.inv_b.out sky130_fd_sc_hd__inv_1
XFILLER_26_247 VGND VPWR VPWR VGND sky130_fd_sc_hd__decap_4
XFILLER_41_217 VPWR VGND VPWR VGND sky130_fd_sc_hd__decap_6
XFILLER_17_203 VPWR VGND VPWR VGND sky130_fd_sc_hd__decap_8
XFILLER_32_239 VGND VPWR VPWR VGND sky130_ef_sc_hd__decap_12
X_533_ VGND VPWR VPWR VGND _117_ sel_one_hot\[58\] _116_ sel_reg\[58\] sky130_fd_sc_hd__dfrtp_2
XFILLER_27_51 VGND VPWR VPWR VGND sky130_fd_sc_hd__decap_4
XFILLER_17_225 VGND VPWR VPWR VGND sky130_ef_sc_hd__decap_12
X_464_ VPWR VGND VPWR VGND _107_ clk sky130_fd_sc_hd__inv_2
Xdelay_chain\[1\].genblk1.inv_a.core_inv VPWR VGND VGND VPWR delay_chain\[0\].genblk1.inv_b.out
+ delay_chain\[1\].genblk1.inv_a.out sky130_fd_sc_hd__inv_1
X_395_ VPWR VGND VPWR VGND _032_ rst sky130_fd_sc_hd__inv_2
XFILLER_4_77 VPWR VGND VPWR VGND sky130_fd_sc_hd__decap_6
XPHY_EDGE_ROW_18_Left_63 VPWR VGND VPWR VGND sky130_fd_sc_hd__decap_3
X_516_ VGND VPWR VPWR VGND _083_ sel_one_hot\[41\] _082_ sel_reg\[41\] sky130_fd_sc_hd__dfrtp_2
X_378_ VPWR VGND VPWR VGND _066_ rst sky130_fd_sc_hd__inv_2
X_447_ VPWR VGND VPWR VGND _073_ clk sky130_fd_sc_hd__inv_2
XFILLER_13_261 VPWR VGND VPWR VGND sky130_fd_sc_hd__decap_6
XPHY_EDGE_ROW_3_Left_48 VPWR VGND VPWR VGND sky130_fd_sc_hd__decap_3
XFILLER_24_41 VPWR VGND VPWR VGND sky130_fd_sc_hd__decap_6
X_232_ VPWR VGND VPWR VGND _152_ delay_chain\[51\].genblk1.inv_b.out sel_reg\[51\]
+ sel_reg\[48\] delay_chain\[48\].genblk1.inv_b.out _153_ sky130_fd_sc_hd__a221o_2
X_301_ VPWR VGND VGND VPWR Q[5] Q[4] _166_ _174_ sel_one_hot\[19\] sky130_fd_sc_hd__and4b_2
XFILLER_10_253 VGND VPWR VPWR VGND sky130_ef_sc_hd__decap_12
XFILLER_37_106 VPWR VGND VPWR VGND sky130_fd_sc_hd__decap_6
XFILLER_28_128 VGND VPWR VPWR VGND sky130_ef_sc_hd__decap_12
XFILLER_3_205 VGND VPWR VPWR VGND sky130_ef_sc_hd__decap_12
XFILLER_3_249 VGND VPWR VPWR VGND sky130_ef_sc_hd__decap_12
XFILLER_10_65 VGND VPWR VPWR VGND sky130_ef_sc_hd__decap_12
XFILLER_35_51 VGND VPWR VPWR VGND sky130_fd_sc_hd__decap_4
XFILLER_42_197 VGND VPWR VPWR VGND sky130_ef_sc_hd__decap_12
XFILLER_42_153 VGND VPWR VPWR VGND sky130_ef_sc_hd__decap_12
X_215_ VPWR VGND VPWR VGND _131_ _135_ _133_ _129_ _136_ sky130_fd_sc_hd__or4_2
XFILLER_18_172 VPWR VGND VPWR VGND sky130_fd_sc_hd__decap_8
XFILLER_24_153 VGND VPWR VPWR VGND sky130_ef_sc_hd__decap_12
XPHY_EDGE_ROW_6_Left_51 VPWR VGND VPWR VGND sky130_fd_sc_hd__decap_3
XFILLER_30_156 VPWR VGND VPWR VGND sky130_fd_sc_hd__decap_6
XFILLER_30_3 VGND VPWR VPWR VGND sky130_ef_sc_hd__decap_12
XFILLER_38_245 VPWR VGND VPWR VGND sky130_fd_sc_hd__decap_6
XFILLER_21_134 VGND VPWR VPWR VGND sky130_fd_sc_hd__decap_4
X_480_ VGND VPWR VPWR VGND _011_ sel_one_hot\[5\] _010_ sel_reg\[5\] sky130_fd_sc_hd__dfrtp_2
XFILLER_44_237 VGND VPWR VPWR VGND sky130_ef_sc_hd__decap_12
XPHY_EDGE_ROW_32_Left_77 VPWR VGND VPWR VGND sky130_fd_sc_hd__decap_3
XFILLER_32_41 VGND VPWR VPWR VGND sky130_ef_sc_hd__decap_12
XFILLER_26_204 VGND VPWR VPWR VGND sky130_fd_sc_hd__decap_4
XFILLER_17_237 VGND VPWR VPWR VGND sky130_ef_sc_hd__decap_12
XFILLER_43_51 VGND VPWR VPWR VGND sky130_fd_sc_hd__decap_4
X_532_ VGND VPWR VPWR VGND _115_ sel_one_hot\[57\] _114_ sel_reg\[57\] sky130_fd_sc_hd__dfrtp_2
X_463_ VPWR VGND VPWR VGND _105_ clk sky130_fd_sc_hd__inv_2
X_394_ VPWR VGND VPWR VGND _034_ rst sky130_fd_sc_hd__inv_2
XFILLER_4_141 VGND VPWR VPWR VGND sky130_ef_sc_hd__decap_12
XFILLER_8_3 VGND VPWR VPWR VGND sky130_ef_sc_hd__decap_12
X_515_ VGND VPWR VPWR VGND _081_ sel_one_hot\[40\] _080_ sel_reg\[40\] sky130_fd_sc_hd__dfrtp_2
XPHY_EDGE_ROW_35_Left_80 VPWR VGND VPWR VGND sky130_fd_sc_hd__decap_3
X_377_ VPWR VGND VPWR VGND _068_ rst sky130_fd_sc_hd__inv_2
X_446_ VPWR VGND VPWR VGND _071_ clk sky130_fd_sc_hd__inv_2
XFILLER_39_181 VGND VPWR VPWR VGND sky130_ef_sc_hd__decap_12
X_231_ VPWR VGND VPWR VGND delay_chain\[54\].genblk1.inv_b.out sel_reg\[54\] sel_reg\[53\]
+ delay_chain\[53\].genblk1.inv_b.out _152_ sky130_fd_sc_hd__a22o_2
X_300_ VPWR VGND VGND VPWR Q[5] Q[4] _166_ _172_ sel_one_hot\[18\] sky130_fd_sc_hd__and4b_2
XFILLER_10_232 VGND VPWR VPWR VGND sky130_ef_sc_hd__decap_12
XFILLER_40_41 VGND VPWR VPWR VGND sky130_ef_sc_hd__decap_12
XFILLER_40_85 VGND VPWR VPWR VGND sky130_ef_sc_hd__decap_12
XFILLER_1_57 VGND VPWR VPWR VGND sky130_ef_sc_hd__decap_12
X_429_ VPWR VGND VPWR VGND _037_ clk sky130_fd_sc_hd__inv_2
XFILLER_3_217 VPWR VGND VPWR VGND sky130_fd_sc_hd__decap_6
XFILLER_10_77 VPWR VGND VPWR VGND sky130_fd_sc_hd__decap_6
XFILLER_42_121 VGND VPWR VPWR VGND sky130_ef_sc_hd__decap_12
XFILLER_42_165 VGND VPWR VPWR VGND sky130_ef_sc_hd__decap_12
X_214_ VPWR VGND VPWR VGND _134_ delay_chain\[19\].genblk1.inv_b.out sel_reg\[19\]
+ sel_reg\[16\] delay_chain\[16\].genblk1.inv_b.out _135_ sky130_fd_sc_hd__a221o_2
XFILLER_0_209 VGND VPWR VPWR VGND sky130_ef_sc_hd__decap_12
XFILLER_24_165 VPWR VGND VPWR VGND sky130_fd_sc_hd__decap_8
XFILLER_23_3 VGND VPWR VPWR VGND sky130_ef_sc_hd__decap_12
XFILLER_21_113 VPWR VGND VPWR VGND sky130_fd_sc_hd__decap_8
XFILLER_44_249 VPWR VGND VPWR VGND sky130_fd_sc_hd__decap_3
XFILLER_16_76 VPWR VGND VPWR VGND sky130_fd_sc_hd__decap_8
XFILLER_8_117 VGND VPWR VPWR VGND sky130_ef_sc_hd__decap_12
XFILLER_32_53 VGND VPWR VPWR VGND sky130_ef_sc_hd__decap_12
XFILLER_20_190 VPWR VGND VPWR VGND sky130_fd_sc_hd__decap_6
XFILLER_11_190 VPWR VGND VPWR VGND sky130_fd_sc_hd__decap_6
XPHY_EDGE_ROW_9_Right_9 VPWR VGND VPWR VGND sky130_fd_sc_hd__decap_3
X_531_ VGND VPWR VPWR VGND _113_ sel_one_hot\[56\] _112_ sel_reg\[56\] sky130_fd_sc_hd__dfrtp_2
XFILLER_17_249 VGND VPWR VPWR VGND sky130_ef_sc_hd__decap_12
X_462_ VPWR VGND VPWR VGND _103_ clk sky130_fd_sc_hd__inv_2
X_393_ VPWR VGND VPWR VGND _036_ rst sky130_fd_sc_hd__inv_2
XFILLER_4_153 VGND VPWR VPWR VGND sky130_ef_sc_hd__decap_12
XFILLER_4_197 VGND VPWR VPWR VGND sky130_ef_sc_hd__decap_12
Xdelay_chain\[10\].genblk1.inv_b.core_inv VPWR VGND VGND VPWR delay_chain\[10\].genblk1.inv_a.out
+ delay_chain\[10\].genblk1.inv_b.out sky130_fd_sc_hd__inv_1
XFILLER_22_241 VPWR VGND VPWR VGND sky130_fd_sc_hd__decap_8
XFILLER_38_41 VGND VPWR VPWR VGND sky130_ef_sc_hd__decap_12
XFILLER_38_85 VGND VPWR VPWR VGND sky130_ef_sc_hd__decap_12
X_514_ VGND VPWR VPWR VGND _079_ sel_one_hot\[39\] _078_ sel_reg\[39\] sky130_fd_sc_hd__dfrtp_2
Xdelay_chain\[11\].genblk1.inv_a.core_inv VPWR VGND VGND VPWR delay_chain\[10\].genblk1.inv_b.out
+ delay_chain\[11\].genblk1.inv_a.out sky130_fd_sc_hd__inv_1
X_445_ VPWR VGND VPWR VGND _069_ clk sky130_fd_sc_hd__inv_2
X_376_ VPWR VGND VPWR VGND _070_ rst sky130_fd_sc_hd__inv_2
Xdelay_chain\[20\].genblk1.inv_a.core_inv VPWR VGND VGND VPWR delay_chain\[19\].genblk1.inv_b.out
+ delay_chain\[20\].genblk1.inv_a.out sky130_fd_sc_hd__inv_1
XFILLER_39_193 VGND VPWR VPWR VGND sky130_ef_sc_hd__decap_12
X_230_ VPWR VGND VPWR VGND _150_ delay_chain\[58\].genblk1.inv_b.out sel_reg\[58\]
+ sel_reg\[57\] delay_chain\[57\].genblk1.inv_b.out _151_ sky130_fd_sc_hd__a221o_2
XFILLER_10_244 VPWR VGND VPWR VGND sky130_fd_sc_hd__decap_8
XFILLER_10_200 VGND VPWR VPWR VGND sky130_ef_sc_hd__decap_12
XFILLER_40_53 VGND VPWR VPWR VGND sky130_ef_sc_hd__decap_12
XFILLER_40_97 VGND VPWR VPWR VGND sky130_ef_sc_hd__decap_12
XFILLER_1_69 VGND VPWR VPWR VGND sky130_ef_sc_hd__decap_12
X_428_ VPWR VGND VPWR VGND _035_ clk sky130_fd_sc_hd__inv_2
X_359_ VPWR VGND VPWR VGND _104_ rst sky130_fd_sc_hd__inv_2
XFILLER_42_177 VGND VPWR VPWR VGND sky130_ef_sc_hd__decap_12
XFILLER_42_133 VPWR VGND VPWR VGND sky130_fd_sc_hd__decap_6
X_213_ VPWR VGND VPWR VGND delay_chain\[22\].genblk1.inv_b.out sel_reg\[22\] sel_reg\[21\]
+ delay_chain\[21\].genblk1.inv_b.out _134_ sky130_fd_sc_hd__a22o_2
XFILLER_7_57 VGND VPWR VPWR VGND sky130_ef_sc_hd__decap_12
XFILLER_16_3 VGND VPWR VPWR VGND sky130_ef_sc_hd__decap_12
XFILLER_29_225 VPWR VGND VPWR VGND sky130_fd_sc_hd__decap_6
XFILLER_8_129 VPWR VGND VPWR VGND sky130_fd_sc_hd__decap_6
XFILLER_32_65 VPWR VGND VPWR VGND sky130_fd_sc_hd__decap_6
XFILLER_35_206 VGND VPWR VPWR VGND sky130_ef_sc_hd__decap_12
XFILLER_35_228 VGND VPWR VPWR VGND sky130_ef_sc_hd__decap_12
XFILLER_43_261 VPWR VGND VPWR VGND sky130_fd_sc_hd__decap_6
X_461_ VPWR VGND VPWR VGND _101_ clk sky130_fd_sc_hd__inv_2
X_530_ VGND VPWR VPWR VGND _111_ sel_one_hot\[55\] _110_ sel_reg\[55\] sky130_fd_sc_hd__dfrtp_2
XFILLER_17_217 VPWR VGND VPWR VGND sky130_fd_sc_hd__decap_6
XFILLER_40_253 VGND VPWR VPWR VGND sky130_ef_sc_hd__decap_12
X_392_ VPWR VGND VPWR VGND _038_ rst sky130_fd_sc_hd__inv_2
XFILLER_4_121 VGND VPWR VPWR VGND sky130_ef_sc_hd__decap_12
XFILLER_4_165 VGND VPWR VPWR VGND sky130_ef_sc_hd__decap_12
XFILLER_22_253 VGND VPWR VPWR VGND sky130_ef_sc_hd__decap_12
XFILLER_1_113 VGND VPWR VPWR VGND sky130_ef_sc_hd__decap_12
XFILLER_38_53 VGND VPWR VPWR VGND sky130_ef_sc_hd__decap_12
XFILLER_38_97 VGND VPWR VPWR VGND sky130_ef_sc_hd__decap_12
X_444_ VPWR VGND VPWR VGND _067_ clk sky130_fd_sc_hd__inv_2
X_513_ VGND VPWR VPWR VGND _077_ sel_one_hot\[38\] _076_ sel_reg\[38\] sky130_fd_sc_hd__dfrtp_2
X_375_ VPWR VGND VPWR VGND _072_ rst sky130_fd_sc_hd__inv_2
Xdelay_chain\[29\].genblk1.inv_b.core_inv VPWR VGND VGND VPWR delay_chain\[29\].genblk1.inv_a.out
+ delay_chain\[29\].genblk1.inv_b.out sky130_fd_sc_hd__inv_1
XFILLER_39_161 VPWR VGND VPWR VGND sky130_fd_sc_hd__decap_6
Xdelay_chain\[38\].genblk1.inv_b.core_inv VPWR VGND VGND VPWR delay_chain\[38\].genblk1.inv_a.out
+ delay_chain\[38\].genblk1.inv_b.out sky130_fd_sc_hd__inv_1
XFILLER_10_212 VGND VPWR VPWR VGND sky130_ef_sc_hd__decap_12
XFILLER_40_65 VGND VPWR VPWR VGND sky130_ef_sc_hd__decap_12
XFILLER_1_15 VGND VPWR VPWR VGND sky130_ef_sc_hd__decap_12
X_427_ VPWR VGND VPWR VGND _033_ clk sky130_fd_sc_hd__inv_2
X_358_ VPWR VGND VPWR VGND _106_ rst sky130_fd_sc_hd__inv_2
X_289_ VGND VPWR VPWR VGND Q[4] _196_ _195_ sky130_fd_sc_hd__and2b_2
Xdelay_chain\[47\].genblk1.inv_b.core_inv VPWR VGND VGND VPWR delay_chain\[47\].genblk1.inv_a.out
+ delay_chain\[47\].genblk1.inv_b.out sky130_fd_sc_hd__inv_1
Xdelay_chain\[39\].genblk1.inv_a.core_inv VPWR VGND VGND VPWR delay_chain\[38\].genblk1.inv_b.out
+ delay_chain\[39\].genblk1.inv_a.out sky130_fd_sc_hd__inv_1
XPHY_EDGE_ROW_18_Right_18 VPWR VGND VPWR VGND sky130_fd_sc_hd__decap_3
XPHY_EDGE_ROW_27_Right_27 VPWR VGND VPWR VGND sky130_fd_sc_hd__decap_3
XPHY_EDGE_ROW_36_Right_36 VPWR VGND VPWR VGND sky130_fd_sc_hd__decap_3
Xdelay_chain\[48\].genblk1.inv_a.core_inv VPWR VGND VGND VPWR delay_chain\[47\].genblk1.inv_b.out
+ delay_chain\[48\].genblk1.inv_a.out sky130_fd_sc_hd__inv_1
Xdelay_chain\[56\].genblk1.inv_b.core_inv VPWR VGND VGND VPWR delay_chain\[56\].genblk1.inv_a.out
+ delay_chain\[56\].genblk1.inv_b.out sky130_fd_sc_hd__inv_1
XFILLER_27_131 VGND VPWR VPWR VGND sky130_ef_sc_hd__decap_12
XFILLER_42_189 VPWR VGND VPWR VGND sky130_fd_sc_hd__decap_6
X_212_ VPWR VGND VPWR VGND _132_ delay_chain\[26\].genblk1.inv_b.out sel_reg\[26\]
+ sel_reg\[25\] delay_chain\[25\].genblk1.inv_b.out _133_ sky130_fd_sc_hd__a221o_2
Xdelay_chain\[57\].genblk1.inv_a.core_inv VPWR VGND VGND VPWR delay_chain\[56\].genblk1.inv_b.out
+ delay_chain\[57\].genblk1.inv_a.out sky130_fd_sc_hd__inv_1
XFILLER_7_69 VGND VPWR VPWR VGND sky130_ef_sc_hd__decap_12
XPHY_EDGE_ROW_0_Right_0 VPWR VGND VPWR VGND sky130_fd_sc_hd__decap_3
Xdelay_chain\[3\].genblk1.inv_b.core_inv VPWR VGND VGND VPWR delay_chain\[3\].genblk1.inv_a.out
+ delay_chain\[3\].genblk1.inv_b.out sky130_fd_sc_hd__inv_1
XFILLER_35_218 VPWR VGND VPWR VGND sky130_fd_sc_hd__decap_6
Xdelay_chain\[4\].genblk1.inv_a.core_inv VPWR VGND VGND VPWR delay_chain\[3\].genblk1.inv_b.out
+ delay_chain\[4\].genblk1.inv_a.out sky130_fd_sc_hd__inv_1
X_460_ VPWR VGND VPWR VGND _099_ clk sky130_fd_sc_hd__inv_2
X_391_ VPWR VGND VPWR VGND _040_ rst sky130_fd_sc_hd__inv_2
XFILLER_40_221 VGND VPWR VPWR VGND sky130_ef_sc_hd__decap_12
XFILLER_4_15 VGND VPWR VPWR VGND sky130_ef_sc_hd__decap_12
XFILLER_4_133 VPWR VGND VPWR VGND sky130_fd_sc_hd__decap_6
XFILLER_1_125 VGND VPWR VPWR VGND sky130_ef_sc_hd__decap_12
XFILLER_1_169 VGND VPWR VPWR VGND sky130_ef_sc_hd__decap_12
XFILLER_38_65 VGND VPWR VPWR VGND sky130_ef_sc_hd__decap_12
X_443_ VPWR VGND VPWR VGND _065_ clk sky130_fd_sc_hd__inv_2
X_512_ VGND VPWR VPWR VGND _075_ sel_one_hot\[37\] _074_ sel_reg\[37\] sky130_fd_sc_hd__dfrtp_2
X_374_ VPWR VGND VPWR VGND _074_ rst sky130_fd_sc_hd__inv_2
XFILLER_9_225 VGND VPWR VPWR VGND sky130_ef_sc_hd__decap_12
XFILLER_40_77 VPWR VGND VPWR VGND sky130_fd_sc_hd__decap_6
XFILLER_10_224 VGND VPWR VPWR VGND sky130_fd_sc_hd__decap_4
XFILLER_6_3 VGND VPWR VPWR VGND sky130_ef_sc_hd__decap_12
XPHY_EDGE_ROW_39_Left_84 VPWR VGND VPWR VGND sky130_fd_sc_hd__decap_3
XFILLER_1_27 VGND VPWR VPWR VGND sky130_ef_sc_hd__decap_12
X_426_ VPWR VGND VPWR VGND _031_ clk sky130_fd_sc_hd__inv_2
XPHY_EDGE_ROW_23_Left_68 VPWR VGND VPWR VGND sky130_fd_sc_hd__decap_3
X_357_ VPWR VGND VPWR VGND _108_ rst sky130_fd_sc_hd__inv_2
XFILLER_5_261 VPWR VGND VPWR VGND sky130_fd_sc_hd__decap_6
X_288_ Q[2] _195_ Q[3] _165_ VPWR VGND VPWR VGND sky130_fd_sc_hd__and3_2
XFILLER_39_3 VGND VPWR VPWR VGND sky130_ef_sc_hd__decap_12
XFILLER_36_165 VGND VPWR VPWR VGND sky130_ef_sc_hd__decap_12
XFILLER_27_143 VGND VPWR VPWR VGND sky130_ef_sc_hd__decap_12
X_211_ VPWR VGND VPWR VGND delay_chain\[31\].genblk1.inv_b.out sel_reg\[31\] sel_reg\[28\]
+ delay_chain\[28\].genblk1.inv_b.out _132_ sky130_fd_sc_hd__a22o_2
XFILLER_2_253 VGND VPWR VPWR VGND sky130_ef_sc_hd__decap_12
XFILLER_33_113 VGND VPWR VPWR VGND sky130_ef_sc_hd__decap_12
X_409_ VPWR VGND VPWR VGND _004_ rst sky130_fd_sc_hd__inv_2
XFILLER_7_15 VGND VPWR VPWR VGND sky130_ef_sc_hd__decap_12
XPHY_EDGE_ROW_26_Left_71 VPWR VGND VPWR VGND sky130_fd_sc_hd__decap_3
XPHY_EDGE_ROW_10_Left_55 VPWR VGND VPWR VGND sky130_fd_sc_hd__decap_3
XFILLER_21_3 VGND VPWR VPWR VGND sky130_ef_sc_hd__decap_12
X_390_ VPWR VGND VPWR VGND _042_ rst sky130_fd_sc_hd__inv_2
XFILLER_40_233 VGND VPWR VPWR VGND sky130_ef_sc_hd__decap_12
XFILLER_1_137 VGND VPWR VPWR VGND sky130_ef_sc_hd__decap_12
XFILLER_38_77 VPWR VGND VPWR VGND sky130_fd_sc_hd__decap_6
X_511_ VGND VPWR VPWR VGND _073_ sel_one_hot\[36\] _072_ sel_reg\[36\] sky130_fd_sc_hd__dfrtp_2
X_442_ VPWR VGND VPWR VGND _063_ clk sky130_fd_sc_hd__inv_2
X_373_ VPWR VGND VPWR VGND _076_ rst sky130_fd_sc_hd__inv_2
XFILLER_9_237 VGND VPWR VPWR VGND sky130_ef_sc_hd__decap_12
XFILLER_0_181 VGND VPWR VPWR VGND sky130_ef_sc_hd__decap_12
XFILLER_5_81 VGND VPWR VPWR VGND sky130_ef_sc_hd__decap_12
XFILLER_1_39 VGND VPWR VPWR VGND sky130_ef_sc_hd__decap_12
X_425_ VPWR VGND VPWR VGND _029_ clk sky130_fd_sc_hd__inv_2
X_356_ VPWR VGND VPWR VGND _110_ rst sky130_fd_sc_hd__inv_2
X_287_ VPWR VGND VGND VPWR _194_ sel_one_hot\[11\] Q[5] sky130_fd_sc_hd__nor2_2
XFILLER_36_144 VGND VPWR VPWR VGND sky130_fd_sc_hd__decap_4
XFILLER_36_177 VPWR VGND VPWR VGND sky130_fd_sc_hd__decap_6
XFILLER_10_15 VGND VPWR VPWR VGND sky130_ef_sc_hd__decap_12
XPHY_EDGE_ROW_40_Left_85 VPWR VGND VPWR VGND sky130_fd_sc_hd__decap_3
XFILLER_27_155 VPWR VGND VPWR VGND sky130_fd_sc_hd__decap_8
X_210_ VPWR VGND VPWR VGND _130_ delay_chain\[11\].genblk1.inv_b.out sel_reg\[11\]
+ sel_reg\[8\] delay_chain\[8\].genblk1.inv_b.out _131_ sky130_fd_sc_hd__a221o_2
XFILLER_2_221 VGND VPWR VPWR VGND sky130_ef_sc_hd__decap_12
X_408_ VPWR VGND VPWR VGND _006_ rst sky130_fd_sc_hd__inv_2
X_339_ _180_ sel_one_hot\[54\] _171_ _183_ VPWR VGND VPWR VGND sky130_fd_sc_hd__and3_2
XFILLER_32_180 VPWR VGND VPWR VGND sky130_fd_sc_hd__decap_6
XFILLER_7_27 VGND VPWR VPWR VGND sky130_ef_sc_hd__decap_12
XFILLER_37_261 VPWR VGND VPWR VGND sky130_fd_sc_hd__decap_6
XFILLER_44_209 VGND VPWR VPWR VGND sky130_ef_sc_hd__decap_12
XFILLER_12_106 VGND VPWR VPWR VGND sky130_fd_sc_hd__decap_4
XFILLER_14_3 VGND VPWR VPWR VGND sky130_ef_sc_hd__decap_12
XFILLER_34_253 VGND VPWR VPWR VGND sky130_ef_sc_hd__decap_12
XFILLER_27_57 VPWR VGND VPWR VGND sky130_fd_sc_hd__decap_6
XFILLER_40_245 VPWR VGND VPWR VGND sky130_fd_sc_hd__decap_6
Xdelay_chain\[13\].genblk1.inv_b.core_inv VPWR VGND VGND VPWR delay_chain\[13\].genblk1.inv_a.out
+ delay_chain\[13\].genblk1.inv_b.out sky130_fd_sc_hd__inv_1
XFILLER_16_253 VGND VPWR VPWR VGND sky130_ef_sc_hd__decap_12
XFILLER_31_245 VGND VPWR VPWR VGND sky130_ef_sc_hd__decap_12
Xdelay_chain\[22\].genblk1.inv_b.core_inv VPWR VGND VGND VPWR delay_chain\[22\].genblk1.inv_a.out
+ delay_chain\[22\].genblk1.inv_b.out sky130_fd_sc_hd__inv_1
Xdelay_chain\[14\].genblk1.inv_a.core_inv VPWR VGND VGND VPWR delay_chain\[13\].genblk1.inv_b.out
+ delay_chain\[14\].genblk1.inv_a.out sky130_fd_sc_hd__inv_1
XFILLER_13_15 VGND VPWR VPWR VGND sky130_ef_sc_hd__decap_12
XFILLER_1_105 VPWR VGND VPWR VGND sky130_fd_sc_hd__decap_6
XFILLER_1_149 VGND VPWR VPWR VGND sky130_ef_sc_hd__decap_12
Xdelay_chain\[31\].genblk1.inv_b.core_inv VPWR VGND VGND VPWR delay_chain\[31\].genblk1.inv_a.out
+ delay_chain\[31\].genblk1.inv_b.out sky130_fd_sc_hd__inv_1
X_441_ VPWR VGND VPWR VGND _061_ clk sky130_fd_sc_hd__inv_2
X_510_ VGND VPWR VPWR VGND _071_ sel_one_hot\[35\] _070_ sel_reg\[35\] sky130_fd_sc_hd__dfrtp_2
X_372_ VPWR VGND VPWR VGND _078_ rst sky130_fd_sc_hd__inv_2
Xdelay_chain\[23\].genblk1.inv_a.core_inv VPWR VGND VGND VPWR delay_chain\[22\].genblk1.inv_b.out
+ delay_chain\[23\].genblk1.inv_a.out sky130_fd_sc_hd__inv_1
XFILLER_9_249 VGND VPWR VPWR VGND sky130_ef_sc_hd__decap_12
XFILLER_0_193 VPWR VGND VPWR VGND sky130_fd_sc_hd__decap_3
Xdelay_chain\[40\].genblk1.inv_b.core_inv VPWR VGND VGND VPWR delay_chain\[40\].genblk1.inv_a.out
+ delay_chain\[40\].genblk1.inv_b.out sky130_fd_sc_hd__inv_1
Xdelay_chain\[32\].genblk1.inv_a.core_inv VPWR VGND VGND VPWR delay_chain\[31\].genblk1.inv_b.out
+ delay_chain\[32\].genblk1.inv_a.out sky130_fd_sc_hd__inv_1
XFILLER_5_93 VGND VPWR VPWR VGND sky130_ef_sc_hd__decap_12
Xdelay_chain\[41\].genblk1.inv_a.core_inv VPWR VGND VGND VPWR delay_chain\[40\].genblk1.inv_b.out
+ delay_chain\[41\].genblk1.inv_a.out sky130_fd_sc_hd__inv_1
X_424_ VPWR VGND VPWR VGND _027_ clk sky130_fd_sc_hd__inv_2
X_355_ VPWR VGND VPWR VGND _112_ rst sky130_fd_sc_hd__inv_2
X_286_ VPWR VGND VPWR VGND _173_ _188_ _178_ _168_ _194_ sky130_fd_sc_hd__or4_2
Xdelay_chain\[50\].genblk1.inv_a.core_inv VPWR VGND VGND VPWR delay_chain\[49\].genblk1.inv_b.out
+ delay_chain\[50\].genblk1.inv_a.out sky130_fd_sc_hd__inv_1
XFILLER_35_57 VGND VPWR VPWR VGND sky130_ef_sc_hd__decap_12
XPHY_EDGE_ROW_14_Right_14 VPWR VGND VPWR VGND sky130_fd_sc_hd__decap_3
XFILLER_2_233 VGND VPWR VPWR VGND sky130_ef_sc_hd__decap_12
XPHY_EDGE_ROW_23_Right_23 VPWR VGND VPWR VGND sky130_fd_sc_hd__decap_3
X_407_ VPWR VGND VPWR VGND _008_ rst sky130_fd_sc_hd__inv_2
XFILLER_41_181 VGND VPWR VPWR VGND sky130_ef_sc_hd__decap_12
XPHY_EDGE_ROW_32_Right_32 VPWR VGND VPWR VGND sky130_fd_sc_hd__decap_3
XFILLER_25_90 VPWR VGND VPWR VGND sky130_fd_sc_hd__decap_3
X_338_ _180_ sel_one_hot\[53\] _171_ _181_ VPWR VGND VPWR VGND sky130_fd_sc_hd__and3_2
X_269_ VPWR VGND VGND VPWR _182_ sel_one_hot\[5\] Q[5] sky130_fd_sc_hd__nor2_2
XPHY_EDGE_ROW_41_Right_41 VPWR VGND VPWR VGND sky130_fd_sc_hd__decap_3
XFILLER_44_3 VGND VPWR VPWR VGND sky130_ef_sc_hd__decap_12
XFILLER_24_104 VPWR VGND VPWR VGND sky130_fd_sc_hd__decap_3
XFILLER_21_15 VGND VPWR VPWR VGND sky130_ef_sc_hd__decap_12
XFILLER_15_137 VPWR VGND VPWR VGND sky130_fd_sc_hd__decap_6
XFILLER_7_39 VGND VPWR VPWR VGND sky130_ef_sc_hd__decap_12
XFILLER_14_192 VGND VPWR VPWR VGND sky130_fd_sc_hd__decap_4
XFILLER_16_15 VGND VPWR VPWR VGND sky130_ef_sc_hd__decap_12
XFILLER_28_240 VGND VPWR VPWR VGND sky130_ef_sc_hd__decap_12
XPHY_EDGE_ROW_4_Right_4 VPWR VGND VPWR VGND sky130_fd_sc_hd__decap_3
XFILLER_27_69 VGND VPWR VPWR VGND sky130_ef_sc_hd__decap_12
XFILLER_43_57 VGND VPWR VPWR VGND sky130_ef_sc_hd__decap_12
XFILLER_4_29 VGND VPWR VPWR VGND sky130_ef_sc_hd__decap_12
XFILLER_16_221 VGND VPWR VPWR VGND sky130_ef_sc_hd__decap_12
XFILLER_31_257 VPWR VGND VPWR VGND sky130_fd_sc_hd__decap_8
XFILLER_13_27 VGND VPWR VPWR VGND sky130_ef_sc_hd__decap_12
X_440_ VPWR VGND VPWR VGND _059_ clk sky130_fd_sc_hd__inv_2
X_371_ VPWR VGND VPWR VGND _080_ rst sky130_fd_sc_hd__inv_2
XFILLER_24_15 VGND VPWR VPWR VGND sky130_ef_sc_hd__decap_12
XFILLER_6_209 VGND VPWR VPWR VGND sky130_ef_sc_hd__decap_12
X_423_ VPWR VGND VPWR VGND _025_ clk sky130_fd_sc_hd__inv_2
Xdelay_chain\[59\].genblk1.inv_b.core_inv VPWR VGND VGND VPWR delay_chain\[59\].genblk1.inv_a.out
+ delay_chain\[59\].genblk1.inv_b.out sky130_fd_sc_hd__inv_1
X_354_ VPWR VGND VPWR VGND _114_ rst sky130_fd_sc_hd__inv_2
X_285_ VPWR VGND VGND VPWR _193_ sel_one_hot\[10\] Q[5] sky130_fd_sc_hd__nor2_2
XFILLER_36_113 VGND VPWR VPWR VGND sky130_fd_sc_hd__decap_4
XFILLER_27_113 VGND VPWR VPWR VGND sky130_ef_sc_hd__decap_12
XFILLER_19_15 VGND VPWR VPWR VGND sky130_ef_sc_hd__decap_12
XFILLER_35_69 VGND VPWR VPWR VGND sky130_ef_sc_hd__decap_12
XFILLER_2_245 VPWR VGND VPWR VGND sky130_fd_sc_hd__decap_6
XFILLER_4_3 VGND VPWR VPWR VGND sky130_ef_sc_hd__decap_12
X_406_ VPWR VGND VPWR VGND _010_ rst sky130_fd_sc_hd__inv_2
XFILLER_41_193 VGND VPWR VPWR VGND sky130_ef_sc_hd__decap_12
X_337_ VGND VPWR VGND VPWR Q[3] sel_one_hot\[52\] Q[5] Q[4] _176_ sky130_fd_sc_hd__and4bb_2
X_268_ VPWR VGND VPWR VGND _181_ _182_ _168_ _178_ sky130_fd_sc_hd__or3b_2
XFILLER_37_3 VGND VPWR VPWR VGND sky130_ef_sc_hd__decap_12
XFILLER_21_27 VGND VPWR VPWR VGND sky130_ef_sc_hd__decap_12
Xdelay_chain\[6\].genblk1.inv_b.core_inv VPWR VGND VGND VPWR delay_chain\[6\].genblk1.inv_a.out
+ delay_chain\[6\].genblk1.inv_b.out sky130_fd_sc_hd__inv_1
XFILLER_32_15 VGND VPWR VPWR VGND sky130_ef_sc_hd__decap_12
Xdelay_chain\[7\].genblk1.inv_a.core_inv VPWR VGND VGND VPWR delay_chain\[6\].genblk1.inv_b.out
+ delay_chain\[7\].genblk1.inv_a.out sky130_fd_sc_hd__inv_1
XFILLER_7_101 VPWR VGND VPWR VGND sky130_fd_sc_hd__decap_3
XFILLER_34_200 VGND VPWR VPWR VGND sky130_ef_sc_hd__decap_12
XPHY_EDGE_ROW_14_Left_59 VPWR VGND VPWR VGND sky130_fd_sc_hd__decap_3
XFILLER_27_15 VGND VPWR VPWR VGND sky130_ef_sc_hd__decap_12
XFILLER_25_255 VGND VPWR VPWR VGND sky130_ef_sc_hd__decap_12
XFILLER_43_69 VGND VPWR VPWR VGND sky130_ef_sc_hd__decap_12
XFILLER_16_233 VGND VPWR VPWR VGND sky130_ef_sc_hd__decap_12
XFILLER_3_181 VGND VPWR VPWR VGND sky130_ef_sc_hd__decap_12
XFILLER_13_39 VPWR VGND VPWR VGND sky130_fd_sc_hd__decap_8
X_370_ VPWR VGND VPWR VGND _082_ rst sky130_fd_sc_hd__inv_2
XFILLER_13_225 VGND VPWR VPWR VGND sky130_ef_sc_hd__decap_12
X_499_ VGND VPWR VPWR VGND _049_ sel_one_hot\[24\] _048_ sel_reg\[24\] sky130_fd_sc_hd__dfrtp_2
XFILLER_5_51 VGND VPWR VPWR VGND sky130_fd_sc_hd__decap_4
XFILLER_40_15 VGND VPWR VPWR VGND sky130_ef_sc_hd__decap_12
XPHY_EDGE_ROW_17_Left_62 VPWR VGND VPWR VGND sky130_fd_sc_hd__decap_3
X_353_ VPWR VGND VPWR VGND _116_ rst sky130_fd_sc_hd__inv_2
X_284_ VPWR VGND VPWR VGND _192_ _193_ _168_ _178_ sky130_fd_sc_hd__or3b_2
X_422_ VPWR VGND VPWR VGND _023_ clk sky130_fd_sc_hd__inv_2
XFILLER_14_71 VGND VPWR VPWR VGND sky130_ef_sc_hd__decap_12
XFILLER_5_221 VPWR VGND VPWR VGND sky130_fd_sc_hd__decap_3
XFILLER_10_29 VGND VPWR VPWR VGND sky130_ef_sc_hd__decap_12
XFILLER_35_15 VGND VPWR VPWR VGND sky130_ef_sc_hd__decap_12
XFILLER_19_27 VGND VPWR VPWR VGND sky130_ef_sc_hd__decap_12
XFILLER_27_169 VGND VPWR VPWR VGND sky130_ef_sc_hd__decap_12
XPHY_EDGE_ROW_2_Left_47 VPWR VGND VPWR VGND sky130_fd_sc_hd__decap_3
X_405_ VPWR VGND VPWR VGND _012_ rst sky130_fd_sc_hd__inv_2
XFILLER_41_161 VPWR VGND VPWR VGND sky130_fd_sc_hd__decap_6
X_336_ VGND VPWR VGND VPWR sel_one_hot\[51\] _174_ _166_ Q[4] Q[5] sky130_fd_sc_hd__and4_2
X_267_ VGND VPWR VGND VPWR _181_ _169_ Q[2] Q[3] sky130_fd_sc_hd__and3b_2
XFILLER_2_41 VGND VPWR VPWR VGND sky130_ef_sc_hd__decap_12
XFILLER_2_85 VGND VPWR VPWR VGND sky130_ef_sc_hd__decap_12
XPHY_EDGE_ROW_44_Left_89 VPWR VGND VPWR VGND sky130_fd_sc_hd__decap_3
XFILLER_17_191 VGND VPWR VPWR VGND sky130_ef_sc_hd__decap_12
XFILLER_21_39 VGND VPWR VPWR VGND sky130_ef_sc_hd__decap_12
XFILLER_38_209 VGND VPWR VPWR VGND sky130_ef_sc_hd__decap_12
XFILLER_21_109 VPWR VGND VPWR VGND sky130_fd_sc_hd__decap_3
X_319_ VPWR VGND VGND VPWR Q[4] _166_ _171_ _172_ sel_one_hot\[34\] sky130_fd_sc_hd__and4b_2
XFILLER_29_209 VGND VPWR VPWR VGND sky130_ef_sc_hd__decap_12
XFILLER_28_253 VGND VPWR VPWR VGND sky130_ef_sc_hd__decap_12
XFILLER_7_113 VPWR VGND VPWR VGND sky130_fd_sc_hd__decap_6
XFILLER_11_153 VPWR VGND VPWR VGND sky130_fd_sc_hd__decap_6
XFILLER_11_131 VGND VPWR VPWR VGND sky130_ef_sc_hd__decap_12
XPHY_EDGE_ROW_5_Left_50 VPWR VGND VPWR VGND sky130_fd_sc_hd__decap_3
XFILLER_27_27 VGND VPWR VPWR VGND sky130_ef_sc_hd__decap_12
XFILLER_43_15 VGND VPWR VPWR VGND sky130_ef_sc_hd__decap_12
XPHY_EDGE_ROW_31_Left_76 VPWR VGND VPWR VGND sky130_fd_sc_hd__decap_3
XFILLER_31_215 VPWR VGND VPWR VGND sky130_fd_sc_hd__decap_8
XFILLER_16_245 VPWR VGND VPWR VGND sky130_fd_sc_hd__decap_6
XFILLER_3_193 VGND VPWR VPWR VGND sky130_ef_sc_hd__decap_12
XFILLER_12_3 VGND VPWR VPWR VGND sky130_ef_sc_hd__decap_12
XFILLER_38_15 VGND VPWR VPWR VGND sky130_ef_sc_hd__decap_12
XFILLER_13_237 VGND VPWR VPWR VGND sky130_ef_sc_hd__decap_12
XFILLER_0_141 VGND VPWR VPWR VGND sky130_ef_sc_hd__decap_12
X_498_ VGND VPWR VPWR VGND _047_ sel_one_hot\[23\] _046_ sel_reg\[23\] sky130_fd_sc_hd__dfrtp_2
X_421_ VPWR VGND VPWR VGND _021_ clk sky130_fd_sc_hd__inv_2
X_352_ VPWR VGND VPWR VGND _118_ rst sky130_fd_sc_hd__inv_2
X_283_ VPWR VGND _172_ _192_ _187_ VPWR VGND sky130_fd_sc_hd__and2_2
XFILLER_44_181 VGND VPWR VPWR VGND sky130_ef_sc_hd__decap_12
XFILLER_35_27 VGND VPWR VPWR VGND sky130_ef_sc_hd__decap_12
XFILLER_19_39 VPWR VGND VPWR VGND sky130_fd_sc_hd__decap_6
X_404_ VPWR VGND VPWR VGND _014_ rst sky130_fd_sc_hd__inv_2
XFILLER_18_148 VGND VPWR VPWR VGND sky130_ef_sc_hd__decap_12
XFILLER_41_81 VGND VPWR VPWR VGND sky130_ef_sc_hd__decap_12
X_335_ VGND VPWR VGND VPWR sel_one_hot\[50\] _172_ _166_ Q[4] Q[5] sky130_fd_sc_hd__and4_2
X_266_ VPWR VGND VPWR VGND _180_ _168_ _178_ sky130_fd_sc_hd__or2_2
XFILLER_2_53 VGND VPWR VPWR VGND sky130_ef_sc_hd__decap_12
XFILLER_2_97 VGND VPWR VPWR VGND sky130_ef_sc_hd__decap_12
XPHY_EDGE_ROW_10_Right_10 VPWR VGND VPWR VGND sky130_fd_sc_hd__decap_3
XFILLER_11_51 VGND VPWR VPWR VGND sky130_fd_sc_hd__decap_4
X_318_ VPWR VGND VGND VPWR Q[4] _166_ _169_ _171_ sel_one_hot\[33\] sky130_fd_sc_hd__and4b_2
X_249_ VGND VPWR VPWR VGND Q[5] sel_one_hot\[0\] _168_ sky130_fd_sc_hd__and2b_2
XFILLER_42_3 VGND VPWR VPWR VGND sky130_ef_sc_hd__decap_12
XFILLER_16_29 VGND VPWR VPWR VGND sky130_ef_sc_hd__decap_12
XFILLER_20_121 VPWR VGND VPWR VGND sky130_fd_sc_hd__decap_6
XFILLER_28_210 VGND VPWR VPWR VGND sky130_ef_sc_hd__decap_12
XFILLER_11_143 VPWR VGND VPWR VGND sky130_fd_sc_hd__decap_6
XFILLER_34_235 VGND VPWR VPWR VGND sky130_ef_sc_hd__decap_12
XFILLER_8_41 VGND VPWR VPWR VGND sky130_ef_sc_hd__decap_12
XFILLER_6_191 VGND VPWR VPWR VGND sky130_fd_sc_hd__decap_4
Xdelay_chain\[16\].genblk1.inv_b.core_inv VPWR VGND VGND VPWR delay_chain\[16\].genblk1.inv_a.out
+ delay_chain\[16\].genblk1.inv_b.out sky130_fd_sc_hd__inv_1
XFILLER_27_39 VGND VPWR VPWR VGND sky130_ef_sc_hd__decap_12
XFILLER_43_27 VGND VPWR VPWR VGND sky130_ef_sc_hd__decap_12
Xdelay_chain\[25\].genblk1.inv_b.core_inv VPWR VGND VGND VPWR delay_chain\[25\].genblk1.inv_a.out
+ delay_chain\[25\].genblk1.inv_b.out sky130_fd_sc_hd__inv_1
XFILLER_17_83 VGND VPWR VPWR VGND sky130_ef_sc_hd__decap_12
Xdelay_chain\[17\].genblk1.inv_a.core_inv VPWR VGND VGND VPWR delay_chain\[16\].genblk1.inv_b.out
+ delay_chain\[17\].genblk1.inv_a.out sky130_fd_sc_hd__inv_1
XFILLER_3_161 VPWR VGND VPWR VGND sky130_fd_sc_hd__decap_6
Xdelay_chain\[34\].genblk1.inv_b.core_inv VPWR VGND VGND VPWR delay_chain\[34\].genblk1.inv_a.out
+ delay_chain\[34\].genblk1.inv_b.out sky130_fd_sc_hd__inv_1
XPHY_EDGE_ROW_8_Right_8 VPWR VGND VPWR VGND sky130_fd_sc_hd__decap_3
Xdelay_chain\[26\].genblk1.inv_a.core_inv VPWR VGND VGND VPWR delay_chain\[25\].genblk1.inv_b.out
+ delay_chain\[26\].genblk1.inv_a.out sky130_fd_sc_hd__inv_1
XFILLER_22_249 VPWR VGND VPWR VGND sky130_fd_sc_hd__decap_3
XPHY_EDGE_ROW_39_Right_39 VPWR VGND VPWR VGND sky130_fd_sc_hd__decap_3
Xdelay_chain\[43\].genblk1.inv_b.core_inv VPWR VGND VGND VPWR delay_chain\[43\].genblk1.inv_a.out
+ delay_chain\[43\].genblk1.inv_b.out sky130_fd_sc_hd__inv_1
Xdelay_chain\[35\].genblk1.inv_a.core_inv VPWR VGND VGND VPWR delay_chain\[34\].genblk1.inv_b.out
+ delay_chain\[35\].genblk1.inv_a.out sky130_fd_sc_hd__inv_1
XFILLER_13_249 VGND VPWR VPWR VGND sky130_ef_sc_hd__decap_12
XFILLER_0_153 VGND VPWR VPWR VGND sky130_ef_sc_hd__decap_12
XFILLER_0_197 VGND VPWR VPWR VGND sky130_ef_sc_hd__decap_12
Xdelay_chain\[44\].genblk1.inv_a.core_inv VPWR VGND VGND VPWR delay_chain\[43\].genblk1.inv_b.out
+ delay_chain\[44\].genblk1.inv_a.out sky130_fd_sc_hd__inv_1
Xdelay_chain\[52\].genblk1.inv_b.core_inv VPWR VGND VGND VPWR delay_chain\[52\].genblk1.inv_a.out
+ delay_chain\[52\].genblk1.inv_b.out sky130_fd_sc_hd__inv_1
X_497_ VGND VPWR VPWR VGND _045_ sel_one_hot\[22\] _044_ sel_reg\[22\] sky130_fd_sc_hd__dfrtp_2
XFILLER_8_253 VGND VPWR VPWR VGND sky130_ef_sc_hd__decap_12
XFILLER_44_81 VPWR VGND VPWR VGND sky130_fd_sc_hd__decap_3
XFILLER_39_113 VGND VPWR VPWR VGND sky130_ef_sc_hd__decap_12
Xdelay_chain\[61\].genblk1.inv_b.core_inv VPWR VGND VGND VPWR delay_chain\[61\].genblk1.inv_a.out
+ delay_chain\[61\].genblk1.inv_b.out sky130_fd_sc_hd__inv_1
XFILLER_24_29 VGND VPWR VPWR VGND sky130_ef_sc_hd__decap_12
Xdelay_chain\[53\].genblk1.inv_a.core_inv VPWR VGND VGND VPWR delay_chain\[52\].genblk1.inv_b.out
+ delay_chain\[53\].genblk1.inv_a.out sky130_fd_sc_hd__inv_1
X_351_ VPWR VGND VPWR VGND _120_ rst sky130_fd_sc_hd__inv_2
X_420_ VPWR VGND VPWR VGND _019_ clk sky130_fd_sc_hd__inv_2
Xdelay_chain\[62\].genblk1.inv_a.core_inv VPWR VGND VGND VPWR delay_chain\[61\].genblk1.inv_b.out
+ delay_chain\[62\].genblk1.inv_a.out sky130_fd_sc_hd__inv_1
X_282_ VPWR VGND VGND VPWR _191_ sel_one_hot\[9\] Q[5] sky130_fd_sc_hd__nor2_2
XFILLER_39_81 VGND VPWR VPWR VGND sky130_ef_sc_hd__decap_12
XFILLER_44_193 VPWR VGND VPWR VGND sky130_fd_sc_hd__decap_3
XFILLER_35_39 VGND VPWR VPWR VGND sky130_ef_sc_hd__decap_12
XFILLER_18_127 VGND VPWR VPWR VGND sky130_ef_sc_hd__decap_12
X_334_ VGND VPWR VGND VPWR sel_one_hot\[49\] _169_ _166_ Q[4] Q[5] sky130_fd_sc_hd__and4_2
X_403_ VPWR VGND VPWR VGND _016_ rst sky130_fd_sc_hd__inv_2
XFILLER_41_93 VGND VPWR VPWR VGND sky130_ef_sc_hd__decap_12
X_265_ VPWR VGND VGND VPWR _178_ _179_ _168_ sky130_fd_sc_hd__nor2_2
XFILLER_2_65 VGND VPWR VPWR VGND sky130_ef_sc_hd__decap_12
XFILLER_32_141 VPWR VGND VPWR VGND sky130_fd_sc_hd__decap_8
XFILLER_15_119 VGND VPWR VPWR VGND sky130_ef_sc_hd__decap_12
XFILLER_15_108 VGND VPWR VPWR VGND sky130_fd_sc_hd__decap_4
XFILLER_23_196 VPWR VGND VPWR VGND sky130_fd_sc_hd__decap_8
XFILLER_2_3 VGND VPWR VPWR VGND sky130_ef_sc_hd__decap_12
Xdelay_chain\[0\].genblk1.inv_a.core_inv VPWR VGND VGND VPWR A delay_chain\[0\].genblk1.inv_a.out
+ sky130_fd_sc_hd__inv_1
X_317_ _180_ sel_one_hot\[31\] _170_ _199_ VPWR VGND VPWR VGND sky130_fd_sc_hd__and3_2
X_248_ VPWR VGND VGND VPWR _167_ _168_ Q[4] sky130_fd_sc_hd__nor2_2
XFILLER_35_3 VGND VPWR VPWR VGND sky130_ef_sc_hd__decap_12
XFILLER_32_29 VGND VPWR VPWR VGND sky130_ef_sc_hd__decap_12
XFILLER_43_225 VGND VPWR VPWR VGND sky130_ef_sc_hd__decap_12
XFILLER_28_222 VGND VPWR VPWR VGND sky130_ef_sc_hd__decap_12
XFILLER_34_247 VGND VPWR VPWR VGND sky130_fd_sc_hd__decap_4
XFILLER_8_53 VGND VPWR VPWR VGND sky130_ef_sc_hd__decap_12
XFILLER_43_39 VGND VPWR VPWR VGND sky130_ef_sc_hd__decap_12
XFILLER_31_228 VPWR VGND VPWR VGND sky130_fd_sc_hd__decap_3
XFILLER_22_217 VGND VPWR VPWR VGND sky130_ef_sc_hd__decap_12
XFILLER_13_206 VGND VPWR VPWR VGND sky130_ef_sc_hd__decap_12
XFILLER_0_165 VPWR VGND VPWR VGND sky130_fd_sc_hd__decap_3
X_496_ VGND VPWR VPWR VGND _043_ sel_one_hot\[21\] _042_ sel_reg\[21\] sky130_fd_sc_hd__dfrtp_2
XFILLER_39_125 VGND VPWR VPWR VGND sky130_ef_sc_hd__decap_12
XFILLER_39_169 VGND VPWR VPWR VGND sky130_ef_sc_hd__decap_12
XFILLER_40_29 VGND VPWR VPWR VGND sky130_ef_sc_hd__decap_12
X_350_ VPWR VGND VPWR VGND _122_ rst sky130_fd_sc_hd__inv_2
X_281_ VPWR VGND VPWR VGND _190_ _191_ _168_ _178_ sky130_fd_sc_hd__or3b_2
XFILLER_14_96 VGND VPWR VPWR VGND sky130_fd_sc_hd__decap_4
XFILLER_14_85 VGND VPWR VPWR VGND sky130_fd_sc_hd__decap_4
XFILLER_14_41 VPWR VGND VPWR VGND sky130_fd_sc_hd__decap_8
XFILLER_39_93 VGND VPWR VPWR VGND sky130_ef_sc_hd__decap_12
X_479_ VGND VPWR VPWR VGND _009_ sel_one_hot\[4\] _008_ sel_reg\[4\] sky130_fd_sc_hd__dfrtp_2
XFILLER_42_109 VGND VPWR VPWR VGND sky130_ef_sc_hd__decap_12
X_402_ VPWR VGND VPWR VGND _018_ rst sky130_fd_sc_hd__inv_2
X_264_ VPWR VGND Q[4] _178_ _167_ VPWR VGND sky130_fd_sc_hd__and2_2
X_333_ VPWR VGND VGND VPWR _200_ sel_one_hot\[48\] _170_ sky130_fd_sc_hd__nor2_2
XFILLER_2_77 VPWR VGND VPWR VGND sky130_fd_sc_hd__decap_6
XFILLER_32_153 VPWR VGND VPWR VGND sky130_fd_sc_hd__decap_8
XFILLER_23_131 VGND VPWR VPWR VGND sky130_ef_sc_hd__decap_12
Xdelay_chain\[9\].genblk1.inv_b.core_inv VPWR VGND VGND VPWR delay_chain\[9\].genblk1.inv_a.out
+ delay_chain\[10\].genblk1.inv_a.in sky130_fd_sc_hd__inv_1
XFILLER_11_86 VPWR VGND VPWR VGND sky130_fd_sc_hd__decap_8
X_316_ VPWR VGND _170_ sel_one_hot\[30\] _204_ VPWR VGND sky130_fd_sc_hd__and2_2
X_247_ VPWR VGND VGND VPWR _167_ _165_ _166_ sky130_fd_sc_hd__nand2_2
XFILLER_28_3 VGND VPWR VPWR VGND sky130_ef_sc_hd__decap_12
XFILLER_43_237 VGND VPWR VPWR VGND sky130_ef_sc_hd__decap_12
XFILLER_28_234 VPWR VGND VPWR VGND sky130_fd_sc_hd__decap_3
XFILLER_22_41 VGND VPWR VPWR VGND sky130_ef_sc_hd__decap_12
XFILLER_8_65 VGND VPWR VPWR VGND sky130_ef_sc_hd__decap_12
XPHY_EDGE_ROW_9_Left_54 VPWR VGND VPWR VGND sky130_fd_sc_hd__decap_3
XFILLER_31_207 VGND VPWR VPWR VGND sky130_fd_sc_hd__decap_4
XFILLER_33_51 VGND VPWR VPWR VGND sky130_fd_sc_hd__decap_4
XFILLER_22_229 VPWR VGND VPWR VGND sky130_fd_sc_hd__decap_8
XFILLER_38_29 VGND VPWR VPWR VGND sky130_ef_sc_hd__decap_12
XFILLER_13_218 VPWR VGND VPWR VGND sky130_fd_sc_hd__decap_6
XFILLER_8_211 VGND VPWR VPWR VGND sky130_ef_sc_hd__decap_12
X_495_ VGND VPWR VPWR VGND _041_ sel_one_hot\[20\] _040_ sel_reg\[20\] sky130_fd_sc_hd__dfrtp_2
XFILLER_39_137 VGND VPWR VPWR VGND sky130_ef_sc_hd__decap_12
XFILLER_10_3 VGND VPWR VPWR VGND sky130_ef_sc_hd__decap_12
X_280_ VPWR VGND _169_ _190_ _187_ VPWR VGND sky130_fd_sc_hd__and2_2
XFILLER_5_225 VGND VPWR VPWR VGND sky130_ef_sc_hd__decap_12
XFILLER_30_41 VGND VPWR VPWR VGND sky130_ef_sc_hd__decap_12
XFILLER_30_85 VGND VPWR VPWR VGND sky130_ef_sc_hd__decap_12
X_478_ VGND VPWR VPWR VGND _007_ sel_one_hot\[3\] _006_ sel_reg\[3\] sky130_fd_sc_hd__dfrtp_2
XFILLER_27_107 VGND VPWR VPWR VGND sky130_fd_sc_hd__decap_4
X_401_ VPWR VGND VPWR VGND _020_ rst sky130_fd_sc_hd__inv_2
X_332_ _179_ sel_one_hot\[47\] _171_ _199_ VPWR VGND VPWR VGND sky130_fd_sc_hd__and3_2
X_263_ VPWR VGND VGND VPWR _177_ sel_one_hot\[4\] _171_ sky130_fd_sc_hd__nor2_2
XPHY_EDGE_ROW_38_Left_83 VPWR VGND VPWR VGND sky130_fd_sc_hd__decap_3
XFILLER_41_51 VGND VPWR VPWR VGND sky130_fd_sc_hd__decap_4
XFILLER_1_261 VPWR VGND VPWR VGND sky130_fd_sc_hd__decap_6
XPHY_EDGE_ROW_22_Left_67 VPWR VGND VPWR VGND sky130_fd_sc_hd__decap_3
XFILLER_32_165 VPWR VGND VPWR VGND sky130_fd_sc_hd__decap_8
XFILLER_23_143 VGND VPWR VPWR VGND sky130_ef_sc_hd__decap_12
XFILLER_11_98 VGND VPWR VPWR VGND sky130_ef_sc_hd__decap_12
X_315_ VGND VPWR VGND VPWR _204_ _198_ _178_ _168_ sky130_fd_sc_hd__o21a_2
X_246_ VPWR VGND VGND VPWR Q[2] _166_ Q[3] sky130_fd_sc_hd__nor2_2
XFILLER_14_176 VGND VPWR VPWR VGND sky130_ef_sc_hd__decap_12
XFILLER_43_249 VGND VPWR VPWR VGND sky130_ef_sc_hd__decap_12
XFILLER_43_205 VGND VPWR VPWR VGND sky130_ef_sc_hd__decap_12
XFILLER_22_53 VPWR VGND VPWR VGND sky130_fd_sc_hd__decap_6
Xdelay_chain\[10\].genblk1.inv_a.core_inv VPWR VGND VGND VPWR delay_chain\[10\].genblk1.inv_a.in
+ delay_chain\[10\].genblk1.inv_a.out sky130_fd_sc_hd__inv_1
XFILLER_19_246 VGND VPWR VPWR VGND sky130_ef_sc_hd__decap_12
XFILLER_6_161 VPWR VGND VPWR VGND sky130_fd_sc_hd__decap_6
XFILLER_8_77 VPWR VGND VPWR VGND sky130_fd_sc_hd__decap_6
X_229_ VPWR VGND VPWR VGND delay_chain\[63\].genblk1.inv_b.out sel_reg\[63\] sel_reg\[60\]
+ delay_chain\[60\].genblk1.inv_b.out _150_ sky130_fd_sc_hd__a22o_2
XFILLER_40_3 VGND VPWR VPWR VGND sky130_ef_sc_hd__decap_12
XPHY_EDGE_ROW_25_Left_70 VPWR VGND VPWR VGND sky130_fd_sc_hd__decap_3
XFILLER_4_109 VGND VPWR VPWR VGND sky130_ef_sc_hd__decap_12
XPHY_EDGE_ROW_17_Right_17 VPWR VGND VPWR VGND sky130_fd_sc_hd__decap_3
XPHY_EDGE_ROW_26_Right_26 VPWR VGND VPWR VGND sky130_fd_sc_hd__decap_3
XFILLER_28_41 VGND VPWR VPWR VGND sky130_ef_sc_hd__decap_12
XFILLER_8_223 VGND VPWR VPWR VGND sky130_ef_sc_hd__decap_12
XPHY_EDGE_ROW_35_Right_35 VPWR VGND VPWR VGND sky130_fd_sc_hd__decap_3
X_494_ VGND VPWR VPWR VGND _039_ sel_one_hot\[19\] _038_ sel_reg\[19\] sky130_fd_sc_hd__dfrtp_2
XFILLER_39_105 VPWR VGND VPWR VGND sky130_fd_sc_hd__decap_6
XFILLER_39_149 VGND VPWR VPWR VGND sky130_ef_sc_hd__decap_12
XPHY_EDGE_ROW_44_Right_44 VPWR VGND VPWR VGND sky130_fd_sc_hd__decap_3
XFILLER_5_237 VGND VPWR VPWR VGND sky130_ef_sc_hd__decap_12
XFILLER_30_97 VPWR VGND VPWR VGND sky130_fd_sc_hd__decap_8
XFILLER_30_53 VGND VPWR VPWR VGND sky130_ef_sc_hd__decap_12
XFILLER_39_51 VGND VPWR VPWR VGND sky130_fd_sc_hd__decap_4
XFILLER_44_141 VGND VPWR VPWR VGND sky130_ef_sc_hd__decap_12
X_477_ VGND VPWR VPWR VGND _005_ sel_one_hot\[2\] _004_ sel_reg\[2\] sky130_fd_sc_hd__dfrtp_2
X_331_ _179_ sel_one_hot\[46\] _171_ _198_ VPWR VGND VPWR VGND sky130_fd_sc_hd__and3_2
XFILLER_26_141 VGND VPWR VPWR VGND sky130_ef_sc_hd__decap_12
X_400_ VPWR VGND VPWR VGND _022_ rst sky130_fd_sc_hd__inv_2
X_262_ VGND VPWR VPWR VGND Q[3] _176_ Q[4] _177_ sky130_fd_sc_hd__or3_2
X_529_ VGND VPWR VPWR VGND _109_ sel_one_hot\[54\] _108_ sel_reg\[54\] sky130_fd_sc_hd__dfrtp_2
XFILLER_23_155 VGND VPWR VPWR VGND sky130_ef_sc_hd__decap_12
XFILLER_36_41 VGND VPWR VPWR VGND sky130_ef_sc_hd__decap_12
XFILLER_36_85 VGND VPWR VPWR VGND sky130_fd_sc_hd__decap_4
X_314_ VPWR VGND _170_ sel_one_hot\[29\] _203_ VPWR VGND sky130_fd_sc_hd__and2_2
XFILLER_14_122 VPWR VGND VPWR VGND sky130_fd_sc_hd__decap_8
X_245_ VPWR VGND VGND VPWR Q[0] _165_ Q[1] sky130_fd_sc_hd__nor2_2
XFILLER_37_225 VGND VPWR VPWR VGND sky130_ef_sc_hd__decap_12
XFILLER_43_217 VPWR VGND VPWR VGND sky130_fd_sc_hd__decap_6
XFILLER_7_107 VGND VPWR VPWR VGND sky130_fd_sc_hd__decap_4
Xdelay_chain\[19\].genblk1.inv_b.core_inv VPWR VGND VGND VPWR delay_chain\[19\].genblk1.inv_a.out
+ delay_chain\[19\].genblk1.inv_b.out sky130_fd_sc_hd__inv_1
XFILLER_0_3 VGND VPWR VPWR VGND sky130_ef_sc_hd__decap_12
XFILLER_19_258 VPWR VGND VPWR VGND sky130_fd_sc_hd__decap_8
Xdelay_chain\[28\].genblk1.inv_b.core_inv VPWR VGND VGND VPWR delay_chain\[28\].genblk1.inv_a.out
+ delay_chain\[28\].genblk1.inv_b.out sky130_fd_sc_hd__inv_1
X_228_ VPWR VGND VPWR VGND _148_ delay_chain\[43\].genblk1.inv_b.out sel_reg\[43\]
+ sel_reg\[40\] delay_chain\[40\].genblk1.inv_b.out _149_ sky130_fd_sc_hd__a221o_2
XFILLER_33_3 VGND VPWR VPWR VGND sky130_ef_sc_hd__decap_12
XFILLER_40_209 VGND VPWR VPWR VGND sky130_ef_sc_hd__decap_12
Xdelay_chain\[37\].genblk1.inv_b.core_inv VPWR VGND VGND VPWR delay_chain\[37\].genblk1.inv_a.out
+ delay_chain\[37\].genblk1.inv_b.out sky130_fd_sc_hd__inv_1
Xdelay_chain\[29\].genblk1.inv_a.core_inv VPWR VGND VGND VPWR delay_chain\[28\].genblk1.inv_b.out
+ delay_chain\[29\].genblk1.inv_a.out sky130_fd_sc_hd__inv_1
XFILLER_33_86 VGND VPWR VPWR VGND sky130_ef_sc_hd__decap_12
Xdelay_chain\[46\].genblk1.inv_b.core_inv VPWR VGND VGND VPWR delay_chain\[46\].genblk1.inv_a.out
+ delay_chain\[46\].genblk1.inv_b.out sky130_fd_sc_hd__inv_1
Xdelay_chain\[38\].genblk1.inv_a.core_inv VPWR VGND VGND VPWR delay_chain\[37\].genblk1.inv_b.out
+ delay_chain\[38\].genblk1.inv_a.out sky130_fd_sc_hd__inv_1
XFILLER_15_261 VPWR VGND VPWR VGND sky130_fd_sc_hd__decap_6
XFILLER_30_253 VGND VPWR VPWR VGND sky130_ef_sc_hd__decap_12
Xdelay_chain\[47\].genblk1.inv_a.core_inv VPWR VGND VGND VPWR delay_chain\[46\].genblk1.inv_b.out
+ delay_chain\[47\].genblk1.inv_a.out sky130_fd_sc_hd__inv_1
Xdelay_chain\[55\].genblk1.inv_b.core_inv VPWR VGND VGND VPWR delay_chain\[55\].genblk1.inv_a.out
+ delay_chain\[55\].genblk1.inv_b.out sky130_fd_sc_hd__inv_1
XFILLER_21_264 VPWR VGND VPWR VGND sky130_fd_sc_hd__decap_3
XFILLER_0_113 VGND VPWR VPWR VGND sky130_ef_sc_hd__decap_12
XFILLER_44_41 VGND VPWR VPWR VGND sky130_ef_sc_hd__decap_12
XFILLER_28_53 VGND VPWR VPWR VGND sky130_ef_sc_hd__decap_12
Xdelay_chain\[56\].genblk1.inv_a.core_inv VPWR VGND VGND VPWR delay_chain\[55\].genblk1.inv_b.out
+ delay_chain\[56\].genblk1.inv_a.out sky130_fd_sc_hd__inv_1
X_493_ VGND VPWR VPWR VGND _037_ sel_one_hot\[18\] _036_ sel_reg\[18\] sky130_fd_sc_hd__dfrtp_2
XFILLER_8_235 VGND VPWR VPWR VGND sky130_ef_sc_hd__decap_12
XFILLER_44_85 VGND VPWR VPWR VGND sky130_ef_sc_hd__decap_12
XFILLER_12_253 VGND VPWR VPWR VGND sky130_ef_sc_hd__decap_12
XFILLER_5_57 VGND VPWR VPWR VGND sky130_ef_sc_hd__decap_12
XFILLER_5_249 VGND VPWR VPWR VGND sky130_ef_sc_hd__decap_12
XFILLER_30_65 VGND VPWR VPWR VGND sky130_ef_sc_hd__decap_12
XFILLER_44_197 VGND VPWR VPWR VGND sky130_ef_sc_hd__decap_12
XFILLER_44_153 VGND VPWR VPWR VGND sky130_ef_sc_hd__decap_12
X_476_ VGND VPWR VPWR VGND _003_ sel_one_hot\[1\] _002_ sel_reg\[1\] sky130_fd_sc_hd__dfrtp_2
XFILLER_35_175 VPWR VGND VPWR VGND sky130_fd_sc_hd__decap_8
X_330_ _179_ sel_one_hot\[45\] _171_ _197_ VPWR VGND VPWR VGND sky130_fd_sc_hd__and3_2
XFILLER_26_153 VPWR VGND VPWR VGND sky130_fd_sc_hd__decap_6
X_261_ VPWR VGND VGND VPWR _176_ Q[2] _165_ sky130_fd_sc_hd__nand2_2
Xdelay_chain\[2\].genblk1.inv_b.core_inv VPWR VGND VGND VPWR delay_chain\[2\].genblk1.inv_a.out
+ delay_chain\[2\].genblk1.inv_b.out sky130_fd_sc_hd__inv_1
X_459_ VPWR VGND VPWR VGND _097_ clk sky130_fd_sc_hd__inv_2
X_528_ VGND VPWR VPWR VGND _107_ sel_one_hot\[53\] _106_ sel_reg\[53\] sky130_fd_sc_hd__dfrtp_2
Xdelay_chain\[3\].genblk1.inv_a.core_inv VPWR VGND VGND VPWR delay_chain\[2\].genblk1.inv_b.out
+ delay_chain\[3\].genblk1.inv_a.out sky130_fd_sc_hd__inv_1
XFILLER_36_53 VGND VPWR VPWR VGND sky130_ef_sc_hd__decap_12
X_313_ VGND VPWR VGND VPWR _203_ _197_ _178_ _168_ sky130_fd_sc_hd__o21a_2
X_244_ VPWR VGND VPWR VGND Y _136_ _164_ sky130_fd_sc_hd__or2_2
XFILLER_37_237 VGND VPWR VPWR VGND sky130_ef_sc_hd__decap_12
XFILLER_28_204 VPWR VGND VPWR VGND sky130_fd_sc_hd__decap_3
X_227_ VPWR VGND VPWR VGND delay_chain\[46\].genblk1.inv_b.out sel_reg\[46\] sel_reg\[45\]
+ delay_chain\[45\].genblk1.inv_b.out _148_ sky130_fd_sc_hd__a22o_2
XFILLER_6_141 VGND VPWR VPWR VGND sky130_fd_sc_hd__decap_4
XFILLER_26_3 VGND VPWR VPWR VGND sky130_ef_sc_hd__decap_12
XFILLER_33_98 VGND VPWR VPWR VGND sky130_fd_sc_hd__decap_4
XPHY_EDGE_ROW_3_Right_3 VPWR VGND VPWR VGND sky130_fd_sc_hd__decap_3
XFILLER_0_125 VGND VPWR VPWR VGND sky130_ef_sc_hd__decap_12
XFILLER_0_169 VGND VPWR VPWR VGND sky130_ef_sc_hd__decap_12
XFILLER_28_65 VGND VPWR VPWR VGND sky130_ef_sc_hd__decap_12
XFILLER_44_53 VPWR VGND VPWR VGND sky130_fd_sc_hd__decap_3
X_492_ VGND VPWR VPWR VGND _035_ sel_one_hot\[17\] _034_ sel_reg\[17\] sky130_fd_sc_hd__dfrtp_2
XFILLER_12_210 VGND VPWR VPWR VGND sky130_ef_sc_hd__decap_12
XFILLER_8_203 VGND VPWR VPWR VGND sky130_fd_sc_hd__decap_4
XFILLER_8_247 VGND VPWR VPWR VGND sky130_fd_sc_hd__decap_4
XFILLER_44_97 VGND VPWR VPWR VGND sky130_ef_sc_hd__decap_12
XFILLER_5_69 VGND VPWR VPWR VGND sky130_ef_sc_hd__decap_12
XFILLER_30_77 VPWR VGND VPWR VGND sky130_fd_sc_hd__decap_3
XFILLER_44_165 VPWR VGND VPWR VGND sky130_fd_sc_hd__decap_3
X_475_ VPWR VGND VPWR VGND sel_reg\[0\] _000_ sel_one_hot\[0\] _001_ sky130_fd_sc_hd__dfstp_2
XFILLER_2_209 VGND VPWR VPWR VGND sky130_ef_sc_hd__decap_12
XFILLER_41_113 VGND VPWR VPWR VGND sky130_ef_sc_hd__decap_12
X_260_ VPWR VGND VGND VPWR _175_ sel_one_hot\[3\] _171_ sky130_fd_sc_hd__nor2_2
XFILLER_2_15 VGND VPWR VPWR VGND sky130_ef_sc_hd__decap_12
X_527_ VGND VPWR VPWR VGND _105_ sel_one_hot\[52\] _104_ sel_reg\[52\] sky130_fd_sc_hd__dfrtp_2
X_389_ VPWR VGND VPWR VGND _044_ rst sky130_fd_sc_hd__inv_2
X_458_ VPWR VGND VPWR VGND _095_ clk sky130_fd_sc_hd__inv_2
XFILLER_11_57 VPWR VGND VPWR VGND sky130_fd_sc_hd__decap_8
XFILLER_36_65 VGND VPWR VPWR VGND sky130_ef_sc_hd__decap_12
X_312_ VGND VPWR VGND VPWR sel_one_hot\[28\] _195_ Q[4] Q[5] sky130_fd_sc_hd__and3b_2
X_243_ VGND VPWR VPWR VGND _154_ _163_ _145_ _164_ sky130_fd_sc_hd__or3_2
XFILLER_37_205 VGND VPWR VPWR VGND sky130_ef_sc_hd__decap_12
XFILLER_37_249 VGND VPWR VPWR VGND sky130_ef_sc_hd__decap_12
XFILLER_9_161 VPWR VGND VPWR VGND sky130_fd_sc_hd__decap_6
X_226_ VPWR VGND VPWR VGND _146_ delay_chain\[34\].genblk1.inv_b.out sel_reg\[34\]
+ sel_reg\[33\] delay_chain\[33\].genblk1.inv_b.out _147_ sky130_fd_sc_hd__a221o_2
XFILLER_6_197 VGND VPWR VPWR VGND sky130_ef_sc_hd__decap_12
XFILLER_19_3 VGND VPWR VPWR VGND sky130_ef_sc_hd__decap_12
XFILLER_33_241 VGND VPWR VPWR VGND sky130_ef_sc_hd__decap_12
X_209_ VPWR VGND VPWR VGND delay_chain\[14\].genblk1.inv_b.out sel_reg\[14\] sel_reg\[13\]
+ delay_chain\[13\].genblk1.inv_b.out _130_ sky130_fd_sc_hd__a22o_2
XPHY_EDGE_ROW_29_Left_74 VPWR VGND VPWR VGND sky130_fd_sc_hd__decap_3
XPHY_EDGE_ROW_13_Left_58 VPWR VGND VPWR VGND sky130_fd_sc_hd__decap_3
XFILLER_0_81 VPWR VGND VPWR VGND sky130_fd_sc_hd__decap_3
XFILLER_21_244 VGND VPWR VPWR VGND sky130_ef_sc_hd__decap_12
XFILLER_0_137 VPWR VGND VPWR VGND sky130_fd_sc_hd__decap_3
XFILLER_28_77 VGND VPWR VPWR VGND sky130_fd_sc_hd__decap_4
X_491_ VGND VPWR VPWR VGND _033_ sel_one_hot\[16\] _032_ sel_reg\[16\] sky130_fd_sc_hd__dfrtp_2
XFILLER_12_222 VGND VPWR VPWR VGND sky130_ef_sc_hd__decap_12
XFILLER_5_15 VGND VPWR VPWR VGND sky130_ef_sc_hd__decap_12
XPHY_EDGE_ROW_13_Right_13 VPWR VGND VPWR VGND sky130_fd_sc_hd__decap_3
XPHY_EDGE_ROW_22_Right_22 VPWR VGND VPWR VGND sky130_fd_sc_hd__decap_3
XFILLER_38_141 VGND VPWR VPWR VGND sky130_ef_sc_hd__decap_12
XPHY_EDGE_ROW_31_Right_31 VPWR VGND VPWR VGND sky130_fd_sc_hd__decap_3
XPHY_EDGE_ROW_40_Right_40 VPWR VGND VPWR VGND sky130_fd_sc_hd__decap_3
X_474_ VPWR VGND VPWR VGND _127_ clk sky130_fd_sc_hd__inv_2
XPHY_EDGE_ROW_16_Left_61 VPWR VGND VPWR VGND sky130_fd_sc_hd__decap_3
XFILLER_41_125 VGND VPWR VPWR VGND sky130_ef_sc_hd__decap_12
XFILLER_41_169 VGND VPWR VPWR VGND sky130_ef_sc_hd__decap_12
X_526_ VGND VPWR VPWR VGND _103_ sel_one_hot\[51\] _102_ sel_reg\[51\] sky130_fd_sc_hd__dfrtp_2
X_457_ VPWR VGND VPWR VGND _093_ clk sky130_fd_sc_hd__inv_2
X_388_ VPWR VGND VPWR VGND _046_ rst sky130_fd_sc_hd__inv_2
XFILLER_11_69 VGND VPWR VPWR VGND sky130_fd_sc_hd__decap_4
XPHY_EDGE_ROW_1_Left_46 VPWR VGND VPWR VGND sky130_fd_sc_hd__decap_3
XFILLER_36_77 VPWR VGND VPWR VGND sky130_fd_sc_hd__decap_6
Xdelay_chain\[12\].genblk1.inv_b.core_inv VPWR VGND VGND VPWR delay_chain\[12\].genblk1.inv_a.out
+ delay_chain\[12\].genblk1.inv_b.out sky130_fd_sc_hd__inv_1
X_311_ VPWR VGND _170_ sel_one_hot\[27\] _202_ VPWR VGND sky130_fd_sc_hd__and2_2
X_242_ VPWR VGND VPWR VGND _158_ _162_ _160_ _156_ _163_ sky130_fd_sc_hd__or4_2
XFILLER_22_191 VGND VPWR VPWR VGND sky130_fd_sc_hd__decap_4
XFILLER_37_217 VPWR VGND VPWR VGND sky130_fd_sc_hd__decap_6
X_509_ VGND VPWR VPWR VGND _069_ sel_one_hot\[34\] _068_ sel_reg\[34\] sky130_fd_sc_hd__dfrtp_2
XFILLER_20_106 VPWR VGND VPWR VGND sky130_fd_sc_hd__decap_8
Xdelay_chain\[13\].genblk1.inv_a.core_inv VPWR VGND VGND VPWR delay_chain\[12\].genblk1.inv_b.out
+ delay_chain\[13\].genblk1.inv_a.out sky130_fd_sc_hd__inv_1
Xdelay_chain\[21\].genblk1.inv_b.core_inv VPWR VGND VGND VPWR delay_chain\[21\].genblk1.inv_a.out
+ delay_chain\[21\].genblk1.inv_b.out sky130_fd_sc_hd__inv_1
XFILLER_3_81 VGND VPWR VPWR VGND sky130_ef_sc_hd__decap_12
XPHY_EDGE_ROW_43_Left_88 VPWR VGND VPWR VGND sky130_fd_sc_hd__decap_3
Xdelay_chain\[30\].genblk1.inv_b.core_inv VPWR VGND VGND VPWR delay_chain\[30\].genblk1.inv_a.out
+ delay_chain\[30\].genblk1.inv_b.out sky130_fd_sc_hd__inv_1
Xdelay_chain\[22\].genblk1.inv_a.core_inv VPWR VGND VGND VPWR delay_chain\[21\].genblk1.inv_b.out
+ delay_chain\[22\].genblk1.inv_a.out sky130_fd_sc_hd__inv_1
XFILLER_8_15 VGND VPWR VPWR VGND sky130_ef_sc_hd__decap_12
XFILLER_42_253 VGND VPWR VPWR VGND sky130_ef_sc_hd__decap_12
XFILLER_6_121 VGND VPWR VPWR VGND sky130_ef_sc_hd__decap_12
X_225_ VPWR VGND VPWR VGND delay_chain\[39\].genblk1.inv_b.out sel_reg\[39\] sel_reg\[36\]
+ delay_chain\[36\].genblk1.inv_b.out _146_ sky130_fd_sc_hd__a22o_2
Xdelay_chain\[31\].genblk1.inv_a.core_inv VPWR VGND VGND VPWR delay_chain\[30\].genblk1.inv_b.out
+ delay_chain\[31\].genblk1.inv_a.out sky130_fd_sc_hd__inv_1
XFILLER_33_253 VGND VPWR VPWR VGND sky130_ef_sc_hd__decap_12
Xdelay_chain\[40\].genblk1.inv_a.core_inv VPWR VGND VGND VPWR delay_chain\[39\].genblk1.inv_b.out
+ delay_chain\[40\].genblk1.inv_a.out sky130_fd_sc_hd__inv_1
XFILLER_24_253 VGND VPWR VPWR VGND sky130_ef_sc_hd__decap_12
XFILLER_16_209 VGND VPWR VPWR VGND sky130_ef_sc_hd__decap_12
XFILLER_3_113 VGND VPWR VPWR VGND sky130_ef_sc_hd__decap_12
X_208_ VPWR VGND VPWR VGND _128_ delay_chain\[2\].genblk1.inv_b.out sel_reg\[2\] sel_reg\[1\]
+ delay_chain\[1\].genblk1.inv_b.out _129_ sky130_fd_sc_hd__a221o_2
XFILLER_31_3 VGND VPWR VPWR VGND sky130_ef_sc_hd__decap_12
XFILLER_21_256 VPWR VGND VPWR VGND sky130_fd_sc_hd__decap_8
X_490_ VGND VPWR VPWR VGND _031_ sel_one_hot\[15\] _030_ sel_reg\[15\] sky130_fd_sc_hd__dfrtp_2
XFILLER_12_234 VGND VPWR VPWR VGND sky130_ef_sc_hd__decap_12
XFILLER_5_27 VGND VPWR VPWR VGND sky130_ef_sc_hd__decap_12
XPHY_EDGE_ROW_30_Left_75 VPWR VGND VPWR VGND sky130_fd_sc_hd__decap_3
XFILLER_38_153 VGND VPWR VPWR VGND sky130_ef_sc_hd__decap_12
XFILLER_38_197 VGND VPWR VPWR VGND sky130_ef_sc_hd__decap_12
X_473_ VPWR VGND VPWR VGND _125_ clk sky130_fd_sc_hd__inv_2
XFILLER_26_178 VPWR VGND VPWR VGND sky130_fd_sc_hd__decap_8
XFILLER_41_137 VGND VPWR VPWR VGND sky130_ef_sc_hd__decap_12
XFILLER_9_3 VGND VPWR VPWR VGND sky130_ef_sc_hd__decap_12
X_456_ VPWR VGND VPWR VGND _091_ clk sky130_fd_sc_hd__inv_2
X_525_ VGND VPWR VPWR VGND _101_ sel_one_hot\[50\] _100_ sel_reg\[50\] sky130_fd_sc_hd__dfrtp_2
XFILLER_17_134 VPWR VGND VPWR VGND sky130_fd_sc_hd__decap_8
X_387_ VPWR VGND VPWR VGND _048_ rst sky130_fd_sc_hd__inv_2
XFILLER_23_104 VPWR VGND VPWR VGND sky130_fd_sc_hd__decap_8
XFILLER_31_181 VPWR VGND VPWR VGND sky130_fd_sc_hd__decap_6
XFILLER_11_15 VGND VPWR VPWR VGND sky130_ef_sc_hd__decap_12
X_310_ VGND VPWR VGND VPWR _202_ _187_ Q[0] Q[1] Q[4] sky130_fd_sc_hd__and4_2
X_241_ VPWR VGND VPWR VGND _161_ delay_chain\[18\].genblk1.inv_b.out sel_reg\[18\]
+ sel_reg\[17\] delay_chain\[17\].genblk1.inv_b.out _162_ sky130_fd_sc_hd__a221o_2
X_439_ VPWR VGND VPWR VGND _057_ clk sky130_fd_sc_hd__inv_2
X_508_ VGND VPWR VPWR VGND _067_ sel_one_hot\[33\] _066_ sel_reg\[33\] sky130_fd_sc_hd__dfrtp_2
XFILLER_13_181 VGND VPWR VPWR VGND sky130_ef_sc_hd__decap_12
XFILLER_3_93 VGND VPWR VPWR VGND sky130_ef_sc_hd__decap_12
XFILLER_42_221 VGND VPWR VPWR VGND sky130_ef_sc_hd__decap_12
X_224_ VPWR VGND VPWR VGND _140_ _144_ _142_ _138_ _145_ sky130_fd_sc_hd__or4_2
XFILLER_6_133 VGND VPWR VPWR VGND sky130_fd_sc_hd__decap_4
XFILLER_33_210 VGND VPWR VPWR VGND sky130_fd_sc_hd__decap_4
Xdelay_chain\[49\].genblk1.inv_b.core_inv VPWR VGND VGND VPWR delay_chain\[49\].genblk1.inv_a.out
+ delay_chain\[49\].genblk1.inv_b.out sky130_fd_sc_hd__inv_1
XFILLER_33_57 VGND VPWR VPWR VGND sky130_ef_sc_hd__decap_12
XFILLER_3_125 VGND VPWR VPWR VGND sky130_ef_sc_hd__decap_12
XFILLER_3_169 VGND VPWR VPWR VGND sky130_ef_sc_hd__decap_12
Xdelay_chain\[58\].genblk1.inv_b.core_inv VPWR VGND VGND VPWR delay_chain\[58\].genblk1.inv_a.out
+ delay_chain\[58\].genblk1.inv_b.out sky130_fd_sc_hd__inv_1
XFILLER_15_221 VPWR VGND VPWR VGND sky130_fd_sc_hd__decap_3
X_207_ VPWR VGND VPWR VGND delay_chain\[7\].genblk1.inv_b.out sel_reg\[7\] sel_reg\[4\]
+ delay_chain\[4\].genblk1.inv_b.out _128_ sky130_fd_sc_hd__a22o_2
Xdelay_chain\[59\].genblk1.inv_a.core_inv VPWR VGND VGND VPWR delay_chain\[58\].genblk1.inv_b.out
+ delay_chain\[59\].genblk1.inv_a.out sky130_fd_sc_hd__inv_1
XFILLER_24_3 VGND VPWR VPWR VGND sky130_ef_sc_hd__decap_12
XFILLER_9_81 VPWR VGND VPWR VGND sky130_fd_sc_hd__decap_8
XFILLER_12_246 VPWR VGND VPWR VGND sky130_fd_sc_hd__decap_6
XFILLER_5_39 VGND VPWR VPWR VGND sky130_ef_sc_hd__decap_12
XFILLER_7_261 VPWR VGND VPWR VGND sky130_fd_sc_hd__decap_6
XPHY_EDGE_ROW_7_Right_7 VPWR VGND VPWR VGND sky130_fd_sc_hd__decap_3
XFILLER_38_121 VGND VPWR VPWR VGND sky130_ef_sc_hd__decap_12
XFILLER_38_165 VGND VPWR VPWR VGND sky130_ef_sc_hd__decap_12
XFILLER_14_15 VGND VPWR VPWR VGND sky130_ef_sc_hd__decap_12
XFILLER_5_209 VGND VPWR VPWR VGND sky130_ef_sc_hd__decap_12
X_472_ VPWR VGND VPWR VGND _123_ clk sky130_fd_sc_hd__inv_2
XFILLER_44_113 VGND VPWR VPWR VGND sky130_ef_sc_hd__decap_12
XFILLER_4_253 VGND VPWR VPWR VGND sky130_ef_sc_hd__decap_12
XFILLER_20_91 VGND VPWR VPWR VGND sky130_fd_sc_hd__decap_4
Xdelay_chain\[5\].genblk1.inv_b.core_inv VPWR VGND VGND VPWR delay_chain\[5\].genblk1.inv_a.out
+ delay_chain\[5\].genblk1.inv_b.out sky130_fd_sc_hd__inv_1
XFILLER_41_105 VPWR VGND VPWR VGND sky130_fd_sc_hd__decap_6
Xdelay_chain\[6\].genblk1.inv_a.core_inv VPWR VGND VGND VPWR delay_chain\[5\].genblk1.inv_b.out
+ delay_chain\[6\].genblk1.inv_a.out sky130_fd_sc_hd__inv_1
XFILLER_41_57 VGND VPWR VPWR VGND sky130_ef_sc_hd__decap_12
XFILLER_41_149 VGND VPWR VPWR VGND sky130_ef_sc_hd__decap_12
XFILLER_2_29 VGND VPWR VPWR VGND sky130_ef_sc_hd__decap_12
X_455_ VPWR VGND VPWR VGND _089_ clk sky130_fd_sc_hd__inv_2
X_386_ VPWR VGND VPWR VGND _050_ rst sky130_fd_sc_hd__inv_2
X_524_ VGND VPWR VPWR VGND _099_ sel_one_hot\[49\] _098_ sel_reg\[49\] sky130_fd_sc_hd__dfrtp_2
XFILLER_11_27 VGND VPWR VPWR VGND sky130_ef_sc_hd__decap_12
X_240_ VPWR VGND VPWR VGND delay_chain\[23\].genblk1.inv_b.out sel_reg\[23\] sel_reg\[20\]
+ delay_chain\[20\].genblk1.inv_b.out _161_ sky130_fd_sc_hd__a22o_2
X_369_ VPWR VGND VPWR VGND _084_ rst sky130_fd_sc_hd__inv_2
X_438_ VPWR VGND VPWR VGND _055_ clk sky130_fd_sc_hd__inv_2
X_507_ VGND VPWR VPWR VGND _065_ sel_one_hot\[32\] _064_ sel_reg\[32\] sky130_fd_sc_hd__dfrtp_2
XFILLER_13_193 VPWR VGND VPWR VGND sky130_fd_sc_hd__decap_6
XFILLER_11_119 VGND VPWR VPWR VGND sky130_ef_sc_hd__decap_12
XFILLER_22_15 VGND VPWR VPWR VGND sky130_ef_sc_hd__decap_12
XFILLER_27_241 VGND VPWR VPWR VGND sky130_ef_sc_hd__decap_12
XFILLER_42_233 VGND VPWR VPWR VGND sky130_ef_sc_hd__decap_12
X_223_ VPWR VGND VPWR VGND _143_ delay_chain\[50\].genblk1.inv_b.out sel_reg\[50\]
+ sel_reg\[49\] delay_chain\[49\].genblk1.inv_b.out _144_ sky130_fd_sc_hd__a221o_2
XFILLER_18_230 VPWR VGND VPWR VGND sky130_fd_sc_hd__decap_3
XFILLER_17_15 VGND VPWR VPWR VGND sky130_ef_sc_hd__decap_12
XFILLER_33_69 VGND VPWR VPWR VGND sky130_ef_sc_hd__decap_12
XFILLER_3_137 VGND VPWR VPWR VGND sky130_ef_sc_hd__decap_12
X_206_ VPWR VGND VPWR VGND _001_ clk sky130_fd_sc_hd__inv_2
XFILLER_17_3 VGND VPWR VPWR VGND sky130_ef_sc_hd__decap_12
XFILLER_21_225 VPWR VGND VPWR VGND sky130_fd_sc_hd__decap_8
XFILLER_44_57 VGND VPWR VPWR VGND sky130_ef_sc_hd__decap_12
XFILLER_38_133 VPWR VGND VPWR VGND sky130_fd_sc_hd__decap_6
XFILLER_38_177 VGND VPWR VPWR VGND sky130_ef_sc_hd__decap_12
XFILLER_30_15 VGND VPWR VPWR VGND sky130_ef_sc_hd__decap_12
XFILLER_39_57 VGND VPWR VPWR VGND sky130_ef_sc_hd__decap_12
XFILLER_44_169 VGND VPWR VPWR VGND sky130_ef_sc_hd__decap_12
XFILLER_44_125 VGND VPWR VPWR VGND sky130_ef_sc_hd__decap_12
X_471_ VPWR VGND VPWR VGND _121_ clk sky130_fd_sc_hd__inv_2
XFILLER_4_221 VGND VPWR VPWR VGND sky130_ef_sc_hd__decap_12
XFILLER_25_15 VGND VPWR VPWR VGND sky130_ef_sc_hd__decap_12
XFILLER_41_69 VGND VPWR VPWR VGND sky130_ef_sc_hd__decap_12
X_523_ VGND VPWR VPWR VGND _097_ sel_one_hot\[48\] _096_ sel_reg\[48\] sky130_fd_sc_hd__dfrtp_2
XFILLER_32_128 VGND VPWR VPWR VGND sky130_ef_sc_hd__decap_12
XFILLER_32_117 VPWR VGND VPWR VGND sky130_fd_sc_hd__decap_8
X_385_ VPWR VGND VPWR VGND _052_ rst sky130_fd_sc_hd__inv_2
X_454_ VPWR VGND VPWR VGND _087_ clk sky130_fd_sc_hd__inv_2
XFILLER_15_70 VGND VPWR VPWR VGND sky130_ef_sc_hd__decap_12
XFILLER_11_39 VGND VPWR VPWR VGND sky130_ef_sc_hd__decap_12
XFILLER_39_261 VPWR VGND VPWR VGND sky130_fd_sc_hd__decap_6
X_506_ VGND VPWR VPWR VGND _063_ sel_one_hot\[31\] _062_ sel_reg\[31\] sky130_fd_sc_hd__dfrtp_2
X_437_ VPWR VGND VPWR VGND _053_ clk sky130_fd_sc_hd__inv_2
X_368_ VPWR VGND VPWR VGND _086_ rst sky130_fd_sc_hd__inv_2
X_299_ VPWR VGND VGND VPWR Q[5] Q[4] _166_ _169_ sel_one_hot\[17\] sky130_fd_sc_hd__and4b_2
XFILLER_3_51 VGND VPWR VPWR VGND sky130_fd_sc_hd__decap_4
XFILLER_36_253 VGND VPWR VPWR VGND sky130_ef_sc_hd__decap_12
XFILLER_42_245 VPWR VGND VPWR VGND sky130_fd_sc_hd__decap_6
XPHY_EDGE_ROW_29_Right_29 VPWR VGND VPWR VGND sky130_fd_sc_hd__decap_3
XFILLER_27_253 VGND VPWR VPWR VGND sky130_ef_sc_hd__decap_12
XFILLER_8_29 VGND VPWR VPWR VGND sky130_ef_sc_hd__decap_12
XPHY_EDGE_ROW_38_Right_38 VPWR VGND VPWR VGND sky130_fd_sc_hd__decap_3
X_222_ VPWR VGND VPWR VGND delay_chain\[55\].genblk1.inv_b.out sel_reg\[55\] sel_reg\[52\]
+ delay_chain\[52\].genblk1.inv_b.out _143_ sky130_fd_sc_hd__a22o_2
XFILLER_6_179 VGND VPWR VPWR VGND sky130_ef_sc_hd__decap_12
XFILLER_18_253 VGND VPWR VPWR VGND sky130_ef_sc_hd__decap_12
XFILLER_17_27 VGND VPWR VPWR VGND sky130_ef_sc_hd__decap_12
XFILLER_33_15 VGND VPWR VPWR VGND sky130_ef_sc_hd__decap_12
XFILLER_3_105 VPWR VGND VPWR VGND sky130_fd_sc_hd__decap_6
XFILLER_3_149 VGND VPWR VPWR VGND sky130_ef_sc_hd__decap_12
X_205_ VPWR VGND VPWR VGND _126_ rst sky130_fd_sc_hd__inv_2
XFILLER_30_248 VGND VPWR VPWR VGND sky130_fd_sc_hd__decap_4
XFILLER_0_41 VGND VPWR VPWR VGND sky130_ef_sc_hd__decap_12
XFILLER_0_85 VGND VPWR VPWR VGND sky130_ef_sc_hd__decap_12
XFILLER_28_15 VGND VPWR VPWR VGND sky130_ef_sc_hd__decap_12
XFILLER_44_69 VGND VPWR VPWR VGND sky130_ef_sc_hd__decap_12
XPHY_EDGE_ROW_8_Left_53 VPWR VGND VPWR VGND sky130_fd_sc_hd__decap_3
XFILLER_38_189 VPWR VGND VPWR VGND sky130_fd_sc_hd__decap_6
XFILLER_39_69 VGND VPWR VPWR VGND sky130_ef_sc_hd__decap_12
XFILLER_44_137 VPWR VGND VPWR VGND sky130_fd_sc_hd__decap_3
XPHY_EDGE_ROW_34_Left_79 VPWR VGND VPWR VGND sky130_fd_sc_hd__decap_3
XFILLER_29_189 VGND VPWR VPWR VGND sky130_ef_sc_hd__decap_12
X_470_ VPWR VGND VPWR VGND _119_ clk sky130_fd_sc_hd__inv_2
XFILLER_4_233 VGND VPWR VPWR VGND sky130_ef_sc_hd__decap_12
XFILLER_43_181 VGND VPWR VPWR VGND sky130_ef_sc_hd__decap_12
XFILLER_26_104 VGND VPWR VPWR VGND sky130_ef_sc_hd__decap_12
XFILLER_25_27 VGND VPWR VPWR VGND sky130_ef_sc_hd__decap_12
XFILLER_41_15 VGND VPWR VPWR VGND sky130_ef_sc_hd__decap_12
XFILLER_1_225 VGND VPWR VPWR VGND sky130_ef_sc_hd__decap_12
X_522_ VGND VPWR VPWR VGND _095_ sel_one_hot\[47\] _094_ sel_reg\[47\] sky130_fd_sc_hd__dfrtp_2
X_453_ VPWR VGND VPWR VGND _085_ clk sky130_fd_sc_hd__inv_2
X_384_ VPWR VGND VPWR VGND _054_ rst sky130_fd_sc_hd__inv_2
XFILLER_15_82 VPWR VGND VPWR VGND sky130_fd_sc_hd__decap_8
Xdelay_chain\[15\].genblk1.inv_b.core_inv VPWR VGND VGND VPWR delay_chain\[15\].genblk1.inv_a.out
+ delay_chain\[15\].genblk1.inv_b.out sky130_fd_sc_hd__inv_1
XFILLER_31_195 VGND VPWR VPWR VGND sky130_ef_sc_hd__decap_12
XFILLER_36_15 VGND VPWR VPWR VGND sky130_ef_sc_hd__decap_12
Xdelay_chain\[24\].genblk1.inv_b.core_inv VPWR VGND VGND VPWR delay_chain\[24\].genblk1.inv_a.out
+ delay_chain\[24\].genblk1.inv_b.out sky130_fd_sc_hd__inv_1
Xdelay_chain\[16\].genblk1.inv_a.core_inv VPWR VGND VGND VPWR delay_chain\[15\].genblk1.inv_b.out
+ delay_chain\[16\].genblk1.inv_a.out sky130_fd_sc_hd__inv_1
XFILLER_7_3 VGND VPWR VPWR VGND sky130_ef_sc_hd__decap_12
XPHY_EDGE_ROW_37_Left_82 VPWR VGND VPWR VGND sky130_fd_sc_hd__decap_3
X_505_ VGND VPWR VPWR VGND _061_ sel_one_hot\[30\] _060_ sel_reg\[30\] sky130_fd_sc_hd__dfrtp_2
X_436_ VPWR VGND VPWR VGND _051_ clk sky130_fd_sc_hd__inv_2
X_367_ VPWR VGND VPWR VGND _088_ rst sky130_fd_sc_hd__inv_2
Xdelay_chain\[25\].genblk1.inv_a.core_inv VPWR VGND VGND VPWR delay_chain\[24\].genblk1.inv_b.out
+ delay_chain\[25\].genblk1.inv_a.out sky130_fd_sc_hd__inv_1
XPHY_EDGE_ROW_21_Left_66 VPWR VGND VPWR VGND sky130_fd_sc_hd__decap_3
Xdelay_chain\[33\].genblk1.inv_b.core_inv VPWR VGND VGND VPWR delay_chain\[33\].genblk1.inv_a.out
+ delay_chain\[33\].genblk1.inv_b.out sky130_fd_sc_hd__inv_1
X_298_ VPWR VGND VGND VPWR _200_ sel_one_hot\[16\] Q[5] sky130_fd_sc_hd__nor2_2
Xdelay_chain\[42\].genblk1.inv_b.core_inv VPWR VGND VGND VPWR delay_chain\[42\].genblk1.inv_a.out
+ delay_chain\[42\].genblk1.inv_b.out sky130_fd_sc_hd__inv_1
Xdelay_chain\[34\].genblk1.inv_a.core_inv VPWR VGND VGND VPWR delay_chain\[33\].genblk1.inv_b.out
+ delay_chain\[34\].genblk1.inv_a.out sky130_fd_sc_hd__inv_1
X_221_ VPWR VGND VPWR VGND _141_ delay_chain\[59\].genblk1.inv_b.out sel_reg\[59\]
+ sel_reg\[56\] delay_chain\[56\].genblk1.inv_b.out _142_ sky130_fd_sc_hd__a221o_2
Xdelay_chain\[51\].genblk1.inv_b.core_inv VPWR VGND VGND VPWR delay_chain\[51\].genblk1.inv_a.out
+ delay_chain\[51\].genblk1.inv_b.out sky130_fd_sc_hd__inv_1
Xdelay_chain\[43\].genblk1.inv_a.core_inv VPWR VGND VGND VPWR delay_chain\[42\].genblk1.inv_b.out
+ delay_chain\[43\].genblk1.inv_a.out sky130_fd_sc_hd__inv_1
X_419_ VPWR VGND VPWR VGND _017_ clk sky130_fd_sc_hd__inv_2
Xdelay_chain\[60\].genblk1.inv_b.core_inv VPWR VGND VGND VPWR delay_chain\[60\].genblk1.inv_a.out
+ delay_chain\[60\].genblk1.inv_b.out sky130_fd_sc_hd__inv_1
Xdelay_chain\[52\].genblk1.inv_a.core_inv VPWR VGND VGND VPWR delay_chain\[51\].genblk1.inv_b.out
+ delay_chain\[52\].genblk1.inv_a.out sky130_fd_sc_hd__inv_1
XFILLER_17_39 VGND VPWR VPWR VGND sky130_ef_sc_hd__decap_12
XFILLER_33_27 VGND VPWR VPWR VGND sky130_ef_sc_hd__decap_12
Xdelay_chain\[61\].genblk1.inv_a.core_inv VPWR VGND VGND VPWR delay_chain\[60\].genblk1.inv_b.out
+ delay_chain\[61\].genblk1.inv_a.out sky130_fd_sc_hd__inv_1
XFILLER_15_213 VPWR VGND VPWR VGND sky130_fd_sc_hd__decap_8
XFILLER_23_82 VGND VPWR VPWR VGND sky130_ef_sc_hd__decap_12
XFILLER_0_53 VPWR VGND VPWR VGND sky130_fd_sc_hd__decap_3
XFILLER_0_97 VGND VPWR VPWR VGND sky130_ef_sc_hd__decap_12
XFILLER_9_51 VGND VPWR VPWR VGND sky130_fd_sc_hd__decap_4
XFILLER_21_205 VGND VPWR VPWR VGND sky130_ef_sc_hd__decap_12
XFILLER_0_109 VPWR VGND VPWR VGND sky130_fd_sc_hd__decap_3
XFILLER_44_15 VGND VPWR VPWR VGND sky130_ef_sc_hd__decap_12
XFILLER_22_3 VGND VPWR VPWR VGND sky130_ef_sc_hd__decap_12
XFILLER_14_29 VGND VPWR VPWR VGND sky130_ef_sc_hd__decap_12
XFILLER_39_15 VGND VPWR VPWR VGND sky130_ef_sc_hd__decap_12
XFILLER_29_102 VPWR VGND VPWR VGND sky130_fd_sc_hd__decap_6
XFILLER_4_245 VPWR VGND VPWR VGND sky130_fd_sc_hd__decap_6
XFILLER_29_81 VGND VPWR VPWR VGND sky130_ef_sc_hd__decap_12
XFILLER_43_193 VGND VPWR VPWR VGND sky130_ef_sc_hd__decap_12
XFILLER_6_41 VGND VPWR VPWR VGND sky130_ef_sc_hd__decap_12
XFILLER_6_85 VGND VPWR VPWR VGND sky130_ef_sc_hd__decap_12
XFILLER_26_116 VPWR VGND VPWR VGND sky130_fd_sc_hd__decap_8
XFILLER_41_27 VGND VPWR VPWR VGND sky130_ef_sc_hd__decap_12
XFILLER_34_182 VPWR VGND VPWR VGND sky130_fd_sc_hd__decap_3
XFILLER_25_39 VPWR VGND VPWR VGND sky130_fd_sc_hd__decap_8
XFILLER_1_237 VGND VPWR VPWR VGND sky130_ef_sc_hd__decap_12
X_383_ VPWR VGND VPWR VGND _056_ rst sky130_fd_sc_hd__inv_2
X_521_ VGND VPWR VPWR VGND _093_ sel_one_hot\[46\] _092_ sel_reg\[46\] sky130_fd_sc_hd__dfrtp_2
X_452_ VPWR VGND VPWR VGND _083_ clk sky130_fd_sc_hd__inv_2
XFILLER_17_116 VPWR VGND VPWR VGND sky130_fd_sc_hd__decap_3
XFILLER_40_141 VGND VPWR VPWR VGND sky130_ef_sc_hd__decap_12
XFILLER_23_119 VPWR VGND VPWR VGND sky130_fd_sc_hd__decap_6
XFILLER_22_141 VPWR VGND VPWR VGND sky130_fd_sc_hd__decap_8
X_504_ VGND VPWR VPWR VGND _059_ sel_one_hot\[29\] _058_ sel_reg\[29\] sky130_fd_sc_hd__dfrtp_2
X_366_ VPWR VGND VPWR VGND _090_ rst sky130_fd_sc_hd__inv_2
X_435_ VPWR VGND VPWR VGND _049_ clk sky130_fd_sc_hd__inv_2
XFILLER_13_163 VGND VPWR VPWR VGND sky130_fd_sc_hd__decap_4
X_297_ VGND VPWR VGND VPWR _166_ Q[4] _200_ _165_ sky130_fd_sc_hd__nand3_2
XFILLER_36_233 VGND VPWR VPWR VGND sky130_ef_sc_hd__decap_12
XFILLER_22_29 VGND VPWR VPWR VGND sky130_ef_sc_hd__decap_12
X_220_ VPWR VGND VPWR VGND delay_chain\[62\].genblk1.inv_b.out sel_reg\[62\] sel_reg\[61\]
+ delay_chain\[61\].genblk1.inv_b.out _141_ sky130_fd_sc_hd__a22o_2
XFILLER_10_122 VGND VPWR VPWR VGND sky130_fd_sc_hd__decap_4
XFILLER_37_81 VGND VPWR VPWR VGND sky130_ef_sc_hd__decap_12
X_418_ VPWR VGND VPWR VGND _015_ clk sky130_fd_sc_hd__inv_2
X_349_ VPWR VGND VPWR VGND _124_ rst sky130_fd_sc_hd__inv_2
XFILLER_33_39 VGND VPWR VPWR VGND sky130_ef_sc_hd__decap_12
XFILLER_15_225 VGND VPWR VPWR VGND sky130_ef_sc_hd__decap_12
XFILLER_21_217 VPWR VGND VPWR VGND sky130_fd_sc_hd__decap_6
XFILLER_11_261 VPWR VGND VPWR VGND sky130_fd_sc_hd__decap_6
XFILLER_15_3 VGND VPWR VPWR VGND sky130_ef_sc_hd__decap_12
XFILLER_30_29 VGND VPWR VPWR VGND sky130_ef_sc_hd__decap_12
XFILLER_39_27 VGND VPWR VPWR VGND sky130_ef_sc_hd__decap_12
Xdelay_chain\[8\].genblk1.inv_b.core_inv VPWR VGND VGND VPWR delay_chain\[8\].genblk1.inv_a.out
+ delay_chain\[8\].genblk1.inv_b.out sky130_fd_sc_hd__inv_1
XFILLER_29_93 VPWR VGND VPWR VGND sky130_fd_sc_hd__decap_3
XFILLER_43_161 VPWR VGND VPWR VGND sky130_fd_sc_hd__decap_6
Xdelay_chain\[9\].genblk1.inv_a.core_inv VPWR VGND VGND VPWR delay_chain\[8\].genblk1.inv_b.out
+ delay_chain\[9\].genblk1.inv_a.out sky130_fd_sc_hd__inv_1
XFILLER_6_53 VGND VPWR VPWR VGND sky130_ef_sc_hd__decap_12
XFILLER_6_97 VGND VPWR VPWR VGND sky130_ef_sc_hd__decap_12
XFILLER_41_39 VGND VPWR VPWR VGND sky130_ef_sc_hd__decap_12
XFILLER_1_205 VGND VPWR VPWR VGND sky130_ef_sc_hd__decap_12
XFILLER_1_249 VGND VPWR VPWR VGND sky130_ef_sc_hd__decap_12
X_520_ VGND VPWR VPWR VGND _091_ sel_one_hot\[45\] _090_ sel_reg\[45\] sky130_fd_sc_hd__dfrtp_2
XFILLER_17_106 VPWR VGND VPWR VGND sky130_fd_sc_hd__decap_6
X_382_ VPWR VGND VPWR VGND _058_ rst sky130_fd_sc_hd__inv_2
XFILLER_40_153 VGND VPWR VPWR VGND sky130_ef_sc_hd__decap_12
X_451_ VPWR VGND VPWR VGND _081_ clk sky130_fd_sc_hd__inv_2
XFILLER_15_51 VGND VPWR VPWR VGND sky130_fd_sc_hd__decap_4
XFILLER_40_197 VGND VPWR VPWR VGND sky130_ef_sc_hd__decap_12
XFILLER_31_164 VGND VPWR VPWR VGND sky130_fd_sc_hd__decap_4
XFILLER_31_153 VPWR VGND VPWR VGND sky130_fd_sc_hd__decap_8
XFILLER_22_131 VPWR VGND VPWR VGND sky130_fd_sc_hd__decap_8
XFILLER_22_197 VPWR VGND VPWR VGND sky130_fd_sc_hd__decap_8
X_503_ VGND VPWR VPWR VGND _057_ sel_one_hot\[28\] _056_ sel_reg\[28\] sky130_fd_sc_hd__dfrtp_2
XFILLER_9_113 VGND VPWR VPWR VGND sky130_ef_sc_hd__decap_12
X_365_ VPWR VGND VPWR VGND _092_ rst sky130_fd_sc_hd__inv_2
X_296_ VGND VPWR VGND VPWR sel_one_hot\[15\] _199_ _179_ Q[5] sky130_fd_sc_hd__and3b_2
X_434_ VPWR VGND VPWR VGND _047_ clk sky130_fd_sc_hd__inv_2
XFILLER_36_245 VPWR VGND VPWR VGND sky130_fd_sc_hd__decap_6
XFILLER_6_149 VGND VPWR VPWR VGND sky130_fd_sc_hd__decap_4
XFILLER_12_41 VGND VPWR VPWR VGND sky130_ef_sc_hd__decap_12
XFILLER_37_93 VPWR VGND VPWR VGND sky130_fd_sc_hd__decap_8
XPHY_EDGE_ROW_16_Right_16 VPWR VGND VPWR VGND sky130_fd_sc_hd__decap_3
X_417_ VPWR VGND VPWR VGND _013_ clk sky130_fd_sc_hd__inv_2
X_348_ _180_ sel_one_hot\[63\] _171_ _199_ VPWR VGND VPWR VGND sky130_fd_sc_hd__and3_2
XPHY_EDGE_ROW_25_Right_25 VPWR VGND VPWR VGND sky130_fd_sc_hd__decap_3
X_279_ VPWR VGND VGND VPWR _189_ sel_one_hot\[8\] _171_ sky130_fd_sc_hd__nor2_2
XPHY_EDGE_ROW_34_Right_34 VPWR VGND VPWR VGND sky130_fd_sc_hd__decap_3
XPHY_EDGE_ROW_43_Right_43 VPWR VGND VPWR VGND sky130_fd_sc_hd__decap_3
XFILLER_15_237 VGND VPWR VPWR VGND sky130_ef_sc_hd__decap_12
XFILLER_23_51 VGND VPWR VPWR VGND sky130_fd_sc_hd__decap_4
XFILLER_2_141 VGND VPWR VPWR VGND sky130_ef_sc_hd__decap_12
XFILLER_28_29 VGND VPWR VPWR VGND sky130_ef_sc_hd__decap_12
XPHY_EDGE_ROW_2_Right_2 VPWR VGND VPWR VGND sky130_fd_sc_hd__decap_3
XFILLER_39_39 VGND VPWR VPWR VGND sky130_ef_sc_hd__decap_12
XFILLER_29_137 VPWR VGND VPWR VGND sky130_fd_sc_hd__decap_6
XFILLER_37_181 VGND VPWR VPWR VGND sky130_ef_sc_hd__decap_12
XFILLER_6_65 VGND VPWR VPWR VGND sky130_ef_sc_hd__decap_12
XFILLER_1_217 VPWR VGND VPWR VGND sky130_fd_sc_hd__decap_6
X_381_ VPWR VGND VPWR VGND _060_ rst sky130_fd_sc_hd__inv_2
XFILLER_40_121 VGND VPWR VPWR VGND sky130_ef_sc_hd__decap_12
XFILLER_40_165 VGND VPWR VPWR VGND sky130_ef_sc_hd__decap_12
X_450_ VPWR VGND VPWR VGND _079_ clk sky130_fd_sc_hd__inv_2
XFILLER_15_96 VGND VPWR VPWR VGND sky130_fd_sc_hd__decap_4
XFILLER_31_51 VGND VPWR VPWR VGND sky130_fd_sc_hd__decap_4
XFILLER_36_29 VGND VPWR VPWR VGND sky130_ef_sc_hd__decap_12
X_433_ VPWR VGND VPWR VGND _045_ clk sky130_fd_sc_hd__inv_2
X_502_ VGND VPWR VPWR VGND _055_ sel_one_hot\[27\] _054_ sel_reg\[27\] sky130_fd_sc_hd__dfrtp_2
XFILLER_9_125 VGND VPWR VPWR VGND sky130_ef_sc_hd__decap_12
X_364_ VPWR VGND VPWR VGND _094_ rst sky130_fd_sc_hd__inv_2
X_295_ Q[2] _199_ Q[3] _174_ VPWR VGND VPWR VGND sky130_fd_sc_hd__and3_2
XFILLER_9_169 VPWR VGND VPWR VGND sky130_fd_sc_hd__decap_8
XFILLER_5_3 VGND VPWR VPWR VGND sky130_ef_sc_hd__decap_12
XFILLER_12_53 VGND VPWR VPWR VGND sky130_fd_sc_hd__decap_4
X_416_ VPWR VGND VPWR VGND _011_ clk sky130_fd_sc_hd__inv_2
X_347_ VPWR VGND _171_ sel_one_hot\[62\] _204_ VPWR VGND sky130_fd_sc_hd__and2_2
X_278_ VPWR VGND VPWR VGND _165_ _189_ _188_ Q[4] sky130_fd_sc_hd__or3b_2
XFILLER_38_3 VGND VPWR VPWR VGND sky130_ef_sc_hd__decap_12
XFILLER_15_249 VGND VPWR VPWR VGND sky130_ef_sc_hd__decap_12
XFILLER_2_153 VGND VPWR VPWR VGND sky130_ef_sc_hd__decap_12
XFILLER_2_197 VGND VPWR VPWR VGND sky130_ef_sc_hd__decap_12
XFILLER_44_29 VGND VPWR VPWR VGND sky130_ef_sc_hd__decap_12
XFILLER_18_85 VPWR VGND VPWR VGND sky130_fd_sc_hd__decap_6
XFILLER_18_41 VGND VPWR VPWR VGND sky130_ef_sc_hd__decap_12
XPHY_EDGE_ROW_28_Left_73 VPWR VGND VPWR VGND sky130_fd_sc_hd__decap_3
XPHY_EDGE_ROW_12_Left_57 VPWR VGND VPWR VGND sky130_fd_sc_hd__decap_3
XFILLER_37_193 VGND VPWR VPWR VGND sky130_ef_sc_hd__decap_12
XFILLER_29_51 VGND VPWR VPWR VGND sky130_fd_sc_hd__decap_4
XFILLER_35_119 VPWR VGND VPWR VGND sky130_fd_sc_hd__decap_8
XFILLER_6_77 VPWR VGND VPWR VGND sky130_fd_sc_hd__decap_6
XFILLER_20_3 VGND VPWR VPWR VGND sky130_ef_sc_hd__decap_12
XFILLER_34_141 VGND VPWR VPWR VGND sky130_fd_sc_hd__decap_4
Xdelay_chain\[18\].genblk1.inv_b.core_inv VPWR VGND VGND VPWR delay_chain\[18\].genblk1.inv_a.out
+ delay_chain\[18\].genblk1.inv_b.out sky130_fd_sc_hd__inv_1
XFILLER_40_133 VPWR VGND VPWR VGND sky130_fd_sc_hd__decap_6
XFILLER_40_177 VGND VPWR VPWR VGND sky130_ef_sc_hd__decap_12
X_380_ VPWR VGND VPWR VGND _062_ rst sky130_fd_sc_hd__inv_2
Xdelay_chain\[27\].genblk1.inv_b.core_inv VPWR VGND VGND VPWR delay_chain\[27\].genblk1.inv_a.out
+ delay_chain\[27\].genblk1.inv_b.out sky130_fd_sc_hd__inv_1
XFILLER_16_141 VPWR VGND VPWR VGND sky130_fd_sc_hd__decap_3
Xdelay_chain\[19\].genblk1.inv_a.core_inv VPWR VGND VGND VPWR delay_chain\[18\].genblk1.inv_b.out
+ delay_chain\[19\].genblk1.inv_a.out sky130_fd_sc_hd__inv_1
.ends
