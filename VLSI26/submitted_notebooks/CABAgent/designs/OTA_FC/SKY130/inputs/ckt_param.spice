.param VDD=1.8 VCM=0.9 IB=50u vi=0.05 fi=100000 L1=0.5 W1=4.2 NF1=2 L2=0.5 W2=4.2 NF2=2 L3=0.5 W3=8.4 NF3=4 L4=0.5 W4=4.2 NF4=2 L5=0.5 W5=4.2 NF5=2 L6=0.5 W6=4.2 NF6=2
