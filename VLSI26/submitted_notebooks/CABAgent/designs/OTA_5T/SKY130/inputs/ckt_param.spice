.param VDD=1.8 VCM=0.9 IB=50u vi=0.05 fi=100000 L_NMOS_DIFF=0.15 W_NMOS_DIFF=4.2 NF_NMOS_DIFF=4 L_NMOS_TAIL=0.15 W_NMOS_TAIL=8.4 NF_NMOS_TAIL=8 L_PMOS_LOAD=0.15 W_PMOS_LOAD=4.2 NF_PMOS_LOAD=4 L_NMOS_BIAS=0.15 W_NMOS_BIAS=8.4 NF_NMOS_BIAS=8
