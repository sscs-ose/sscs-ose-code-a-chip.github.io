XM1 net_pmos_mirror_gate VIP net_tail_source VSS sky130_fd_pr__nfet_01v8 L=L_NMOS_DIFF W=W_NMOS_DIFF nf=NF_NMOS_DIFF ad='int((nf+1)/2) * W/nf * 0.29' as='int((nf+2)/2) * W/nf * 0.29' pd='2*int((nf+1)/2) * (W/nf + 0.29)'
+ ps='2*int((nf+2)/2) * (W/nf + 0.29)' nrd='0.29 / W' nrs='0.29 / W' sa=0 sb=0 sd=0 mult=1 m=1
XM2 VOUT VIN net_tail_source VSS sky130_fd_pr__nfet_01v8 L=L_NMOS_DIFF W=W_NMOS_DIFF nf=NF_NMOS_DIFF ad='int((nf+1)/2) * W/nf * 0.29' as='int((nf+2)/2) * W/nf * 0.29' pd='2*int((nf+1)/2) * (W/nf + 0.29)'
+ ps='2*int((nf+2)/2) * (W/nf + 0.29)' nrd='0.29 / W' nrs='0.29 / W' sa=0 sb=0 sd=0 mult=1 m=1
XM3 net_tail_source IB VSS VSS sky130_fd_pr__nfet_01v8 L=L_NMOS_TAIL W=W_NMOS_TAIL nf=NF_NMOS_TAIL ad='int((nf+1)/2) * W/nf * 0.29' as='int((nf+2)/2) * W/nf * 0.29' pd='2*int((nf+1)/2) * (W/nf + 0.29)'
+ ps='2*int((nf+2)/2) * (W/nf + 0.29)' nrd='0.29 / W' nrs='0.29 / W' sa=0 sb=0 sd=0 mult=1 m=1
XM4 net_pmos_mirror_gate net_pmos_mirror_gate VDD VDD sky130_fd_pr__pfet_01v8 L=L_PMOS_LOAD W=W_PMOS_LOAD nf=NF_PMOS_LOAD ad='int((nf+1)/2) * W/nf * 0.29' as='int((nf+2)/2) * W/nf * 0.29' pd='2*int((nf+1)/2) * (W/nf + 0.29)'
+ ps='2*int((nf+2)/2) * (W/nf + 0.29)' nrd='0.29 / W' nrs='0.29 / W' sa=0 sb=0 sd=0 mult=1 m=1
XM5 VOUT net_pmos_mirror_gate VDD VDD sky130_fd_pr__pfet_01v8 L=L_PMOS_LOAD W=W_PMOS_LOAD nf=NF_PMOS_LOAD ad='int((nf+1)/2) * W/nf * 0.29' as='int((nf+2)/2) * W/nf * 0.29' pd='2*int((nf+1)/2) * (W/nf + 0.29)'
+ ps='2*int((nf+2)/2) * (W/nf + 0.29)' nrd='0.29 / W' nrs='0.29 / W' sa=0 sb=0 sd=0 mult=1 m=1
XM6 IB IB VSS VSS sky130_fd_pr__nfet_01v8 L=L_NMOS_BIAS W=W_NMOS_BIAS nf=NF_NMOS_BIAS ad='int((nf+1)/2) * W/nf * 0.29' as='int((nf+2)/2) * W/nf * 0.29' pd='2*int((nf+1)/2) * (W/nf + 0.29)'
+ ps='2*int((nf+2)/2) * (W/nf + 0.29)' nrd='0.29 / W' nrs='0.29 / W' sa=0 sb=0 sd=0 mult=1 m=1
