* NGSPICE file created from microrobot_clock.ext - technology: sky130A

.subckt microrobot_clock clk vdd vss bias_n bias_p
X0 vss bias_n X4_Xni.S vss sky130_fd_pr__nfet_01v8 ad=0.145 pd=1.58 as=0.145 ps=1.58 w=0.5 l=8
X1 vss bias_n bias_p vss sky130_fd_pr__nfet_01v8 ad=0.145 pd=1.58 as=0.145 ps=1.58 w=0.5 l=8
X2 vdd bias_p X4_Xpi.S vdd sky130_fd_pr__pfet_01v8 ad=0.29 pd=2.58 as=0.29 ps=2.58 w=1 l=8
X3 X3_Xns.D Xc2.C1 Xc3.C1 vss sky130_fd_pr__nfet_01v8 ad=0.145 pd=1.58 as=0.145 ps=1.58 w=0.5 l=0.5
X4 Xc3.C1 vss sky130_fd_pr__cap_mim_m3_1 l=2 w=2
X5 Xc2.C1 vss sky130_fd_pr__cap_mim_m3_1 l=2 w=2
X6 vdd bias_p X1_Xps.D vdd sky130_fd_pr__pfet_01v8 ad=0.29 pd=2.58 as=0.29 ps=2.58 w=1 l=8
X7 vss bias_n X3_Xns.D vss sky130_fd_pr__nfet_01v8 ad=0.145 pd=1.58 as=0.145 ps=1.58 w=0.5 l=8
X8 X4_Xpi.S Xc3.C1 X4_Xpi.D vdd sky130_fd_pr__pfet_01v8 ad=0.29 pd=2.58 as=0.29 ps=2.58 w=1 l=0.5
X9 vdd bias_p bias_p vdd sky130_fd_pr__pfet_01v8 ad=0.29 pd=2.58 as=0.29 ps=2.58 w=1 l=8
X10 vdd Xbp2.G clk vdd sky130_fd_pr__pfet_01v8 ad=0.29 pd=2.58 as=0.29 ps=2.58 w=1 l=1
X11 vss X1_Xpi.G Xbp2.G vss sky130_fd_pr__nfet_01v8 ad=0.145 pd=1.58 as=0.145 ps=1.58 w=0.5 l=8
X12 vss bias_n X2_Xns.D vss sky130_fd_pr__nfet_01v8 ad=0.145 pd=1.58 as=0.145 ps=1.58 w=0.5 l=8
X13 X1_Xpi.G vss sky130_fd_pr__cap_mim_m3_1 l=2.5 w=2
X14 vss bias_n bias_n vss sky130_fd_pr__nfet_01v8 ad=0.145 pd=1.58 as=0.145 ps=1.58 w=0.5 l=8
X15 Xbias.Xb2.D vdd vdd vss sky130_fd_pr__nfet_01v8 ad=0.145 pd=1.58 as=0.145 ps=1.58 w=0.5 l=8
X16 X3_Xps.D Xc2.C1 Xc3.C1 vdd sky130_fd_pr__pfet_01v8 ad=0.29 pd=2.58 as=0.29 ps=2.58 w=1 l=0.5
X17 X5_Xni.S X4_Xpi.D X1_Xpi.G vss sky130_fd_pr__nfet_01v8 ad=0.145 pd=1.58 as=0.145 ps=1.58 w=0.5 l=0.5
X18 Xc1.C1 vss sky130_fd_pr__cap_mim_m3_1 l=2 w=2
X19 bias_n vss sky130_fd_pr__cap_mim_m3_1 l=7 w=7
X20 vdd bias_p X3_Xps.D vdd sky130_fd_pr__pfet_01v8 ad=0.29 pd=2.58 as=0.29 ps=2.58 w=1 l=8
X21 vss bias_n X5_Xni.S vss sky130_fd_pr__nfet_01v8 ad=0.145 pd=1.58 as=0.145 ps=1.58 w=0.5 l=8
X22 X2_Xns.D Xc1.C1 Xc2.C1 vss sky130_fd_pr__nfet_01v8 ad=0.145 pd=1.58 as=0.145 ps=1.58 w=0.5 l=0.5
X23 bias_p vss sky130_fd_pr__cap_mim_m3_1 l=7 w=7
X24 vdd bias_p X2_Xps.D vdd sky130_fd_pr__pfet_01v8 ad=0.29 pd=2.58 as=0.29 ps=2.58 w=1 l=8
X25 X5_Xps.D X4_Xpi.D X1_Xpi.G vdd sky130_fd_pr__pfet_01v8 ad=0.29 pd=2.58 as=0.29 ps=2.58 w=1 l=0.5
X26 bias_n Xbias.Xb2.D Xbias.Xb2.D vss sky130_fd_pr__nfet_01v8 ad=0.145 pd=1.58 as=0.145 ps=1.58 w=0.5 l=8
X27 X4_Xpi.D vss sky130_fd_pr__cap_mim_m3_1 l=2 w=2
X28 vss bias_n X1_Xns.D vss sky130_fd_pr__nfet_01v8 ad=0.145 pd=1.58 as=0.145 ps=1.58 w=0.5 l=8
X29 X2_Xps.D Xc1.C1 Xc2.C1 vdd sky130_fd_pr__pfet_01v8 ad=0.29 pd=2.58 as=0.29 ps=2.58 w=1 l=0.5
X30 vdd X1_Xpi.G Xbp2.G vdd sky130_fd_pr__pfet_01v8 ad=0.29 pd=2.58 as=0.29 ps=2.58 w=1 l=8
X31 X1_Xns.D X1_Xpi.G Xc1.C1 vss sky130_fd_pr__nfet_01v8 ad=0.145 pd=1.58 as=0.145 ps=1.58 w=0.5 l=0.5
X32 vss Xbp2.G clk vss sky130_fd_pr__nfet_01v8 ad=0.145 pd=1.58 as=0.145 ps=1.58 w=0.5 l=1
X33 X1_Xps.D X1_Xpi.G Xc1.C1 vdd sky130_fd_pr__pfet_01v8 ad=0.29 pd=2.58 as=0.29 ps=2.58 w=1 l=0.5
X34 X4_Xni.S Xc3.C1 X4_Xpi.D vss sky130_fd_pr__nfet_01v8 ad=0.145 pd=1.58 as=0.145 ps=1.58 w=0.5 l=0.5
X35 vdd bias_p X5_Xps.D vdd sky130_fd_pr__pfet_01v8 ad=0.29 pd=2.58 as=0.29 ps=2.58 w=1 l=8
.ends
