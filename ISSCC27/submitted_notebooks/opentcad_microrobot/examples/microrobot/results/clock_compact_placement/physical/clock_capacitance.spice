* NGSPICE file created from microrobot_clock.ext - technology: sky130A

.subckt microrobot_clock clk vdd vss bias_n bias_p
X0 vss bias_n X4_Xni.S vss sky130_fd_pr__nfet_01v8 ad=0.145 pd=1.58 as=0.145 ps=1.58 w=0.5 l=8
X1 vss bias_n bias_p vss sky130_fd_pr__nfet_01v8 ad=0.145 pd=1.58 as=0.145 ps=1.58 w=0.5 l=8
X2 vdd bias_p X4_Xpi.S vdd sky130_fd_pr__pfet_01v8 ad=0.29 pd=2.58 as=0.29 ps=2.58 w=1 l=8
X3 X3_Xns.D Xc2.C1 Xc3.C1 vss sky130_fd_pr__nfet_01v8 ad=0.145 pd=1.58 as=0.145 ps=1.58 w=0.5 l=0.5
X4 Xc3.C1 vss sky130_fd_pr__cap_mim_m3_1 l=2 w=2
X5 Xc2.C1 vss sky130_fd_pr__cap_mim_m3_1 l=2 w=2
X6 vdd bias_p X1_Xps.D vdd sky130_fd_pr__pfet_01v8 ad=0.29 pd=2.58 as=0.29 ps=2.58 w=1 l=8
X7 vss bias_n X3_Xns.D vss sky130_fd_pr__nfet_01v8 ad=0.145 pd=1.58 as=0.145 ps=1.58 w=0.5 l=8
X8 X4_Xpi.S Xc3.C1 X4_Xpi.D vdd sky130_fd_pr__pfet_01v8 ad=0.29 pd=2.58 as=0.29 ps=2.58 w=1 l=0.5
X9 vdd bias_p bias_p vdd sky130_fd_pr__pfet_01v8 ad=0.29 pd=2.58 as=0.29 ps=2.58 w=1 l=8
X10 vdd Xbp2.G clk vdd sky130_fd_pr__pfet_01v8 ad=0.29 pd=2.58 as=0.29 ps=2.58 w=1 l=1
X11 vss X1_Xpi.G Xbp2.G vss sky130_fd_pr__nfet_01v8 ad=0.145 pd=1.58 as=0.145 ps=1.58 w=0.5 l=8
X12 vss bias_n X2_Xns.D vss sky130_fd_pr__nfet_01v8 ad=0.145 pd=1.58 as=0.145 ps=1.58 w=0.5 l=8
X13 X1_Xpi.G vss sky130_fd_pr__cap_mim_m3_1 l=2.5 w=2
X14 vss bias_n bias_n vss sky130_fd_pr__nfet_01v8 ad=0.145 pd=1.58 as=0.145 ps=1.58 w=0.5 l=8
X15 Xbias.Xb2.D vdd vdd vss sky130_fd_pr__nfet_01v8 ad=0.145 pd=1.58 as=0.145 ps=1.58 w=0.5 l=8
X16 X3_Xps.D Xc2.C1 Xc3.C1 vdd sky130_fd_pr__pfet_01v8 ad=0.29 pd=2.58 as=0.29 ps=2.58 w=1 l=0.5
X17 X5_Xni.S X4_Xpi.D X1_Xpi.G vss sky130_fd_pr__nfet_01v8 ad=0.145 pd=1.58 as=0.145 ps=1.58 w=0.5 l=0.5
X18 Xc1.C1 vss sky130_fd_pr__cap_mim_m3_1 l=2 w=2
X19 bias_n vss sky130_fd_pr__cap_mim_m3_1 l=7 w=7
X20 vdd bias_p X3_Xps.D vdd sky130_fd_pr__pfet_01v8 ad=0.29 pd=2.58 as=0.29 ps=2.58 w=1 l=8
X21 vss bias_n X5_Xni.S vss sky130_fd_pr__nfet_01v8 ad=0.145 pd=1.58 as=0.145 ps=1.58 w=0.5 l=8
X22 X2_Xns.D Xc1.C1 Xc2.C1 vss sky130_fd_pr__nfet_01v8 ad=0.145 pd=1.58 as=0.145 ps=1.58 w=0.5 l=0.5
X23 bias_p vss sky130_fd_pr__cap_mim_m3_1 l=7 w=7
X24 vdd bias_p X2_Xps.D vdd sky130_fd_pr__pfet_01v8 ad=0.29 pd=2.58 as=0.29 ps=2.58 w=1 l=8
X25 X5_Xps.D X4_Xpi.D X1_Xpi.G vdd sky130_fd_pr__pfet_01v8 ad=0.29 pd=2.58 as=0.29 ps=2.58 w=1 l=0.5
X26 bias_n Xbias.Xb2.D Xbias.Xb2.D vss sky130_fd_pr__nfet_01v8 ad=0.145 pd=1.58 as=0.145 ps=1.58 w=0.5 l=8
X27 X4_Xpi.D vss sky130_fd_pr__cap_mim_m3_1 l=2 w=2
X28 vss bias_n X1_Xns.D vss sky130_fd_pr__nfet_01v8 ad=0.145 pd=1.58 as=0.145 ps=1.58 w=0.5 l=8
X29 X2_Xps.D Xc1.C1 Xc2.C1 vdd sky130_fd_pr__pfet_01v8 ad=0.29 pd=2.58 as=0.29 ps=2.58 w=1 l=0.5
X30 vdd X1_Xpi.G Xbp2.G vdd sky130_fd_pr__pfet_01v8 ad=0.29 pd=2.58 as=0.29 ps=2.58 w=1 l=8
X31 X1_Xns.D X1_Xpi.G Xc1.C1 vss sky130_fd_pr__nfet_01v8 ad=0.145 pd=1.58 as=0.145 ps=1.58 w=0.5 l=0.5
X32 vss Xbp2.G clk vss sky130_fd_pr__nfet_01v8 ad=0.145 pd=1.58 as=0.145 ps=1.58 w=0.5 l=1
X33 X1_Xps.D X1_Xpi.G Xc1.C1 vdd sky130_fd_pr__pfet_01v8 ad=0.29 pd=2.58 as=0.29 ps=2.58 w=1 l=0.5
X34 X4_Xni.S Xc3.C1 X4_Xpi.D vss sky130_fd_pr__nfet_01v8 ad=0.145 pd=1.58 as=0.145 ps=1.58 w=0.5 l=0.5
X35 vdd bias_p X5_Xps.D vdd sky130_fd_pr__pfet_01v8 ad=0.29 pd=2.58 as=0.29 ps=2.58 w=1 l=8
C0 vdd Xc2.C1 1.38644f
C1 bias_p Xc3.C1 0.09042f
C2 bias_p X5_Xps.D 3.73804f
C3 bias_n X1_Xns.D 3.91953f
C4 vdd X2_Xps.D 3.87131f
C5 bias_p vdd 23.7033f
C6 Xc2.C1 X2_Xps.D 0.33845f
C7 bias_p Xc2.C1 0.09143f
C8 bias_n X4_Xni.S 3.91946f
C9 bias_n X1_Xpi.G 0.49309f
C10 bias_p X2_Xps.D 4.17699f
C11 bias_n Xbias.Xb2.D 0.35421f
C12 bias_n X5_Xni.S 3.87271f
C13 bias_n Xc3.C1 0.13216f
C14 X4_Xpi.S X1_Xpi.G 0.17979f
C15 bias_n X5_Xps.D 0.17451f
C16 X2_Xns.D X1_Xpi.G 0.17943f
C17 X4_Xpi.S Xc3.C1 0.20863f
C18 X4_Xni.S X4_Xpi.D 0.69385f
C19 X1_Xns.D Xc1.C1 0.87939f
C20 Xbp2.G X1_Xpi.G 2.56657f
C21 bias_n vdd 31.7274f
C22 clk Xbp2.G 10.3343f
C23 bias_n Xc2.C1 0.13329f
C24 X4_Xpi.D X1_Xpi.G 4.7344f
C25 X4_Xpi.D X5_Xni.S 0.02522f
C26 vdd X4_Xpi.S 3.87131f
C27 X4_Xpi.D Xc3.C1 2.39306f
C28 vdd X2_Xns.D 0.15364f
C29 X5_Xps.D X4_Xpi.D 0.20528f
C30 X2_Xns.D Xc2.C1 0.81983f
C31 bias_n X2_Xps.D 0.15476f
C32 vdd Xbp2.G 2.68099f
C33 bias_p bias_n 30.7377f
C34 Xc1.C1 X1_Xpi.G 2.23708f
C35 X1_Xpi.G X1_Xps.D 0.19627f
C36 vdd X4_Xpi.D 1.51132f
C37 bias_p X4_Xpi.S 3.89566f
C38 bias_p X2_Xns.D 0.18105f
C39 X3_Xps.D X1_Xpi.G 0.18414f
C40 Xc3.C1 X3_Xps.D 0.36017f
C41 vdd Xc1.C1 1.2893f
C42 bias_p X4_Xpi.D 0.08708f
C43 vdd X1_Xps.D 3.87175f
C44 Xc2.C1 Xc1.C1 1.94863f
C45 vdd X3_Xps.D 3.87131f
C46 X3_Xps.D Xc2.C1 0.20963f
C47 X2_Xps.D Xc1.C1 0.21014f
C48 bias_p Xc1.C1 0.09866f
C49 bias_p X1_Xps.D 5.28808f
C50 bias_n X4_Xpi.S 0.15476f
C51 bias_n X2_Xns.D 3.91946f
C52 X3_Xns.D X1_Xpi.G 0.17742f
C53 bias_n Xbp2.G 0
C54 bias_p X3_Xps.D 3.89566f
C55 X3_Xns.D Xc3.C1 0.75934f
C56 bias_n X4_Xpi.D 0.12854f
C57 X1_Xns.D X1_Xpi.G 0.27904f
C58 X4_Xpi.S X4_Xpi.D 0.37955f
C59 vdd X3_Xns.D 0.15364f
C60 X3_Xns.D Xc2.C1 0.02522f
C61 X4_Xni.S X1_Xpi.G 0.17073f
C62 bias_n Xc1.C1 0.13394f
C63 bias_n X1_Xps.D 0.15463f
C64 X4_Xni.S Xc3.C1 0.02522f
C65 vdd X1_Xns.D 0.15364f
C66 X2_Xns.D Xc1.C1 0.02522f
C67 clk X1_Xpi.G 0
C68 X5_Xni.S X1_Xpi.G 0.64633f
C69 bias_p X3_Xns.D 0.18105f
C70 Xc3.C1 X1_Xpi.G 1.14045f
C71 bias_n X3_Xps.D 0.15476f
C72 X5_Xps.D X1_Xpi.G 0.49575f
C73 vdd X4_Xni.S 0.15364f
C74 bias_p X1_Xns.D 0.27763f
C75 vdd X1_Xpi.G 6.52239f
C76 vdd Xbias.Xb2.D 0.34322f
C77 Xc2.C1 X1_Xpi.G 0.81422f
C78 clk vdd 0.91641f
C79 vdd X5_Xni.S 0.16352f
C80 vdd Xc3.C1 1.45239f
C81 Xc3.C1 Xc2.C1 2.17084f
C82 bias_p X4_Xni.S 0.18105f
C83 vdd X5_Xps.D 3.87131f
C84 Xc1.C1 X1_Xps.D 0.32111f
C85 X2_Xps.D X1_Xpi.G 0.18563f
C86 bias_p X1_Xpi.G 0.35928f
C87 bias_p Xbias.Xb2.D 6.27185f
C88 bias_n X3_Xns.D 3.91946f
C89 clk vss 8.52623f
C90 bias_p vss 65.3244f
C91 bias_n vss 84.2581f
C92 vdd vss 0.16437p
C93 Xbp2.G vss 24.1522f
C94 X5_Xni.S vss 13.4061f
C95 X5_Xps.D vss 11.2478f
C96 X4_Xni.S vss 13.0046f
C97 X4_Xpi.D vss 8.78269f
C98 X4_Xpi.S vss 10.6828f
C99 X3_Xns.D vss 12.4756f
C100 Xc3.C1 vss 9.07646f
C101 X3_Xps.D vss 10.1179f
C102 X2_Xns.D vss 11.9466f
C103 Xc2.C1 vss 9.19737f
C104 X2_Xps.D vss 9.18266f
C105 X1_Xns.D vss 11.2011f
C106 Xc1.C1 vss 9.38692f
C107 X1_Xpi.G vss 33.7814f
C108 X1_Xps.D vss 7.88847f
C109 Xbias.Xb2.D vss 18.8034f
.ends
