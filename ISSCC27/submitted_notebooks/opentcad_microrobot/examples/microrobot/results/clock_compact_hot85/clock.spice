* Our low-power clock candidate; three scaled S2E-fit cells, optical ramp, chosen storage capacitor
.lib "/usr/local/share/pdk/sky130A/libs.tech/ngspice/sky130.lib.spice" tt
.temp 85
* NGSPICE file created from microrobot_clock.ext - technology: sky130A

.subckt microrobot_clock clk vdd vss bias_n bias_p
X0 vss.t23 bias_n.t3 X4_Xni.S.t0 vss.t22 sky130_fd_pr__nfet_01v8 ad=0.145 pd=1.58 as=0.145 ps=1.58 w=0.5 l=8
X1 vss.t13 bias_n.t4 bias_p.t2 vss.t12 sky130_fd_pr__nfet_01v8 ad=0.145 pd=1.58 as=0.145 ps=1.58 w=0.5 l=8
X2 vdd.t16 bias_p.t4 X4_Xpi.S.t0 vdd.t15 sky130_fd_pr__pfet_01v8 ad=0.29 pd=2.58 as=0.29 ps=2.58 w=1 l=8
X3 X3_Xns.D.t0 Xc2.C1.t2 Xc3.C1.t1 vss.t29 sky130_fd_pr__nfet_01v8 ad=0.145 pd=1.58 as=0.145 ps=1.58 w=0.5 l=0.5
X4 Xc3.C1.t2 vss.t31 sky130_fd_pr__cap_mim_m3_1 l=2 w=2
X5 Xc2.C1.t3 vss.t28 sky130_fd_pr__cap_mim_m3_1 l=2 w=2
X6 vdd.t18 bias_p.t5 X1_Xps.D.t1 vdd.t17 sky130_fd_pr__pfet_01v8 ad=0.29 pd=2.58 as=0.29 ps=2.58 w=1 l=8
X7 vss.t19 bias_n.t5 X3_Xns.D.t1 vss.t18 sky130_fd_pr__nfet_01v8 ad=0.145 pd=1.58 as=0.145 ps=1.58 w=0.5 l=8
X8 X4_Xpi.S.t1 Xc3.C1.t3 X4_Xpi.D.t0 vdd.t22 sky130_fd_pr__pfet_01v8 ad=0.29 pd=2.58 as=0.29 ps=2.58 w=1 l=0.5
X9 vdd.t20 bias_p.t0 bias_p.t1 vdd.t19 sky130_fd_pr__pfet_01v8 ad=0.29 pd=2.58 as=0.29 ps=2.58 w=1 l=8
X10 vdd.t3 Xbp2.G.t2 clk.t0 vdd.t2 sky130_fd_pr__pfet_01v8 ad=0.29 pd=2.58 as=0.29 ps=2.58 w=1 l=1
X11 vss.t2 X1_Xpi.G.t2 Xbp2.G.t1 vss.t1 sky130_fd_pr__nfet_01v8 ad=0.145 pd=1.58 as=0.145 ps=1.58 w=0.5 l=8
X12 vss.t17 bias_n.t6 X2_Xns.D.t1 vss.t16 sky130_fd_pr__nfet_01v8 ad=0.145 pd=1.58 as=0.145 ps=1.58 w=0.5 l=8
X13 X1_Xpi.G.t3 vss.t0 sky130_fd_pr__cap_mim_m3_1 l=2.5 w=2
X14 vss.t21 bias_n.t0 bias_n.t1 vss.t20 sky130_fd_pr__nfet_01v8 ad=0.145 pd=1.58 as=0.145 ps=1.58 w=0.5 l=8
X15 Xbias.Xb2.D.t2 vdd.t7 vdd.t8 vss.t9 sky130_fd_pr__nfet_01v8 ad=0.145 pd=1.58 as=0.145 ps=1.58 w=0.5 l=8
X16 X3_Xps.D.t0 Xc2.C1.t4 Xc3.C1.t0 vdd.t21 sky130_fd_pr__pfet_01v8 ad=0.29 pd=2.58 as=0.29 ps=2.58 w=1 l=0.5
X17 X5_Xni.S.t0 X4_Xpi.D.t2 X1_Xpi.G.t0 vss.t7 sky130_fd_pr__nfet_01v8 ad=0.145 pd=1.58 as=0.145 ps=1.58 w=0.5 l=0.5
X18 Xc1.C1.t2 vss.t10 sky130_fd_pr__cap_mim_m3_1 l=2 w=2
X19 bias_n.t9 vss.t26 sky130_fd_pr__cap_mim_m3_1 l=7 w=7
X20 vdd.t14 bias_p.t7 X3_Xps.D.t1 vdd.t13 sky130_fd_pr__pfet_01v8 ad=0.29 pd=2.58 as=0.29 ps=2.58 w=1 l=8
X21 vss.t15 bias_n.t8 X5_Xni.S.t1 vss.t14 sky130_fd_pr__nfet_01v8 ad=0.145 pd=1.58 as=0.145 ps=1.58 w=0.5 l=8
X22 X2_Xns.D.t0 Xc1.C1.t3 Xc2.C1.t0 vss.t11 sky130_fd_pr__nfet_01v8 ad=0.145 pd=1.58 as=0.145 ps=1.58 w=0.5 l=0.5
X23 bias_p.t8 vss.t5 sky130_fd_pr__cap_mim_m3_1 l=7 w=7
X24 vdd.t12 bias_p.t6 X2_Xps.D.t1 vdd.t11 sky130_fd_pr__pfet_01v8 ad=0.29 pd=2.58 as=0.29 ps=2.58 w=1 l=8
X25 X5_Xps.D.t0 X4_Xpi.D.t3 X1_Xpi.G.t1 vdd.t5 sky130_fd_pr__pfet_01v8 ad=0.29 pd=2.58 as=0.29 ps=2.58 w=1 l=0.5
X26 bias_n.t2 Xbias.Xb2.D.t0 Xbias.Xb2.D.t1 vss.t27 sky130_fd_pr__nfet_01v8 ad=0.145 pd=1.58 as=0.145 ps=1.58 w=0.5 l=8
X27 X4_Xpi.D.t4 vss.t8 sky130_fd_pr__cap_mim_m3_1 l=2 w=2
X28 vss.t25 bias_n.t7 X1_Xns.D.t1 vss.t24 sky130_fd_pr__nfet_01v8 ad=0.145 pd=1.58 as=0.145 ps=1.58 w=0.5 l=8
X29 X2_Xps.D.t0 Xc1.C1.t4 Xc2.C1.t1 vdd.t6 sky130_fd_pr__pfet_01v8 ad=0.29 pd=2.58 as=0.29 ps=2.58 w=1 l=0.5
X30 vdd.t1 X1_Xpi.G.t4 Xbp2.G.t0 vdd.t0 sky130_fd_pr__pfet_01v8 ad=0.29 pd=2.58 as=0.29 ps=2.58 w=1 l=8
X31 X1_Xns.D.t0 X1_Xpi.G.t5 Xc1.C1.t0 vss.t6 sky130_fd_pr__nfet_01v8 ad=0.145 pd=1.58 as=0.145 ps=1.58 w=0.5 l=0.5
X32 vss.t4 Xbp2.G.t3 clk.t1 vss.t3 sky130_fd_pr__nfet_01v8 ad=0.145 pd=1.58 as=0.145 ps=1.58 w=0.5 l=1
X33 X1_Xps.D.t0 X1_Xpi.G.t6 Xc1.C1.t1 vdd.t4 sky130_fd_pr__pfet_01v8 ad=0.29 pd=2.58 as=0.29 ps=2.58 w=1 l=0.5
X34 X4_Xni.S.t1 Xc3.C1.t4 X4_Xpi.D.t1 vss.t30 sky130_fd_pr__nfet_01v8 ad=0.145 pd=1.58 as=0.145 ps=1.58 w=0.5 l=0.5
X35 vdd.t10 bias_p.t3 X5_Xps.D.t1 vdd.t9 sky130_fd_pr__pfet_01v8 ad=0.29 pd=2.58 as=0.29 ps=2.58 w=1 l=8
R0 bias_n bias_n.t1 219.8
R1 bias_n bias_n.t2 219.8
R2 bias_n.t8 bias_n.n8 45.8154
R3 bias_n.n5 bias_n.t7 39.5879
R4 bias_n.n6 bias_n.t6 39.5879
R5 bias_n.n7 bias_n.t5 39.5879
R6 bias_n.n8 bias_n.t3 39.5879
R7 bias_n.n0 bias_n 30.9416
R8 bias_n.n2 bias_n 28.5746
R9 bias_n.n1 bias_n 20.0305
R10 bias_n.n0 bias_n 20.0305
R11 bias_n.n5 bias_n.n4 19.1195
R12 bias_n.n3 bias_n 16.2272
R13 bias_n.n4 bias_n 15.667
R14 bias_n bias_n.t0 9.77232
R15 bias_n bias_n.t4 9.77232
R16 bias_n.t7 bias_n 9.77232
R17 bias_n.t6 bias_n 9.77232
R18 bias_n.t5 bias_n 9.77232
R19 bias_n.t3 bias_n 9.77232
R20 bias_n bias_n.t8 9.77232
R21 bias_n.n8 bias_n.n7 6.228
R22 bias_n.n7 bias_n.n6 6.228
R23 bias_n.n6 bias_n.n5 6.228
R24 bias_n.n4 bias_n 2.468
R25 bias_n.n1 bias_n.n0 1.763
R26 bias_n.n3 bias_n.n2 1.00747
R27 bias_n.n2 bias_n.n1 0.370038
R28 bias_n bias_n.n3 0.259
R29 bias_n bias_n.t9 0.0180781
R30 X4_Xni.S X4_Xni.S.t1 219.8
R31 X4_Xni.S X4_Xni.S.t0 219.8
R32 X4_Xni.S X4_Xni.S.n0 42.7417
R33 X4_Xni.S.n0 X4_Xni.S 42.1543
R34 X4_Xni.S.n0 X4_Xni.S 0.05925
R35 vss.n177 vss.n26 10393.1
R36 vss.n178 vss.n24 10393.1
R37 vss.n179 vss.n22 10393.1
R38 vss.n180 vss.n20 10393.1
R39 vss.n181 vss.n18 10393.1
R40 vss.n160 vss.n46 6564.74
R41 vss.n50 vss.n46 6564.74
R42 vss.n160 vss.n47 6564.74
R43 vss.n44 vss.n41 6564.74
R44 vss.n163 vss.n41 6564.74
R45 vss.n44 vss.n39 6564.74
R46 vss.n163 vss.n39 6564.74
R47 vss.n169 vss.n33 6564.74
R48 vss.n42 vss.n33 6564.74
R49 vss.n169 vss.n34 6564.74
R50 vss.n42 vss.n34 6564.74
R51 vss.n175 vss.n27 6564.74
R52 vss.n172 vss.n27 6564.74
R53 vss.n175 vss.n28 6564.74
R54 vss.n172 vss.n28 6564.74
R55 vss.n141 vss.n139 6564.74
R56 vss.n143 vss.n138 6564.74
R57 vss.n143 vss.n139 6564.74
R58 vss.n120 vss.n118 6564.74
R59 vss.n122 vss.n117 6564.74
R60 vss.n122 vss.n118 6564.74
R61 vss.n99 vss.n97 6564.74
R62 vss.n101 vss.n96 6564.74
R63 vss.n101 vss.n97 6564.74
R64 vss.n78 vss.n76 6564.74
R65 vss.n80 vss.n75 6564.74
R66 vss.n80 vss.n76 6564.74
R67 vss.n57 vss.n55 6564.74
R68 vss.n59 vss.n54 6564.74
R69 vss.n59 vss.n55 6564.74
R70 vss.n9 vss.n7 6564.74
R71 vss.n183 vss.n6 6564.74
R72 vss.t24 vss.n25 6503.45
R73 vss.t16 vss.n23 6503.45
R74 vss.t18 vss.n21 6503.45
R75 vss.t22 vss.n19 6503.45
R76 vss.t14 vss.n17 6503.45
R77 vss.n177 vss.n176 4944.6
R78 vss.n142 vss.n138 3297.63
R79 vss.n121 vss.n117 3297.63
R80 vss.n100 vss.n96 3297.63
R81 vss.n79 vss.n75 3297.63
R82 vss.n58 vss.n54 3297.63
R83 vss.n10 vss.n6 3297.63
R84 vss.n182 vss.n7 3297.63
R85 vss.n181 vss.n180 2869.27
R86 vss.n180 vss.n179 2869.27
R87 vss.n179 vss.n178 2869.27
R88 vss.n178 vss.n177 2869.27
R89 vss.n15 vss.n14 2508.85
R90 vss.n15 vss.n1 2508.85
R91 vss.n11 vss.n1 2508.85
R92 vss.t1 vss.n16 2458.74
R93 vss.n153 vss.n150 2219.15
R94 vss.n153 vss.n151 2219.15
R95 vss.n155 vss.n150 2219.15
R96 vss.n132 vss.n129 2219.15
R97 vss.n132 vss.n130 2219.15
R98 vss.n134 vss.n129 2219.15
R99 vss.n111 vss.n108 2219.15
R100 vss.n111 vss.n109 2219.15
R101 vss.n113 vss.n108 2219.15
R102 vss.n90 vss.n87 2219.15
R103 vss.n90 vss.n88 2219.15
R104 vss.n92 vss.n87 2219.15
R105 vss.n69 vss.n66 2219.15
R106 vss.n69 vss.n67 2219.15
R107 vss.n71 vss.n66 2219.15
R108 vss.t1 vss.n181 2097.82
R109 vss.n16 vss.t3 1675.86
R110 vss.t6 vss.n26 1331.03
R111 vss.t11 vss.n24 1331.03
R112 vss.t29 vss.n22 1331.03
R113 vss.t30 vss.n20 1331.03
R114 vss.t7 vss.n18 1331.03
R115 vss.n12 vss.n11 1027.75
R116 vss.n154 vss.n151 842.444
R117 vss.n133 vss.n130 842.444
R118 vss.n112 vss.n109 842.444
R119 vss.n91 vss.n88 842.444
R120 vss.n70 vss.n67 842.444
R121 vss.n159 vss.n48 426.541
R122 vss.n159 vss 426.541
R123 vss.n51 vss.n48 426.541
R124 vss vss.n51 426.541
R125 vss.n40 vss.n38 426.541
R126 vss vss.n38 426.541
R127 vss.n164 vss.n40 426.541
R128 vss vss.n164 426.541
R129 vss.n168 vss.n35 426.541
R130 vss.n168 vss 426.541
R131 vss.n36 vss.n35 426.541
R132 vss vss.n36 426.541
R133 vss.n174 vss.n29 426.541
R134 vss.n173 vss.n29 426.541
R135 vss.n174 vss 426.541
R136 vss vss.n173 426.541
R137 vss.n140 vss.n136 426.541
R138 vss.n140 vss.n137 426.541
R139 vss vss.n136 426.541
R140 vss vss.n137 426.541
R141 vss.n119 vss.n115 426.541
R142 vss.n119 vss.n116 426.541
R143 vss vss.n115 426.541
R144 vss vss.n116 426.541
R145 vss.n98 vss.n94 426.541
R146 vss.n98 vss.n95 426.541
R147 vss vss.n94 426.541
R148 vss vss.n95 426.541
R149 vss.n77 vss.n73 426.541
R150 vss.n77 vss.n74 426.541
R151 vss vss.n73 426.541
R152 vss vss.n74 426.541
R153 vss.n56 vss.n52 426.541
R154 vss.n56 vss.n53 426.541
R155 vss vss.n52 426.541
R156 vss vss.n53 426.541
R157 vss.n8 vss.n4 426.541
R158 vss.n8 vss.n5 426.541
R159 vss vss.n4 426.541
R160 vss vss.n5 426.541
R161 vss.n50 vss.n49 368.553
R162 vss.n171 vss.n170 290.156
R163 vss.n45 vss.n43 290.156
R164 vss.n162 vss.n161 290.156
R165 vss.n176 vss.t9 245.618
R166 vss.n171 vss.t9 245.618
R167 vss.n170 vss.t27 245.618
R168 vss.n43 vss.t27 245.618
R169 vss.t12 vss.n45 245.618
R170 vss.n162 vss.t12 245.618
R171 vss.n161 vss.t20 245.618
R172 vss vss.t25 219.8
R173 vss vss.t17 219.8
R174 vss vss.t19 219.8
R175 vss vss.t23 219.8
R176 vss vss.t15 219.8
R177 vss vss.t2 219.8
R178 vss vss.t4 219.8
R179 vss vss.t21 219.8
R180 vss vss.t13 219.8
R181 vss vss.n155 195
R182 vss.n153 vss.n152 195
R183 vss.t6 vss.n153 195
R184 vss vss.n134 195
R185 vss.n132 vss.n131 195
R186 vss.t11 vss.n132 195
R187 vss vss.n113 195
R188 vss.n111 vss.n110 195
R189 vss.t29 vss.n111 195
R190 vss vss.n92 195
R191 vss.n90 vss.n89 195
R192 vss.t30 vss.n90 195
R193 vss vss.n71 195
R194 vss.n69 vss.n68 195
R195 vss.t7 vss.n69 195
R196 vss.n13 vss.n0 163.012
R197 vss vss.n0 163.012
R198 vss.n13 vss.n2 163.012
R199 vss vss.n2 163.012
R200 vss.n173 vss.n172 146.25
R201 vss.n172 vss.n171 146.25
R202 vss.n175 vss.n174 146.25
R203 vss.n176 vss.n175 146.25
R204 vss.n42 vss.n36 146.25
R205 vss.n43 vss.n42 146.25
R206 vss.n169 vss.n168 146.25
R207 vss.n170 vss.n169 146.25
R208 vss.n164 vss.n163 146.25
R209 vss.n163 vss.n162 146.25
R210 vss.n44 vss.n38 146.25
R211 vss.n45 vss.n44 146.25
R212 vss.n51 vss.n50 146.25
R213 vss.n160 vss.n159 146.25
R214 vss.n161 vss.n160 146.25
R215 vss.n139 vss.n137 146.25
R216 vss.n139 vss.n25 146.25
R217 vss.n138 vss.n136 146.25
R218 vss.n151 vss.n149 146.25
R219 vss.n150 vss.n148 146.25
R220 vss.n150 vss.n26 146.25
R221 vss.n118 vss.n116 146.25
R222 vss.n118 vss.n23 146.25
R223 vss.n117 vss.n115 146.25
R224 vss.n130 vss.n128 146.25
R225 vss.n129 vss.n127 146.25
R226 vss.n129 vss.n24 146.25
R227 vss.n97 vss.n95 146.25
R228 vss.n97 vss.n21 146.25
R229 vss.n96 vss.n94 146.25
R230 vss.n109 vss.n107 146.25
R231 vss.n108 vss.n106 146.25
R232 vss.n108 vss.n22 146.25
R233 vss.n76 vss.n74 146.25
R234 vss.n76 vss.n19 146.25
R235 vss.n75 vss.n73 146.25
R236 vss.n88 vss.n86 146.25
R237 vss.n87 vss.n85 146.25
R238 vss.n87 vss.n20 146.25
R239 vss.n55 vss.n53 146.25
R240 vss.n55 vss.n17 146.25
R241 vss.n54 vss.n52 146.25
R242 vss.n67 vss.n65 146.25
R243 vss.n66 vss.n64 146.25
R244 vss.n66 vss.n18 146.25
R245 vss.n7 vss.n5 146.25
R246 vss.n6 vss.n4 146.25
R247 vss.n11 vss.n0 146.25
R248 vss.n15 vss.n2 146.25
R249 vss.n16 vss.n15 146.25
R250 vss.n152 vss.n148 144.189
R251 vss.n152 vss.n149 144.189
R252 vss vss.n148 144.189
R253 vss vss.n149 144.189
R254 vss.n131 vss.n127 144.189
R255 vss.n131 vss.n128 144.189
R256 vss vss.n127 144.189
R257 vss vss.n128 144.189
R258 vss.n110 vss.n106 144.189
R259 vss.n110 vss.n107 144.189
R260 vss vss.n106 144.189
R261 vss vss.n107 144.189
R262 vss.n89 vss.n85 144.189
R263 vss.n89 vss.n86 144.189
R264 vss vss.n85 144.189
R265 vss vss.n86 144.189
R266 vss.n68 vss.n64 144.189
R267 vss.n68 vss.n65 144.189
R268 vss vss.n64 144.189
R269 vss vss.n65 144.189
R270 vss.n14 vss.n13 117.001
R271 vss vss.n1 117.001
R272 vss.t3 vss.n1 117.001
R273 vss.n155 vss.n154 111.203
R274 vss.n134 vss.n133 111.203
R275 vss.n113 vss.n112 111.203
R276 vss.n92 vss.n91 111.203
R277 vss.n71 vss.n70 111.203
R278 vss.n154 vss.t6 74.0279
R279 vss.n133 vss.t11 74.0279
R280 vss.n112 vss.t29 74.0279
R281 vss.n91 vss.t30 74.0279
R282 vss.n70 vss.t7 74.0279
R283 vss.n14 vss.n12 65.9943
R284 vss.n177 vss.n25 48.2764
R285 vss.n178 vss.n23 48.2764
R286 vss.n179 vss.n21 48.2764
R287 vss.n180 vss.n19 48.2764
R288 vss.n181 vss.n17 48.2764
R289 vss.n12 vss.t3 47.9301
R290 vss.n145 vss 36.1543
R291 vss.n124 vss 36.1543
R292 vss.n103 vss 36.1543
R293 vss.n82 vss 36.1543
R294 vss.n61 vss 36.1543
R295 vss.n3 vss 36.1543
R296 vss.n185 vss 36.1543
R297 vss.n156 vss 29.6584
R298 vss.n135 vss 29.6584
R299 vss.n114 vss 29.6584
R300 vss.n93 vss 29.6584
R301 vss.n72 vss 29.6584
R302 vss vss.n185 29.544
R303 vss.n144 vss 29.328
R304 vss.n123 vss 29.328
R305 vss.n102 vss 29.328
R306 vss.n81 vss 29.328
R307 vss.n60 vss 29.328
R308 vss.n184 vss 29.328
R309 vss.n37 vss 27.8246
R310 vss.n166 vss 27.8246
R311 vss vss.n28 23.4005
R312 vss.n28 vss.t9 23.4005
R313 vss.n29 vss.n27 23.4005
R314 vss.n27 vss.t9 23.4005
R315 vss vss.n34 23.4005
R316 vss.n34 vss.t27 23.4005
R317 vss.n35 vss.n33 23.4005
R318 vss.n33 vss.t27 23.4005
R319 vss vss.n39 23.4005
R320 vss.t12 vss.n39 23.4005
R321 vss.n41 vss.n40 23.4005
R322 vss.t12 vss.n41 23.4005
R323 vss vss.n47 23.4005
R324 vss.n48 vss.n46 23.4005
R325 vss.n46 vss.t20 23.4005
R326 vss vss.n143 23.4005
R327 vss.n143 vss.t24 23.4005
R328 vss.n141 vss.n140 23.4005
R329 vss vss.n122 23.4005
R330 vss.n122 vss.t16 23.4005
R331 vss.n120 vss.n119 23.4005
R332 vss vss.n101 23.4005
R333 vss.n101 vss.t18 23.4005
R334 vss.n99 vss.n98 23.4005
R335 vss vss.n80 23.4005
R336 vss.n80 vss.t22 23.4005
R337 vss.n78 vss.n77 23.4005
R338 vss vss.n59 23.4005
R339 vss.n59 vss.t14 23.4005
R340 vss.n57 vss.n56 23.4005
R341 vss vss.n183 23.4005
R342 vss.n9 vss.n8 23.4005
R343 vss.n49 vss.n47 22.0088
R344 vss vss.n158 19.703
R345 vss.n165 vss 19.703
R346 vss vss.n167 19.703
R347 vss vss.n32 19.703
R348 vss.n157 vss.n156 18.532
R349 vss.n147 vss.n146 18.2505
R350 vss.n126 vss.n125 18.2505
R351 vss.n105 vss.n104 18.2505
R352 vss.n84 vss.n83 18.2505
R353 vss.n63 vss.n62 18.1715
R354 vss.n32 vss.n31 16.8306
R355 vss vss.n157 15.432
R356 vss.t24 vss.n142 11.7554
R357 vss.t16 vss.n121 11.7554
R358 vss.t18 vss.n100 11.7554
R359 vss.t22 vss.n79 11.7554
R360 vss.t14 vss.n58 11.7554
R361 vss.n182 vss.t1 11.7554
R362 vss.t1 vss.n10 11.7554
R363 vss.n142 vss.n141 11.6052
R364 vss.n121 vss.n120 11.6052
R365 vss.n100 vss.n99 11.6052
R366 vss.n79 vss.n78 11.6052
R367 vss.n58 vss.n57 11.6052
R368 vss.n10 vss.n9 11.6052
R369 vss.n183 vss.n182 11.6052
R370 vss.n81 vss.n72 4.2305
R371 vss.n102 vss.n93 4.2305
R372 vss.n123 vss.n114 4.2305
R373 vss.n144 vss.n135 4.2305
R374 vss.n60 vss.n3 3.878
R375 vss.n157 vss 2.703
R376 vss.t5 vss.n30 2.47435
R377 vss.n185 vss.n184 2.233
R378 vss.n158 vss 1.87051
R379 vss.n167 vss.n32 1.763
R380 vss.n167 vss.n166 1.39346
R381 vss.n165 vss.n37 1.39346
R382 vss.n49 vss.t20 1.31471
R383 vss.n63 vss.n61 1.11264
R384 vss.n84 vss.n82 1.11264
R385 vss.n105 vss.n103 1.11264
R386 vss.n126 vss.n124 1.11264
R387 vss.n147 vss.n145 1.11264
R388 vss.n72 vss.n63 0.768362
R389 vss.n93 vss.n84 0.768362
R390 vss.n114 vss.n105 0.768362
R391 vss.n135 vss.n126 0.768362
R392 vss.n156 vss.n147 0.768362
R393 vss.n146 vss 0.6825
R394 vss.n125 vss 0.6825
R395 vss.n104 vss 0.6825
R396 vss.n83 vss 0.6825
R397 vss.n62 vss 0.568833
R398 vss.n166 vss.n165 0.370038
R399 vss.n158 vss.n37 0.370038
R400 vss.n30 vss 0.189944
R401 vss.n31 vss 0.189944
R402 vss.n184 vss.n3 0.118
R403 vss.n61 vss.n60 0.118
R404 vss.n82 vss.n81 0.118
R405 vss.n103 vss.n102 0.118
R406 vss.n124 vss.n123 0.118
R407 vss.n145 vss.n144 0.118
R408 vss.n146 vss.t10 0.053375
R409 vss.n125 vss.t28 0.053375
R410 vss.n104 vss.t31 0.053375
R411 vss.n83 vss.t8 0.053375
R412 vss.n62 vss.t0 0.0442586
R413 vss.n30 vss.t26 0.033527
R414 vss.n31 vss.t5 0.033527
R415 bias_p bias_p.t1 223.565
R416 bias_p bias_p.t2 219.8
R417 bias_p.t3 bias_p.n7 47.9677
R418 bias_p.n4 bias_p.t5 41.7402
R419 bias_p.n5 bias_p.t6 41.7402
R420 bias_p.n6 bias_p.t7 41.7402
R421 bias_p.n7 bias_p.t4 41.7402
R422 bias_p.n2 bias_p 28.9496
R423 bias_p.n1 bias_p 24.2074
R424 bias_p.n0 bias_p 20.2211
R425 bias_p.n0 bias_p 18.5861
R426 bias_p.n3 bias_p 15.902
R427 bias_p.n4 bias_p.n3 15.1245
R428 bias_p bias_p.t0 11.5497
R429 bias_p.t5 bias_p 11.5497
R430 bias_p.t6 bias_p 11.5497
R431 bias_p.t7 bias_p 11.5497
R432 bias_p.t4 bias_p 11.5497
R433 bias_p bias_p.t3 11.5497
R434 bias_p.n7 bias_p.n6 6.228
R435 bias_p.n6 bias_p.n5 6.228
R436 bias_p.n5 bias_p.n4 6.228
R437 bias_p.n2 bias_p.n1 5.288
R438 bias_p bias_p.n2 3.02848
R439 bias_p.n3 bias_p 2.233
R440 bias_p.n1 bias_p.n0 0.370038
R441 bias_p bias_p.t8 0.0180781
R442 X4_Xpi.S X4_Xpi.S.t1 223.565
R443 X4_Xpi.S X4_Xpi.S.t0 223.565
R444 X4_Xpi.S.n0 X4_Xpi.S 39.1883
R445 X4_Xpi.S X4_Xpi.S.n0 36.6621
R446 X4_Xpi.S.n0 X4_Xpi.S 0.05925
R447 vdd.n16 vdd.n12 4207.06
R448 vdd.n13 vdd.n10 4207.06
R449 vdd.n30 vdd.n26 4207.06
R450 vdd.n27 vdd.n24 4207.06
R451 vdd.n51 vdd.n47 4207.06
R452 vdd.n48 vdd.n45 4207.06
R453 vdd.n72 vdd.n68 4207.06
R454 vdd.n69 vdd.n66 4207.06
R455 vdd.n93 vdd.n89 4207.06
R456 vdd.n90 vdd.n87 4207.06
R457 vdd.n114 vdd.n110 4207.06
R458 vdd.n111 vdd.n108 4207.06
R459 vdd.n135 vdd.n131 4207.06
R460 vdd.n132 vdd.n129 4207.06
R461 vdd.n7 vdd.n3 1736.47
R462 vdd.n4 vdd.n1 1736.47
R463 vdd.n40 vdd.n36 1560
R464 vdd.n37 vdd.n34 1560
R465 vdd.n61 vdd.n57 1560
R466 vdd.n58 vdd.n55 1560
R467 vdd.n82 vdd.n78 1560
R468 vdd.n79 vdd.n76 1560
R469 vdd.n103 vdd.n99 1560
R470 vdd.n100 vdd.n97 1560
R471 vdd.n124 vdd.n120 1560
R472 vdd.n121 vdd.n118 1560
R473 vdd.n14 vdd.n13 1068.61
R474 vdd.n16 vdd.n15 1068.61
R475 vdd.n28 vdd.n27 1068.61
R476 vdd.n30 vdd.n29 1068.61
R477 vdd.n49 vdd.n48 1068.61
R478 vdd.n51 vdd.n50 1068.61
R479 vdd.n70 vdd.n69 1068.61
R480 vdd.n72 vdd.n71 1068.61
R481 vdd.n91 vdd.n90 1068.61
R482 vdd.n93 vdd.n92 1068.61
R483 vdd.n112 vdd.n111 1068.61
R484 vdd.n114 vdd.n113 1068.61
R485 vdd.n133 vdd.n132 1068.61
R486 vdd.n135 vdd.n134 1068.61
R487 vdd.n11 vdd.n9 448.753
R488 vdd vdd.n9 448.753
R489 vdd.n17 vdd.n11 448.753
R490 vdd vdd.n17 448.753
R491 vdd.n25 vdd.n23 448.753
R492 vdd vdd.n23 448.753
R493 vdd.n31 vdd.n25 448.753
R494 vdd vdd.n31 448.753
R495 vdd.n46 vdd.n44 448.753
R496 vdd vdd.n44 448.753
R497 vdd.n52 vdd.n46 448.753
R498 vdd vdd.n52 448.753
R499 vdd.n67 vdd.n65 448.753
R500 vdd vdd.n65 448.753
R501 vdd.n73 vdd.n67 448.753
R502 vdd vdd.n73 448.753
R503 vdd.n88 vdd.n86 448.753
R504 vdd vdd.n86 448.753
R505 vdd.n94 vdd.n88 448.753
R506 vdd vdd.n94 448.753
R507 vdd.n109 vdd.n107 448.753
R508 vdd vdd.n107 448.753
R509 vdd.n115 vdd.n109 448.753
R510 vdd vdd.n115 448.753
R511 vdd.n130 vdd.n128 448.753
R512 vdd vdd.n128 448.753
R513 vdd.n136 vdd.n130 448.753
R514 vdd vdd.n136 448.753
R515 vdd.n5 vdd.n4 314.781
R516 vdd.n7 vdd.n6 314.781
R517 vdd.n38 vdd.n37 255.901
R518 vdd.n59 vdd.n58 255.901
R519 vdd.n80 vdd.n79 255.901
R520 vdd.n101 vdd.n100 255.901
R521 vdd.n122 vdd.n121 255.901
R522 vdd.n40 vdd.n39 255.901
R523 vdd.n61 vdd.n60 255.901
R524 vdd.n82 vdd.n81 255.901
R525 vdd.n103 vdd.n102 255.901
R526 vdd.n124 vdd.n123 255.901
R527 vdd vdd.t20 223.565
R528 vdd vdd.t18 223.565
R529 vdd vdd.t12 223.565
R530 vdd vdd.t14 223.565
R531 vdd vdd.t16 223.565
R532 vdd vdd.t10 223.565
R533 vdd vdd.t1 223.565
R534 vdd vdd.t3 223.565
R535 vdd vdd.t8 219.8
R536 vdd.n2 vdd.n0 185.225
R537 vdd vdd.n0 185.225
R538 vdd.n8 vdd.n2 185.225
R539 vdd vdd.n8 185.225
R540 vdd.n35 vdd.n33 166.4
R541 vdd vdd.n33 166.4
R542 vdd.n41 vdd.n35 166.4
R543 vdd vdd.n41 166.4
R544 vdd.n56 vdd.n54 166.4
R545 vdd vdd.n54 166.4
R546 vdd.n62 vdd.n56 166.4
R547 vdd vdd.n62 166.4
R548 vdd.n77 vdd.n75 166.4
R549 vdd vdd.n75 166.4
R550 vdd.n83 vdd.n77 166.4
R551 vdd vdd.n83 166.4
R552 vdd.n98 vdd.n96 166.4
R553 vdd vdd.n96 166.4
R554 vdd.n104 vdd.n98 166.4
R555 vdd vdd.n104 166.4
R556 vdd.n119 vdd.n117 166.4
R557 vdd vdd.n117 166.4
R558 vdd.n125 vdd.n119 166.4
R559 vdd vdd.n125 166.4
R560 vdd.n36 vdd.n35 61.6672
R561 vdd vdd.n34 61.6672
R562 vdd.n57 vdd.n56 61.6672
R563 vdd vdd.n55 61.6672
R564 vdd.n78 vdd.n77 61.6672
R565 vdd vdd.n76 61.6672
R566 vdd.n99 vdd.n98 61.6672
R567 vdd vdd.n97 61.6672
R568 vdd.n120 vdd.n119 61.6672
R569 vdd vdd.n118 61.6672
R570 vdd.n38 vdd.n36 49.5916
R571 vdd.n59 vdd.n57 49.5916
R572 vdd.n80 vdd.n78 49.5916
R573 vdd.n101 vdd.n99 49.5916
R574 vdd.n122 vdd.n120 49.5916
R575 vdd.n39 vdd.n34 49.5916
R576 vdd.n60 vdd.n55 49.5916
R577 vdd.n81 vdd.n76 49.5916
R578 vdd.n102 vdd.n97 49.5916
R579 vdd.n123 vdd.n118 49.5916
R580 vdd.n3 vdd.n2 37.0005
R581 vdd vdd.n1 37.0005
R582 vdd.n22 vdd 31.7871
R583 vdd.n43 vdd 31.7871
R584 vdd.n64 vdd 31.7871
R585 vdd.n85 vdd 31.7871
R586 vdd.n106 vdd 31.7871
R587 vdd.n127 vdd 31.7871
R588 vdd.n138 vdd 31.7871
R589 vdd.n13 vdd.n9 30.8338
R590 vdd.n17 vdd.n16 30.8338
R591 vdd.n27 vdd.n23 30.8338
R592 vdd.n31 vdd.n30 30.8338
R593 vdd.n37 vdd.n33 30.8338
R594 vdd.n41 vdd.n40 30.8338
R595 vdd.n48 vdd.n44 30.8338
R596 vdd.n52 vdd.n51 30.8338
R597 vdd.n58 vdd.n54 30.8338
R598 vdd.n62 vdd.n61 30.8338
R599 vdd.n69 vdd.n65 30.8338
R600 vdd.n73 vdd.n72 30.8338
R601 vdd.n79 vdd.n75 30.8338
R602 vdd.n83 vdd.n82 30.8338
R603 vdd.n90 vdd.n86 30.8338
R604 vdd.n94 vdd.n93 30.8338
R605 vdd.n100 vdd.n96 30.8338
R606 vdd.n104 vdd.n103 30.8338
R607 vdd.n111 vdd.n107 30.8338
R608 vdd.n115 vdd.n114 30.8338
R609 vdd.n121 vdd.n117 30.8338
R610 vdd.n125 vdd.n124 30.8338
R611 vdd.n132 vdd.n128 30.8338
R612 vdd.n136 vdd.n135 30.8338
R613 vdd.n4 vdd.n0 30.8338
R614 vdd.n8 vdd.n7 30.8338
R615 vdd.n42 vdd 30.0334
R616 vdd.n63 vdd 30.0334
R617 vdd.n84 vdd 30.0334
R618 vdd.n105 vdd 30.0334
R619 vdd.n126 vdd 30.0334
R620 vdd vdd.n138 29.919
R621 vdd.n32 vdd 29.703
R622 vdd.n53 vdd 29.703
R623 vdd.n74 vdd 29.703
R624 vdd.n95 vdd 29.703
R625 vdd.n116 vdd 29.703
R626 vdd.n137 vdd 29.703
R627 vdd.n5 vdd.n3 29.6618
R628 vdd.n6 vdd.n1 29.6618
R629 vdd.n20 vdd 28.1996
R630 vdd.n18 vdd 23.8269
R631 vdd.n18 vdd 20.078
R632 vdd.n19 vdd 19.6555
R633 vdd.n22 vdd.n21 15.947
R634 vdd.n21 vdd 15.197
R635 vdd.t4 vdd.n38 10.1167
R636 vdd.t6 vdd.n59 10.1167
R637 vdd.t21 vdd.n80 10.1167
R638 vdd.t22 vdd.n101 10.1167
R639 vdd.t5 vdd.n122 10.1167
R640 vdd.n39 vdd.t4 10.1167
R641 vdd.n60 vdd.t6 10.1167
R642 vdd.n81 vdd.t21 10.1167
R643 vdd.n102 vdd.t22 10.1167
R644 vdd.n123 vdd.t5 10.1167
R645 vdd vdd.t7 9.77232
R646 vdd.n12 vdd.n11 7.4005
R647 vdd vdd.n10 7.4005
R648 vdd.n26 vdd.n25 7.4005
R649 vdd vdd.n24 7.4005
R650 vdd.n47 vdd.n46 7.4005
R651 vdd vdd.n45 7.4005
R652 vdd.n68 vdd.n67 7.4005
R653 vdd vdd.n66 7.4005
R654 vdd.n89 vdd.n88 7.4005
R655 vdd vdd.n87 7.4005
R656 vdd.n110 vdd.n109 7.4005
R657 vdd vdd.n108 7.4005
R658 vdd.n131 vdd.n130 7.4005
R659 vdd vdd.n129 7.4005
R660 vdd.n6 vdd.t2 6.70818
R661 vdd.t2 vdd.n5 6.70818
R662 vdd vdd.n20 6.55348
R663 vdd.n14 vdd.n12 5.51167
R664 vdd.n15 vdd.n10 5.51167
R665 vdd.n28 vdd.n26 5.51167
R666 vdd.n29 vdd.n24 5.51167
R667 vdd.n49 vdd.n47 5.51167
R668 vdd.n50 vdd.n45 5.51167
R669 vdd.n70 vdd.n68 5.51167
R670 vdd.n71 vdd.n66 5.51167
R671 vdd.n91 vdd.n89 5.51167
R672 vdd.n92 vdd.n87 5.51167
R673 vdd.n112 vdd.n110 5.51167
R674 vdd.n113 vdd.n108 5.51167
R675 vdd.n133 vdd.n131 5.51167
R676 vdd.n134 vdd.n129 5.51167
R677 vdd.n127 vdd.n126 4.99425
R678 vdd.n106 vdd.n105 4.99425
R679 vdd.n85 vdd.n84 4.99425
R680 vdd.n64 vdd.n63 4.99425
R681 vdd.n43 vdd.n42 4.99425
R682 vdd.n138 vdd.n137 3.0555
R683 vdd.n21 vdd 2.938
R684 vdd.n19 vdd.n18 1.998
R685 vdd.n15 vdd.t19 1.88064
R686 vdd.t19 vdd.n14 1.88064
R687 vdd.n29 vdd.t17 1.88064
R688 vdd.t17 vdd.n28 1.88064
R689 vdd.n50 vdd.t11 1.88064
R690 vdd.t11 vdd.n49 1.88064
R691 vdd.n71 vdd.t13 1.88064
R692 vdd.t13 vdd.n70 1.88064
R693 vdd.n92 vdd.t15 1.88064
R694 vdd.t15 vdd.n91 1.88064
R695 vdd.n113 vdd.t9 1.88064
R696 vdd.t9 vdd.n112 1.88064
R697 vdd.n134 vdd.t0 1.88064
R698 vdd.t0 vdd.n133 1.88064
R699 vdd.n126 vdd.n116 1.11675
R700 vdd.n105 vdd.n95 1.11675
R701 vdd.n84 vdd.n74 1.11675
R702 vdd.n63 vdd.n53 1.11675
R703 vdd.n42 vdd.n32 1.11675
R704 vdd.n20 vdd.n19 0.370038
R705 vdd.n137 vdd.n127 0.118
R706 vdd.n116 vdd.n106 0.118
R707 vdd.n95 vdd.n85 0.118
R708 vdd.n74 vdd.n64 0.118
R709 vdd.n53 vdd.n43 0.118
R710 vdd.n32 vdd.n22 0.118
R711 Xc2.C1.n0 Xc2.C1.t4 252.82
R712 Xc2.C1.t4 Xc2.C1 231.048
R713 Xc2.C1.n0 Xc2.C1.t2 225.498
R714 Xc2.C1 Xc2.C1.t1 223.565
R715 Xc2.C1 Xc2.C1.t0 219.8
R716 Xc2.C1.t2 Xc2.C1 202.611
R717 Xc2.C1 Xc2.C1.n3 21.1542
R718 Xc2.C1.n2 Xc2.C1 16.4121
R719 Xc2.C1.n1 Xc2.C1 14.4337
R720 Xc2.C1.n1 Xc2.C1.n0 3.72114
R721 Xc2.C1.n3 Xc2.C1.n1 1.27361
R722 Xc2.C1.n3 Xc2.C1.n2 1.11675
R723 Xc2.C1 Xc2.C1.t3 0.28175
R724 Xc2.C1.n2 Xc2.C1 0.05925
R725 Xc3.C1.n0 Xc3.C1.t3 253.445
R726 Xc3.C1.t3 Xc3.C1 231.048
R727 Xc3.C1.n0 Xc3.C1.t4 226.123
R728 Xc3.C1 Xc3.C1.t0 223.565
R729 Xc3.C1 Xc3.C1.t1 219.8
R730 Xc3.C1.t4 Xc3.C1 202.611
R731 Xc3.C1.n2 Xc3.C1 21.7792
R732 Xc3.C1 Xc3.C1.n3 17.0371
R733 Xc3.C1.n1 Xc3.C1 13.8087
R734 Xc3.C1.n1 Xc3.C1.n0 3.72114
R735 Xc3.C1.n2 Xc3.C1.n1 1.27361
R736 Xc3.C1.n3 Xc3.C1.n2 1.11675
R737 Xc3.C1 Xc3.C1.t2 0.28175
R738 Xc3.C1.n3 Xc3.C1 0.05925
R739 X3_Xns.D X3_Xns.D.t1 219.8
R740 X3_Xns.D X3_Xns.D.t0 219.8
R741 X3_Xns.D.n0 X3_Xns.D 41.6167
R742 X3_Xns.D X3_Xns.D.n0 41.0293
R743 X3_Xns.D.n0 X3_Xns.D 0.05925
R744 X1_Xps.D X1_Xps.D.t1 223.565
R745 X1_Xps.D X1_Xps.D.t0 223.565
R746 X1_Xps.D X1_Xps.D.n0 35.4383
R747 X1_Xps.D.n0 X1_Xps.D 32.9121
R748 X1_Xps.D.n0 X1_Xps.D 0.05925
R749 X4_Xpi.D.n0 X4_Xpi.D.t3 254.07
R750 X4_Xpi.D.t3 X4_Xpi.D 231.048
R751 X4_Xpi.D.n0 X4_Xpi.D.t2 226.748
R752 X4_Xpi.D X4_Xpi.D.t0 223.565
R753 X4_Xpi.D X4_Xpi.D.t1 219.8
R754 X4_Xpi.D.t2 X4_Xpi.D 202.611
R755 X4_Xpi.D.n2 X4_Xpi.D 22.4042
R756 X4_Xpi.D X4_Xpi.D.n3 17.6621
R757 X4_Xpi.D.n1 X4_Xpi.D 13.1837
R758 X4_Xpi.D.n1 X4_Xpi.D.n0 3.72114
R759 X4_Xpi.D.n2 X4_Xpi.D.n1 1.27361
R760 X4_Xpi.D.n3 X4_Xpi.D.n2 1.11675
R761 X4_Xpi.D X4_Xpi.D.t4 0.28175
R762 X4_Xpi.D.n3 X4_Xpi.D 0.05925
R763 Xbp2.G Xbp2.G.t0 223.565
R764 Xbp2.G Xbp2.G.t1 219.8
R765 Xbp2.G.n0 Xbp2.G.t2 154.849
R766 Xbp2.G.n0 Xbp2.G.t3 141.804
R767 Xbp2.G.t2 Xbp2.G 115.525
R768 Xbp2.G.t3 Xbp2.G 101.305
R769 Xbp2.G.n1 Xbp2.G 43.2793
R770 Xbp2.G Xbp2.G.n2 38.5371
R771 Xbp2.G.n2 Xbp2.G.n1 1.998
R772 Xbp2.G.n1 Xbp2.G.n0 1.8805
R773 Xbp2.G.n2 Xbp2.G 0.05925
R774 clk clk.t0 223.565
R775 clk clk.t1 219.8
R776 clk clk.n0 44.8293
R777 clk.n0 clk 38.9121
R778 clk.n0 clk 0.05925
R779 X1_Xpi.G.n2 X1_Xpi.G.t6 254.695
R780 X1_Xpi.G.t6 X1_Xpi.G 231.048
R781 X1_Xpi.G.n3 X1_Xpi.G.t5 226.256
R782 X1_Xpi.G X1_Xpi.G.t1 223.565
R783 X1_Xpi.G X1_Xpi.G.t0 219.8
R784 X1_Xpi.G.t5 X1_Xpi.G 202.611
R785 X1_Xpi.G.n0 X1_Xpi.G.t2 27.7104
R786 X1_Xpi.G.n0 X1_Xpi.G.t4 27.4902
R787 X1_Xpi.G.n4 X1_Xpi.G.n3 23.9117
R788 X1_Xpi.G X1_Xpi.G.n5 23.0292
R789 X1_Xpi.G.n4 X1_Xpi.G 18.2871
R790 X1_Xpi.G.n1 X1_Xpi.G 12.566
R791 X1_Xpi.G.t4 X1_Xpi.G 11.5497
R792 X1_Xpi.G.t2 X1_Xpi.G 9.77232
R793 X1_Xpi.G.n1 X1_Xpi.G.n0 1.72364
R794 X1_Xpi.G.n5 X1_Xpi.G.n1 1.27361
R795 X1_Xpi.G.n5 X1_Xpi.G.n4 1.11675
R796 X1_Xpi.G.n3 X1_Xpi.G.n2 1.11675
R797 X1_Xpi.G X1_Xpi.G.t3 0.2255
R798 X1_Xpi.G.n2 X1_Xpi.G 0.05925
R799 X2_Xns.D X2_Xns.D.t1 219.8
R800 X2_Xns.D X2_Xns.D.t0 219.8
R801 X2_Xns.D.n0 X2_Xns.D 40.4917
R802 X2_Xns.D X2_Xns.D.n0 39.9043
R803 X2_Xns.D.n0 X2_Xns.D 0.05925
R804 Xbias.Xb2.D Xbias.Xb2.D.t2 219.8
R805 Xbias.Xb2.D Xbias.Xb2.D.t1 219.8
R806 Xbias.Xb2.D.n0 Xbias.Xb2.D 31.6916
R807 Xbias.Xb2.D Xbias.Xb2.D.n1 29.3246
R808 Xbias.Xb2.D.n0 Xbias.Xb2.D 20.7805
R809 Xbias.Xb2.D Xbias.Xb2.D.t0 9.77232
R810 Xbias.Xb2.D.n1 Xbias.Xb2.D 4.79097
R811 Xbias.Xb2.D.n1 Xbias.Xb2.D.n0 0.370038
R812 X3_Xps.D X3_Xps.D.t1 223.565
R813 X3_Xps.D X3_Xps.D.t0 223.565
R814 X3_Xps.D X3_Xps.D.n0 38.0633
R815 X3_Xps.D.n0 X3_Xps.D 35.5371
R816 X3_Xps.D.n0 X3_Xps.D 0.05925
R817 X5_Xni.S X5_Xni.S.t1 219.8
R818 X5_Xni.S X5_Xni.S.t0 219.8
R819 X5_Xni.S.n0 X5_Xni.S 43.4917
R820 X5_Xni.S X5_Xni.S.n0 42.9043
R821 X5_Xni.S.n0 X5_Xni.S 0.05925
R822 Xc1.C1.n0 Xc1.C1.t4 252.195
R823 Xc1.C1.t4 Xc1.C1 231.048
R824 Xc1.C1.n0 Xc1.C1.t3 224.873
R825 Xc1.C1 Xc1.C1.t1 223.565
R826 Xc1.C1 Xc1.C1.t0 219.8
R827 Xc1.C1.t3 Xc1.C1 202.611
R828 Xc1.C1 Xc1.C1.n3 20.5292
R829 Xc1.C1.n2 Xc1.C1 15.7871
R830 Xc1.C1.n1 Xc1.C1 15.0587
R831 Xc1.C1.n1 Xc1.C1.n0 3.72114
R832 Xc1.C1.n3 Xc1.C1.n1 1.27361
R833 Xc1.C1.n3 Xc1.C1.n2 1.11675
R834 Xc1.C1 Xc1.C1.t2 0.28175
R835 Xc1.C1.n2 Xc1.C1 0.05925
R836 X2_Xps.D X2_Xps.D.t1 223.565
R837 X2_Xps.D X2_Xps.D.t0 223.565
R838 X2_Xps.D X2_Xps.D.n0 36.9383
R839 X2_Xps.D.n0 X2_Xps.D 34.4121
R840 X2_Xps.D.n0 X2_Xps.D 0.05925
R841 X5_Xps.D X5_Xps.D.t1 223.565
R842 X5_Xps.D X5_Xps.D.t0 223.565
R843 X5_Xps.D X5_Xps.D.n0 40.3133
R844 X5_Xps.D.n0 X5_Xps.D 37.7871
R845 X5_Xps.D.n0 X5_Xps.D 0.05925
R846 X1_Xns.D X1_Xns.D.t1 219.8
R847 X1_Xns.D X1_Xns.D.t0 219.8
R848 X1_Xns.D.n0 X1_Xns.D 39.3667
R849 X1_Xns.D X1_Xns.D.n0 38.7793
R850 X1_Xns.D.n0 X1_Xns.D 0.05925
C0 X5_Xni.S X4_Xpi.D 0.02522f
C1 X5_Xps.D vdd 3.87131f
C2 X1_Xpi.G Xc3.C1 1.14045f
C3 Xc2.C1 Xc1.C1 1.94863f
C4 bias_n Xc3.C1 0.13216f
C5 X1_Xpi.G X1_Xps.D 0.19627f
C6 Xc2.C1 X2_Xps.D 0.33845f
C7 X1_Xps.D bias_n 0.15463f
C8 X3_Xps.D vdd 3.87131f
C9 X1_Xpi.G X3_Xns.D 0.17742f
C10 Xc2.C1 vdd 1.38644f
C11 X1_Xpi.G X1_Xns.D 0.27904f
C12 vdd X5_Xni.S 0.16352f
C13 bias_n X3_Xns.D 3.91946f
C14 bias_p Xc3.C1 0.09042f
C15 X1_Xns.D bias_n 3.91953f
C16 Xbias.Xb2.D bias_n 0.35421f
C17 Xc2.C1 X2_Xns.D 0.81983f
C18 X1_Xps.D bias_p 5.28808f
C19 vdd Xbp2.G 2.68099f
C20 X4_Xpi.S X4_Xpi.D 0.37955f
C21 X4_Xni.S X4_Xpi.D 0.69385f
C22 bias_p X3_Xns.D 0.18105f
C23 X1_Xpi.G bias_n 0.49309f
C24 X1_Xns.D bias_p 0.27763f
C25 Xbias.Xb2.D bias_p 6.27185f
C26 vdd X4_Xpi.D 1.51132f
C27 X2_Xps.D Xc1.C1 0.21014f
C28 X1_Xpi.G bias_p 0.35928f
C29 Xc1.C1 vdd 1.2893f
C30 X1_Xpi.G clk 0
C31 bias_p bias_n 30.7377f
C32 Xc3.C1 X3_Xps.D 0.36017f
C33 Xc2.C1 Xc3.C1 2.17084f
C34 X4_Xpi.S vdd 3.87131f
C35 X4_Xni.S vdd 0.15364f
C36 X2_Xps.D vdd 3.87131f
C37 Xc1.C1 X2_Xns.D 0.02522f
C38 X1_Xpi.G X5_Xps.D 0.49575f
C39 bias_n X5_Xps.D 0.17451f
C40 Xc2.C1 X3_Xns.D 0.02522f
C41 X2_Xns.D vdd 0.15364f
C42 Xc3.C1 X4_Xpi.D 2.39306f
C43 X1_Xpi.G X3_Xps.D 0.18414f
C44 bias_p X5_Xps.D 3.73804f
C45 X1_Xpi.G Xc2.C1 0.81422f
C46 bias_n X3_Xps.D 0.15476f
C47 X1_Xpi.G X5_Xni.S 0.64633f
C48 Xc2.C1 bias_n 0.13329f
C49 bias_n X5_Xni.S 3.87271f
C50 X4_Xpi.S Xc3.C1 0.20863f
C51 Xc1.C1 X1_Xps.D 0.32111f
C52 X4_Xni.S Xc3.C1 0.02522f
C53 X1_Xpi.G Xbp2.G 2.56657f
C54 bias_p X3_Xps.D 3.89566f
C55 Xc3.C1 vdd 1.45239f
C56 bias_n Xbp2.G 0
C57 Xc2.C1 bias_p 0.09143f
C58 X1_Xns.D Xc1.C1 0.87939f
C59 X1_Xpi.G X4_Xpi.D 4.7344f
C60 X1_Xps.D vdd 3.87175f
C61 bias_n X4_Xpi.D 0.12854f
C62 X3_Xns.D vdd 0.15364f
C63 X1_Xns.D vdd 0.15364f
C64 X1_Xpi.G Xc1.C1 2.23708f
C65 clk Xbp2.G 10.3343f
C66 Xc1.C1 bias_n 0.13394f
C67 Xbias.Xb2.D vdd 0.34322f
C68 X1_Xpi.G X4_Xpi.S 0.17979f
C69 bias_p X4_Xpi.D 0.08708f
C70 X1_Xpi.G X4_Xni.S 0.17073f
C71 X1_Xpi.G X2_Xps.D 0.18563f
C72 bias_n X4_Xpi.S 0.15476f
C73 bias_n X4_Xni.S 3.91946f
C74 X2_Xps.D bias_n 0.15476f
C75 X1_Xpi.G vdd 6.52239f
C76 bias_n vdd 31.7274f
C77 Xc2.C1 X3_Xps.D 0.20963f
C78 Xc1.C1 bias_p 0.09866f
C79 X1_Xpi.G X2_Xns.D 0.17943f
C80 X5_Xps.D X4_Xpi.D 0.20528f
C81 bias_p X4_Xpi.S 3.89566f
C82 bias_p X4_Xni.S 0.18105f
C83 X2_Xps.D bias_p 4.17699f
C84 bias_n X2_Xns.D 3.91946f
C85 bias_p vdd 23.7033f
C86 clk vdd 0.91641f
C87 X3_Xns.D Xc3.C1 0.75934f
C88 bias_p X2_Xns.D 0.18105f
C89 clk vss 12.55616f
C90 bias_p vss 79.86434f
C91 bias_n vss 98.46964f
C92 vdd vss 0.18513p
C93 Xbp2.G vss 26.8997f
C94 X5_Xni.S vss 14.86707f
C95 X5_Xps.D vss 14.25221f
C96 X4_Xni.S vss 14.45689f
C97 X4_Xpi.D vss 10.13763f
C98 X4_Xpi.S vss 13.74086f
C99 X3_Xns.D vss 13.91427f
C100 Xc3.C1 vss 9.96657f
C101 X3_Xps.D vss 13.1489f
C102 X2_Xns.D vss 13.37088f
C103 Xc2.C1 vss 9.63018f
C104 X2_Xps.D vss 12.30025f
C105 X1_Xns.D vss 12.61016f
C106 Xc1.C1 vss 9.82823f
C107 X1_Xpi.G vss 35.11689f
C108 X1_Xps.D vss 11.38026f
C109 Xbias.Xb2.D vss 20.79524f
C110 X1_Xns.D.t1 vss 0.00845f
C111 X1_Xns.D.n0 vss 2.47405f
C112 X1_Xns.D.t0 vss 0.00845f
C113 X5_Xps.D.t1 vss 0.0265f
C114 X5_Xps.D.n0 vss 4.54259f
C115 X5_Xps.D.t0 vss 0.0265f
C116 X2_Xps.D.t1 vss 0.03191f
C117 X2_Xps.D.n0 vss 4.91859f
C118 X2_Xps.D.t0 vss 0.03191f
C119 Xc1.C1.t3 vss 0.02622f
C120 Xc1.C1.t4 vss 0.03148f
C121 Xc1.C1.n0 vss 0.72497f
C122 Xc1.C1.t2 vss 0.13639f
C123 Xc1.C1.n1 vss 0.40063f
C124 Xc1.C1.t1 vss 0.00894f
C125 Xc1.C1.n2 vss 0.16983f
C126 Xc1.C1.n3 vss 0.25588f
C127 Xc1.C1.t0 vss 0.00436f
C128 X5_Xni.S.t1 vss 0.00716f
C129 X5_Xni.S.n0 vss 2.4247f
C130 X5_Xni.S.t0 vss 0.00716f
C131 X3_Xps.D.t1 vss 0.02945f
C132 X3_Xps.D.n0 vss 4.71009f
C133 X3_Xps.D.t0 vss 0.02945f
C134 Xbias.Xb2.D.t2 vss 0.0083f
C135 Xbias.Xb2.D.t0 vss 0.61427f
C136 Xbias.Xb2.D.n0 vss 2.41562f
C137 Xbias.Xb2.D.n1 vss 1.26168f
C138 Xbias.Xb2.D.t1 vss 0.0083f
C139 X2_Xns.D.t1 vss 0.00805f
C140 X2_Xns.D.n0 vss 2.45961f
C141 X2_Xns.D.t0 vss 0.00805f
C142 X1_Xpi.G.t2 vss 1.02706f
C143 X1_Xpi.G.t4 vss 1.22236f
C144 X1_Xpi.G.n0 vss 1.95427f
C145 X1_Xpi.G.t3 vss 0.39466f
C146 X1_Xpi.G.n1 vss 0.50008f
C147 X1_Xpi.G.t6 vss 0.08168f
C148 X1_Xpi.G.n2 vss 0.83361f
C149 X1_Xpi.G.t5 vss 0.06757f
C150 X1_Xpi.G.n3 vss 4.03265f
C151 X1_Xpi.G.t1 vss 0.0207f
C152 X1_Xpi.G.n4 vss 3.75472f
C153 X1_Xpi.G.n5 vss 0.76506f
C154 X1_Xpi.G.t0 vss 0.01009f
C155 clk.t1 vss 0.01791f
C156 clk.t0 vss 0.03675f
C157 clk.n0 vss 6.2154f
C158 Xbp2.G.t3 vss 0.55657f
C159 Xbp2.G.t2 vss 0.5343f
C160 Xbp2.G.n0 vss 6.78214f
C161 Xbp2.G.t1 vss 0.01259f
C162 Xbp2.G.n1 vss 2.70343f
C163 Xbp2.G.n2 vss 2.23765f
C164 Xbp2.G.t0 vss 0.02583f
C165 X4_Xpi.D.t2 vss 0.08618f
C166 X4_Xpi.D.t3 vss 0.09941f
C167 X4_Xpi.D.n0 vss 2.56191f
C168 X4_Xpi.D.t4 vss 0.39597f
C169 X4_Xpi.D.n1 vss 1.01475f
C170 X4_Xpi.D.t1 vss 0.01265f
C171 X4_Xpi.D.n2 vss 0.90656f
C172 X4_Xpi.D.n3 vss 0.64167f
C173 X4_Xpi.D.t0 vss 0.02596f
C174 X1_Xps.D.t1 vss 0.03846f
C175 X1_Xps.D.n0 vss 5.63128f
C176 X1_Xps.D.t0 vss 0.03846f
C177 X3_Xns.D.t1 vss 0.00769f
C178 X3_Xns.D.n0 vss 2.44594f
C179 X3_Xns.D.t0 vss 0.00769f
C180 Xc3.C1.t4 vss 0.05539f
C181 Xc3.C1.t3 vss 0.06473f
C182 Xc3.C1.n0 vss 1.61542f
C183 Xc3.C1.t2 vss 0.26543f
C184 Xc3.C1.n1 vss 0.71396f
C185 Xc3.C1.t1 vss 0.00848f
C186 Xc3.C1.n2 vss 0.57169f
C187 Xc3.C1.n3 vss 0.3974f
C188 Xc3.C1.t0 vss 0.0174f
C189 Xc2.C1.t2 vss 0.02632f
C190 Xc2.C1.t4 vss 0.03118f
C191 Xc2.C1.n0 vss 0.7497f
C192 Xc2.C1.t3 vss 0.13149f
C193 Xc2.C1.n1 vss 0.37012f
C194 Xc2.C1.t1 vss 0.00862f
C195 Xc2.C1.n2 vss 0.18044f
C196 Xc2.C1.n3 vss 0.26511f
C197 Xc2.C1.t0 vss 0.0042f
C198 vdd.n0 vss 0.03163f
C199 vdd.n1 vss 0.03166f
C200 vdd.n2 vss 0.03166f
C201 vdd.n3 vss 0.03166f
C202 vdd.n4 vss 0.21923f
C203 vdd.t2 vss 0.31547f
C204 vdd.n7 vss 0.21923f
C205 vdd.n8 vss 0.03163f
C206 vdd.t20 vss 0.01918f
C207 vdd.n9 vss 0.07578f
C208 vdd.n10 vss 0.07455f
C209 vdd.n11 vss 0.07455f
C210 vdd.n12 vss 0.07455f
C211 vdd.n13 vss 0.67454f
C212 vdd.t19 vss 1.12645f
C213 vdd.n16 vss 0.67454f
C214 vdd.n17 vss 0.07578f
C215 vdd.n18 vss 1.94388f
C216 vdd.t7 vss 0.6921f
C217 vdd.n19 vss 0.85994f
C218 vdd.t8 vss 0.00935f
C219 vdd.n20 vss 1.57714f
C220 vdd.n21 vss 2.73927f
C221 vdd.t18 vss 0.01918f
C222 vdd.n22 vss 3.07149f
C223 vdd.n23 vss 0.07578f
C224 vdd.n24 vss 0.07455f
C225 vdd.n25 vss 0.07455f
C226 vdd.n26 vss 0.07455f
C227 vdd.n27 vss 0.67454f
C228 vdd.t17 vss 1.12645f
C229 vdd.n30 vss 0.67454f
C230 vdd.n31 vss 0.07578f
C231 vdd.n32 vss 1.20543f
C232 vdd.n33 vss 0.0284f
C233 vdd.n34 vss 0.02867f
C234 vdd.n35 vss 0.02867f
C235 vdd.n36 vss 0.02867f
C236 vdd.n37 vss 0.18592f
C237 vdd.t4 vss 0.25896f
C238 vdd.n40 vss 0.18592f
C239 vdd.n41 vss 0.0284f
C240 vdd.n42 vss 1.803f
C241 vdd.t12 vss 0.01918f
C242 vdd.n43 vss 1.70786f
C243 vdd.n44 vss 0.07578f
C244 vdd.n45 vss 0.07455f
C245 vdd.n46 vss 0.07455f
C246 vdd.n47 vss 0.07455f
C247 vdd.n48 vss 0.67454f
C248 vdd.t11 vss 1.12645f
C249 vdd.n51 vss 0.67454f
C250 vdd.n52 vss 0.07578f
C251 vdd.n53 vss 1.20543f
C252 vdd.n54 vss 0.0284f
C253 vdd.n55 vss 0.02867f
C254 vdd.n56 vss 0.02867f
C255 vdd.n57 vss 0.02867f
C256 vdd.n58 vss 0.18592f
C257 vdd.t6 vss 0.25896f
C258 vdd.n61 vss 0.18592f
C259 vdd.n62 vss 0.0284f
C260 vdd.n63 vss 1.803f
C261 vdd.t14 vss 0.01918f
C262 vdd.n64 vss 1.70786f
C263 vdd.n65 vss 0.07578f
C264 vdd.n66 vss 0.07455f
C265 vdd.n67 vss 0.07455f
C266 vdd.n68 vss 0.07455f
C267 vdd.n69 vss 0.67454f
C268 vdd.t13 vss 1.12645f
C269 vdd.n72 vss 0.67454f
C270 vdd.n73 vss 0.07578f
C271 vdd.n74 vss 1.20543f
C272 vdd.n75 vss 0.0284f
C273 vdd.n76 vss 0.02867f
C274 vdd.n77 vss 0.02867f
C275 vdd.n78 vss 0.02867f
C276 vdd.n79 vss 0.18592f
C277 vdd.t21 vss 0.25896f
C278 vdd.n82 vss 0.18592f
C279 vdd.n83 vss 0.0284f
C280 vdd.n84 vss 1.803f
C281 vdd.t16 vss 0.01918f
C282 vdd.n85 vss 1.70786f
C283 vdd.n86 vss 0.07578f
C284 vdd.n87 vss 0.07455f
C285 vdd.n88 vss 0.07455f
C286 vdd.n89 vss 0.07455f
C287 vdd.n90 vss 0.67454f
C288 vdd.t15 vss 1.12645f
C289 vdd.n93 vss 0.67454f
C290 vdd.n94 vss 0.07578f
C291 vdd.n95 vss 1.20543f
C292 vdd.n96 vss 0.0284f
C293 vdd.n97 vss 0.02867f
C294 vdd.n98 vss 0.02867f
C295 vdd.n99 vss 0.02867f
C296 vdd.n100 vss 0.18592f
C297 vdd.t22 vss 0.25896f
C298 vdd.n103 vss 0.18592f
C299 vdd.n104 vss 0.0284f
C300 vdd.n105 vss 1.803f
C301 vdd.t10 vss 0.01918f
C302 vdd.n106 vss 1.70786f
C303 vdd.n107 vss 0.07578f
C304 vdd.n108 vss 0.07455f
C305 vdd.n109 vss 0.07455f
C306 vdd.n110 vss 0.07455f
C307 vdd.n111 vss 0.67454f
C308 vdd.t9 vss 1.12645f
C309 vdd.n114 vss 0.67454f
C310 vdd.n115 vss 0.07578f
C311 vdd.n116 vss 1.20543f
C312 vdd.n117 vss 0.0284f
C313 vdd.n118 vss 0.02867f
C314 vdd.n119 vss 0.02867f
C315 vdd.n120 vss 0.02867f
C316 vdd.n121 vss 0.18592f
C317 vdd.t5 vss 0.25896f
C318 vdd.n124 vss 0.18592f
C319 vdd.n125 vss 0.0284f
C320 vdd.n126 vss 1.803f
C321 vdd.t1 vss 0.01918f
C322 vdd.n127 vss 1.70786f
C323 vdd.n128 vss 0.07578f
C324 vdd.n129 vss 0.07455f
C325 vdd.n130 vss 0.07455f
C326 vdd.n131 vss 0.07455f
C327 vdd.n132 vss 0.67454f
C328 vdd.t0 vss 1.12645f
C329 vdd.n135 vss 0.67454f
C330 vdd.n136 vss 0.07578f
C331 vdd.n137 vss 1.44681f
C332 vdd.t3 vss 0.01918f
C333 vdd.n138 vss 2.53465f
C334 X4_Xpi.S.t1 vss 0.02828f
C335 X4_Xpi.S.n0 vss 4.68537f
C336 X4_Xpi.S.t0 vss 0.02828f
C337 bias_p.t8 vss 6.84344f
C338 bias_p.t0 vss 1.8605f
C339 bias_p.n0 vss 2.75234f
C340 bias_p.t1 vss 0.03662f
C341 bias_p.n1 vss 2.64711f
C342 bias_p.t2 vss 0.01785f
C343 bias_p.n2 vss 3.42398f
C344 bias_p.n3 vss 4.9171f
C345 bias_p.t5 vss 3.18653f
C346 bias_p.n4 vss 7.72588f
C347 bias_p.t6 vss 3.18653f
C348 bias_p.n5 vss 5.61098f
C349 bias_p.t7 vss 3.18653f
C350 bias_p.n6 vss 5.61098f
C351 bias_p.t4 vss 3.18653f
C352 bias_p.n7 vss 9.23931f
C353 bias_p.t3 vss 3.72787f
C354 X4_Xni.S.t1 vss 0.00737f
C355 X4_Xni.S.n0 vss 2.43297f
C356 X4_Xni.S.t0 vss 0.00737f
C357 bias_n.t2 vss 0.01767f
C358 bias_n.t4 vss 1.30862f
C359 bias_n.n0 vss 6.09059f
C360 bias_n.t0 vss 1.30862f
C361 bias_n.n1 vss 1.60531f
C362 bias_n.t1 vss 0.01767f
C363 bias_n.n2 vss 1.7169f
C364 bias_n.t9 vss 6.77673f
C365 bias_n.n3 vss 0.83341f
C366 bias_n.n4 vss 5.84731f
C367 bias_n.t7 vss 2.6892f
C368 bias_n.n5 vss 8.45716f
C369 bias_n.t6 vss 2.6892f
C370 bias_n.n6 vss 5.42243f
C371 bias_n.t5 vss 2.6892f
C372 bias_n.n7 vss 5.42243f
C373 bias_n.t3 vss 2.6892f
C374 bias_n.n8 vss 8.87454f
C375 bias_n.t8 vss 3.23226f
.ends

Vlight illumination 0 PWL(0 0 1u 0 0.000101 1000)
.model fitted_pv D(IS=2.9405522317e-17 N=1.14470885396 TNOM=26.85 EG=0 XTI=0)
Bph1 0 pv1 I={4.0350658074e-08*v(illumination)/1000}
Bph2 pv1 pv2 I={4.0350658074e-08*v(illumination)/1000}
Bph3 pv2 supply I={4.0350658074e-08*v(illumination)/1000}
Dp1 pv1 0 fitted_pv TEMP=26.85
Dp2 pv2 pv1 fitted_pv TEMP=26.85
Dp3 supply pv2 fitted_pv TEMP=26.85
Cstore supply 0 2e-12
Vsense supply vdd 0
Xclock clk vdd 0 bn bp microrobot_clock
Vlogic supply digital_supply 0
.include "receiver_cells.spice"
Xff clk feedback 0 0 digital_supply digital_supply div2 sky130_fd_sc_hd__dfxtp_1
Xfeedback div2 0 0 digital_supply digital_supply feedback sky130_fd_sc_hd__inv_1
Coutput clk 0 2e-15
.options method=gear maxord=2 reltol=1e-06 abstol=1e-15
.control
set wr_vecnames
set wr_singlescale
tran 1.25e-08 0.004 0 1.25e-08
wrdata clock.dat v(vdd) v(clk) v(bn) v(bp) i(Vsense) i(Vlogic) v(div2)
quit
.endc
.end
