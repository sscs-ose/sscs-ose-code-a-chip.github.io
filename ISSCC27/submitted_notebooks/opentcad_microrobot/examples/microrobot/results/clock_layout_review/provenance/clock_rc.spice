* NGSPICE file created from microrobot_clock.ext - technology: sky130A

.subckt microrobot_clock clk vdd vss bias_n bias_p
X0 Xc3.C1.t2 vss.t16 sky130_fd_pr__cap_mim_m3_1 l=2 w=2
X1 vss.t10 bias_n.t4 bias_p.t2 vss.t9 sky130_fd_pr__nfet_01v8 ad=0.145 pd=1.58 as=0.145 ps=1.58 w=0.5 l=8
X2 Xc4.C1.t2 vss.t29 sky130_fd_pr__cap_mim_m3_1 l=2 w=2
X3 X2_Xps.D.t0 Xc1.C1.t2 Xc2.C1.t1 vdd.t3 sky130_fd_pr__pfet_01v8 ad=0.29 pd=2.58 as=0.29 ps=2.58 w=1 l=0.5
X4 vss.t12 bias_n.t5 X2_Xns.D.t1 vss.t11 sky130_fd_pr__nfet_01v8 ad=0.145 pd=1.58 as=0.145 ps=1.58 w=0.5 l=8
X5 vdd.t8 bias_p.t5 X1_Xps.D.t1 vdd.t7 sky130_fd_pr__pfet_01v8 ad=0.29 pd=2.58 as=0.29 ps=2.58 w=1 l=8
X6 X1_Xns.D.t0 X1_Xpi.G.t2 Xc1.C1.t1 vss.t20 sky130_fd_pr__nfet_01v8 ad=0.145 pd=1.58 as=0.145 ps=1.58 w=0.5 l=0.5
X7 vdd.t14 bias_p.t0 bias_p.t1 vdd.t13 sky130_fd_pr__pfet_01v8 ad=0.29 pd=2.58 as=0.29 ps=2.58 w=1 l=8
X8 X5_Xps.D.t0 Xc4.C1.t3 X1_Xpi.G.t1 vdd.t6 sky130_fd_pr__pfet_01v8 ad=0.29 pd=2.58 as=0.29 ps=2.58 w=1 l=0.5
X9 vdd.t20 X1_Xpi.G.t3 Xbp1.D.t1 vdd.t19 sky130_fd_pr__pfet_01v8 ad=0.29 pd=2.58 as=0.29 ps=2.58 w=1 l=8
X10 vdd.t12 bias_p.t3 X4_Xps.D.t1 vdd.t11 sky130_fd_pr__pfet_01v8 ad=0.29 pd=2.58 as=0.29 ps=2.58 w=1 l=8
X11 X4_Xns.D.t0 Xc3.C1.t3 Xc4.C1.t0 vss.t17 sky130_fd_pr__nfet_01v8 ad=0.145 pd=1.58 as=0.145 ps=1.58 w=0.5 l=0.5
X12 vss.t3 bias_n.t0 bias_n.t1 vss.t2 sky130_fd_pr__nfet_01v8 ad=0.145 pd=1.58 as=0.145 ps=1.58 w=0.5 l=8
X13 Xbias.Xb2.D.t2 vdd.t4 vdd.t5 vss.t27 sky130_fd_pr__nfet_01v8 ad=0.145 pd=1.58 as=0.145 ps=1.58 w=0.5 l=8
X14 vdd.t22 Xbp1.D.t2 clk.t1 vdd.t21 sky130_fd_pr__pfet_01v8 ad=0.29 pd=2.58 as=0.29 ps=2.58 w=1 l=1
X15 vss.t1 bias_n.t3 X5_Xns.D.t1 vss.t0 sky130_fd_pr__nfet_01v8 ad=0.145 pd=1.58 as=0.145 ps=1.58 w=0.5 l=8
X16 X3_Xps.D.t0 Xc2.C1.t2 Xc3.C1.t0 vdd.t2 sky130_fd_pr__pfet_01v8 ad=0.29 pd=2.58 as=0.29 ps=2.58 w=1 l=0.5
X17 Xc1.C1.t3 vss.t30 sky130_fd_pr__cap_mim_m3_1 l=2 w=2
X18 vdd.t10 bias_p.t8 X2_Xps.D.t1 vdd.t9 sky130_fd_pr__pfet_01v8 ad=0.29 pd=2.58 as=0.29 ps=2.58 w=1 l=8
X19 bias_n.t8 vss.t6 sky130_fd_pr__cap_mim_m3_1 l=7 w=7
X20 Xc2.C1.t3 vss.t25 sky130_fd_pr__cap_mim_m3_1 l=2 w=2
X21 vss.t8 bias_n.t9 X3_Xns.D.t1 vss.t7 sky130_fd_pr__nfet_01v8 ad=0.145 pd=1.58 as=0.145 ps=1.58 w=0.5 l=8
X22 X1_Xpi.G.t4 vss.t21 sky130_fd_pr__cap_mim_m3_1 l=2.5 w=2
X23 bias_p.t6 vss.t15 sky130_fd_pr__cap_mim_m3_1 l=7 w=7
X24 X2_Xns.D.t0 Xc1.C1.t4 Xc2.C1.t0 vss.t31 sky130_fd_pr__nfet_01v8 ad=0.145 pd=1.58 as=0.145 ps=1.58 w=0.5 l=0.5
X25 vdd.t18 bias_p.t4 X5_Xps.D.t1 vdd.t17 sky130_fd_pr__pfet_01v8 ad=0.29 pd=2.58 as=0.29 ps=2.58 w=1 l=8
X26 X5_Xns.D.t0 Xc4.C1.t4 X1_Xpi.G.t0 vss.t28 sky130_fd_pr__nfet_01v8 ad=0.145 pd=1.58 as=0.145 ps=1.58 w=0.5 l=0.5
X27 vss.t19 X1_Xpi.G.t5 Xbp1.D.t0 vss.t18 sky130_fd_pr__nfet_01v8 ad=0.145 pd=1.58 as=0.145 ps=1.58 w=0.5 l=8
X28 bias_n.t2 Xbias.Xb2.D.t0 Xbias.Xb2.D.t1 vss.t22 sky130_fd_pr__nfet_01v8 ad=0.145 pd=1.58 as=0.145 ps=1.58 w=0.5 l=8
X29 X1_Xps.D.t0 X1_Xpi.G.t6 Xc1.C1.t0 vdd.t1 sky130_fd_pr__pfet_01v8 ad=0.29 pd=2.58 as=0.29 ps=2.58 w=1 l=0.5
X30 vss.t14 bias_n.t6 X1_Xns.D.t1 vss.t13 sky130_fd_pr__nfet_01v8 ad=0.145 pd=1.58 as=0.145 ps=1.58 w=0.5 l=8
X31 vss.t24 Xbp1.D.t3 clk.t0 vss.t23 sky130_fd_pr__nfet_01v8 ad=0.145 pd=1.58 as=0.145 ps=1.58 w=0.5 l=1
X32 X4_Xps.D.t0 Xc3.C1.t4 Xc4.C1.t1 vdd.t0 sky130_fd_pr__pfet_01v8 ad=0.29 pd=2.58 as=0.29 ps=2.58 w=1 l=0.5
X33 vss.t5 bias_n.t7 X4_Xns.D.t1 vss.t4 sky130_fd_pr__nfet_01v8 ad=0.145 pd=1.58 as=0.145 ps=1.58 w=0.5 l=8
X34 vdd.t16 bias_p.t7 X3_Xps.D.t1 vdd.t15 sky130_fd_pr__pfet_01v8 ad=0.29 pd=2.58 as=0.29 ps=2.58 w=1 l=8
X35 X3_Xns.D.t0 Xc2.C1.t4 Xc3.C1.t1 vss.t26 sky130_fd_pr__nfet_01v8 ad=0.145 pd=1.58 as=0.145 ps=1.58 w=0.5 l=0.5
R0 Xc3.C1.n0 Xc3.C1.t4 272.32
R1 Xc3.C1.n0 Xc3.C1.t3 246.232
R2 Xc3.C1.t4 Xc3.C1 231.048
R3 Xc3.C1 Xc3.C1.t0 223.565
R4 Xc3.C1 Xc3.C1.t1 219.8
R5 Xc3.C1.t3 Xc3.C1 202.611
R6 Xc3.C1.n2 Xc3.C1 40.6543
R7 Xc3.C1 Xc3.C1.n3 35.9121
R8 Xc3.C1.n1 Xc3.C1 22.3197
R9 Xc3.C1.n1 Xc3.C1.n0 6.55876
R10 Xc3.C1.n3 Xc3.C1.n2 2.3505
R11 Xc3.C1.n2 Xc3.C1.n1 0.374737
R12 Xc3.C1 Xc3.C1.t2 0.28175
R13 Xc3.C1.n3 Xc3.C1 0.05925
R14 vss.n177 vss.n25 12462.1
R15 vss.n177 vss.n26 12462.1
R16 vss.n178 vss.n23 12462.1
R17 vss.n178 vss.n24 12462.1
R18 vss.n179 vss.n21 12462.1
R19 vss.n179 vss.n22 12462.1
R20 vss.n180 vss.n19 12462.1
R21 vss.n180 vss.n20 12462.1
R22 vss.n181 vss.n17 12462.1
R23 vss.n181 vss.n18 12462.1
R24 vss.t18 vss.n16 9788.38
R25 vss.n160 vss.n46 6564.74
R26 vss.n50 vss.n46 6564.74
R27 vss.n160 vss.n47 6564.74
R28 vss.n44 vss.n41 6564.74
R29 vss.n163 vss.n41 6564.74
R30 vss.n44 vss.n39 6564.74
R31 vss.n163 vss.n39 6564.74
R32 vss.n169 vss.n33 6564.74
R33 vss.n42 vss.n33 6564.74
R34 vss.n169 vss.n34 6564.74
R35 vss.n42 vss.n34 6564.74
R36 vss.n175 vss.n27 6564.74
R37 vss.n172 vss.n27 6564.74
R38 vss.n175 vss.n28 6564.74
R39 vss.n172 vss.n28 6564.74
R40 vss.n141 vss.n139 6564.74
R41 vss.n143 vss.n138 6564.74
R42 vss.n143 vss.n139 6564.74
R43 vss.n120 vss.n118 6564.74
R44 vss.n122 vss.n117 6564.74
R45 vss.n122 vss.n118 6564.74
R46 vss.n99 vss.n97 6564.74
R47 vss.n101 vss.n96 6564.74
R48 vss.n101 vss.n97 6564.74
R49 vss.n78 vss.n76 6564.74
R50 vss.n80 vss.n75 6564.74
R51 vss.n80 vss.n76 6564.74
R52 vss.n57 vss.n55 6564.74
R53 vss.n59 vss.n54 6564.74
R54 vss.n59 vss.n55 6564.74
R55 vss.n9 vss.n7 6564.74
R56 vss.n183 vss.n6 6564.74
R57 vss.t13 vss.n25 6503.45
R58 vss.t11 vss.n23 6503.45
R59 vss.t7 vss.n21 6503.45
R60 vss.t4 vss.n19 6503.45
R61 vss.t0 vss.n17 6503.45
R62 vss.n177 vss.n176 5756.66
R63 vss.n181 vss.n180 4330.98
R64 vss.n180 vss.n179 4330.98
R65 vss.n179 vss.n178 4330.98
R66 vss.n178 vss.n177 4330.98
R67 vss.n142 vss.n138 3297.63
R68 vss.n121 vss.n117 3297.63
R69 vss.n100 vss.n96 3297.63
R70 vss.n79 vss.n75 3297.63
R71 vss.n58 vss.n54 3297.63
R72 vss.n10 vss.n6 3297.63
R73 vss.n182 vss.n7 3297.63
R74 vss.t18 vss.n181 2909.87
R75 vss.n15 vss.n14 2508.85
R76 vss.n15 vss.n1 2508.85
R77 vss.n11 vss.n1 2508.85
R78 vss.n153 vss.n150 2219.15
R79 vss.n153 vss.n151 2219.15
R80 vss.n155 vss.n150 2219.15
R81 vss.n132 vss.n129 2219.15
R82 vss.n132 vss.n130 2219.15
R83 vss.n134 vss.n129 2219.15
R84 vss.n111 vss.n108 2219.15
R85 vss.n111 vss.n109 2219.15
R86 vss.n113 vss.n108 2219.15
R87 vss.n90 vss.n87 2219.15
R88 vss.n90 vss.n88 2219.15
R89 vss.n92 vss.n87 2219.15
R90 vss.n69 vss.n66 2219.15
R91 vss.n69 vss.n67 2219.15
R92 vss.n71 vss.n66 2219.15
R93 vss.n16 vss.t23 1675.86
R94 vss.t20 vss.n26 1331.03
R95 vss.t31 vss.n24 1331.03
R96 vss.t26 vss.n22 1331.03
R97 vss.t17 vss.n20 1331.03
R98 vss.t28 vss.n18 1331.03
R99 vss.n12 vss.n11 1027.75
R100 vss.n154 vss.n151 842.444
R101 vss.n133 vss.n130 842.444
R102 vss.n112 vss.n109 842.444
R103 vss.n91 vss.n88 842.444
R104 vss.n70 vss.n67 842.444
R105 vss.n159 vss.n48 426.541
R106 vss.n159 vss 426.541
R107 vss.n51 vss.n48 426.541
R108 vss vss.n51 426.541
R109 vss.n40 vss.n38 426.541
R110 vss vss.n38 426.541
R111 vss.n164 vss.n40 426.541
R112 vss vss.n164 426.541
R113 vss.n168 vss.n35 426.541
R114 vss.n168 vss 426.541
R115 vss.n36 vss.n35 426.541
R116 vss vss.n36 426.541
R117 vss.n174 vss.n29 426.541
R118 vss.n173 vss.n29 426.541
R119 vss.n174 vss 426.541
R120 vss vss.n173 426.541
R121 vss.n140 vss.n136 426.541
R122 vss.n140 vss.n137 426.541
R123 vss vss.n136 426.541
R124 vss vss.n137 426.541
R125 vss.n119 vss.n115 426.541
R126 vss.n119 vss.n116 426.541
R127 vss vss.n115 426.541
R128 vss vss.n116 426.541
R129 vss.n98 vss.n94 426.541
R130 vss.n98 vss.n95 426.541
R131 vss vss.n94 426.541
R132 vss vss.n95 426.541
R133 vss.n77 vss.n73 426.541
R134 vss.n77 vss.n74 426.541
R135 vss vss.n73 426.541
R136 vss vss.n74 426.541
R137 vss.n56 vss.n52 426.541
R138 vss.n56 vss.n53 426.541
R139 vss vss.n52 426.541
R140 vss vss.n53 426.541
R141 vss.n8 vss.n4 426.541
R142 vss.n8 vss.n5 426.541
R143 vss vss.n4 426.541
R144 vss vss.n5 426.541
R145 vss.n50 vss.n49 368.553
R146 vss.n171 vss.n170 290.156
R147 vss.n45 vss.n43 290.156
R148 vss.n162 vss.n161 290.156
R149 vss.n176 vss.t27 245.618
R150 vss.n171 vss.t27 245.618
R151 vss.n170 vss.t22 245.618
R152 vss.n43 vss.t22 245.618
R153 vss.t9 vss.n45 245.618
R154 vss.n162 vss.t9 245.618
R155 vss.n161 vss.t2 245.618
R156 vss vss.t14 219.8
R157 vss vss.t12 219.8
R158 vss vss.t8 219.8
R159 vss vss.t5 219.8
R160 vss vss.t1 219.8
R161 vss vss.t19 219.8
R162 vss vss.t24 219.8
R163 vss vss.t3 219.8
R164 vss vss.t10 219.8
R165 vss vss.n155 195
R166 vss.n153 vss.n152 195
R167 vss.t20 vss.n153 195
R168 vss vss.n134 195
R169 vss.n132 vss.n131 195
R170 vss.t31 vss.n132 195
R171 vss vss.n113 195
R172 vss.n111 vss.n110 195
R173 vss.t26 vss.n111 195
R174 vss vss.n92 195
R175 vss.n90 vss.n89 195
R176 vss.t17 vss.n90 195
R177 vss vss.n71 195
R178 vss.n69 vss.n68 195
R179 vss.t28 vss.n69 195
R180 vss.n13 vss.n0 163.012
R181 vss vss.n0 163.012
R182 vss.n13 vss.n2 163.012
R183 vss vss.n2 163.012
R184 vss.n173 vss.n172 146.25
R185 vss.n172 vss.n171 146.25
R186 vss.n175 vss.n174 146.25
R187 vss.n176 vss.n175 146.25
R188 vss.n42 vss.n36 146.25
R189 vss.n43 vss.n42 146.25
R190 vss.n169 vss.n168 146.25
R191 vss.n170 vss.n169 146.25
R192 vss.n164 vss.n163 146.25
R193 vss.n163 vss.n162 146.25
R194 vss.n44 vss.n38 146.25
R195 vss.n45 vss.n44 146.25
R196 vss.n51 vss.n50 146.25
R197 vss.n160 vss.n159 146.25
R198 vss.n161 vss.n160 146.25
R199 vss.n139 vss.n137 146.25
R200 vss.n139 vss.n25 146.25
R201 vss.n138 vss.n136 146.25
R202 vss.n151 vss.n149 146.25
R203 vss.n150 vss.n148 146.25
R204 vss.n150 vss.n26 146.25
R205 vss.n118 vss.n116 146.25
R206 vss.n118 vss.n23 146.25
R207 vss.n117 vss.n115 146.25
R208 vss.n130 vss.n128 146.25
R209 vss.n129 vss.n127 146.25
R210 vss.n129 vss.n24 146.25
R211 vss.n97 vss.n95 146.25
R212 vss.n97 vss.n21 146.25
R213 vss.n96 vss.n94 146.25
R214 vss.n109 vss.n107 146.25
R215 vss.n108 vss.n106 146.25
R216 vss.n108 vss.n22 146.25
R217 vss.n76 vss.n74 146.25
R218 vss.n76 vss.n19 146.25
R219 vss.n75 vss.n73 146.25
R220 vss.n88 vss.n86 146.25
R221 vss.n87 vss.n85 146.25
R222 vss.n87 vss.n20 146.25
R223 vss.n55 vss.n53 146.25
R224 vss.n55 vss.n17 146.25
R225 vss.n54 vss.n52 146.25
R226 vss.n67 vss.n65 146.25
R227 vss.n66 vss.n64 146.25
R228 vss.n66 vss.n18 146.25
R229 vss.n7 vss.n5 146.25
R230 vss.n6 vss.n4 146.25
R231 vss.n11 vss.n0 146.25
R232 vss.n15 vss.n2 146.25
R233 vss.n16 vss.n15 146.25
R234 vss.n152 vss.n148 144.189
R235 vss.n152 vss.n149 144.189
R236 vss vss.n148 144.189
R237 vss vss.n149 144.189
R238 vss.n131 vss.n127 144.189
R239 vss.n131 vss.n128 144.189
R240 vss vss.n127 144.189
R241 vss vss.n128 144.189
R242 vss.n110 vss.n106 144.189
R243 vss.n110 vss.n107 144.189
R244 vss vss.n106 144.189
R245 vss vss.n107 144.189
R246 vss.n89 vss.n85 144.189
R247 vss.n89 vss.n86 144.189
R248 vss vss.n85 144.189
R249 vss vss.n86 144.189
R250 vss.n68 vss.n64 144.189
R251 vss.n68 vss.n65 144.189
R252 vss vss.n64 144.189
R253 vss vss.n65 144.189
R254 vss.n14 vss.n13 117.001
R255 vss vss.n1 117.001
R256 vss.t23 vss.n1 117.001
R257 vss.n155 vss.n154 111.203
R258 vss.n134 vss.n133 111.203
R259 vss.n113 vss.n112 111.203
R260 vss.n92 vss.n91 111.203
R261 vss.n71 vss.n70 111.203
R262 vss.n154 vss.t20 74.0279
R263 vss.n133 vss.t31 74.0279
R264 vss.n112 vss.t26 74.0279
R265 vss.n91 vss.t17 74.0279
R266 vss.n70 vss.t28 74.0279
R267 vss.n14 vss.n12 65.9943
R268 vss.n12 vss.t23 47.9301
R269 vss.n145 vss 36.1543
R270 vss.n124 vss 36.1543
R271 vss.n103 vss 36.1543
R272 vss.n82 vss 36.1543
R273 vss.n61 vss 36.1543
R274 vss.n3 vss 36.1543
R275 vss.n185 vss 36.1543
R276 vss.n156 vss 29.6584
R277 vss.n135 vss 29.6584
R278 vss.n114 vss 29.6584
R279 vss.n93 vss 29.6584
R280 vss.n72 vss 29.6584
R281 vss vss.n185 29.544
R282 vss.n144 vss 29.328
R283 vss.n123 vss 29.328
R284 vss.n102 vss 29.328
R285 vss.n81 vss 29.328
R286 vss.n60 vss 29.328
R287 vss.n184 vss 29.328
R288 vss.n37 vss 27.8246
R289 vss.n166 vss 27.8246
R290 vss vss.n28 23.4005
R291 vss.n28 vss.t27 23.4005
R292 vss.n29 vss.n27 23.4005
R293 vss.n27 vss.t27 23.4005
R294 vss vss.n34 23.4005
R295 vss.n34 vss.t22 23.4005
R296 vss.n35 vss.n33 23.4005
R297 vss.n33 vss.t22 23.4005
R298 vss vss.n39 23.4005
R299 vss.t9 vss.n39 23.4005
R300 vss.n41 vss.n40 23.4005
R301 vss.t9 vss.n41 23.4005
R302 vss vss.n47 23.4005
R303 vss.n48 vss.n46 23.4005
R304 vss.n46 vss.t2 23.4005
R305 vss vss.n143 23.4005
R306 vss.n143 vss.t13 23.4005
R307 vss.n141 vss.n140 23.4005
R308 vss vss.n122 23.4005
R309 vss.n122 vss.t11 23.4005
R310 vss.n120 vss.n119 23.4005
R311 vss vss.n101 23.4005
R312 vss.n101 vss.t7 23.4005
R313 vss.n99 vss.n98 23.4005
R314 vss vss.n80 23.4005
R315 vss.n80 vss.t4 23.4005
R316 vss.n78 vss.n77 23.4005
R317 vss vss.n59 23.4005
R318 vss.n59 vss.t0 23.4005
R319 vss.n57 vss.n56 23.4005
R320 vss vss.n183 23.4005
R321 vss.n9 vss.n8 23.4005
R322 vss.n49 vss.n47 22.0088
R323 vss.n157 vss.n156 20.1183
R324 vss vss.n158 19.703
R325 vss.n165 vss 19.703
R326 vss vss.n167 19.703
R327 vss vss.n32 19.703
R328 vss.n147 vss.n146 18.2505
R329 vss.n126 vss.n125 18.2505
R330 vss.n105 vss.n104 18.2505
R331 vss.n84 vss.n83 18.2505
R332 vss.n63 vss.n62 18.1715
R333 vss.n32 vss.n31 16.8306
R334 vss vss.n157 15.432
R335 vss.t13 vss.n142 11.7554
R336 vss.t11 vss.n121 11.7554
R337 vss.t7 vss.n100 11.7554
R338 vss.t4 vss.n79 11.7554
R339 vss.t0 vss.n58 11.7554
R340 vss.n182 vss.t18 11.7554
R341 vss.t18 vss.n10 11.7554
R342 vss.n142 vss.n141 11.6052
R343 vss.n121 vss.n120 11.6052
R344 vss.n100 vss.n99 11.6052
R345 vss.n79 vss.n78 11.6052
R346 vss.n58 vss.n57 11.6052
R347 vss.n10 vss.n9 11.6052
R348 vss.n183 vss.n182 11.6052
R349 vss.n81 vss.n72 6.16925
R350 vss.n102 vss.n93 6.16925
R351 vss.n123 vss.n114 6.16925
R352 vss.n144 vss.n135 6.16925
R353 vss.n60 vss.n3 4.583
R354 vss.n185 vss.n184 3.7605
R355 vss.n63 vss.n61 2.96326
R356 vss.n84 vss.n82 2.96326
R357 vss.n105 vss.n103 2.96326
R358 vss.n126 vss.n124 2.96326
R359 vss.n147 vss.n145 2.96326
R360 vss.n157 vss 2.703
R361 vss.t15 vss.n30 2.47435
R362 vss.n158 vss 1.87051
R363 vss.n167 vss.n32 1.763
R364 vss.n167 vss.n166 1.39346
R365 vss.n165 vss.n37 1.39346
R366 vss.n49 vss.t2 1.31471
R367 vss.n146 vss 0.6825
R368 vss.n125 vss 0.6825
R369 vss.n104 vss 0.6825
R370 vss.n83 vss 0.6825
R371 vss.n62 vss 0.568833
R372 vss.n166 vss.n165 0.370038
R373 vss.n158 vss.n37 0.370038
R374 vss.n30 vss 0.189944
R375 vss.n31 vss 0.189944
R376 vss.n72 vss.n63 0.151488
R377 vss.n93 vss.n84 0.151488
R378 vss.n114 vss.n105 0.151488
R379 vss.n135 vss.n126 0.151488
R380 vss.n156 vss.n147 0.151488
R381 vss.n184 vss.n3 0.118
R382 vss.n61 vss.n60 0.118
R383 vss.n82 vss.n81 0.118
R384 vss.n103 vss.n102 0.118
R385 vss.n124 vss.n123 0.118
R386 vss.n145 vss.n144 0.118
R387 vss.n146 vss.t30 0.053375
R388 vss.n125 vss.t25 0.053375
R389 vss.n104 vss.t16 0.053375
R390 vss.n83 vss.t29 0.053375
R391 vss.n62 vss.t21 0.0442586
R392 vss.n30 vss.t6 0.033527
R393 vss.n31 vss.t15 0.033527
R394 bias_n bias_n.t1 219.8
R395 bias_n bias_n.t2 219.8
R396 bias_n.t3 bias_n.n8 48.9879
R397 bias_n.n5 bias_n.t6 39.5879
R398 bias_n.n6 bias_n.t5 39.5879
R399 bias_n.n7 bias_n.t9 39.5879
R400 bias_n.n8 bias_n.t7 39.5879
R401 bias_n.n0 bias_n 30.9416
R402 bias_n.n2 bias_n 28.5746
R403 bias_n.n5 bias_n.n4 21.9395
R404 bias_n.n1 bias_n 20.0305
R405 bias_n.n0 bias_n 20.0305
R406 bias_n.n3 bias_n 16.2272
R407 bias_n.n4 bias_n 15.667
R408 bias_n bias_n.t0 9.77232
R409 bias_n bias_n.t4 9.77232
R410 bias_n.t6 bias_n 9.77232
R411 bias_n.t5 bias_n 9.77232
R412 bias_n.t9 bias_n 9.77232
R413 bias_n.t7 bias_n 9.77232
R414 bias_n bias_n.t3 9.77232
R415 bias_n.n8 bias_n.n7 9.4005
R416 bias_n.n7 bias_n.n6 9.4005
R417 bias_n.n6 bias_n.n5 9.4005
R418 bias_n.n4 bias_n 2.468
R419 bias_n.n1 bias_n.n0 1.763
R420 bias_n.n3 bias_n.n2 1.00747
R421 bias_n.n2 bias_n.n1 0.370038
R422 bias_n bias_n.n3 0.259
R423 bias_n bias_n.t8 0.0180781
R424 bias_p bias_p.t1 223.565
R425 bias_p bias_p.t2 219.8
R426 bias_p.t4 bias_p.n7 51.1402
R427 bias_p.n4 bias_p.t5 41.7402
R428 bias_p.n5 bias_p.t8 41.7402
R429 bias_p.n6 bias_p.t7 41.7402
R430 bias_p.n7 bias_p.t3 41.7402
R431 bias_p.n2 bias_p 28.9496
R432 bias_p.n1 bias_p 24.2074
R433 bias_p.n0 bias_p 20.2211
R434 bias_p.n0 bias_p 18.5861
R435 bias_p.n3 bias_p 15.902
R436 bias_p.n4 bias_p.n3 15.1245
R437 bias_p bias_p.t0 11.5497
R438 bias_p.t5 bias_p 11.5497
R439 bias_p.t8 bias_p 11.5497
R440 bias_p.t7 bias_p 11.5497
R441 bias_p.t3 bias_p 11.5497
R442 bias_p bias_p.t4 11.5497
R443 bias_p.n7 bias_p.n6 9.4005
R444 bias_p.n6 bias_p.n5 9.4005
R445 bias_p.n5 bias_p.n4 9.4005
R446 bias_p.n2 bias_p.n1 5.288
R447 bias_p bias_p.n2 3.02848
R448 bias_p.n3 bias_p 2.233
R449 bias_p.n1 bias_p.n0 0.370038
R450 bias_p bias_p.t6 0.0180781
R451 Xc4.C1.n0 Xc4.C1.t3 273.445
R452 Xc4.C1.n0 Xc4.C1.t4 247.357
R453 Xc4.C1.t3 Xc4.C1 231.048
R454 Xc4.C1 Xc4.C1.t1 223.565
R455 Xc4.C1 Xc4.C1.t0 219.8
R456 Xc4.C1.t4 Xc4.C1 202.611
R457 Xc4.C1 Xc4.C1.n3 41.7793
R458 Xc4.C1.n2 Xc4.C1 37.0371
R459 Xc4.C1.n1 Xc4.C1 23.4447
R460 Xc4.C1.n1 Xc4.C1.n0 6.55876
R461 Xc4.C1.n3 Xc4.C1.n2 2.3505
R462 Xc4.C1.n3 Xc4.C1.n1 0.374737
R463 Xc4.C1 Xc4.C1.t2 0.28175
R464 Xc4.C1.n2 Xc4.C1 0.05925
R465 Xc1.C1.n0 Xc1.C1.t2 269.695
R466 Xc1.C1.n0 Xc1.C1.t4 243.607
R467 Xc1.C1.t2 Xc1.C1 231.048
R468 Xc1.C1 Xc1.C1.t0 223.565
R469 Xc1.C1 Xc1.C1.t1 219.8
R470 Xc1.C1.t4 Xc1.C1 202.611
R471 Xc1.C1.n2 Xc1.C1 38.0293
R472 Xc1.C1 Xc1.C1.n3 33.2871
R473 Xc1.C1.n1 Xc1.C1 19.6947
R474 Xc1.C1.n1 Xc1.C1.n0 6.55876
R475 Xc1.C1.n3 Xc1.C1.n2 2.3505
R476 Xc1.C1.n2 Xc1.C1.n1 0.374737
R477 Xc1.C1 Xc1.C1.t3 0.28175
R478 Xc1.C1.n3 Xc1.C1 0.05925
R479 Xc2.C1.n0 Xc2.C1.t2 271.195
R480 Xc2.C1.n0 Xc2.C1.t4 245.107
R481 Xc2.C1.t2 Xc2.C1 231.048
R482 Xc2.C1 Xc2.C1.t1 223.565
R483 Xc2.C1 Xc2.C1.t0 219.8
R484 Xc2.C1.t4 Xc2.C1 202.611
R485 Xc2.C1 Xc2.C1.n3 39.5293
R486 Xc2.C1.n2 Xc2.C1 34.7871
R487 Xc2.C1.n1 Xc2.C1 21.1947
R488 Xc2.C1.n1 Xc2.C1.n0 6.55876
R489 Xc2.C1.n3 Xc2.C1.n2 2.3505
R490 Xc2.C1.n3 Xc2.C1.n1 0.374737
R491 Xc2.C1 Xc2.C1.t3 0.28175
R492 Xc2.C1.n2 Xc2.C1 0.05925
R493 X2_Xps.D X2_Xps.D.t1 223.565
R494 X2_Xps.D X2_Xps.D.t0 223.565
R495 X2_Xps.D X2_Xps.D.n0 37.2908
R496 X2_Xps.D.n0 X2_Xps.D 34.4121
R497 X2_Xps.D.n0 X2_Xps.D 0.05925
R498 vdd.n16 vdd.n12 4207.06
R499 vdd.n13 vdd.n10 4207.06
R500 vdd.n30 vdd.n26 4207.06
R501 vdd.n27 vdd.n24 4207.06
R502 vdd.n51 vdd.n47 4207.06
R503 vdd.n48 vdd.n45 4207.06
R504 vdd.n72 vdd.n68 4207.06
R505 vdd.n69 vdd.n66 4207.06
R506 vdd.n93 vdd.n89 4207.06
R507 vdd.n90 vdd.n87 4207.06
R508 vdd.n114 vdd.n110 4207.06
R509 vdd.n111 vdd.n108 4207.06
R510 vdd.n135 vdd.n131 4207.06
R511 vdd.n132 vdd.n129 4207.06
R512 vdd.n7 vdd.n3 1736.47
R513 vdd.n4 vdd.n1 1736.47
R514 vdd.n40 vdd.n36 1560
R515 vdd.n37 vdd.n34 1560
R516 vdd.n61 vdd.n57 1560
R517 vdd.n58 vdd.n55 1560
R518 vdd.n82 vdd.n78 1560
R519 vdd.n79 vdd.n76 1560
R520 vdd.n103 vdd.n99 1560
R521 vdd.n100 vdd.n97 1560
R522 vdd.n124 vdd.n120 1560
R523 vdd.n121 vdd.n118 1560
R524 vdd.n14 vdd.n13 1068.61
R525 vdd.n16 vdd.n15 1068.61
R526 vdd.n28 vdd.n27 1068.61
R527 vdd.n30 vdd.n29 1068.61
R528 vdd.n49 vdd.n48 1068.61
R529 vdd.n51 vdd.n50 1068.61
R530 vdd.n70 vdd.n69 1068.61
R531 vdd.n72 vdd.n71 1068.61
R532 vdd.n91 vdd.n90 1068.61
R533 vdd.n93 vdd.n92 1068.61
R534 vdd.n112 vdd.n111 1068.61
R535 vdd.n114 vdd.n113 1068.61
R536 vdd.n133 vdd.n132 1068.61
R537 vdd.n135 vdd.n134 1068.61
R538 vdd.n11 vdd.n9 448.753
R539 vdd vdd.n9 448.753
R540 vdd.n17 vdd.n11 448.753
R541 vdd vdd.n17 448.753
R542 vdd.n25 vdd.n23 448.753
R543 vdd vdd.n23 448.753
R544 vdd.n31 vdd.n25 448.753
R545 vdd vdd.n31 448.753
R546 vdd.n46 vdd.n44 448.753
R547 vdd vdd.n44 448.753
R548 vdd.n52 vdd.n46 448.753
R549 vdd vdd.n52 448.753
R550 vdd.n67 vdd.n65 448.753
R551 vdd vdd.n65 448.753
R552 vdd.n73 vdd.n67 448.753
R553 vdd vdd.n73 448.753
R554 vdd.n88 vdd.n86 448.753
R555 vdd vdd.n86 448.753
R556 vdd.n94 vdd.n88 448.753
R557 vdd vdd.n94 448.753
R558 vdd.n109 vdd.n107 448.753
R559 vdd vdd.n107 448.753
R560 vdd.n115 vdd.n109 448.753
R561 vdd vdd.n115 448.753
R562 vdd.n130 vdd.n128 448.753
R563 vdd vdd.n128 448.753
R564 vdd.n136 vdd.n130 448.753
R565 vdd vdd.n136 448.753
R566 vdd.n5 vdd.n4 314.781
R567 vdd.n7 vdd.n6 314.781
R568 vdd.n38 vdd.n37 255.901
R569 vdd.n59 vdd.n58 255.901
R570 vdd.n80 vdd.n79 255.901
R571 vdd.n101 vdd.n100 255.901
R572 vdd.n122 vdd.n121 255.901
R573 vdd.n40 vdd.n39 255.901
R574 vdd.n61 vdd.n60 255.901
R575 vdd.n82 vdd.n81 255.901
R576 vdd.n103 vdd.n102 255.901
R577 vdd.n124 vdd.n123 255.901
R578 vdd vdd.t14 223.565
R579 vdd vdd.t8 223.565
R580 vdd vdd.t10 223.565
R581 vdd vdd.t16 223.565
R582 vdd vdd.t12 223.565
R583 vdd vdd.t18 223.565
R584 vdd vdd.t20 223.565
R585 vdd vdd.t22 223.565
R586 vdd vdd.t5 219.8
R587 vdd.n2 vdd.n0 185.225
R588 vdd vdd.n0 185.225
R589 vdd.n8 vdd.n2 185.225
R590 vdd vdd.n8 185.225
R591 vdd.n35 vdd.n33 166.4
R592 vdd vdd.n33 166.4
R593 vdd.n41 vdd.n35 166.4
R594 vdd vdd.n41 166.4
R595 vdd.n56 vdd.n54 166.4
R596 vdd vdd.n54 166.4
R597 vdd.n62 vdd.n56 166.4
R598 vdd vdd.n62 166.4
R599 vdd.n77 vdd.n75 166.4
R600 vdd vdd.n75 166.4
R601 vdd.n83 vdd.n77 166.4
R602 vdd vdd.n83 166.4
R603 vdd.n98 vdd.n96 166.4
R604 vdd vdd.n96 166.4
R605 vdd.n104 vdd.n98 166.4
R606 vdd vdd.n104 166.4
R607 vdd.n119 vdd.n117 166.4
R608 vdd vdd.n117 166.4
R609 vdd.n125 vdd.n119 166.4
R610 vdd vdd.n125 166.4
R611 vdd.n36 vdd.n35 61.6672
R612 vdd vdd.n34 61.6672
R613 vdd.n57 vdd.n56 61.6672
R614 vdd vdd.n55 61.6672
R615 vdd.n78 vdd.n77 61.6672
R616 vdd vdd.n76 61.6672
R617 vdd.n99 vdd.n98 61.6672
R618 vdd vdd.n97 61.6672
R619 vdd.n120 vdd.n119 61.6672
R620 vdd vdd.n118 61.6672
R621 vdd.n38 vdd.n36 49.5916
R622 vdd.n59 vdd.n57 49.5916
R623 vdd.n80 vdd.n78 49.5916
R624 vdd.n101 vdd.n99 49.5916
R625 vdd.n122 vdd.n120 49.5916
R626 vdd.n39 vdd.n34 49.5916
R627 vdd.n60 vdd.n55 49.5916
R628 vdd.n81 vdd.n76 49.5916
R629 vdd.n102 vdd.n97 49.5916
R630 vdd.n123 vdd.n118 49.5916
R631 vdd.n3 vdd.n2 37.0005
R632 vdd vdd.n1 37.0005
R633 vdd.n22 vdd 31.7871
R634 vdd.n43 vdd 31.7871
R635 vdd.n64 vdd 31.7871
R636 vdd.n85 vdd 31.7871
R637 vdd.n106 vdd 31.7871
R638 vdd.n127 vdd 31.7871
R639 vdd.n138 vdd 31.7871
R640 vdd.n13 vdd.n9 30.8338
R641 vdd.n17 vdd.n16 30.8338
R642 vdd.n27 vdd.n23 30.8338
R643 vdd.n31 vdd.n30 30.8338
R644 vdd.n37 vdd.n33 30.8338
R645 vdd.n41 vdd.n40 30.8338
R646 vdd.n48 vdd.n44 30.8338
R647 vdd.n52 vdd.n51 30.8338
R648 vdd.n58 vdd.n54 30.8338
R649 vdd.n62 vdd.n61 30.8338
R650 vdd.n69 vdd.n65 30.8338
R651 vdd.n73 vdd.n72 30.8338
R652 vdd.n79 vdd.n75 30.8338
R653 vdd.n83 vdd.n82 30.8338
R654 vdd.n90 vdd.n86 30.8338
R655 vdd.n94 vdd.n93 30.8338
R656 vdd.n100 vdd.n96 30.8338
R657 vdd.n104 vdd.n103 30.8338
R658 vdd.n111 vdd.n107 30.8338
R659 vdd.n115 vdd.n114 30.8338
R660 vdd.n121 vdd.n117 30.8338
R661 vdd.n125 vdd.n124 30.8338
R662 vdd.n132 vdd.n128 30.8338
R663 vdd.n136 vdd.n135 30.8338
R664 vdd.n4 vdd.n0 30.8338
R665 vdd.n8 vdd.n7 30.8338
R666 vdd.n42 vdd 30.0334
R667 vdd.n63 vdd 30.0334
R668 vdd.n84 vdd 30.0334
R669 vdd.n105 vdd 30.0334
R670 vdd.n126 vdd 30.0334
R671 vdd vdd.n138 29.919
R672 vdd.n32 vdd 29.703
R673 vdd.n53 vdd 29.703
R674 vdd.n74 vdd 29.703
R675 vdd.n95 vdd 29.703
R676 vdd.n116 vdd 29.703
R677 vdd.n137 vdd 29.703
R678 vdd.n5 vdd.n3 29.6618
R679 vdd.n6 vdd.n1 29.6618
R680 vdd.n20 vdd 28.1996
R681 vdd.n18 vdd 23.8269
R682 vdd.n18 vdd 20.078
R683 vdd.n19 vdd 19.6555
R684 vdd.n22 vdd.n21 15.947
R685 vdd.n21 vdd 15.197
R686 vdd.t1 vdd.n38 10.1167
R687 vdd.t3 vdd.n59 10.1167
R688 vdd.t2 vdd.n80 10.1167
R689 vdd.t0 vdd.n101 10.1167
R690 vdd.t6 vdd.n122 10.1167
R691 vdd.n39 vdd.t1 10.1167
R692 vdd.n60 vdd.t3 10.1167
R693 vdd.n81 vdd.t2 10.1167
R694 vdd.n102 vdd.t0 10.1167
R695 vdd.n123 vdd.t6 10.1167
R696 vdd vdd.t4 9.77232
R697 vdd.n127 vdd.n126 7.81425
R698 vdd.n106 vdd.n105 7.81425
R699 vdd.n85 vdd.n84 7.81425
R700 vdd.n64 vdd.n63 7.81425
R701 vdd.n43 vdd.n42 7.81425
R702 vdd.n12 vdd.n11 7.4005
R703 vdd vdd.n10 7.4005
R704 vdd.n26 vdd.n25 7.4005
R705 vdd vdd.n24 7.4005
R706 vdd.n47 vdd.n46 7.4005
R707 vdd vdd.n45 7.4005
R708 vdd.n68 vdd.n67 7.4005
R709 vdd vdd.n66 7.4005
R710 vdd.n89 vdd.n88 7.4005
R711 vdd vdd.n87 7.4005
R712 vdd.n110 vdd.n109 7.4005
R713 vdd vdd.n108 7.4005
R714 vdd.n131 vdd.n130 7.4005
R715 vdd vdd.n129 7.4005
R716 vdd.n6 vdd.t21 6.70818
R717 vdd.t21 vdd.n5 6.70818
R718 vdd vdd.n20 6.55348
R719 vdd.n14 vdd.n12 5.51167
R720 vdd.n15 vdd.n10 5.51167
R721 vdd.n28 vdd.n26 5.51167
R722 vdd.n29 vdd.n24 5.51167
R723 vdd.n49 vdd.n47 5.51167
R724 vdd.n50 vdd.n45 5.51167
R725 vdd.n70 vdd.n68 5.51167
R726 vdd.n71 vdd.n66 5.51167
R727 vdd.n91 vdd.n89 5.51167
R728 vdd.n92 vdd.n87 5.51167
R729 vdd.n112 vdd.n110 5.51167
R730 vdd.n113 vdd.n108 5.51167
R731 vdd.n133 vdd.n131 5.51167
R732 vdd.n134 vdd.n129 5.51167
R733 vdd.n138 vdd.n137 3.7605
R734 vdd.n21 vdd 2.938
R735 vdd.n19 vdd.n18 1.998
R736 vdd.n15 vdd.t13 1.88064
R737 vdd.t13 vdd.n14 1.88064
R738 vdd.n29 vdd.t7 1.88064
R739 vdd.t7 vdd.n28 1.88064
R740 vdd.n50 vdd.t9 1.88064
R741 vdd.t9 vdd.n49 1.88064
R742 vdd.n71 vdd.t15 1.88064
R743 vdd.t15 vdd.n70 1.88064
R744 vdd.n92 vdd.t11 1.88064
R745 vdd.t11 vdd.n91 1.88064
R746 vdd.n113 vdd.t17 1.88064
R747 vdd.t17 vdd.n112 1.88064
R748 vdd.n134 vdd.t19 1.88064
R749 vdd.t19 vdd.n133 1.88064
R750 vdd.n126 vdd.n116 1.46925
R751 vdd.n105 vdd.n95 1.46925
R752 vdd.n84 vdd.n74 1.46925
R753 vdd.n63 vdd.n53 1.46925
R754 vdd.n42 vdd.n32 1.46925
R755 vdd.n20 vdd.n19 0.370038
R756 vdd.n137 vdd.n127 0.118
R757 vdd.n116 vdd.n106 0.118
R758 vdd.n95 vdd.n85 0.118
R759 vdd.n74 vdd.n64 0.118
R760 vdd.n53 vdd.n43 0.118
R761 vdd.n32 vdd.n22 0.118
R762 X2_Xns.D X2_Xns.D.t1 219.8
R763 X2_Xns.D X2_Xns.D.t0 219.8
R764 X2_Xns.D.n0 X2_Xns.D 41.7255
R765 X2_Xns.D X2_Xns.D.n0 39.9043
R766 X2_Xns.D.n0 X2_Xns.D 0.05925
R767 X1_Xps.D X1_Xps.D.t1 223.565
R768 X1_Xps.D X1_Xps.D.t0 223.565
R769 X1_Xps.D X1_Xps.D.n0 35.7908
R770 X1_Xps.D.n0 X1_Xps.D 32.9121
R771 X1_Xps.D.n0 X1_Xps.D 0.05925
R772 X1_Xpi.G.n2 X1_Xpi.G.t6 270.07
R773 X1_Xpi.G.n3 X1_Xpi.G.t2 241.631
R774 X1_Xpi.G.t6 X1_Xpi.G 231.048
R775 X1_Xpi.G X1_Xpi.G.t1 223.565
R776 X1_Xpi.G X1_Xpi.G.t0 219.8
R777 X1_Xpi.G.t2 X1_Xpi.G 202.611
R778 X1_Xpi.G.n0 X1_Xpi.G.t5 43.4379
R779 X1_Xpi.G.n0 X1_Xpi.G.t3 42.8652
R780 X1_Xpi.G X1_Xpi.G.n5 38.4043
R781 X1_Xpi.G.n4 X1_Xpi.G.n3 35.368
R782 X1_Xpi.G.n4 X1_Xpi.G 33.6621
R783 X1_Xpi.G.n1 X1_Xpi.G 20.0182
R784 X1_Xpi.G.t3 X1_Xpi.G 11.5497
R785 X1_Xpi.G.t5 X1_Xpi.G 9.77232
R786 X1_Xpi.G.n1 X1_Xpi.G.n0 4.20876
R787 X1_Xpi.G.n5 X1_Xpi.G.n4 2.3505
R788 X1_Xpi.G.n3 X1_Xpi.G.n2 2.3505
R789 X1_Xpi.G.n5 X1_Xpi.G.n1 0.374737
R790 X1_Xpi.G X1_Xpi.G.t4 0.2255
R791 X1_Xpi.G.n2 X1_Xpi.G 0.05925
R792 X1_Xns.D X1_Xns.D.t1 219.8
R793 X1_Xns.D X1_Xns.D.t0 219.8
R794 X1_Xns.D.n0 X1_Xns.D 40.6005
R795 X1_Xns.D X1_Xns.D.n0 38.7793
R796 X1_Xns.D.n0 X1_Xns.D 0.05925
R797 X5_Xps.D X5_Xps.D.t1 223.565
R798 X5_Xps.D X5_Xps.D.t0 223.565
R799 X5_Xps.D X5_Xps.D.n0 40.6658
R800 X5_Xps.D.n0 X5_Xps.D 37.7871
R801 X5_Xps.D.n0 X5_Xps.D 0.05925
R802 Xbp1.D Xbp1.D.t1 223.565
R803 Xbp1.D Xbp1.D.t0 219.8
R804 Xbp1.D.n0 Xbp1.D.t2 154.849
R805 Xbp1.D.n0 Xbp1.D.t3 142.98
R806 Xbp1.D.t2 Xbp1.D 115.525
R807 Xbp1.D.t3 Xbp1.D 101.305
R808 Xbp1.D Xbp1.D.n2 43.2793
R809 Xbp1.D.n1 Xbp1.D 38.5371
R810 Xbp1.D.n2 Xbp1.D.n1 2.3505
R811 Xbp1.D.n2 Xbp1.D.n0 2.233
R812 Xbp1.D.n1 Xbp1.D 0.05925
R813 X4_Xps.D X4_Xps.D.t1 223.565
R814 X4_Xps.D X4_Xps.D.t0 223.565
R815 X4_Xps.D X4_Xps.D.n0 39.5408
R816 X4_Xps.D.n0 X4_Xps.D 36.6621
R817 X4_Xps.D.n0 X4_Xps.D 0.05925
R818 X4_Xns.D X4_Xns.D.t1 219.8
R819 X4_Xns.D X4_Xns.D.t0 219.8
R820 X4_Xns.D.n0 X4_Xns.D 43.9755
R821 X4_Xns.D X4_Xns.D.n0 42.1543
R822 X4_Xns.D.n0 X4_Xns.D 0.05925
R823 Xbias.Xb2.D Xbias.Xb2.D.t2 219.8
R824 Xbias.Xb2.D Xbias.Xb2.D.t1 219.8
R825 Xbias.Xb2.D.n0 Xbias.Xb2.D 31.6916
R826 Xbias.Xb2.D Xbias.Xb2.D.n1 29.3246
R827 Xbias.Xb2.D.n0 Xbias.Xb2.D 20.7805
R828 Xbias.Xb2.D Xbias.Xb2.D.t0 9.77232
R829 Xbias.Xb2.D.n1 Xbias.Xb2.D 4.79097
R830 Xbias.Xb2.D.n1 Xbias.Xb2.D.n0 0.370038
R831 clk clk.t1 223.565
R832 clk clk.t0 219.8
R833 clk clk.n0 46.0042
R834 clk.n0 clk 38.9121
R835 clk.n0 clk 0.05925
R836 X5_Xns.D X5_Xns.D.t1 219.8
R837 X5_Xns.D X5_Xns.D.t0 219.8
R838 X5_Xns.D.n0 X5_Xns.D 44.7255
R839 X5_Xns.D X5_Xns.D.n0 42.9043
R840 X5_Xns.D.n0 X5_Xns.D 0.05925
R841 X3_Xps.D X3_Xps.D.t1 223.565
R842 X3_Xps.D X3_Xps.D.t0 223.565
R843 X3_Xps.D X3_Xps.D.n0 38.4158
R844 X3_Xps.D.n0 X3_Xps.D 35.5371
R845 X3_Xps.D.n0 X3_Xps.D 0.05925
R846 X3_Xns.D X3_Xns.D.t1 219.8
R847 X3_Xns.D X3_Xns.D.t0 219.8
R848 X3_Xns.D.n0 X3_Xns.D 42.8505
R849 X3_Xns.D X3_Xns.D.n0 41.0293
R850 X3_Xns.D.n0 X3_Xns.D 0.05925
C0 vdd clk 0.91555f
C1 bias_n bias_p 37.396f
C2 vdd bias_p 23.7033f
C3 vdd bias_n 39.8723f
C4 Xbp1.D clk 10.9509f
C5 X5_Xns.D bias_n 3.83617f
C6 Xbp1.D vdd 1.05506f
C7 X5_Xps.D bias_p 3.73804f
C8 X5_Xns.D vdd 0.15838f
C9 X5_Xps.D bias_n 0.17152f
C10 X4_Xns.D bias_p 0.17288f
C11 Xc4.C1 bias_p 0.24257f
C12 X4_Xns.D bias_n 3.88396f
C13 X5_Xps.D vdd 3.87054f
C14 X4_Xns.D vdd 0.14906f
C15 Xc4.C1 bias_n 0.38307f
C16 X4_Xps.D bias_p 3.89108f
C17 X4_Xps.D bias_n 0.15386f
C18 X3_Xns.D bias_p 0.17288f
C19 Xc4.C1 vdd 1.43816f
C20 Xc3.C1 bias_p 0.40526f
C21 X4_Xps.D vdd 3.87054f
C22 X3_Xns.D bias_n 3.88396f
C23 X3_Xps.D bias_p 3.89108f
C24 Xc3.C1 bias_n 0.36542f
C25 X3_Xns.D vdd 0.14906f
C26 X2_Xns.D bias_p 0.17288f
C27 Xc4.C1 X5_Xns.D 0.12529f
C28 Xc3.C1 vdd 1.43816f
C29 X3_Xps.D bias_n 0.15386f
C30 Xc4.C1 X5_Xps.D 1.1225f
C31 X2_Xns.D bias_n 3.88396f
C32 Xc2.C1 bias_p 0.40349f
C33 X3_Xps.D vdd 3.87054f
C34 Xc2.C1 bias_n 0.36542f
C35 Xc4.C1 X4_Xns.D 3.18406f
C36 X2_Xps.D bias_p 3.88742f
C37 X2_Xns.D vdd 0.14906f
C38 Xc2.C1 vdd 1.43816f
C39 X1_Xns.D bias_p 0.16921f
C40 X2_Xps.D bias_n 0.15386f
C41 X1_Xns.D bias_n 3.88404f
C42 X4_Xps.D Xc4.C1 1.43565f
C43 Xc1.C1 bias_p 3.30423f
C44 X2_Xps.D vdd 3.87054f
C45 X1_Xns.D vdd 0.14906f
C46 Xc1.C1 bias_n 0.36564f
C47 X1_Xpi.G bias_p 4.26489f
C48 Xc3.C1 X4_Xns.D 0.02515f
C49 X1_Xps.D bias_p 5.47231f
C50 Xc1.C1 vdd 1.43865f
C51 Xc3.C1 Xc4.C1 9.14191f
C52 X1_Xpi.G bias_n 1.31751f
C53 Xbias.Xb2.D bias_p 6.27185f
C54 Xc3.C1 X4_Xps.D 1.02174f
C55 X1_Xps.D bias_n 0.15386f
C56 X1_Xpi.G vdd 6.22484f
C57 Xbias.Xb2.D bias_n 0.35421f
C58 Xc3.C1 X3_Xns.D 3.03546f
C59 X1_Xps.D vdd 3.87098f
C60 Xbias.Xb2.D vdd 0.34322f
C61 X1_Xpi.G Xbp1.D 8.03218f
C62 X3_Xps.D Xc3.C1 1.39474f
C63 X1_Xpi.G X5_Xns.D 1.71539f
C64 Xc2.C1 X3_Xns.D 0.02515f
C65 X1_Xpi.G X5_Xps.D 1.07324f
C66 Xc2.C1 Xc3.C1 8.74023f
C67 X1_Xpi.G X4_Xns.D 0.19262f
C68 Xc2.C1 X3_Xps.D 1.01839f
C69 X1_Xpi.G Xc4.C1 8.39237f
C70 Xc2.C1 X2_Xns.D 2.88396f
C71 X1_Xpi.G X4_Xps.D 0.19697f
C72 X1_Xpi.G X3_Xns.D 0.19217f
C73 X1_Xpi.G Xc3.C1 1.27404f
C74 X2_Xps.D Xc2.C1 1.35383f
C75 X1_Xpi.G X3_Xps.D 0.19362f
C76 Xc1.C1 X2_Xns.D 0.02515f
C77 X1_Xpi.G X2_Xns.D 0.18881f
C78 Xc1.C1 Xc2.C1 7.90077f
C79 X1_Xpi.G Xc2.C1 2.39356f
C80 Xc1.C1 X2_Xps.D 0.20357f
C81 Xc1.C1 X1_Xns.D 1.6406f
C82 X1_Xpi.G X2_Xps.D 0.9726f
C83 X1_Xpi.G X1_Xns.D 1.2403f
C84 X1_Xpi.G Xc1.C1 14.1024f
C85 X1_Xps.D Xc1.C1 1.28527f
C86 X1_Xps.D X1_Xpi.G 0.1402f
C87 clk vss 13.21499f
C88 bias_p vss 79.52169f
C89 bias_n vss 0.10174p
C90 vdd vss 0.19708p
C91 Xbp1.D vss 27.21623f
C92 X5_Xns.D vss 14.86821f
C93 X5_Xps.D vss 12.89655f
C94 X4_Xns.D vss 14.86789f
C95 Xc4.C1 vss 30.25167f
C96 X4_Xps.D vss 12.12642f
C97 X3_Xns.D vss 14.2841f
C98 Xc3.C1 vss 27.55348f
C99 X3_Xps.D vss 11.55729f
C100 X2_Xns.D vss 13.73568f
C101 Xc2.C1 vss 26.37326f
C102 X2_Xps.D vss 10.98633f
C103 X1_Xns.D vss 12.23433f
C104 Xc1.C1 vss 23.33204f
C105 X1_Xpi.G vss 54.27979f
C106 X1_Xps.D vss 10.61548f
C107 Xbias.Xb2.D vss 20.79524f
C108 X3_Xns.D.t1 vss 0.01278f
C109 X3_Xns.D.n0 vss 4.41683f
C110 X3_Xns.D.t0 vss 0.01278f
C111 X3_Xps.D.t1 vss 0.02895f
C112 X3_Xps.D.n0 vss 4.73701f
C113 X3_Xps.D.t0 vss 0.02895f
C114 X5_Xns.D.t1 vss 0.00658f
C115 X5_Xns.D.n0 vss 2.40932f
C116 X5_Xns.D.t0 vss 0.00658f
C117 clk.t0 vss 0.01814f
C118 clk.t1 vss 0.03723f
C119 clk.n0 vss 6.76593f
C120 Xbias.Xb2.D.t2 vss 0.0083f
C121 Xbias.Xb2.D.t0 vss 0.61427f
C122 Xbias.Xb2.D.n0 vss 2.41562f
C123 Xbias.Xb2.D.n1 vss 1.26168f
C124 Xbias.Xb2.D.t1 vss 0.0083f
C125 X4_Xns.D.t1 vss 0.01263f
C126 X4_Xns.D.n0 vss 4.51846f
C127 X4_Xns.D.t0 vss 0.01263f
C128 X4_Xps.D.t1 vss 0.02782f
C129 X4_Xps.D.n0 vss 4.71163f
C130 X4_Xps.D.t0 vss 0.02782f
C131 Xbp1.D.t3 vss 0.68623f
C132 Xbp1.D.t2 vss 0.62547f
C133 Xbp1.D.n0 vss 8.43521f
C134 Xbp1.D.t1 vss 0.03024f
C135 Xbp1.D.n1 vss 2.68867f
C136 Xbp1.D.n2 vss 3.30312f
C137 Xbp1.D.t0 vss 0.01474f
C138 X5_Xps.D.t1 vss 0.02608f
C139 X5_Xps.D.n0 vss 4.56756f
C140 X5_Xps.D.t0 vss 0.02608f
C141 X1_Xns.D.t1 vss 0.00788f
C142 X1_Xns.D.n0 vss 2.528f
C143 X1_Xns.D.t0 vss 0.00788f
C144 X1_Xpi.G.t5 vss 2.41913f
C145 X1_Xpi.G.t3 vss 2.63101f
C146 X1_Xpi.G.n0 vss 5.95253f
C147 X1_Xpi.G.t4 vss 0.56109f
C148 X1_Xpi.G.n1 vss 1.63366f
C149 X1_Xpi.G.t6 vss 0.26106f
C150 X1_Xpi.G.n2 vss 3.48434f
C151 X1_Xpi.G.t2 vss 0.25755f
C152 X1_Xpi.G.n3 vss 10.2041f
C153 X1_Xpi.G.t1 vss 0.02942f
C154 X1_Xpi.G.n4 vss 8.99184f
C155 X1_Xpi.G.n5 vss 2.4728f
C156 X1_Xpi.G.t0 vss 0.01434f
C157 X1_Xps.D.t1 vss 0.03856f
C158 X1_Xps.D.n0 vss 5.78816f
C159 X1_Xps.D.t0 vss 0.03856f
C160 X2_Xns.D.t1 vss 0.01315f
C161 X2_Xns.D.n0 vss 4.37952f
C162 X2_Xns.D.t0 vss 0.01315f
C163 vdd.n0 vss 0.03202f
C164 vdd.n1 vss 0.03204f
C165 vdd.n2 vss 0.03204f
C166 vdd.n3 vss 0.03204f
C167 vdd.n4 vss 0.2219f
C168 vdd.t21 vss 0.31931f
C169 vdd.n7 vss 0.2219f
C170 vdd.n8 vss 0.03202f
C171 vdd.t14 vss 0.01941f
C172 vdd.n9 vss 0.07671f
C173 vdd.n10 vss 0.07546f
C174 vdd.n11 vss 0.07546f
C175 vdd.n12 vss 0.07546f
C176 vdd.n13 vss 0.68276f
C177 vdd.t13 vss 1.14017f
C178 vdd.n16 vss 0.68276f
C179 vdd.n17 vss 0.07671f
C180 vdd.n18 vss 1.96755f
C181 vdd.t4 vss 0.70053f
C182 vdd.n19 vss 0.87042f
C183 vdd.t5 vss 0.00946f
C184 vdd.n20 vss 1.59635f
C185 vdd.n21 vss 2.77264f
C186 vdd.t8 vss 0.01941f
C187 vdd.n22 vss 3.10891f
C188 vdd.n23 vss 0.07671f
C189 vdd.n24 vss 0.07546f
C190 vdd.n25 vss 0.07546f
C191 vdd.n26 vss 0.07546f
C192 vdd.n27 vss 0.68276f
C193 vdd.t7 vss 1.14017f
C194 vdd.n30 vss 0.68276f
C195 vdd.n31 vss 0.07671f
C196 vdd.n32 vss 1.26453f
C197 vdd.n33 vss 0.02875f
C198 vdd.n34 vss 0.02902f
C199 vdd.n35 vss 0.02902f
C200 vdd.n36 vss 0.02902f
C201 vdd.n37 vss 0.18818f
C202 vdd.t1 vss 0.26212f
C203 vdd.n40 vss 0.18818f
C204 vdd.n41 vss 0.02875f
C205 vdd.n42 vss 2.22476f
C206 vdd.t10 vss 0.01941f
C207 vdd.n43 vss 2.08404f
C208 vdd.n44 vss 0.07671f
C209 vdd.n45 vss 0.07546f
C210 vdd.n46 vss 0.07546f
C211 vdd.n47 vss 0.07546f
C212 vdd.n48 vss 0.68276f
C213 vdd.t9 vss 1.14017f
C214 vdd.n51 vss 0.68276f
C215 vdd.n52 vss 0.07671f
C216 vdd.n53 vss 1.26453f
C217 vdd.n54 vss 0.02875f
C218 vdd.n55 vss 0.02902f
C219 vdd.n56 vss 0.02902f
C220 vdd.n57 vss 0.02902f
C221 vdd.n58 vss 0.18818f
C222 vdd.t3 vss 0.26212f
C223 vdd.n61 vss 0.18818f
C224 vdd.n62 vss 0.02875f
C225 vdd.n63 vss 2.22476f
C226 vdd.t16 vss 0.01941f
C227 vdd.n64 vss 2.08404f
C228 vdd.n65 vss 0.07671f
C229 vdd.n66 vss 0.07546f
C230 vdd.n67 vss 0.07546f
C231 vdd.n68 vss 0.07546f
C232 vdd.n69 vss 0.68276f
C233 vdd.t15 vss 1.14017f
C234 vdd.n72 vss 0.68276f
C235 vdd.n73 vss 0.07671f
C236 vdd.n74 vss 1.26453f
C237 vdd.n75 vss 0.02875f
C238 vdd.n76 vss 0.02902f
C239 vdd.n77 vss 0.02902f
C240 vdd.n78 vss 0.02902f
C241 vdd.n79 vss 0.18818f
C242 vdd.t2 vss 0.26212f
C243 vdd.n82 vss 0.18818f
C244 vdd.n83 vss 0.02875f
C245 vdd.n84 vss 2.22476f
C246 vdd.t12 vss 0.01941f
C247 vdd.n85 vss 2.08404f
C248 vdd.n86 vss 0.07671f
C249 vdd.n87 vss 0.07546f
C250 vdd.n88 vss 0.07546f
C251 vdd.n89 vss 0.07546f
C252 vdd.n90 vss 0.68276f
C253 vdd.t11 vss 1.14017f
C254 vdd.n93 vss 0.68276f
C255 vdd.n94 vss 0.07671f
C256 vdd.n95 vss 1.26453f
C257 vdd.n96 vss 0.02875f
C258 vdd.n97 vss 0.02902f
C259 vdd.n98 vss 0.02902f
C260 vdd.n99 vss 0.02902f
C261 vdd.n100 vss 0.18818f
C262 vdd.t0 vss 0.26212f
C263 vdd.n103 vss 0.18818f
C264 vdd.n104 vss 0.02875f
C265 vdd.n105 vss 2.22476f
C266 vdd.t18 vss 0.01941f
C267 vdd.n106 vss 2.08404f
C268 vdd.n107 vss 0.07671f
C269 vdd.n108 vss 0.07546f
C270 vdd.n109 vss 0.07546f
C271 vdd.n110 vss 0.07546f
C272 vdd.n111 vss 0.68276f
C273 vdd.t17 vss 1.14017f
C274 vdd.n114 vss 0.68276f
C275 vdd.n115 vss 0.07671f
C276 vdd.n116 vss 1.26453f
C277 vdd.n117 vss 0.02875f
C278 vdd.n118 vss 0.02902f
C279 vdd.n119 vss 0.02902f
C280 vdd.n120 vss 0.02902f
C281 vdd.n121 vss 0.18818f
C282 vdd.t6 vss 0.26212f
C283 vdd.n124 vss 0.18818f
C284 vdd.n125 vss 0.02875f
C285 vdd.n126 vss 2.22476f
C286 vdd.t20 vss 0.01941f
C287 vdd.n127 vss 2.08404f
C288 vdd.n128 vss 0.07671f
C289 vdd.n129 vss 0.07546f
C290 vdd.n130 vss 0.07546f
C291 vdd.n131 vss 0.07546f
C292 vdd.n132 vss 0.68276f
C293 vdd.t19 vss 1.14017f
C294 vdd.n135 vss 0.68276f
C295 vdd.n136 vss 0.07671f
C296 vdd.n137 vss 1.55327f
C297 vdd.t22 vss 0.01941f
C298 vdd.n138 vss 2.65437f
C299 X2_Xps.D.t1 vss 0.03018f
C300 X2_Xps.D.n0 vss 4.76404f
C301 X2_Xps.D.t0 vss 0.03018f
C302 Xc2.C1.t4 vss 0.32192f
C303 Xc2.C1.t2 vss 0.28766f
C304 Xc2.C1.n0 vss 8.82234f
C305 Xc2.C1.t3 vss 0.46794f
C306 Xc2.C1.n1 vss 2.26993f
C307 Xc2.C1.t1 vss 0.03067f
C308 Xc2.C1.n2 vss 2.43222f
C309 Xc2.C1.n3 vss 2.6717f
C310 Xc2.C1.t0 vss 0.01495f
C311 Xc1.C1.t4 vss 0.36214f
C312 Xc1.C1.t2 vss 0.32526f
C313 Xc1.C1.n0 vss 10.2508f
C314 Xc1.C1.t3 vss 0.56981f
C315 Xc1.C1.n1 vss 2.60915f
C316 Xc1.C1.t1 vss 0.0182f
C317 Xc1.C1.n2 vss 3.10076f
C318 Xc1.C1.n3 vss 2.81668f
C319 Xc1.C1.t0 vss 0.03735f
C320 Xc4.C1.t4 vss 0.31659f
C321 Xc4.C1.t3 vss 0.28118f
C322 Xc4.C1.n0 vss 8.27197f
C323 Xc4.C1.t2 vss 0.41071f
C324 Xc4.C1.n1 vss 2.15667f
C325 Xc4.C1.t1 vss 0.02692f
C326 Xc4.C1.n2 vss 2.29062f
C327 Xc4.C1.n3 vss 2.50834f
C328 Xc4.C1.t0 vss 0.01312f
C329 bias_p.t6 vss 7.48045f
C330 bias_p.t0 vss 2.03368f
C331 bias_p.n0 vss 3.00854f
C332 bias_p.t1 vss 0.04003f
C333 bias_p.n1 vss 2.89352f
C334 bias_p.t2 vss 0.01951f
C335 bias_p.n2 vss 3.7427f
C336 bias_p.n3 vss 5.37481f
C337 bias_p.t5 vss 3.48314f
C338 bias_p.n4 vss 9.26942f
C339 bias_p.t8 vss 3.48314f
C340 bias_p.n5 vss 7.78202f
C341 bias_p.t7 vss 3.48314f
C342 bias_p.n6 vss 7.78202f
C343 bias_p.t3 vss 3.48314f
C344 bias_p.n7 vss 12.1749f
C345 bias_p.t4 vss 4.47244f
C346 bias_n.t2 vss 0.01916f
C347 bias_n.t4 vss 1.41862f
C348 bias_n.n0 vss 6.60252f
C349 bias_n.t0 vss 1.41862f
C350 bias_n.n1 vss 1.74024f
C351 bias_n.t1 vss 0.01916f
C352 bias_n.n2 vss 1.86121f
C353 bias_n.t8 vss 7.34634f
C354 bias_n.n3 vss 0.90346f
C355 bias_n.n4 vss 7.05844f
C356 bias_n.t6 vss 2.91524f
C357 bias_n.n5 vss 10.6972f
C358 bias_n.t5 vss 2.91524f
C359 bias_n.n6 vss 7.49739f
C360 bias_n.t9 vss 2.91524f
C361 bias_n.n7 vss 7.49739f
C362 bias_n.t7 vss 2.91524f
C363 bias_n.n8 vss 11.6516f
C364 bias_n.t3 vss 3.90164f
C365 Xc3.C1.t3 vss 0.3119f
C366 Xc3.C1.t4 vss 0.27779f
C367 Xc3.C1.n0 vss 8.34485f
C368 Xc3.C1.t2 vss 0.42798f
C369 Xc3.C1.n1 vss 2.16214f
C370 Xc3.C1.t1 vss 0.01367f
C371 Xc3.C1.n2 vss 2.52889f
C372 Xc3.C1.n3 vss 2.30585f
C373 Xc3.C1.t0 vss 0.02806f
.ends
