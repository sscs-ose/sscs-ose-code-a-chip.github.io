* NGSPICE file created from microrobot_clock.ext - technology: sky130A

.subckt microrobot_clock clk vdd vss bias_n bias_p
X0 Xc3.C1 vss sky130_fd_pr__cap_mim_m3_1 l=2 w=2
X1 vss bias_n bias_p vss sky130_fd_pr__nfet_01v8 ad=0.145 pd=1.58 as=0.145 ps=1.58 w=0.5 l=8
X2 Xc4.C1 vss sky130_fd_pr__cap_mim_m3_1 l=2 w=2
X3 X2_Xps.D Xc1.C1 Xc2.C1 vdd sky130_fd_pr__pfet_01v8 ad=0.29 pd=2.58 as=0.29 ps=2.58 w=1 l=0.5
X4 vss bias_n X2_Xns.D vss sky130_fd_pr__nfet_01v8 ad=0.145 pd=1.58 as=0.145 ps=1.58 w=0.5 l=8
X5 vdd bias_p X1_Xps.D vdd sky130_fd_pr__pfet_01v8 ad=0.29 pd=2.58 as=0.29 ps=2.58 w=1 l=8
X6 X1_Xns.D X1_Xpi.G Xc1.C1 vss sky130_fd_pr__nfet_01v8 ad=0.145 pd=1.58 as=0.145 ps=1.58 w=0.5 l=0.5
X7 vdd bias_p bias_p vdd sky130_fd_pr__pfet_01v8 ad=0.29 pd=2.58 as=0.29 ps=2.58 w=1 l=8
X8 X5_Xps.D Xc4.C1 X1_Xpi.G vdd sky130_fd_pr__pfet_01v8 ad=0.29 pd=2.58 as=0.29 ps=2.58 w=1 l=0.5
X9 vdd X1_Xpi.G Xbp1.D vdd sky130_fd_pr__pfet_01v8 ad=0.29 pd=2.58 as=0.29 ps=2.58 w=1 l=8
X10 vdd bias_p X4_Xps.D vdd sky130_fd_pr__pfet_01v8 ad=0.29 pd=2.58 as=0.29 ps=2.58 w=1 l=8
X11 X4_Xns.D Xc3.C1 Xc4.C1 vss sky130_fd_pr__nfet_01v8 ad=0.145 pd=1.58 as=0.145 ps=1.58 w=0.5 l=0.5
X12 vss bias_n bias_n vss sky130_fd_pr__nfet_01v8 ad=0.145 pd=1.58 as=0.145 ps=1.58 w=0.5 l=8
X13 Xbias.Xb2.D vdd vdd vss sky130_fd_pr__nfet_01v8 ad=0.145 pd=1.58 as=0.145 ps=1.58 w=0.5 l=8
X14 vdd Xbp1.D clk vdd sky130_fd_pr__pfet_01v8 ad=0.29 pd=2.58 as=0.29 ps=2.58 w=1 l=1
X15 vss bias_n X5_Xns.D vss sky130_fd_pr__nfet_01v8 ad=0.145 pd=1.58 as=0.145 ps=1.58 w=0.5 l=8
X16 X3_Xps.D Xc2.C1 Xc3.C1 vdd sky130_fd_pr__pfet_01v8 ad=0.29 pd=2.58 as=0.29 ps=2.58 w=1 l=0.5
X17 Xc1.C1 vss sky130_fd_pr__cap_mim_m3_1 l=2 w=2
X18 vdd bias_p X2_Xps.D vdd sky130_fd_pr__pfet_01v8 ad=0.29 pd=2.58 as=0.29 ps=2.58 w=1 l=8
X19 bias_n vss sky130_fd_pr__cap_mim_m3_1 l=7 w=7
X20 Xc2.C1 vss sky130_fd_pr__cap_mim_m3_1 l=2 w=2
X21 vss bias_n X3_Xns.D vss sky130_fd_pr__nfet_01v8 ad=0.145 pd=1.58 as=0.145 ps=1.58 w=0.5 l=8
X22 X1_Xpi.G vss sky130_fd_pr__cap_mim_m3_1 l=2.5 w=2
X23 bias_p vss sky130_fd_pr__cap_mim_m3_1 l=7 w=7
X24 X2_Xns.D Xc1.C1 Xc2.C1 vss sky130_fd_pr__nfet_01v8 ad=0.145 pd=1.58 as=0.145 ps=1.58 w=0.5 l=0.5
X25 vdd bias_p X5_Xps.D vdd sky130_fd_pr__pfet_01v8 ad=0.29 pd=2.58 as=0.29 ps=2.58 w=1 l=8
X26 X5_Xns.D Xc4.C1 X1_Xpi.G vss sky130_fd_pr__nfet_01v8 ad=0.145 pd=1.58 as=0.145 ps=1.58 w=0.5 l=0.5
X27 vss X1_Xpi.G Xbp1.D vss sky130_fd_pr__nfet_01v8 ad=0.145 pd=1.58 as=0.145 ps=1.58 w=0.5 l=8
X28 bias_n Xbias.Xb2.D Xbias.Xb2.D vss sky130_fd_pr__nfet_01v8 ad=0.145 pd=1.58 as=0.145 ps=1.58 w=0.5 l=8
X29 X1_Xps.D X1_Xpi.G Xc1.C1 vdd sky130_fd_pr__pfet_01v8 ad=0.29 pd=2.58 as=0.29 ps=2.58 w=1 l=0.5
X30 vss bias_n X1_Xns.D vss sky130_fd_pr__nfet_01v8 ad=0.145 pd=1.58 as=0.145 ps=1.58 w=0.5 l=8
X31 vss Xbp1.D clk vss sky130_fd_pr__nfet_01v8 ad=0.145 pd=1.58 as=0.145 ps=1.58 w=0.5 l=1
X32 X4_Xps.D Xc3.C1 Xc4.C1 vdd sky130_fd_pr__pfet_01v8 ad=0.29 pd=2.58 as=0.29 ps=2.58 w=1 l=0.5
X33 vss bias_n X4_Xns.D vss sky130_fd_pr__nfet_01v8 ad=0.145 pd=1.58 as=0.145 ps=1.58 w=0.5 l=8
X34 vdd bias_p X3_Xps.D vdd sky130_fd_pr__pfet_01v8 ad=0.29 pd=2.58 as=0.29 ps=2.58 w=1 l=8
X35 X3_Xns.D Xc2.C1 Xc3.C1 vss sky130_fd_pr__nfet_01v8 ad=0.145 pd=1.58 as=0.145 ps=1.58 w=0.5 l=0.5
C0 Xbias.Xb2.D vdd 0.34322f
C1 bias_n vdd 39.8723f
C2 X3_Xns.D vdd 0.14906f
C3 X2_Xps.D vdd 3.87054f
C4 X1_Xpi.G X4_Xps.D 0.19697f
C5 clk vdd 0.91555f
C6 X1_Xns.D vdd 0.14906f
C7 X5_Xns.D bias_n 3.83617f
C8 Xc4.C1 X4_Xns.D 3.18406f
C9 Xc2.C1 bias_p 0.40349f
C10 X1_Xpi.G vdd 6.22484f
C11 Xc1.C1 X1_Xps.D 1.28527f
C12 Xbias.Xb2.D bias_p 6.27185f
C13 X5_Xps.D vdd 3.87054f
C14 bias_p bias_n 37.396f
C15 X3_Xns.D bias_p 0.17288f
C16 X2_Xps.D bias_p 3.88742f
C17 X2_Xns.D Xc1.C1 0.02515f
C18 X1_Xpi.G X5_Xns.D 1.71539f
C19 Xc2.C1 bias_n 0.36542f
C20 Xc2.C1 X3_Xns.D 0.02515f
C21 Xbias.Xb2.D bias_n 0.35421f
C22 X1_Xns.D bias_p 0.16921f
C23 Xc2.C1 X2_Xps.D 1.35383f
C24 X3_Xns.D bias_n 3.88396f
C25 Xc4.C1 Xc3.C1 9.14191f
C26 X1_Xpi.G bias_p 4.26489f
C27 X2_Xps.D bias_n 0.15386f
C28 X5_Xps.D bias_p 3.73804f
C29 Xc2.C1 X1_Xpi.G 2.39356f
C30 X1_Xns.D bias_n 3.88404f
C31 X1_Xpi.G bias_n 1.31751f
C32 X1_Xpi.G X3_Xns.D 0.19217f
C33 X1_Xpi.G X2_Xps.D 0.9726f
C34 X5_Xps.D bias_n 0.17152f
C35 X1_Xpi.G X1_Xns.D 1.2403f
C36 X4_Xns.D vdd 0.14906f
C37 X1_Xpi.G X5_Xps.D 1.07324f
C38 X3_Xps.D vdd 3.87054f
C39 X4_Xps.D Xc3.C1 1.02174f
C40 X4_Xns.D bias_p 0.17288f
C41 Xbp1.D vdd 1.05506f
C42 Xc3.C1 vdd 1.43816f
C43 X3_Xps.D bias_p 3.89108f
C44 X4_Xns.D bias_n 3.88396f
C45 Xc2.C1 X3_Xps.D 1.01839f
C46 X1_Xps.D vdd 3.87098f
C47 Xc3.C1 bias_p 0.40526f
C48 X3_Xps.D bias_n 0.15386f
C49 X1_Xpi.G X4_Xns.D 0.19262f
C50 Xc2.C1 Xc3.C1 8.74023f
C51 X2_Xns.D vdd 0.14906f
C52 Xc1.C1 vdd 1.43865f
C53 Xc3.C1 bias_n 0.36542f
C54 X3_Xns.D Xc3.C1 3.03546f
C55 X3_Xps.D X1_Xpi.G 0.19362f
C56 X1_Xps.D bias_p 5.47231f
C57 Xbp1.D clk 10.9509f
C58 X1_Xpi.G Xbp1.D 8.03218f
C59 X2_Xns.D bias_p 0.17288f
C60 X1_Xpi.G Xc3.C1 1.27404f
C61 Xc1.C1 bias_p 3.30423f
C62 X1_Xps.D bias_n 0.15386f
C63 X2_Xns.D Xc2.C1 2.88396f
C64 Xc2.C1 Xc1.C1 7.90077f
C65 Xc4.C1 X4_Xps.D 1.43565f
C66 X2_Xns.D bias_n 3.88396f
C67 Xc1.C1 bias_n 0.36564f
C68 Xc4.C1 vdd 1.43816f
C69 X1_Xpi.G X1_Xps.D 0.1402f
C70 Xc1.C1 X2_Xps.D 0.20357f
C71 Xc1.C1 X1_Xns.D 1.6406f
C72 X2_Xns.D X1_Xpi.G 0.18881f
C73 Xc4.C1 X5_Xns.D 0.12529f
C74 X1_Xpi.G Xc1.C1 14.1024f
C75 Xc4.C1 bias_p 0.24257f
C76 Xc3.C1 X4_Xns.D 0.02515f
C77 Xc4.C1 bias_n 0.38307f
C78 X3_Xps.D Xc3.C1 1.39474f
C79 X4_Xps.D vdd 3.87054f
C80 X1_Xpi.G Xc4.C1 8.39237f
C81 Xc4.C1 X5_Xps.D 1.1225f
C82 X5_Xns.D vdd 0.15838f
C83 X4_Xps.D bias_p 3.89108f
C84 bias_p vdd 23.7033f
C85 X4_Xps.D bias_n 0.15386f
C86 Xc2.C1 vdd 1.43816f
C87 clk vss 9.03629f
C88 bias_p vss 63.6283f
C89 bias_n vss 86.3316f
C90 vdd vss 0.17608p
C91 Xbp1.D vss 23.9999f
C92 X5_Xns.D vss 13.4907f
C93 X5_Xps.D vss 9.91628f
C94 X4_Xns.D vss 12.3116f
C95 Xc4.C1 vss 25.8278f
C96 X4_Xps.D vss 9.09369f
C97 X3_Xns.D vss 11.8265f
C98 Xc3.C1 vss 23.1546f
C99 X3_Xps.D vss 8.55222f
C100 X2_Xns.D vss 11.3415f
C101 Xc2.C1 vss 21.7926f
C102 X2_Xps.D vss 8.01074f
C103 X1_Xns.D vss 10.8781f
C104 Xc1.C1 vss 18.1222f
C105 X1_Xpi.G vss 49.7927f
C106 X1_Xps.D vss 7.08076f
C107 Xbias.Xb2.D vss 18.8034f
.ends
