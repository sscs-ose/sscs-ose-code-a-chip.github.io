* Bias subset of the electrically characterized clock; supply-dependent.
.subckt microrobot_bias vdd vss bias_n bias_p
Xb1 bias_n bias_n vss vss sky130_fd_pr__nfet_01v8 w=0.5 l=8
Xb2 b2 b2 bias_n vss sky130_fd_pr__nfet_01v8 w=0.5 l=8
Xb3 vdd vdd b2 vss sky130_fd_pr__nfet_01v8 w=0.5 l=8
Xmirror bias_p bias_n vss vss sky130_fd_pr__nfet_01v8 w=0.5 l=8
Xpdiode bias_p bias_p vdd vdd sky130_fd_pr__pfet_01v8 w=1 l=8
Xcbiasp bias_p vss sky130_fd_pr__cap_mim_m3_1 w=7 l=7
Xcbiasn bias_n vss sky130_fd_pr__cap_mim_m3_1 w=7 l=7
.ends microrobot_bias
