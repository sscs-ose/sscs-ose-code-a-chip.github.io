* Exploratory current-limited reset level converter; NOT accepted POR.
* Cross-coupled logic-domain PMOS L increased4->16um to limit transient
* reservoir discharge when slow actuator-domain input turns on both NMOS sinks.
* No supply storage increase; delay and low-voltage behavior require validation.
* Our actuator-to-logic reset level converter; all dimensions in um.
* Input inverter uses VACT; cross-coupled output latch uses VDDL.
.subckt microrobot_ready_levelshift ready reset_n vact vlogic vss
Xip input_b ready vact vact sky130_fd_pr__pfet_01v8 w=0.84 l=1
Xin input_b ready vss vss sky130_fd_pr__nfet_01v8 w=0.42 l=1
Xn0 output_b ready vss vss sky130_fd_pr__nfet_01v8 w=0.42 l=1
Xn1 reset_n input_b vss vss sky130_fd_pr__nfet_01v8 w=0.42 l=1
Xp0 output_b reset_n vlogic vlogic sky130_fd_pr__pfet_01v8 w=0.42 l=16
Xp1 reset_n output_b vlogic vlogic sky130_fd_pr__pfet_01v8 w=0.42 l=16
.ends microrobot_ready_levelshift
