* AC Small-Signal Testbench for NeuroDyn OTA
.include "C:/sscs-ose-code-a-chip.github.io/ISSCC27/submitted_notebooks/joseph_project/data/models/sky130_fd_pr/models/sky130_neurodyn_tt.lib.spice"

.option noacct
.option method=gear
.option trtol=1
.option chgtol=1e-15

* NeuroDyn-AFE Dynamic Operational Transconductance Amplifier (OTA)
* SkyWater SKY130 130nm Process (sky130_fd_pr__nfet_01v8_lvt, sky130_fd_pr__pfet_01v8_lvt)
.subckt neurodyn_ota inp inm outp outm vdd vss vbn_tail vbp vaux_p vaux_n vbn_out

* Tail Current Source (I_tail = 2.76 uA, Vbn_tail = 0.49V, Vds >= 70mV >= 3*U_T for weak-inversion saturation)
XM_tail tail vbn_tail vss vss sky130_fd_pr__nfet_01v8_lvt W=10.15u L=2.0u mult=2

* Main Input Differential Pair (2nd-Order Optimal Common-Centroid [D,A,B,B,A,B,A,A,B,D])
XM1 nodep inp tail vss sky130_fd_pr__nfet_01v8_lvt W=10.15u L=1.00u mult=4
XM2 noden inm tail vss sky130_fd_pr__nfet_01v8_lvt W=10.15u L=1.00u mult=4

* Auxiliary Differential Pair for Ripple Reduction Loop (RRL) (1/10th Sized for Fine Steering)
XM1_aux nodep vaux_p tail vss sky130_fd_pr__nfet_01v8_lvt W=4.06u L=1.00u mult=1
XM2_aux noden vaux_n tail vss sky130_fd_pr__nfet_01v8_lvt W=4.06u L=1.00u mult=1

* Active PMOS load with Low-Vt to prevent headroom pinch-off under 0.60V VDD
XM3 nodep vbp_cmfb vdd vdd sky130_fd_pr__pfet_01v8_lvt W=3.15u L=2.00u mult=4
XM4 noden vbp_cmfb vdd vdd sky130_fd_pr__pfet_01v8_lvt W=3.15u L=2.00u mult=4

* Continuous-Time Resistive Common-Mode Sensing Network with RC pole to guarantee transient stability
R_cm1 nodep vcm_sense 10MEG
R_cm2 noden vcm_sense 10MEG
E_cmfb vbp_cmfb_raw 0 VOL='V(vbp) + 20.0*(V(vcm_sense) - 0.30)'
R_cmfb vbp_cmfb_raw vbp_cmfb 10k
C_cmfb vbp_cmfb 0 10p

* Miller Frequency Compensation Capacitors
C_c1 noden outp 1.2p
C_c2 nodep outm 1.2p

* Second gain stage (common-source output conversion with Low-Vt PMOS and Low-Vt NMOS loads)
* Sized for I_stage2 = 0.20 uA under Vbn_out = 0.27215V
XM5 outp noden vdd vdd sky130_fd_pr__pfet_01v8_lvt W=3.15u L=2.00u mult=4
XM6 outp vbn_out vss vss sky130_fd_pr__nfet_01v8_lvt W=10.15u L=2.0u mult=2

XM7 outm nodep vdd vdd sky130_fd_pr__pfet_01v8_lvt W=3.15u L=2.00u mult=4
XM8 outm vbn_out vss vss sky130_fd_pr__nfet_01v8_lvt W=10.15u L=2.0u mult=2

.ends neurodyn_ota

* Power Supplies
Vdd vdd 0 DC 0.6
Vss vss 0 DC 0

* Biasing Rails (Saturated Subthreshold: I_tail = 2.76 uA, Vtail >= 70 mV)
Vbn_tail vbn_tail 0 DC 0.49
Vbp vbp 0 DC 0.16
Vbn_out vbn_out 0 DC 0.27215

* Input Common-Mode Reference (0.53 V)
Vcm_ref vcm 0 DC 0.53

* Balanced AC Differential Excitation (0.5V and -0.5V)
Vin_ac_p inp_ac 0 DC 0 AC 0.5
Vin_ac_n inm_ac 0 DC 0 AC -0.5

* Middlebrook DC Servo Inductors & AC Coupling Capacitors
L_dcp inp vcm 1e12
L_dcn inm vcm 1e12
C_acp inp inp_ac 1
C_acn inm inm_ac 1

* Auxiliary Inputs Symmetrically Biased
Vauxp vaux_p 0 DC 0
Vauxn vaux_n 0 DC 0

* Device Under Test (DUT)
XDUT inp inm outp outm vdd vss vbn_tail vbp vaux_p vaux_n vbn_out neurodyn_ota

* Differential Output Probe
E_outdiff outdiff 0 VOL='V(outp) - V(outm)'

* Load Capacitance (5 pF per single-ended branch)
CL1 outp vss 5p
CL2 outm vss 5p

.control
set filetype=ascii
ac dec 50 1 100meg
write ac_results.raw v(outdiff) v(outp) v(outm) v(inp) v(inm)
.endc
.end
