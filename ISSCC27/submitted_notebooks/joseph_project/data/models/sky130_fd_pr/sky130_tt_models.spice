* Pinned SKY130 primitive models
* Source: google/skywater-pdk-libs-sky130_fd_pr
* Commit: f62031a1be9aefe902d6d54cddd6f59b57627436
* TT corner only; regular and LVT NMOS/PMOS used by NeuroDyn-AFE
.include "cells/nfet_01v8/sky130_fd_pr__nfet_01v8__tt.corner.spice"
.include "cells/pfet_01v8/sky130_fd_pr__pfet_01v8__tt.corner.spice"
.include "cells/nfet_01v8_lvt/sky130_fd_pr__nfet_01v8_lvt__tt.corner.spice"
.include "cells/pfet_01v8_lvt/sky130_fd_pr__pfet_01v8_lvt__tt.corner.spice"
