* Dynamic Chopper Transient Testbench for NeuroDyn-AFE
.include "C:/sscs-ose-code-a-chip.github.io/ISSCC27/submitted_notebooks/joseph_project/data/models/sky130_fd_pr/models/sky130_neurodyn_tt.lib.spice"

.option noacct method=gear trtol=1 reltol=1e-3

* NeuroDyn-AFE Dynamic Operational Transconductance Amplifier (OTA)
* SkyWater SKY130 130nm Process (sky130_fd_pr__nfet_01v8_lvt, sky130_fd_pr__pfet_01v8_lvt)
.subckt neurodyn_ota inp inm outp outm vdd vss vbn_tail vbp vaux_p vaux_n vbn_out

* Tail Current Source (I_tail = 2.76 uA, Vbn_tail = 0.38V, Vds >= 100mV >= 3*U_T for weak-inversion saturation)
XM_tail tail vbn_tail vss vss sky130_fd_pr__nfet_01v8_lvt W=10.15u L=2.0u mult=2

* Main Input Differential Pair (2nd-Order Optimal Common-Centroid [D,A,B,B,A,B,A,A,B,D])
XM1 nodep inp tail vss sky130_fd_pr__nfet_01v8_lvt W=10.15u L=1.00u mult=4
XM2 noden inm tail vss sky130_fd_pr__nfet_01v8_lvt W=10.15u L=1.00u mult=4

* Auxiliary Differential Pair for Ripple Reduction Loop (RRL) (1/10th Sized for Fine Steering)
XM1_aux nodep vaux_p tail vss sky130_fd_pr__nfet_01v8_lvt W=4.06u L=1.00u mult=1
XM2_aux noden vaux_n tail vss sky130_fd_pr__nfet_01v8_lvt W=4.06u L=1.00u mult=1

* Active PMOS load with Low-Vt to prevent headroom pinch-off under 0.60V VDD
XM3 nodep vbp_cmfb vdd vdd sky130_fd_pr__pfet_01v8_lvt W=3.15u L=2.00u mult=4
XM4 noden vbp_cmfb vdd vdd sky130_fd_pr__pfet_01v8_lvt W=3.15u L=2.00u mult=4

* Continuous-Time Resistive Common-Mode Sensing Network
R_cm1 nodep vcm_sense 10MEG
R_cm2 noden vcm_sense 10MEG
E_cmfb vbp_cmfb 0 VOL='V(vbp) + 15.0*(V(vcm_sense) - 0.30)'

* Miller Frequency Compensation Capacitors
C_c1 noden outp 1.2p
C_c2 nodep outm 1.2p

* Second gain stage (common-source output conversion with Low-Vt PMOS and Low-Vt NMOS loads)
* Sized for I_stage2 = 0.20 uA under Vbn_out = 0.32V
XM5 outp noden vdd vdd sky130_fd_pr__pfet_01v8_lvt W=3.15u L=2.00u mult=4
XM6 outp vbn_out vss vss sky130_fd_pr__nfet_01v8_lvt W=10.15u L=2.0u mult=2

XM7 outm nodep vdd vdd sky130_fd_pr__pfet_01v8_lvt W=3.15u L=2.00u mult=4
XM8 outm vbn_out vss vss sky130_fd_pr__nfet_01v8_lvt W=10.15u L=2.0u mult=2

.ends neurodyn_ota

* 4-Switch Low-Vt CMOS Chopper Bridge (SkyWater SKY130 LVT)
.subckt chopper_bridge in_p in_n out_p out_n phi phi_bar vdd vss
* Direct Phase (phi high, phi_bar low)
XMN1 in_p phi out_p vss sky130_fd_pr__nfet_01v8_lvt W=3.0u L=0.15u
XMP1 in_p phi_bar out_p vdd sky130_fd_pr__pfet_01v8_lvt W=6.0u L=0.15u

XMN2 in_n phi out_n vss sky130_fd_pr__nfet_01v8_lvt W=3.0u L=0.15u
XMP2 in_n phi_bar out_n vdd sky130_fd_pr__pfet_01v8_lvt W=6.0u L=0.15u

* Inverted Phase (phi low, phi_bar high -> Cross connection)
XMN3 in_p phi_bar out_n vss sky130_fd_pr__nfet_01v8_lvt W=3.0u L=0.15u
XMP3 in_p phi out_n vdd sky130_fd_pr__pfet_01v8_lvt W=6.0u L=0.15u

XMN4 in_n phi_bar out_p vss sky130_fd_pr__nfet_01v8_lvt W=3.0u L=0.15u
XMP4 in_n phi out_p vdd sky130_fd_pr__pfet_01v8_lvt W=6.0u L=0.15u
.ends chopper_bridge

* Power Supplies
Vdd vdd 0 DC 0.6
Vss vss 0 DC 0
Vbn_tail vbn_tail 0 DC 0.38
Vbp vbp 0 DC 0.28
Vbn_out vbn_out 0 DC 0.32
Vcm_ref vcm 0 DC 0.3

* 4 kHz Non-Overlapping Chopping Clocks (Period = 250 us, Width = 120 us)
Vphi phi 0 PULSE(0 0.6 0 10n 10n 120u 250u)
Vphib phi_bar 0 PULSE(0.6 0 0 10n 10n 120u 250u)

* Biosignal Input (100 uVpp, 20 Hz Sine Wave) + 15 mV DC Electrode Offset
Vin_sig in_sig 0 SIN(0 50u 20 0 0)
V_edo in_edo 0 DC 15m
E_vin_p vin_p 0 VOL='V(vcm) + V(in_edo)/2 + V(in_sig)/2'
E_vin_n vin_n 0 VOL='V(vcm) - V(in_edo)/2 - V(in_sig)/2'

* Input Chopper (CHOP1)
XCHOP1 vin_p vin_n chop_p chop_n phi phi_bar vdd vss chopper_bridge

* Core Dynamic OTA
Vauxp vaux_p 0 DC 0
Vauxn vaux_n 0 DC 0
XOTA chop_p chop_n amp_p amp_n vdd vss vbn_tail vbp vaux_p vaux_n vbn_out neurodyn_ota

* Output Demodulator Chopper (CHOP2)
XCHOP2 amp_p amp_n out_demod_p out_demod_n phi phi_bar vdd vss chopper_bridge

* Load Capacitors
CL1 out_demod_p vss 5p
CL2 out_demod_n vss 5p

.control
set filetype=ascii
tran 100n 2m
write tran_results.raw v(vin_p) v(vin_n) v(chop_p) v(amp_p) v(out_demod_p)
.endc
.end
