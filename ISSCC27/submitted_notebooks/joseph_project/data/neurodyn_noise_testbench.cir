* Noise Analysis Testbench for NeuroDyn OTA
.include "C:/sscs-ose-code-a-chip.github.io/ISSCC27/submitted_notebooks/joseph_project/data/models/sky130_fd_pr/models/sky130_neurodyn_tt.lib.spice"

.option noacct method=gear

* NeuroDyn-AFE Dynamic Operational Transconductance Amplifier (OTA)
* SkyWater SKY130 130nm Process (sky130_fd_pr__nfet_01v8_lvt, sky130_fd_pr__pfet_01v8_lvt)
.subckt neurodyn_ota inp inm outp outm vdd vss vbn_tail vbp vaux_p vaux_n vbn_out

* Tail Current Source (I_tail = 2.76 uA, Vbn_tail = 0.38V, Vds >= 100mV >= 3*U_T for weak-inversion saturation)
XM_tail tail vbn_tail vss vss sky130_fd_pr__nfet_01v8_lvt W=10.15u L=2.0u mult=2

* Main Input Differential Pair (2nd-Order Optimal Common-Centroid [D,A,B,B,A,B,A,A,B,D])
XM1 nodep inp tail vss sky130_fd_pr__nfet_01v8_lvt W=10.15u L=1.00u mult=4
XM2 noden inm tail vss sky130_fd_pr__nfet_01v8_lvt W=10.15u L=1.00u mult=4

* Auxiliary Differential Pair for Ripple Reduction Loop (RRL) (1/10th Sized for Fine Steering)
XM1_aux nodep vaux_p tail vss sky130_fd_pr__nfet_01v8_lvt W=4.06u L=1.00u mult=1
XM2_aux noden vaux_n tail vss sky130_fd_pr__nfet_01v8_lvt W=4.06u L=1.00u mult=1

* Active PMOS load with Low-Vt to prevent headroom pinch-off under 0.60V VDD
XM3 nodep vbp_cmfb vdd vdd sky130_fd_pr__pfet_01v8_lvt W=3.15u L=2.00u mult=4
XM4 noden vbp_cmfb vdd vdd sky130_fd_pr__pfet_01v8_lvt W=3.15u L=2.00u mult=4

* Continuous-Time Resistive Common-Mode Sensing Network
R_cm1 nodep vcm_sense 10MEG
R_cm2 noden vcm_sense 10MEG
E_cmfb vbp_cmfb 0 VOL='V(vbp) + 15.0*(V(vcm_sense) - 0.30)'

* Miller Frequency Compensation Capacitors
C_c1 noden outp 1.2p
C_c2 nodep outm 1.2p

* Second gain stage (common-source output conversion with Low-Vt PMOS and Low-Vt NMOS loads)
* Sized for I_stage2 = 0.20 uA under Vbn_out = 0.32V
XM5 outp noden vdd vdd sky130_fd_pr__pfet_01v8_lvt W=3.15u L=2.00u mult=4
XM6 outp vbn_out vss vss sky130_fd_pr__nfet_01v8_lvt W=10.15u L=2.0u mult=2

XM7 outm nodep vdd vdd sky130_fd_pr__pfet_01v8_lvt W=3.15u L=2.00u mult=4
XM8 outm vbn_out vss vss sky130_fd_pr__nfet_01v8_lvt W=10.15u L=2.0u mult=2

.ends neurodyn_ota

Vdd vdd 0 DC 0.6
Vss vss 0 DC 0
Vbn_tail vbn_tail 0 DC 0.38
Vbp vbp 0 DC 0.28
Vbn_out vbn_out 0 DC 0.32

Vcm_ref vcm 0 DC 0.3
Vin_ac_p inp_ac 0 DC 0 AC 0.5
Vin_ac_n inm_ac 0 DC 0 AC -0.5
E_inp inp 0 VOL='V(vcm) + V(inp_ac)'
E_inm inm 0 VOL='V(vcm) + V(inm_ac)'
Vauxp vaux_p 0 DC 0
Vauxn vaux_n 0 DC 0

XDUT inp inm outp outm vdd vss vbn_tail vbp vaux_p vaux_n vbn_out neurodyn_ota
E_outdiff outdiff 0 VOL='V(outp) - V(outm)'
CL1 outp vss 5p
CL2 outm vss 5p

.control
set filetype=ascii
noise v(outdiff) Vin_ac_p dec 20 0.1 100k
write noise_results.raw all
.endc
.end
