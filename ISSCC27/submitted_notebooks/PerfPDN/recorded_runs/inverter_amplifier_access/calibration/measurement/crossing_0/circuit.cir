PerfPDN AC points
.lib /home/gokalp/.local/share/perfpdn/pdks/sky130A/libs.tech/ngspice/sky130.lib.spice tt
.option scale=1e-6
.temp 27
.option klu reltol=1e-8 abstol=1e-14 vntol=1e-10
vdd vdd 0 DC 0 AC 0 0
vin in 0 DC 0 AC 1 0
C1 out 0 1e-13
v_m1_d t_m1_d m1_d 0
v_m1_g t_m1_g m1_g -0.89000000000000001
v_m1_s t_m1_s m1_s -1.8
v_m1_b t_m1_b m1_b -1.8
XM1 m1_d m1_g m1_s m1_b sky130_fd_pr__pfet_01v8 L=0.15 W=6.325 nf=1 ad='int(( 1 + 1 ) / 2 ) * 6.325 / 1 * 0.29' as='int(( 1 + 2 ) / 2 ) * 6.325 / 1 * 0.29' pd='2 * int(( 1 + 1 ) / 2 ) * ( 6.325 / 1 + 0.29 )' ps='2 * int(( 1 + 2 ) / 2 ) * ( 6.325 / 1 + 0.29 )' nrd='0.29 / 6.325 ' nrs='0.29 / 6.325 ' sa=0 sb=0 sd=0 mult=1 m=1
v_m2_d t_m2_d m2_d 0
v_m2_g t_m2_g m2_g -0.89000000000000001
v_m2_s t_m2_s m2_s -0
v_m2_b t_m2_b m2_b -0
XM2 m2_d m2_g m2_s m2_b sky130_fd_pr__nfet_01v8 L=0.15 W=1.67 nf=1 ad='int(( 1 + 1 ) / 2 ) * 1.67 / 1 * 0.29' as='int(( 1 + 2 ) / 2 ) * 1.67 / 1 * 0.29' pd='2 * int(( 1 + 1 ) / 2 ) * ( 1.67 / 1 + 0.29 )' ps='2 * int(( 1 + 2 ) / 2 ) * ( 1.67 / 1 + 0.29 )' nrd='0.29 / 1.67 ' nrs='0.29 / 1.67 ' sa=0 sb=0 sd=0 mult=1 m=1
r0 n0 n1 2.9767441860465116
r1 n1 n2 4.9116279069767446
r2 n2 n3 3.7209302325581395
r3 n3 n4 4.7627906976744185
r4 n4 n5 4.7627906976744185
r5 n5 n6 3.7209302325581395
r6 n6 n7 4.9116279069767446
r7 n7 n8 2.9767441860465116
r8 n9 n10 2.9767441860465116
r9 n10 n11 4.9116279069767446
r10 n11 n12 3.7209302325581395
r11 n12 n13 4.7627906976744185
r12 n13 n14 4.7627906976744185
r13 n14 n15 3.7209302325581395
r14 n15 n16 4.9116279069767446
r15 n16 n17 2.9767441860465116
r16 n0 n18 49.280000000000001
r17 n1 n19 49.280000000000001
r18 n18 n19 3.7647058823529411
r19 n2 n20 21.42608695652174
r20 n19 n20 6.2117647058823531
r21 n3 n21 246.40000000000001
r22 n20 n21 4.7058823529411766
r23 n4 n22 16.426666666666666
r24 n21 n22 6.0235294117647058
r25 n5 n23 246.40000000000001
r26 n22 n23 6.0235294117647058
r27 n6 n24 21.42608695652174
r28 n23 n24 4.7058823529411766
r29 n7 n25 49.280000000000001
r30 n24 n25 6.2117647058823531
r31 n8 n26 49.280000000000001
r32 n25 n26 3.7647058823529411
r33 n9 n27 49.280000000000001
r34 n10 n28 49.280000000000001
r35 n27 n28 3.7647058823529411
r36 n11 n29 21.42608695652174
r37 n28 n29 6.2117647058823531
r38 n12 n30 246.40000000000001
r39 n29 n30 4.7058823529411766
r40 n13 n31 16.426666666666666
r41 n30 n31 6.0235294117647058
r42 n14 n32 246.40000000000001
r43 n31 n32 6.0235294117647058
r44 n15 n33 21.42608695652174
r45 n32 n33 4.7058823529411766
r46 n16 n34 49.280000000000001
r47 n33 n34 6.2117647058823531
r48 n17 n35 49.280000000000001
r49 n34 n35 3.7647058823529411
r50 n18 n36 49.280000000000001
r51 n19 n37 49.280000000000001
r52 n36 n37 2.9767441860465116
r53 n20 n38 21.42608695652174
r54 n37 n38 4.9116279069767446
r55 n21 n39 246.40000000000001
r56 n38 n39 3.7209302325581395
r57 n22 n40 16.426666666666666
r58 n39 n40 4.7627906976744185
r59 n23 n41 246.40000000000001
r60 n40 n41 4.7627906976744185
r61 n24 n42 21.42608695652174
r62 n41 n42 3.7209302325581395
r63 n25 n43 49.280000000000001
r64 n42 n43 4.9116279069767446
r65 n26 n44 49.280000000000001
r66 n43 n44 2.9767441860465116
r67 n27 n45 49.280000000000001
r68 n28 n46 49.280000000000001
r69 n45 n46 2.9767441860465116
r70 n29 n47 21.42608695652174
r71 n46 n47 4.9116279069767446
r72 n30 n48 246.40000000000001
r73 n47 n48 3.7209302325581395
r74 n31 n49 16.426666666666666
r75 n48 n49 4.7627906976744185
r76 n32 n50 246.40000000000001
r77 n49 n50 4.7627906976744185
r78 n33 n51 21.42608695652174
r79 n50 n51 3.7209302325581395
r80 n34 n52 49.280000000000001
r81 n51 n52 4.9116279069767446
r82 n35 n53 49.280000000000001
r83 n52 n53 2.9767441860465116
r84 n39 n54 296.32000000000005
r85 n40 n55 19.754666666666669
r86 n54 n55 4.129032258064516
r87 n41 n56 296.32000000000005
r88 n55 n56 4.129032258064516
r89 n48 n57 296.32000000000005
r90 n49 n58 19.754666666666669
r91 n57 n58 4.129032258064516
r92 n50 n59 296.32000000000005
r93 n58 n59 4.129032258064516
r94 n54 n60 317.44
r95 n55 n61 21.162666666666667
r96 n60 n61 4.129032258064516
r97 n56 n62 317.44
r98 n61 n62 4.129032258064516
r99 n57 n63 317.44
r100 n58 n64 21.162666666666667
r101 n63 n64 4.129032258064516
r102 n59 n65 317.44
r103 n64 n65 4.129032258064516
r104 n60 n66 317.44
r105 n61 n67 21.162666666666667
r106 n66 n67 4.129032258064516
r107 n62 n68 317.44
r108 n67 n68 4.129032258064516
r109 n63 n69 317.44
r110 n64 n70 21.162666666666667
r111 n69 n70 4.129032258064516
r112 n65 n71 317.44
r113 n70 n71 4.129032258064516
r114 n66 n72 317.44
r115 n67 n73 21.162666666666667
r116 n72 n73 4.129032258064516
r117 n68 n74 317.44
r118 n73 n74 4.129032258064516
r119 n69 n75 317.44
r120 n70 n76 21.162666666666667
r121 n75 n76 4.129032258064516
r122 n71 n77 317.44
r123 n76 n77 4.129032258064516
r124 n72 n78 317.44
r125 n73 n79 21.162666666666667
r126 n78 n79 4.129032258064516
r127 n74 n80 317.44
r128 n79 n80 4.129032258064516
r129 n75 n81 317.44
r130 n76 n82 21.162666666666667
r131 n81 n82 4.129032258064516
r132 n77 n83 317.44
r133 n82 n83 4.129032258064516
r134 n78 n84 317.44
r135 n79 n85 21.162666666666667
r136 n84 n85 4.129032258064516
r137 n80 n86 317.44
r138 n85 n86 4.129032258064516
r139 n81 n87 317.44
r140 n82 n88 21.162666666666667
r141 n87 n88 4.129032258064516
r142 n83 n89 317.44
r143 n88 n89 4.129032258064516
r144 n84 n90 316.80000000000001
r145 n85 n91 21.120000000000001
r146 n90 n91 4.1457489878542511
r147 n86 n92 316.80000000000001
r148 n91 n92 4.1457489878542511
r149 n87 n93 316.80000000000001
r150 n88 n94 21.120000000000001
r151 n93 n94 4.1457489878542511
r152 n89 n95 316.80000000000001
r153 n94 n95 4.1457489878542511
r154 n90 n96 316.80000000000001
r155 n91 n97 21.120000000000001
r156 n96 n97 4.129032258064516
r157 n92 n98 316.80000000000001
r158 n97 n98 4.129032258064516
r159 n93 n99 316.80000000000001
r160 n94 n100 21.120000000000001
r161 n99 n100 4.129032258064516
r162 n95 n101 316.80000000000001
r163 n100 n101 4.129032258064516
r164 n96 n102 317.44
r165 n97 n103 21.162666666666667
r166 n102 n103 4.129032258064516
r167 n98 n104 317.44
r168 n103 n104 4.129032258064516
r169 n99 n105 317.44
r170 n100 n106 21.162666666666667
r171 n105 n106 4.129032258064516
r172 n101 n107 317.44
r173 n106 n107 4.129032258064516
r174 n102 n108 317.44
r175 n103 n109 21.162666666666667
r176 n108 n109 4.129032258064516
r177 n104 n110 317.44
r178 n109 n110 4.129032258064516
r179 n105 n111 317.44
r180 n106 n112 21.162666666666667
r181 n111 n112 4.129032258064516
r182 n107 n113 317.44
r183 n112 n113 4.129032258064516
r184 n108 n114 317.44
r185 n109 n115 21.162666666666667
r186 n114 n115 4.129032258064516
r187 n110 n116 317.44
r188 n115 n116 4.129032258064516
r189 n111 n117 317.44
r190 n112 n118 21.162666666666667
r191 n117 n118 4.129032258064516
r192 n113 n119 317.44
r193 n118 n119 4.129032258064516
r194 n114 n120 317.44
r195 n115 n121 21.162666666666667
r196 n120 n121 4.129032258064516
r197 n116 n122 317.44
r198 n121 n122 4.129032258064516
r199 n117 n123 317.44
r200 n118 n124 21.162666666666667
r201 n123 n124 4.129032258064516
r202 n119 n125 317.44
r203 n124 n125 4.129032258064516
r204 n120 n126 317.44
r205 n121 n127 21.162666666666667
r206 n126 n127 4.129032258064516
r207 n122 n128 317.44
r208 n127 n128 4.129032258064516
r209 n123 n129 317.44
r210 n124 n130 21.162666666666667
r211 n129 n130 4.129032258064516
r212 n125 n131 317.44
r213 n130 n131 4.129032258064516
r214 n126 n132 317.44
r215 n127 n133 21.162666666666667
r216 n132 n133 4.129032258064516
r217 n128 n134 317.44
r218 n133 n134 4.129032258064516
r219 n129 n135 317.44
r220 n130 n136 21.162666666666667
r221 n135 n136 4.129032258064516
r222 n131 n137 317.44
r223 n136 n137 4.129032258064516
r224 n132 n138 317.44
r225 n133 n139 21.162666666666667
r226 n138 n139 4.129032258064516
r227 n134 n140 317.44
r228 n139 n140 4.129032258064516
r229 n135 n141 317.44
r230 n136 n142 21.162666666666667
r231 n141 n142 4.129032258064516
r232 n137 n143 317.44
r233 n142 n143 4.129032258064516
r234 n138 n144 317.44
r235 n139 n145 21.162666666666667
r236 n144 n145 4.129032258064516
r237 n140 n146 317.44
r238 n145 n146 4.129032258064516
r239 n141 n147 317.44
r240 n142 n148 21.162666666666667
r241 n147 n148 4.129032258064516
r242 n143 n149 317.44
r243 n148 n149 4.129032258064516
r244 n144 n150 317.44
r245 n145 n151 21.162666666666667
r246 n150 n151 4.129032258064516
r247 n146 n152 317.44
r248 n151 n152 4.129032258064516
r249 n147 n153 317.44
r250 n148 n154 21.162666666666667
r251 n153 n154 4.129032258064516
r252 n149 n155 317.44
r253 n154 n155 4.129032258064516
r254 n150 n156 316.80000000000001
r255 n151 n157 21.120000000000001
r256 n156 n157 4.1457489878542511
r257 n152 n158 316.80000000000001
r258 n157 n158 4.1457489878542511
r259 n153 n159 316.80000000000001
r260 n154 n160 21.120000000000001
r261 n159 n160 4.1457489878542511
r262 n155 n161 316.80000000000001
r263 n160 n161 4.1457489878542511
r264 n156 n162 316.80000000000001
r265 n157 n163 21.120000000000001
r266 n162 n163 4.129032258064516
r267 n158 n164 316.80000000000001
r268 n163 n164 4.129032258064516
r269 n159 n165 316.80000000000001
r270 n160 n166 21.120000000000001
r271 n165 n166 4.129032258064516
r272 n161 n167 316.80000000000001
r273 n166 n167 4.129032258064516
r274 n162 n168 317.44
r275 n163 n169 21.162666666666667
r276 n168 n169 4.129032258064516
r277 n164 n170 317.44
r278 n169 n170 4.129032258064516
r279 n165 n171 317.44
r280 n166 n172 21.162666666666667
r281 n171 n172 4.129032258064516
r282 n167 n173 317.44
r283 n172 n173 4.129032258064516
r284 n168 n174 317.44
r285 n169 n175 21.162666666666667
r286 n174 n175 4.129032258064516
r287 n170 n176 317.44
r288 n175 n176 4.129032258064516
r289 n171 n177 317.44
r290 n172 n178 21.162666666666667
r291 n177 n178 4.129032258064516
r292 n173 n179 317.44
r293 n178 n179 4.129032258064516
r294 n174 n180 317.44
r295 n175 n181 21.162666666666667
r296 n180 n181 4.129032258064516
r297 n176 n182 317.44
r298 n181 n182 4.129032258064516
r299 n177 n183 317.44
r300 n178 n184 21.162666666666667
r301 n183 n184 4.129032258064516
r302 n179 n185 317.44
r303 n184 n185 4.129032258064516
r304 n180 n186 317.44
r305 n181 n187 21.162666666666667
r306 n186 n187 4.129032258064516
r307 n182 n188 317.44
r308 n187 n188 4.129032258064516
r309 n183 n189 317.44
r310 n184 n190 21.162666666666667
r311 n189 n190 4.129032258064516
r312 n185 n191 317.44
r313 n190 n191 4.129032258064516
r314 n186 n192 317.44
r315 n187 n193 21.162666666666667
r316 n192 n193 4.129032258064516
r317 n188 n194 317.44
r318 n193 n194 4.129032258064516
r319 n189 n195 317.44
r320 n190 n196 21.162666666666667
r321 n195 n196 4.129032258064516
r322 n191 n197 317.44
r323 n196 n197 4.129032258064516
r324 n192 n198 317.44
r325 n193 n199 21.162666666666667
r326 n198 n199 4.129032258064516
r327 n194 n200 317.44
r328 n199 n200 4.129032258064516
r329 n195 n201 317.44
r330 n196 n202 21.162666666666667
r331 n201 n202 4.129032258064516
r332 n197 n203 317.44
r333 n202 n203 4.129032258064516
r334 n198 n204 317.44
r335 n199 n205 21.162666666666667
r336 n204 n205 4.129032258064516
r337 n200 n206 317.44
r338 n205 n206 4.129032258064516
r339 n201 n207 317.44
r340 n202 n208 21.162666666666667
r341 n207 n208 4.129032258064516
r342 n203 n209 317.44
r343 n208 n209 4.129032258064516
r344 n204 n210 317.44
r345 n205 n211 21.162666666666667
r346 n210 n211 4.129032258064516
r347 n206 n212 317.44
r348 n211 n212 4.129032258064516
r349 n207 n213 317.44
r350 n208 n214 21.162666666666667
r351 n213 n214 4.129032258064516
r352 n209 n215 317.44
r353 n214 n215 4.129032258064516
r354 n210 n216 317.44
r355 n211 n217 21.162666666666667
r356 n216 n217 4.129032258064516
r357 n212 n218 317.44
r358 n217 n218 4.129032258064516
r359 n213 n219 317.44
r360 n214 n220 21.162666666666667
r361 n219 n220 4.129032258064516
r362 n215 n221 317.44
r363 n220 n221 4.129032258064516
r364 n216 n222 317.44
r365 n217 n223 21.162666666666667
r366 n222 n223 4.129032258064516
r367 n218 n224 317.44
r368 n223 n224 4.129032258064516
r369 n219 n225 317.44
r370 n220 n226 21.162666666666667
r371 n225 n226 4.129032258064516
r372 n221 n227 317.44
r373 n226 n227 4.129032258064516
r374 n222 n228 317.44
r375 n223 n229 21.162666666666667
r376 n228 n229 4.129032258064516
r377 n224 n230 317.44
r378 n229 n230 4.129032258064516
r379 n225 n231 317.44
r380 n226 n232 21.162666666666667
r381 n231 n232 4.129032258064516
r382 n227 n233 317.44
r383 n232 n233 4.129032258064516
r384 n228 n234 316.80000000000001
r385 n229 n235 21.120000000000001
r386 n234 n235 4.1457489878542511
r387 n230 n236 316.80000000000001
r388 n235 n236 4.1457489878542511
r389 n231 n237 316.80000000000001
r390 n232 n238 21.120000000000001
r391 n237 n238 4.1457489878542511
r392 n233 n239 316.80000000000001
r393 n238 n239 4.1457489878542511
r394 n234 n240 316.80000000000001
r395 n235 n241 21.120000000000001
r396 n240 n241 4.129032258064516
r397 n236 n242 316.80000000000001
r398 n241 n242 4.129032258064516
r399 n237 n243 316.80000000000001
r400 n238 n244 21.120000000000001
r401 n243 n244 4.129032258064516
r402 n239 n245 316.80000000000001
r403 n244 n245 4.129032258064516
r404 n240 n246 317.44
r405 n241 n247 21.162666666666667
r406 n246 n247 4.129032258064516
r407 n242 n248 317.44
r408 n247 n248 4.129032258064516
r409 n243 n249 317.44
r410 n244 n250 21.162666666666667
r411 n249 n250 4.129032258064516
r412 n245 n251 317.44
r413 n250 n251 4.129032258064516
r414 n246 n252 317.44
r415 n247 n253 21.162666666666667
r416 n252 n253 4.129032258064516
r417 n248 n254 317.44
r418 n253 n254 4.129032258064516
r419 n249 n255 317.44
r420 n250 n256 21.162666666666667
r421 n255 n256 4.129032258064516
r422 n251 n257 317.44
r423 n256 n257 4.129032258064516
r424 n252 n258 317.44
r425 n253 n259 21.162666666666667
r426 n258 n259 4.129032258064516
r427 n254 n260 317.44
r428 n259 n260 4.129032258064516
r429 n255 n261 317.44
r430 n256 n262 21.162666666666667
r431 n261 n262 4.129032258064516
r432 n257 n263 317.44
r433 n262 n263 4.129032258064516
r434 n258 n264 317.44
r435 n259 n265 21.162666666666667
r436 n264 n265 4.129032258064516
r437 n260 n266 317.44
r438 n265 n266 4.129032258064516
r439 n261 n267 317.44
r440 n262 n268 21.162666666666667
r441 n267 n268 4.129032258064516
r442 n263 n269 317.44
r443 n268 n269 4.129032258064516
r444 n264 n270 317.44
r445 n265 n271 21.162666666666667
r446 n270 n271 4.129032258064516
r447 n266 n272 317.44
r448 n271 n272 4.129032258064516
r449 n267 n273 317.44
r450 n268 n274 21.162666666666667
r451 n273 n274 4.129032258064516
r452 n269 n275 317.44
r453 n274 n275 4.129032258064516
r454 n270 n276 317.44
r455 n271 n277 21.162666666666667
r456 n276 n277 4.129032258064516
r457 n272 n278 317.44
r458 n277 n278 4.129032258064516
r459 n273 n279 317.44
r460 n274 n280 21.162666666666667
r461 n279 n280 4.129032258064516
r462 n275 n281 317.44
r463 n280 n281 4.129032258064516
r464 n276 n282 317.44
r465 n277 n283 21.162666666666667
r466 n282 n283 4.129032258064516
r467 n278 n284 317.44
r468 n283 n284 4.129032258064516
r469 n279 n285 317.44
r470 n280 n286 21.162666666666667
r471 n285 n286 4.129032258064516
r472 n281 n287 317.44
r473 n286 n287 4.129032258064516
r474 n282 n288 317.44
r475 n283 n289 21.162666666666667
r476 n288 n289 4.129032258064516
r477 n284 n290 317.44
r478 n289 n290 4.129032258064516
r479 n285 n291 317.44
r480 n286 n292 21.162666666666667
r481 n291 n292 4.129032258064516
r482 n287 n293 317.44
r483 n292 n293 4.129032258064516
r484 n288 n294 317.44
r485 n289 n295 21.162666666666667
r486 n294 n295 4.129032258064516
r487 n290 n296 317.44
r488 n295 n296 4.129032258064516
r489 n291 n297 317.44
r490 n292 n298 21.162666666666667
r491 n297 n298 4.129032258064516
r492 n293 n299 317.44
r493 n298 n299 4.129032258064516
r494 n294 n300 316.80000000000001
r495 n295 n301 21.120000000000001
r496 n300 n301 4.1457489878542511
r497 n296 n302 316.80000000000001
r498 n301 n302 4.1457489878542511
r499 n297 n303 316.80000000000001
r500 n298 n304 21.120000000000001
r501 n303 n304 4.1457489878542511
r502 n299 n305 316.80000000000001
r503 n304 n305 4.1457489878542511
r504 n300 n306 316.80000000000001
r505 n301 n307 21.120000000000001
r506 n306 n307 4.129032258064516
r507 n302 n308 316.80000000000001
r508 n307 n308 4.129032258064516
r509 n303 n309 316.80000000000001
r510 n304 n310 21.120000000000001
r511 n309 n310 4.129032258064516
r512 n305 n311 316.80000000000001
r513 n310 n311 4.129032258064516
r514 n306 n312 317.44
r515 n307 n313 21.162666666666667
r516 n312 n313 4.129032258064516
r517 n308 n314 317.44
r518 n313 n314 4.129032258064516
r519 n309 n315 317.44
r520 n310 n316 21.162666666666667
r521 n315 n316 4.129032258064516
r522 n311 n317 317.44
r523 n316 n317 4.129032258064516
r524 n312 n318 317.44
r525 n313 n319 21.162666666666667
r526 n318 n319 4.129032258064516
r527 n314 n320 317.44
r528 n319 n320 4.129032258064516
r529 n315 n321 317.44
r530 n316 n322 21.162666666666667
r531 n321 n322 4.129032258064516
r532 n317 n323 317.44
r533 n322 n323 4.129032258064516
r534 n318 n324 317.44
r535 n319 n325 21.162666666666667
r536 n324 n325 4.129032258064516
r537 n320 n326 317.44
r538 n325 n326 4.129032258064516
r539 n321 n327 317.44
r540 n322 n328 21.162666666666667
r541 n327 n328 4.129032258064516
r542 n323 n329 317.44
r543 n328 n329 4.129032258064516
r544 n324 n330 317.44
r545 n325 n331 21.162666666666667
r546 n330 n331 4.129032258064516
r547 n326 n332 317.44
r548 n331 n332 4.129032258064516
r549 n327 n333 317.44
r550 n328 n334 21.162666666666667
r551 n333 n334 4.129032258064516
r552 n329 n335 317.44
r553 n334 n335 4.129032258064516
r554 n330 n336 317.44
r555 n331 n337 21.162666666666667
r556 n336 n337 4.129032258064516
r557 n332 n338 317.44
r558 n337 n338 4.129032258064516
r559 n333 n339 317.44
r560 n334 n340 21.162666666666667
r561 n339 n340 4.129032258064516
r562 n335 n341 317.44
r563 n340 n341 4.129032258064516
r564 n342 n343 2.9767441860465116
r565 n343 n344 4.9116279069767446
r566 n336 n345 296.32000000000005
r567 n344 n345 3.7209302325581395
r568 n337 n346 19.754666666666669
r569 n345 n346 4.7627906976744185
r570 n338 n347 296.32000000000005
r571 n346 n347 4.7627906976744185
r572 n347 n348 3.7209302325581395
r573 n348 n349 4.9116279069767446
r574 n349 n350 2.9767441860465116
r575 n351 n352 2.9767441860465116
r576 n352 n353 4.9116279069767446
r577 n339 n354 296.32000000000005
r578 n353 n354 3.7209302325581395
r579 n340 n355 19.754666666666669
r580 n354 n355 4.7627906976744185
r581 n341 n356 296.32000000000005
r582 n355 n356 4.7627906976744185
r583 n356 n357 3.7209302325581395
r584 n357 n358 4.9116279069767446
r585 n358 n359 2.9767441860465116
r586 n342 n360 49.280000000000001
r587 n343 n361 49.280000000000001
r588 n360 n361 3.7647058823529411
r589 n344 n362 21.42608695652174
r590 n361 n362 6.2117647058823531
r591 n345 n363 246.40000000000001
r592 n362 n363 4.7058823529411766
r593 n346 n364 16.426666666666666
r594 n363 n364 6.0235294117647058
r595 n347 n365 246.40000000000001
r596 n364 n365 6.0235294117647058
r597 n348 n366 21.42608695652174
r598 n365 n366 4.7058823529411766
r599 n349 n367 49.280000000000001
r600 n366 n367 6.2117647058823531
r601 n350 n368 49.280000000000001
r602 n367 n368 3.7647058823529411
r603 n351 n369 49.280000000000001
r604 n352 n370 49.280000000000001
r605 n369 n370 3.7647058823529411
r606 n353 n371 21.42608695652174
r607 n370 n371 6.2117647058823531
r608 n354 n372 246.40000000000001
r609 n371 n372 4.7058823529411766
r610 n355 n373 16.426666666666666
r611 n372 n373 6.0235294117647058
r612 n356 n374 246.40000000000001
r613 n373 n374 6.0235294117647058
r614 n357 n375 21.42608695652174
r615 n374 n375 4.7058823529411766
r616 n358 n376 49.280000000000001
r617 n375 n376 6.2117647058823531
r618 n359 n377 49.280000000000001
r619 n376 n377 3.7647058823529411
r620 n360 n378 49.280000000000001
r621 n361 n379 49.280000000000001
r622 n378 n379 2.9767441860465116
r623 n362 n380 21.42608695652174
r624 n379 n380 4.9116279069767446
r625 n363 n381 246.40000000000001
r626 n380 n381 3.7209302325581395
r627 n364 n382 16.426666666666666
r628 n381 n382 4.7627906976744185
r629 n365 n383 246.40000000000001
r630 n382 n383 4.7627906976744185
r631 n366 n384 21.42608695652174
r632 n383 n384 3.7209302325581395
r633 n367 n385 49.280000000000001
r634 n384 n385 4.9116279069767446
r635 n368 n386 49.280000000000001
r636 n385 n386 2.9767441860465116
r637 n369 n387 49.280000000000001
r638 n370 n388 49.280000000000001
r639 n387 n388 2.9767441860465116
r640 n371 n389 21.42608695652174
r641 n388 n389 4.9116279069767446
r642 n372 n390 246.40000000000001
r643 n389 n390 3.7209302325581395
r644 n373 n391 16.426666666666666
r645 n390 n391 4.7627906976744185
r646 n374 n392 246.40000000000001
r647 n391 n392 4.7627906976744185
r648 n375 n393 21.42608695652174
r649 n392 n393 3.7209302325581395
r650 n376 n394 49.280000000000001
r651 n393 n394 4.9116279069767446
r652 n377 n395 49.280000000000001
r653 n394 n395 2.9767441860465116
r654 n396 n397 208
r655 n397 n398 198.40000000000001
r656 n398 n399 208
r657 n399 n400 185.59999999999999
r658 n400 n401 89.599999999999994
r659 n401 n402 44.799999999999997
r660 n402 n403 38.399999999999999
r661 n403 n404 108.8
r662 n404 n405 108.8
r663 n405 n406 121.59999999999999
r664 n406 n407 121.59999999999999
r665 n407 n408 48
r666 n408 n409 80
r667 n409 n410 60.799999999999997
r668 n410 n411 28.800000000000001
r669 n411 n412 19.199999999999999
r670 n412 n413 41.600000000000001
r671 n413 n414 96
r672 n414 n415 73.599999999999994
r673 n415 n416 12.800000000000001
r674 n416 n417 35.200000000000003
r675 n417 n418 67.200000000000003
r676 n418 n419 67.200000000000003
r677 n419 n420 35.200000000000003
r678 n420 n421 12.800000000000001
r679 n421 n422 73.599999999999994
r680 n422 n423 115.2
r681 n423 n424 54.399999999999999
r682 n424 n425 108.8
r683 n425 n426 108.8
r684 n426 n427 44.799999999999997
r685 n427 n428 51.200000000000003
r686 n428 n429 76.799999999999997
r687 n429 n430 172.80000000000001
r688 n430 n431 124.8
r689 n431 n432 48
r690 n432 n433 54.399999999999999
r691 n433 n434 32
r692 n434 n435 19.199999999999999
r693 n435 n436 16
r694 n436 n437 32
r695 n437 n438 96
r696 n438 n439 76.799999999999997
r697 n439 n440 16
r698 n440 n441 19.199999999999999
r699 n441 n442 22.399999999999999
r700 n442 n443 22.399999999999999
r701 n443 n444 41.600000000000001
r702 n444 n445 188.80000000000001
r703 n445 n446 265.60000000000002
r704 n447 n448 204.80000000000001
r705 n448 n449 192
r706 n449 n450 204.80000000000001
r707 n450 n451 185.59999999999999
r708 n451 n452 89.599999999999994
r709 n452 n453 44.799999999999997
r710 n453 n454 38.399999999999999
r711 n454 n455 108.8
r712 n455 n456 108.8
r713 n456 n457 121.59999999999999
r714 n457 n458 121.59999999999999
r715 n458 n459 108.8
r716 n459 n460 108.8
r717 n460 n461 121.59999999999999
r718 n461 n462 121.59999999999999
r719 n462 n463 108.8
r720 n463 n464 108.8
r721 n464 n465 121.59999999999999
r722 n465 n466 121.59999999999999
r723 n466 n467 108.8
r724 n467 n468 108.8
r725 n468 n469 121.59999999999999
r726 n469 n470 121.59999999999999
r727 n470 n471 108.8
r728 n471 n472 108.8
r729 n472 n473 121.59999999999999
r730 n473 n474 121.59999999999999
r731 n474 n475 108.8
r732 n475 n476 108.8
r733 n476 n477 121.59999999999999
r734 n477 n478 121.59999999999999
r735 n478 n479 108.8
r736 n479 n480 108.8
r737 n480 n481 121.59999999999999
r738 n481 n482 121.59999999999999
r739 n482 n483 108.8
r740 n483 n484 108.8
r741 n484 n485 54.399999999999999
r742 n485 n486 86.400000000000006
r743 n486 n487 67.200000000000003
r744 n487 n488 35.200000000000003
r745 n488 n489 12.800000000000001
r746 n489 n490 32
r747 n490 n491 96
r748 n491 n492 73.599999999999994
r749 n492 n493 6.4000000000000004
r750 n493 n494 6.4000000000000004
r751 n494 n495 35.200000000000003
r752 n495 n496 70.400000000000006
r753 n496 n497 64
r754 n497 n498 32
r755 n498 n499 16
r756 n499 n500 16
r757 n500 n501 25.600000000000001
r758 n501 n502 57.600000000000001
r759 n502 n503 83.200000000000003
r760 n503 n504 51.200000000000003
r761 n504 n505 121.59999999999999
r762 n505 n506 121.59999999999999
r763 n506 n507 108.8
r764 n507 n508 108.8
r765 n508 n509 121.59999999999999
r766 n509 n510 121.59999999999999
r767 n510 n511 108.8
r768 n511 n512 108.8
r769 n512 n513 121.59999999999999
r770 n513 n514 121.59999999999999
r771 n514 n515 108.8
r772 n515 n516 108.8
r773 n516 n517 121.59999999999999
r774 n517 n518 121.59999999999999
r775 n518 n519 108.8
r776 n519 n520 108.8
r777 n520 n521 121.59999999999999
r778 n521 n522 121.59999999999999
r779 n522 n523 108.8
r780 n523 n524 108.8
r781 n524 n525 121.59999999999999
r782 n525 n526 121.59999999999999
r783 n526 n527 108.8
r784 n527 n528 108.8
r785 n528 n529 121.59999999999999
r786 n529 n530 121.59999999999999
r787 n530 n531 108.8
r788 n531 n532 108.8
r789 n532 n533 44.799999999999997
r790 n533 n534 51.200000000000003
r791 n534 n535 76.799999999999997
r792 n535 n536 172.80000000000001
r793 n536 n537 115.2
r794 n537 n538 38.399999999999999
r795 n538 n539 54.399999999999999
r796 n539 n540 32
r797 n540 n541 19.199999999999999
r798 n541 n542 16
r799 n542 n543 41.600000000000001
r800 n543 n544 96
r801 n544 n545 67.200000000000003
r802 n545 n546 16
r803 n546 n547 19.199999999999999
r804 n547 n548 32
r805 n548 n549 54.399999999999999
r806 n549 n550 188.80000000000001
r807 n550 n551 265.60000000000002
r808 n396 n552 6.0235294117647058
r809 n397 n553 6.6064516129032258
r810 n552 n553 13.866666666666667
r811 n398 n554 6.6064516129032258
r812 n553 n554 13.226666666666667
r813 n399 n555 6.0235294117647058
r814 n554 n555 13.866666666666667
r815 n400 n556 8.5333333333333332
r816 n555 n556 12.373333333333333
r817 n401 n557 51.200000000000003
r818 n556 n557 5.9733333333333336
r819 n402 n558 20.48
r820 n557 n558 2.9866666666666668
r821 n403 n559 102.40000000000001
r822 n558 n559 2.5600000000000001
r823 n404 n560 6.4000000000000004
r824 n559 n560 7.253333333333333
r825 n405 n561 102.40000000000001
r826 n560 n561 7.253333333333333
r827 n406 n562 5.6888888888888891
r828 n561 n562 8.1066666666666674
r829 n407 n563 102.40000000000001
r830 n562 n563 8.1066666666666674
r831 n408 n564 15.753846153846155
r832 n563 n564 3.2000000000000002
r833 n409 n565 17.066666666666666
r834 n564 n565 5.333333333333333
r835 n410 n566 29.257142857142856
r836 n565 n566 4.0533333333333337
r837 n411 n567 102.40000000000001
r838 n566 n567 1.9199999999999999
r839 n412 n568 51.200000000000003
r840 n567 n568 1.28
r841 n413 n569 22.755555555555556
r842 n568 n569 2.7733333333333334
r843 n414 n570 9.7523809523809533
r844 n569 n570 6.4000000000000004
r845 n415 n571 102.40000000000001
r846 n570 n571 4.9066666666666663
r847 n416 n572 102.40000000000001
r848 n571 n572 0.85333333333333339
r849 n417 n573 22.755555555555556
r850 n572 n573 2.3466666666666667
r851 n418 n574 17.066666666666666
r852 n573 n574 4.4800000000000004
r853 n419 n575 22.755555555555556
r854 n574 n575 4.4800000000000004
r855 n420 n576 102.40000000000001
r856 n575 n576 2.3466666666666667
r857 n421 n577 102.40000000000001
r858 n576 n577 0.85333333333333339
r859 n422 n578 9.7523809523809533
r860 n577 n578 4.9066666666666663
r861 n423 n579 13.653333333333334
r862 n578 n579 7.6799999999999997
r863 n424 n580 102.40000000000001
r864 n579 n580 3.6266666666666665
r865 n425 n581 6.4000000000000004
r866 n580 n581 7.253333333333333
r867 n426 n582 102.40000000000001
r868 n581 n582 7.253333333333333
r869 n427 n583 17.066666666666666
r870 n582 n583 2.9866666666666668
r871 n428 n584 51.200000000000003
r872 n583 n584 3.4133333333333336
r873 n429 n585 10.24
r874 n584 n585 5.1200000000000001
r875 n430 n586 6.0235294117647058
r876 n585 n586 11.52
r877 n431 n587 40.960000000000001
r878 n586 n587 8.3200000000000003
r879 n432 n588 20.48
r880 n587 n588 3.2000000000000002
r881 n433 n589 29.257142857142856
r882 n588 n589 3.6266666666666665
r883 n434 n590 68.266666666666666
r884 n589 n590 2.1333333333333333
r885 n435 n591 68.266666666666666
r886 n590 n591 1.28
r887 n436 n592 102.40000000000001
r888 n591 n592 1.0666666666666667
r889 n437 n593 25.600000000000001
r890 n592 n593 2.1333333333333333
r891 n438 n594 9.3090909090909086
r892 n593 n594 6.4000000000000004
r893 n439 n595 102.40000000000001
r894 n594 n595 5.1200000000000001
r895 n440 n596 68.266666666666666
r896 n595 n596 1.0666666666666667
r897 n441 n597 68.266666666666666
r898 n596 n597 1.28
r899 n442 n598 51.200000000000003
r900 n597 n598 1.4933333333333334
r901 n443 n599 68.266666666666666
r902 n598 n599 1.4933333333333334
r903 n444 n600 20.48
r904 n599 n600 2.7733333333333334
r905 n445 n601 4.1795918367346943
r906 n600 n601 12.586666666666666
r907 n446 n602 6.0235294117647058
r908 n601 n602 17.706666666666667
r909 n447 n603 6.0235294117647058
r910 n448 n604 6.8266666666666671
r911 n603 n604 13.653333333333334
r912 n449 n605 6.8266666666666671
r913 n604 n605 12.800000000000001
r914 n450 n606 6.0235294117647058
r915 n605 n606 13.653333333333334
r916 n451 n607 8.5333333333333332
r917 n606 n607 12.373333333333333
r918 n452 n608 51.200000000000003
r919 n607 n608 5.9733333333333336
r920 n453 n609 20.48
r921 n608 n609 2.9866666666666668
r922 n454 n610 102.40000000000001
r923 n609 n610 2.5600000000000001
r924 n455 n611 6.4000000000000004
r925 n610 n611 7.253333333333333
r926 n456 n612 102.40000000000001
r927 n611 n612 7.253333333333333
r928 n457 n613 5.6888888888888891
r929 n612 n613 8.1066666666666674
r930 n458 n614 102.40000000000001
r931 n613 n614 8.1066666666666674
r932 n459 n615 6.4000000000000004
r933 n614 n615 7.253333333333333
r934 n460 n616 102.40000000000001
r935 n615 n616 7.253333333333333
r936 n461 n617 5.6888888888888891
r937 n616 n617 8.1066666666666674
r938 n462 n618 102.40000000000001
r939 n617 n618 8.1066666666666674
r940 n463 n619 6.4000000000000004
r941 n618 n619 7.253333333333333
r942 n464 n620 102.40000000000001
r943 n619 n620 7.253333333333333
r944 n465 n621 5.6888888888888891
r945 n620 n621 8.1066666666666674
r946 n466 n622 102.40000000000001
r947 n621 n622 8.1066666666666674
r948 n467 n623 6.4000000000000004
r949 n622 n623 7.253333333333333
r950 n468 n624 102.40000000000001
r951 n623 n624 7.253333333333333
r952 n469 n625 5.6888888888888891
r953 n624 n625 8.1066666666666674
r954 n470 n626 102.40000000000001
r955 n625 n626 8.1066666666666674
r956 n471 n627 6.4000000000000004
r957 n626 n627 7.253333333333333
r958 n472 n628 102.40000000000001
r959 n627 n628 7.253333333333333
r960 n473 n629 5.6888888888888891
r961 n628 n629 8.1066666666666674
r962 n474 n630 102.40000000000001
r963 n629 n630 8.1066666666666674
r964 n475 n631 6.4000000000000004
r965 n630 n631 7.253333333333333
r966 n476 n632 102.40000000000001
r967 n631 n632 7.253333333333333
r968 n477 n633 5.6888888888888891
r969 n632 n633 8.1066666666666674
r970 n478 n634 102.40000000000001
r971 n633 n634 8.1066666666666674
r972 n479 n635 6.4000000000000004
r973 n634 n635 7.253333333333333
r974 n480 n636 102.40000000000001
r975 n635 n636 7.253333333333333
r976 n481 n637 5.6888888888888891
r977 n636 n637 8.1066666666666674
r978 n482 n638 102.40000000000001
r979 n637 n638 8.1066666666666674
r980 n483 n639 6.4000000000000004
r981 n638 n639 7.253333333333333
r982 n484 n640 102.40000000000001
r983 n639 n640 7.253333333333333
r984 n485 n641 13.653333333333334
r985 n640 n641 3.6266666666666665
r986 n486 n642 17.066666666666666
r987 n641 n642 5.7599999999999998
r988 n487 n643 22.755555555555556
r989 n642 n643 4.4800000000000004
r990 n488 n644 102.40000000000001
r991 n643 n644 2.3466666666666667
r992 n489 n645 102.40000000000001
r993 n644 n645 0.85333333333333339
r994 n490 n646 25.600000000000001
r995 n645 n646 2.1333333333333333
r996 n491 n647 9.3090909090909086
r997 n646 n647 6.4000000000000004
r998 n492 n648 204.80000000000001
r999 n647 n648 4.9066666666666663
r1000 n493 n649 204.80000000000001
r1001 n648 n649 0.42666666666666669
r1002 n494 n650 204.80000000000001
r1003 n649 n650 0.42666666666666669
r1004 n495 n651 20.48
r1005 n650 n651 2.3466666666666667
r1006 n496 n652 17.066666666666666
r1007 n651 n652 4.6933333333333334
r1008 n497 n653 25.600000000000001
r1009 n652 n653 4.2666666666666666
r1010 n498 n654 102.40000000000001
r1011 n653 n654 2.1333333333333333
r1012 n499 n655 68.266666666666666
r1013 n654 n655 1.0666666666666667
r1014 n500 n656 102.40000000000001
r1015 n655 n656 1.0666666666666667
r1016 n501 n657 34.133333333333333
r1017 n656 n657 1.7066666666666668
r1018 n502 n658 17.066666666666666
r1019 n657 n658 3.8399999999999999
r1020 n503 n659 14.628571428571428
r1021 n658 n659 5.5466666666666669
r1022 n504 n660 102.40000000000001
r1023 n659 n660 3.4133333333333336
r1024 n505 n661 5.6888888888888891
r1025 n660 n661 8.1066666666666674
r1026 n506 n662 102.40000000000001
r1027 n661 n662 8.1066666666666674
r1028 n507 n663 6.4000000000000004
r1029 n662 n663 7.253333333333333
r1030 n508 n664 102.40000000000001
r1031 n663 n664 7.253333333333333
r1032 n509 n665 5.6888888888888891
r1033 n664 n665 8.1066666666666674
r1034 n510 n666 102.40000000000001
r1035 n665 n666 8.1066666666666674
r1036 n511 n667 6.4000000000000004
r1037 n666 n667 7.253333333333333
r1038 n512 n668 102.40000000000001
r1039 n667 n668 7.253333333333333
r1040 n513 n669 5.6888888888888891
r1041 n668 n669 8.1066666666666674
r1042 n514 n670 102.40000000000001
r1043 n669 n670 8.1066666666666674
r1044 n515 n671 6.4000000000000004
r1045 n670 n671 7.253333333333333
r1046 n516 n672 102.40000000000001
r1047 n671 n672 7.253333333333333
r1048 n517 n673 5.6888888888888891
r1049 n672 n673 8.1066666666666674
r1050 n518 n674 102.40000000000001
r1051 n673 n674 8.1066666666666674
r1052 n519 n675 6.4000000000000004
r1053 n674 n675 7.253333333333333
r1054 n520 n676 102.40000000000001
r1055 n675 n676 7.253333333333333
r1056 n521 n677 5.6888888888888891
r1057 n676 n677 8.1066666666666674
r1058 n522 n678 102.40000000000001
r1059 n677 n678 8.1066666666666674
r1060 n523 n679 6.4000000000000004
r1061 n678 n679 7.253333333333333
r1062 n524 n680 102.40000000000001
r1063 n679 n680 7.253333333333333
r1064 n525 n681 5.6888888888888891
r1065 n680 n681 8.1066666666666674
r1066 n526 n682 102.40000000000001
r1067 n681 n682 8.1066666666666674
r1068 n527 n683 6.4000000000000004
r1069 n682 n683 7.253333333333333
r1070 n528 n684 102.40000000000001
r1071 n683 n684 7.253333333333333
r1072 n529 n685 5.6888888888888891
r1073 n684 n685 8.1066666666666674
r1074 n530 n686 102.40000000000001
r1075 n685 n686 8.1066666666666674
r1076 n531 n687 6.4000000000000004
r1077 n686 n687 7.253333333333333
r1078 n532 n688 102.40000000000001
r1079 n687 n688 7.253333333333333
r1080 n533 n689 17.066666666666666
r1081 n688 n689 2.9866666666666668
r1082 n534 n690 51.200000000000003
r1083 n689 n690 3.4133333333333336
r1084 n535 n691 10.24
r1085 n690 n691 5.1200000000000001
r1086 n536 n692 6.0235294117647058
r1087 n691 n692 11.52
r1088 n537 n693 102.40000000000001
r1089 n692 n693 7.6799999999999997
r1090 n538 n694 20.48
r1091 n693 n694 2.5600000000000001
r1092 n539 n695 29.257142857142856
r1093 n694 n695 3.6266666666666665
r1094 n540 n696 68.266666666666666
r1095 n695 n696 2.1333333333333333
r1096 n541 n697 68.266666666666666
r1097 n696 n697 1.28
r1098 n542 n698 102.40000000000001
r1099 n697 n698 1.0666666666666667
r1100 n543 n699 18.618181818181817
r1101 n698 n699 2.7733333333333334
r1102 n544 n700 10.778947368421052
r1103 n699 n700 6.4000000000000004
r1104 n545 n701 102.40000000000001
r1105 n700 n701 4.4800000000000004
r1106 n546 n702 68.266666666666666
r1107 n701 n702 1.0666666666666667
r1108 n547 n703 68.266666666666666
r1109 n702 n703 1.28
r1110 n548 n704 29.257142857142856
r1111 n703 n704 2.1333333333333333
r1112 n549 n705 20.48
r1113 n704 n705 3.6266666666666665
r1114 n550 n706 4.1795918367346943
r1115 n705 n706 12.586666666666666
r1116 n551 n707 6.0235294117647058
r1117 n706 n707 17.706666666666667
r1118 n552 n708 6.0235294117647058
r1119 n553 n709 6.6064516129032258
r1120 n708 n709 208
r1121 n554 n710 6.6064516129032258
r1122 n709 n710 198.40000000000001
r1123 n555 n711 6.0235294117647058
r1124 n710 n711 208
r1125 n556 n712 8.5333333333333332
r1126 n711 n712 185.59999999999999
r1127 n557 n713 51.200000000000003
r1128 n712 n713 89.599999999999994
r1129 n558 n714 20.48
r1130 n713 n714 44.799999999999997
r1131 n559 n715 102.40000000000001
r1132 n714 n715 38.399999999999999
r1133 n560 n716 6.4000000000000004
r1134 n715 n716 108.8
r1135 n561 n717 102.40000000000001
r1136 n716 n717 108.8
r1137 n562 n718 5.6888888888888891
r1138 n717 n718 121.59999999999999
r1139 n563 n719 102.40000000000001
r1140 n718 n719 121.59999999999999
r1141 n564 n720 15.753846153846155
r1142 n719 n720 48
r1143 n565 n721 17.066666666666666
r1144 n720 n721 80
r1145 n566 n722 29.257142857142856
r1146 n721 n722 60.799999999999997
r1147 n567 n723 102.40000000000001
r1148 n722 n723 28.800000000000001
r1149 n568 n724 51.200000000000003
r1150 n723 n724 19.199999999999999
r1151 n569 n725 22.755555555555556
r1152 n724 n725 41.600000000000001
r1153 n570 n726 9.7523809523809533
r1154 n725 n726 96
r1155 n571 n727 102.40000000000001
r1156 n726 n727 73.599999999999994
r1157 n572 n728 102.40000000000001
r1158 n727 n728 12.800000000000001
r1159 n573 n729 22.755555555555556
r1160 n728 n729 35.200000000000003
r1161 n574 n730 17.066666666666666
r1162 n729 n730 67.200000000000003
r1163 n575 n731 22.755555555555556
r1164 n730 n731 67.200000000000003
r1165 n576 n732 102.40000000000001
r1166 n731 n732 35.200000000000003
r1167 n577 n733 102.40000000000001
r1168 n732 n733 12.800000000000001
r1169 n578 n734 9.7523809523809533
r1170 n733 n734 73.599999999999994
r1171 n579 n735 13.653333333333334
r1172 n734 n735 115.2
r1173 n580 n736 102.40000000000001
r1174 n735 n736 54.399999999999999
r1175 n581 n737 6.4000000000000004
r1176 n736 n737 108.8
r1177 n582 n738 102.40000000000001
r1178 n737 n738 108.8
r1179 n583 n739 17.066666666666666
r1180 n738 n739 44.799999999999997
r1181 n584 n740 51.200000000000003
r1182 n739 n740 51.200000000000003
r1183 n585 n741 10.24
r1184 n740 n741 76.799999999999997
r1185 n586 n742 6.0235294117647058
r1186 n741 n742 172.80000000000001
r1187 n587 n743 40.960000000000001
r1188 n742 n743 124.8
r1189 n588 n744 20.48
r1190 n743 n744 48
r1191 n589 n745 29.257142857142856
r1192 n744 n745 54.399999999999999
r1193 n590 n746 68.266666666666666
r1194 n745 n746 32
r1195 n591 n747 68.266666666666666
r1196 n746 n747 19.199999999999999
r1197 n592 n748 102.40000000000001
r1198 n747 n748 16
r1199 n593 n749 25.600000000000001
r1200 n748 n749 32
r1201 n594 n750 9.3090909090909086
r1202 n749 n750 96
r1203 n595 n751 102.40000000000001
r1204 n750 n751 76.799999999999997
r1205 n596 n752 68.266666666666666
r1206 n751 n752 16
r1207 n597 n753 68.266666666666666
r1208 n752 n753 19.199999999999999
r1209 n598 n754 51.200000000000003
r1210 n753 n754 22.399999999999999
r1211 n599 n755 68.266666666666666
r1212 n754 n755 22.399999999999999
r1213 n600 n756 20.48
r1214 n755 n756 41.600000000000001
r1215 n601 n757 4.1795918367346943
r1216 n756 n757 188.80000000000001
r1217 n602 n758 6.0235294117647058
r1218 n757 n758 265.60000000000002
r1219 n603 n759 6.0235294117647058
r1220 n604 n760 6.8266666666666671
r1221 n759 n760 204.80000000000001
r1222 n605 n761 6.8266666666666671
r1223 n760 n761 192
r1224 n606 n762 6.0235294117647058
r1225 n761 n762 204.80000000000001
r1226 n607 n763 8.5333333333333332
r1227 n762 n763 185.59999999999999
r1228 n608 n764 51.200000000000003
r1229 n763 n764 89.599999999999994
r1230 n609 n765 20.48
r1231 n764 n765 44.799999999999997
r1232 n610 n766 102.40000000000001
r1233 n765 n766 38.399999999999999
r1234 n611 n767 6.4000000000000004
r1235 n766 n767 108.8
r1236 n612 n768 102.40000000000001
r1237 n767 n768 108.8
r1238 n613 n769 5.6888888888888891
r1239 n768 n769 121.59999999999999
r1240 n614 n770 102.40000000000001
r1241 n769 n770 121.59999999999999
r1242 n615 n771 6.4000000000000004
r1243 n770 n771 108.8
r1244 n616 n772 102.40000000000001
r1245 n771 n772 108.8
r1246 n617 n773 5.6888888888888891
r1247 n772 n773 121.59999999999999
r1248 n618 n774 102.40000000000001
r1249 n773 n774 121.59999999999999
r1250 n619 n775 6.4000000000000004
r1251 n774 n775 108.8
r1252 n620 n776 102.40000000000001
r1253 n775 n776 108.8
r1254 n621 n777 5.6888888888888891
r1255 n776 n777 121.59999999999999
r1256 n622 n778 102.40000000000001
r1257 n777 n778 121.59999999999999
r1258 n623 n779 6.4000000000000004
r1259 n778 n779 108.8
r1260 n624 n780 102.40000000000001
r1261 n779 n780 108.8
r1262 n625 n781 5.6888888888888891
r1263 n780 n781 121.59999999999999
r1264 n626 n782 102.40000000000001
r1265 n781 n782 121.59999999999999
r1266 n627 n783 6.4000000000000004
r1267 n782 n783 108.8
r1268 n628 n784 102.40000000000001
r1269 n783 n784 108.8
r1270 n629 n785 5.6888888888888891
r1271 n784 n785 121.59999999999999
r1272 n630 n786 102.40000000000001
r1273 n785 n786 121.59999999999999
r1274 n631 n787 6.4000000000000004
r1275 n786 n787 108.8
r1276 n632 n788 102.40000000000001
r1277 n787 n788 108.8
r1278 n633 n789 5.6888888888888891
r1279 n788 n789 121.59999999999999
r1280 n634 n790 102.40000000000001
r1281 n789 n790 121.59999999999999
r1282 n635 n791 6.4000000000000004
r1283 n790 n791 108.8
r1284 n636 n792 102.40000000000001
r1285 n791 n792 108.8
r1286 n637 n793 5.6888888888888891
r1287 n792 n793 121.59999999999999
r1288 n638 n794 102.40000000000001
r1289 n793 n794 121.59999999999999
r1290 n639 n795 6.4000000000000004
r1291 n794 n795 108.8
r1292 n640 n796 102.40000000000001
r1293 n795 n796 108.8
r1294 n641 n797 13.653333333333334
r1295 n796 n797 54.399999999999999
r1296 n642 n798 17.066666666666666
r1297 n797 n798 86.400000000000006
r1298 n643 n799 22.755555555555556
r1299 n798 n799 67.200000000000003
r1300 n644 n800 102.40000000000001
r1301 n799 n800 35.200000000000003
r1302 n645 n801 102.40000000000001
r1303 n800 n801 12.800000000000001
r1304 n646 n802 25.600000000000001
r1305 n801 n802 32
r1306 n647 n803 9.3090909090909086
r1307 n802 n803 96
r1308 n648 n804 204.80000000000001
r1309 n803 n804 73.599999999999994
r1310 n649 n805 204.80000000000001
r1311 n804 n805 6.4000000000000004
r1312 n650 n806 204.80000000000001
r1313 n805 n806 6.4000000000000004
r1314 n651 n807 20.48
r1315 n806 n807 35.200000000000003
r1316 n652 n808 17.066666666666666
r1317 n807 n808 70.400000000000006
r1318 n653 n809 25.600000000000001
r1319 n808 n809 64
r1320 n654 n810 102.40000000000001
r1321 n809 n810 32
r1322 n655 n811 68.266666666666666
r1323 n810 n811 16
r1324 n656 n812 102.40000000000001
r1325 n811 n812 16
r1326 n657 n813 34.133333333333333
r1327 n812 n813 25.600000000000001
r1328 n658 n814 17.066666666666666
r1329 n813 n814 57.600000000000001
r1330 n659 n815 14.628571428571428
r1331 n814 n815 83.200000000000003
r1332 n660 n816 102.40000000000001
r1333 n815 n816 51.200000000000003
r1334 n661 n817 5.6888888888888891
r1335 n816 n817 121.59999999999999
r1336 n662 n818 102.40000000000001
r1337 n817 n818 121.59999999999999
r1338 n663 n819 6.4000000000000004
r1339 n818 n819 108.8
r1340 n664 n820 102.40000000000001
r1341 n819 n820 108.8
r1342 n665 n821 5.6888888888888891
r1343 n820 n821 121.59999999999999
r1344 n666 n822 102.40000000000001
r1345 n821 n822 121.59999999999999
r1346 n667 n823 6.4000000000000004
r1347 n822 n823 108.8
r1348 n668 n824 102.40000000000001
r1349 n823 n824 108.8
r1350 n669 n825 5.6888888888888891
r1351 n824 n825 121.59999999999999
r1352 n670 n826 102.40000000000001
r1353 n825 n826 121.59999999999999
r1354 n671 n827 6.4000000000000004
r1355 n826 n827 108.8
r1356 n672 n828 102.40000000000001
r1357 n827 n828 108.8
r1358 n673 n829 5.6888888888888891
r1359 n828 n829 121.59999999999999
r1360 n674 n830 102.40000000000001
r1361 n829 n830 121.59999999999999
r1362 n675 n831 6.4000000000000004
r1363 n830 n831 108.8
r1364 n676 n832 102.40000000000001
r1365 n831 n832 108.8
r1366 n677 n833 5.6888888888888891
r1367 n832 n833 121.59999999999999
r1368 n678 n834 102.40000000000001
r1369 n833 n834 121.59999999999999
r1370 n679 n835 6.4000000000000004
r1371 n834 n835 108.8
r1372 n680 n836 102.40000000000001
r1373 n835 n836 108.8
r1374 n681 n837 5.6888888888888891
r1375 n836 n837 121.59999999999999
r1376 n682 n838 102.40000000000001
r1377 n837 n838 121.59999999999999
r1378 n683 n839 6.4000000000000004
r1379 n838 n839 108.8
r1380 n684 n840 102.40000000000001
r1381 n839 n840 108.8
r1382 n685 n841 5.6888888888888891
r1383 n840 n841 121.59999999999999
r1384 n686 n842 102.40000000000001
r1385 n841 n842 121.59999999999999
r1386 n687 n843 6.4000000000000004
r1387 n842 n843 108.8
r1388 n688 n844 102.40000000000001
r1389 n843 n844 108.8
r1390 n689 n845 17.066666666666666
r1391 n844 n845 44.799999999999997
r1392 n690 n846 51.200000000000003
r1393 n845 n846 51.200000000000003
r1394 n691 n847 10.24
r1395 n846 n847 76.799999999999997
r1396 n692 n848 6.0235294117647058
r1397 n847 n848 172.80000000000001
r1398 n693 n849 102.40000000000001
r1399 n848 n849 115.2
r1400 n694 n850 20.48
r1401 n849 n850 38.399999999999999
r1402 n695 n851 29.257142857142856
r1403 n850 n851 54.399999999999999
r1404 n696 n852 68.266666666666666
r1405 n851 n852 32
r1406 n697 n853 68.266666666666666
r1407 n852 n853 19.199999999999999
r1408 n698 n854 102.40000000000001
r1409 n853 n854 16
r1410 n699 n855 18.618181818181817
r1411 n854 n855 41.600000000000001
r1412 n700 n856 10.778947368421052
r1413 n855 n856 96
r1414 n701 n857 102.40000000000001
r1415 n856 n857 67.200000000000003
r1416 n702 n858 68.266666666666666
r1417 n857 n858 16
r1418 n703 n859 68.266666666666666
r1419 n858 n859 19.199999999999999
r1420 n704 n860 29.257142857142856
r1421 n859 n860 32
r1422 n705 n861 20.48
r1423 n860 n861 54.399999999999999
r1424 n706 n862 4.1795918367346943
r1425 n861 n862 188.80000000000001
r1426 n707 n863 6.0235294117647058
r1427 n862 n863 265.60000000000002
r1428 n708 n864 2.447058823529412
r1429 n758 n865 2.447058823529412
r1430 n759 n866 2.447058823529412
r1431 n863 n867 2.447058823529412
r1432 n864 n868 2.447058823529412
r1433 n865 n869 2.447058823529412
r1434 n866 n870 2.447058823529412
r1435 n867 n871 2.447058823529412
r1436 n868 n872 6.2117647058823531
r1437 n869 n873 6.2117647058823531
r1438 n870 n874 6.2117647058823531
r1439 n871 n875 6.2117647058823531
r1440 n872 n876 11.670588235294117
r1441 n873 n877 11.670588235294117
r1442 n874 n878 11.670588235294117
r1443 n875 n879 11.670588235294117
r1444 n876 n880 8.4705882352941178
r1445 n877 n881 8.4705882352941178
r1446 n878 n882 8.4705882352941178
r1447 n879 n883 8.4705882352941178
r1448 n880 n884 3.0117647058823529
r1449 n881 n885 3.0117647058823529
r1450 n882 n886 3.0117647058823529
r1451 n883 n887 3.0117647058823529
r1452 n884 n888 1.3176470588235294
r1453 n885 n889 1.3176470588235294
r1454 n886 n890 1.3176470588235294
r1455 n887 n891 1.3176470588235294
r1456 n888 n892 2.0705882352941178
r1457 n889 n893 2.0705882352941178
r1458 n890 n894 2.0705882352941178
r1459 n891 n895 2.0705882352941178
r1460 n892 n896 1.5058823529411764
r1461 n897 n898 44.799999999999997
r1462 n898 n899 38.399999999999999
r1463 n899 n900 108.8
r1464 n900 n901 108.8
r1465 n901 n902 121.59999999999999
r1466 n902 n903 121.59999999999999
r1467 n903 n904 48
r1468 n904 n905 80
r1469 n905 n906 60.799999999999997
r1470 n906 n907 28.800000000000001
r1471 n907 n908 19.199999999999999
r1472 n908 n909 41.600000000000001
r1473 n909 n910 96
r1474 n910 n911 73.599999999999994
r1475 n911 n912 12.800000000000001
r1476 n912 n913 35.200000000000003
r1477 n913 n914 67.200000000000003
r1478 n914 n915 67.200000000000003
r1479 n915 n916 35.200000000000003
r1480 n916 n917 12.800000000000001
r1481 n917 n918 73.599999999999994
r1482 n918 n919 115.2
r1483 n919 n920 54.399999999999999
r1484 n920 n921 108.8
r1485 n921 n922 108.8
r1486 n922 n923 44.799999999999997
r1487 n923 n924 51.200000000000003
r1488 n893 n925 1.5058823529411764
r1489 n894 n926 1.5058823529411764
r1490 n927 n928 44.799999999999997
r1491 n928 n929 38.399999999999999
r1492 n929 n930 108.8
r1493 n930 n931 108.8
r1494 n931 n932 121.59999999999999
r1495 n932 n933 121.59999999999999
r1496 n933 n934 108.8
r1497 n934 n935 108.8
r1498 n935 n936 121.59999999999999
r1499 n936 n937 121.59999999999999
r1500 n937 n938 108.8
r1501 n938 n939 108.8
r1502 n939 n940 121.59999999999999
r1503 n940 n941 121.59999999999999
r1504 n941 n942 108.8
r1505 n942 n943 108.8
r1506 n943 n944 121.59999999999999
r1507 n944 n945 121.59999999999999
r1508 n945 n946 108.8
r1509 n946 n947 108.8
r1510 n947 n948 121.59999999999999
r1511 n948 n949 121.59999999999999
r1512 n949 n950 108.8
r1513 n950 n951 108.8
r1514 n951 n952 121.59999999999999
r1515 n952 n953 121.59999999999999
r1516 n953 n954 108.8
r1517 n954 n955 108.8
r1518 n955 n956 121.59999999999999
r1519 n956 n957 121.59999999999999
r1520 n957 n958 108.8
r1521 n958 n959 108.8
r1522 n959 n960 54.399999999999999
r1523 n960 n961 86.400000000000006
r1524 n961 n962 67.200000000000003
r1525 n962 n963 35.200000000000003
r1526 n963 n964 12.800000000000001
r1527 n964 n965 32
r1528 n965 n966 96
r1529 n966 n967 73.599999999999994
r1530 n967 n968 6.4000000000000004
r1531 n968 n969 6.4000000000000004
r1532 n969 n970 35.200000000000003
r1533 n970 n971 70.400000000000006
r1534 n971 n972 64
r1535 n972 n973 32
r1536 n973 n974 16
r1537 n974 n975 16
r1538 n975 n976 25.600000000000001
r1539 n976 n977 57.600000000000001
r1540 n977 n978 83.200000000000003
r1541 n978 n979 51.200000000000003
r1542 n979 n980 121.59999999999999
r1543 n980 n981 121.59999999999999
r1544 n981 n982 108.8
r1545 n982 n983 108.8
r1546 n983 n984 121.59999999999999
r1547 n984 n985 121.59999999999999
r1548 n985 n986 108.8
r1549 n986 n987 108.8
r1550 n987 n988 121.59999999999999
r1551 n988 n989 121.59999999999999
r1552 n989 n990 108.8
r1553 n990 n991 108.8
r1554 n991 n992 121.59999999999999
r1555 n992 n993 121.59999999999999
r1556 n993 n994 108.8
r1557 n994 n995 108.8
r1558 n995 n996 121.59999999999999
r1559 n996 n997 121.59999999999999
r1560 n997 n998 108.8
r1561 n998 n999 108.8
r1562 n999 n1000 121.59999999999999
r1563 n1000 n1001 121.59999999999999
r1564 n1001 n1002 108.8
r1565 n1002 n1003 108.8
r1566 n1003 n1004 121.59999999999999
r1567 n1004 n1005 121.59999999999999
r1568 n1005 n1006 108.8
r1569 n1006 n1007 108.8
r1570 n1007 n1008 44.799999999999997
r1571 n1008 n1009 51.200000000000003
r1572 n895 n1010 1.5058823529411764
r1573 n896 n1011 1.3176470588235294
r1574 n897 n1012 11.199999999999999
r1575 n898 n1013 4.4800000000000004
r1576 n1012 n1013 17.920000000000002
r1577 n899 n1014 22.399999999999999
r1578 n1013 n1014 15.359999999999999
r1579 n900 n1015 1.3999999999999999
r1580 n1014 n1015 43.520000000000003
r1581 n901 n1016 22.399999999999999
r1582 n1015 n1016 43.520000000000003
r1583 n902 n1017 1.2444444444444445
r1584 n1016 n1017 48.640000000000001
r1585 n903 n1018 22.399999999999999
r1586 n1017 n1018 48.640000000000001
r1587 n904 n1019 3.4461538461538463
r1588 n1018 n1019 19.199999999999999
r1589 n905 n1020 3.7333333333333334
r1590 n1019 n1020 32
r1591 n906 n1021 6.4000000000000004
r1592 n1020 n1021 24.32
r1593 n907 n1022 22.399999999999999
r1594 n1021 n1022 11.52
r1595 n908 n1023 11.199999999999999
r1596 n1022 n1023 7.6799999999999997
r1597 n909 n1024 4.9777777777777779
r1598 n1023 n1024 16.640000000000001
r1599 n910 n1025 2.1333333333333333
r1600 n1024 n1025 38.399999999999999
r1601 n911 n1026 22.399999999999999
r1602 n1025 n1026 29.440000000000001
r1603 n912 n1027 22.399999999999999
r1604 n1026 n1027 5.1200000000000001
r1605 n913 n1028 4.9777777777777779
r1606 n1027 n1028 14.08
r1607 n914 n1029 3.7333333333333334
r1608 n1028 n1029 26.879999999999999
r1609 n915 n1030 4.9777777777777779
r1610 n1029 n1030 26.879999999999999
r1611 n916 n1031 22.399999999999999
r1612 n1030 n1031 14.08
r1613 n917 n1032 22.399999999999999
r1614 n1031 n1032 5.1200000000000001
r1615 n918 n1033 2.1333333333333333
r1616 n1032 n1033 29.440000000000001
r1617 n919 n1034 2.9866666666666668
r1618 n1033 n1034 46.079999999999998
r1619 n920 n1035 22.399999999999999
r1620 n1034 n1035 21.760000000000002
r1621 n921 n1036 1.3999999999999999
r1622 n1035 n1036 43.520000000000003
r1623 n922 n1037 22.399999999999999
r1624 n1036 n1037 43.520000000000003
r1625 n923 n1038 3.7333333333333334
r1626 n1037 n1038 17.920000000000002
r1627 n924 n1039 11.199999999999999
r1628 n1038 n1039 20.48
r1629 n925 n1040 1.3176470588235294
r1630 n926 n1041 1.3176470588235294
r1631 n927 n1042 11.199999999999999
r1632 n928 n1043 4.4800000000000004
r1633 n1042 n1043 17.920000000000002
r1634 n929 n1044 22.399999999999999
r1635 n1043 n1044 15.359999999999999
r1636 n930 n1045 1.3999999999999999
r1637 n1044 n1045 43.520000000000003
r1638 n931 n1046 22.399999999999999
r1639 n1045 n1046 43.520000000000003
r1640 n932 n1047 1.2444444444444445
r1641 n1046 n1047 48.640000000000001
r1642 n933 n1048 22.399999999999999
r1643 n1047 n1048 48.640000000000001
r1644 n934 n1049 1.3999999999999999
r1645 n1048 n1049 43.520000000000003
r1646 n935 n1050 22.399999999999999
r1647 n1049 n1050 43.520000000000003
r1648 n936 n1051 1.2444444444444445
r1649 n1050 n1051 48.640000000000001
r1650 n937 n1052 22.399999999999999
r1651 n1051 n1052 48.640000000000001
r1652 n938 n1053 1.3999999999999999
r1653 n1052 n1053 43.520000000000003
r1654 n939 n1054 22.399999999999999
r1655 n1053 n1054 43.520000000000003
r1656 n940 n1055 1.2444444444444445
r1657 n1054 n1055 48.640000000000001
r1658 n941 n1056 22.399999999999999
r1659 n1055 n1056 48.640000000000001
r1660 n942 n1057 1.3999999999999999
r1661 n1056 n1057 43.520000000000003
r1662 n943 n1058 22.399999999999999
r1663 n1057 n1058 43.520000000000003
r1664 n944 n1059 1.2444444444444445
r1665 n1058 n1059 48.640000000000001
r1666 n945 n1060 22.399999999999999
r1667 n1059 n1060 48.640000000000001
r1668 n946 n1061 1.3999999999999999
r1669 n1060 n1061 43.520000000000003
r1670 n947 n1062 22.399999999999999
r1671 n1061 n1062 43.520000000000003
r1672 n948 n1063 1.2444444444444445
r1673 n1062 n1063 48.640000000000001
r1674 n949 n1064 22.399999999999999
r1675 n1063 n1064 48.640000000000001
r1676 n950 n1065 1.3999999999999999
r1677 n1064 n1065 43.520000000000003
r1678 n951 n1066 22.399999999999999
r1679 n1065 n1066 43.520000000000003
r1680 n952 n1067 1.2444444444444445
r1681 n1066 n1067 48.640000000000001
r1682 n953 n1068 22.399999999999999
r1683 n1067 n1068 48.640000000000001
r1684 n954 n1069 1.3999999999999999
r1685 n1068 n1069 43.520000000000003
r1686 n955 n1070 22.399999999999999
r1687 n1069 n1070 43.520000000000003
r1688 n956 n1071 1.2444444444444445
r1689 n1070 n1071 48.640000000000001
r1690 n957 n1072 22.399999999999999
r1691 n1071 n1072 48.640000000000001
r1692 n958 n1073 1.3999999999999999
r1693 n1072 n1073 43.520000000000003
r1694 n959 n1074 22.399999999999999
r1695 n1073 n1074 43.520000000000003
r1696 n960 n1075 2.9866666666666668
r1697 n1074 n1075 21.760000000000002
r1698 n961 n1076 3.7333333333333334
r1699 n1075 n1076 34.560000000000002
r1700 n962 n1077 4.9777777777777779
r1701 n1076 n1077 26.879999999999999
r1702 n963 n1078 22.399999999999999
r1703 n1077 n1078 14.08
r1704 n964 n1079 22.399999999999999
r1705 n1078 n1079 5.1200000000000001
r1706 n965 n1080 5.5999999999999996
r1707 n1079 n1080 12.800000000000001
r1708 n966 n1081 2.0363636363636362
r1709 n1080 n1081 38.399999999999999
r1710 n967 n1082 44.799999999999997
r1711 n1081 n1082 29.440000000000001
r1712 n968 n1083 44.799999999999997
r1713 n1082 n1083 2.5600000000000001
r1714 n969 n1084 44.799999999999997
r1715 n1083 n1084 2.5600000000000001
r1716 n970 n1085 4.4800000000000004
r1717 n1084 n1085 14.08
r1718 n971 n1086 3.7333333333333334
r1719 n1085 n1086 28.16
r1720 n972 n1087 5.5999999999999996
r1721 n1086 n1087 25.600000000000001
r1722 n973 n1088 22.399999999999999
r1723 n1087 n1088 12.800000000000001
r1724 n974 n1089 14.933333333333334
r1725 n1088 n1089 6.4000000000000004
r1726 n975 n1090 22.399999999999999
r1727 n1089 n1090 6.4000000000000004
r1728 n976 n1091 7.4666666666666668
r1729 n1090 n1091 10.24
r1730 n977 n1092 3.7333333333333334
r1731 n1091 n1092 23.039999999999999
r1732 n978 n1093 3.2000000000000002
r1733 n1092 n1093 33.280000000000001
r1734 n979 n1094 22.399999999999999
r1735 n1093 n1094 20.48
r1736 n980 n1095 1.2444444444444445
r1737 n1094 n1095 48.640000000000001
r1738 n981 n1096 22.399999999999999
r1739 n1095 n1096 48.640000000000001
r1740 n982 n1097 1.3999999999999999
r1741 n1096 n1097 43.520000000000003
r1742 n983 n1098 22.399999999999999
r1743 n1097 n1098 43.520000000000003
r1744 n984 n1099 1.2444444444444445
r1745 n1098 n1099 48.640000000000001
r1746 n985 n1100 22.399999999999999
r1747 n1099 n1100 48.640000000000001
r1748 n986 n1101 1.3999999999999999
r1749 n1100 n1101 43.520000000000003
r1750 n987 n1102 22.399999999999999
r1751 n1101 n1102 43.520000000000003
r1752 n988 n1103 1.2444444444444445
r1753 n1102 n1103 48.640000000000001
r1754 n989 n1104 22.399999999999999
r1755 n1103 n1104 48.640000000000001
r1756 n990 n1105 1.3999999999999999
r1757 n1104 n1105 43.520000000000003
r1758 n991 n1106 22.399999999999999
r1759 n1105 n1106 43.520000000000003
r1760 n992 n1107 1.2444444444444445
r1761 n1106 n1107 48.640000000000001
r1762 n993 n1108 22.399999999999999
r1763 n1107 n1108 48.640000000000001
r1764 n994 n1109 1.3999999999999999
r1765 n1108 n1109 43.520000000000003
r1766 n995 n1110 22.399999999999999
r1767 n1109 n1110 43.520000000000003
r1768 n996 n1111 1.2444444444444445
r1769 n1110 n1111 48.640000000000001
r1770 n997 n1112 22.399999999999999
r1771 n1111 n1112 48.640000000000001
r1772 n998 n1113 1.3999999999999999
r1773 n1112 n1113 43.520000000000003
r1774 n999 n1114 22.399999999999999
r1775 n1113 n1114 43.520000000000003
r1776 n1000 n1115 1.2444444444444445
r1777 n1114 n1115 48.640000000000001
r1778 n1001 n1116 22.399999999999999
r1779 n1115 n1116 48.640000000000001
r1780 n1002 n1117 1.3999999999999999
r1781 n1116 n1117 43.520000000000003
r1782 n1003 n1118 22.399999999999999
r1783 n1117 n1118 43.520000000000003
r1784 n1004 n1119 1.2444444444444445
r1785 n1118 n1119 48.640000000000001
r1786 n1005 n1120 22.399999999999999
r1787 n1119 n1120 48.640000000000001
r1788 n1006 n1121 1.3999999999999999
r1789 n1120 n1121 43.520000000000003
r1790 n1007 n1122 22.399999999999999
r1791 n1121 n1122 43.520000000000003
r1792 n1008 n1123 3.7333333333333334
r1793 n1122 n1123 17.920000000000002
r1794 n1009 n1124 11.199999999999999
r1795 n1123 n1124 20.48
r1796 n1010 n1125 1.3176470588235294
r1797 n1011 n1126 3.7647058823529411
r1798 n1012 n1127 32
r1799 n1013 n1128 12.800000000000001
r1800 n1127 n1128 5.9733333333333336
r1801 n1014 n1129 64
r1802 n1128 n1129 5.1200000000000001
r1803 n1015 n1130 4
r1804 n1129 n1130 14.506666666666666
r1805 n1016 n1131 64
r1806 n1130 n1131 14.506666666666666
r1807 n1017 n1132 3.5555555555555554
r1808 n1131 n1132 16.213333333333335
r1809 n1018 n1133 64
r1810 n1132 n1133 16.213333333333335
r1811 n1019 n1134 9.8461538461538467
r1812 n1133 n1134 6.4000000000000004
r1813 n1020 n1135 10.666666666666666
r1814 n1134 n1135 10.666666666666666
r1815 n1021 n1136 18.285714285714285
r1816 n1135 n1136 8.1066666666666674
r1817 n1022 n1137 64
r1818 n1136 n1137 3.8399999999999999
r1819 n1023 n1138 32
r1820 n1137 n1138 2.5600000000000001
r1821 n1024 n1139 14.222222222222221
r1822 n1138 n1139 5.5466666666666669
r1823 n1025 n1140 6.0952380952380949
r1824 n1139 n1140 12.800000000000001
r1825 n1026 n1141 64
r1826 n1140 n1141 9.8133333333333326
r1827 n1027 n1142 64
r1828 n1141 n1142 1.7066666666666668
r1829 n1028 n1143 14.222222222222221
r1830 n1142 n1143 4.6933333333333334
r1831 n1029 n1144 10.666666666666666
r1832 n1143 n1144 8.9600000000000009
r1833 n1030 n1145 14.222222222222221
r1834 n1144 n1145 8.9600000000000009
r1835 n1031 n1146 64
r1836 n1145 n1146 4.6933333333333334
r1837 n1032 n1147 64
r1838 n1146 n1147 1.7066666666666668
r1839 n1033 n1148 6.0952380952380949
r1840 n1147 n1148 9.8133333333333326
r1841 n1034 n1149 8.5333333333333332
r1842 n1148 n1149 15.359999999999999
r1843 n1035 n1150 64
r1844 n1149 n1150 7.253333333333333
r1845 n1036 n1151 4
r1846 n1150 n1151 14.506666666666666
r1847 n1037 n1152 64
r1848 n1151 n1152 14.506666666666666
r1849 n1038 n1153 10.666666666666666
r1850 n1152 n1153 5.9733333333333336
r1851 n1039 n1154 32
r1852 n1153 n1154 6.8266666666666671
r1853 n1040 n1155 3.7647058823529411
r1854 n1041 n1156 3.7647058823529411
r1855 n1042 n1157 32
r1856 n1043 n1158 12.800000000000001
r1857 n1157 n1158 5.9733333333333336
r1858 n1044 n1159 64
r1859 n1158 n1159 5.1200000000000001
r1860 n1045 n1160 4
r1861 n1159 n1160 14.506666666666666
r1862 n1046 n1161 64
r1863 n1160 n1161 14.506666666666666
r1864 n1047 n1162 3.5555555555555554
r1865 n1161 n1162 16.213333333333335
r1866 n1048 n1163 64
r1867 n1162 n1163 16.213333333333335
r1868 n1049 n1164 4
r1869 n1163 n1164 14.506666666666666
r1870 n1050 n1165 64
r1871 n1164 n1165 14.506666666666666
r1872 n1051 n1166 3.5555555555555554
r1873 n1165 n1166 16.213333333333335
r1874 n1052 n1167 64
r1875 n1166 n1167 16.213333333333335
r1876 n1053 n1168 4
r1877 n1167 n1168 14.506666666666666
r1878 n1054 n1169 64
r1879 n1168 n1169 14.506666666666666
r1880 n1055 n1170 3.5555555555555554
r1881 n1169 n1170 16.213333333333335
r1882 n1056 n1171 64
r1883 n1170 n1171 16.213333333333335
r1884 n1057 n1172 4
r1885 n1171 n1172 14.506666666666666
r1886 n1058 n1173 64
r1887 n1172 n1173 14.506666666666666
r1888 n1059 n1174 3.5555555555555554
r1889 n1173 n1174 16.213333333333335
r1890 n1060 n1175 64
r1891 n1174 n1175 16.213333333333335
r1892 n1061 n1176 4
r1893 n1175 n1176 14.506666666666666
r1894 n1062 n1177 64
r1895 n1176 n1177 14.506666666666666
r1896 n1063 n1178 3.5555555555555554
r1897 n1177 n1178 16.213333333333335
r1898 n1064 n1179 64
r1899 n1178 n1179 16.213333333333335
r1900 n1065 n1180 4
r1901 n1179 n1180 14.506666666666666
r1902 n1066 n1181 64
r1903 n1180 n1181 14.506666666666666
r1904 n1067 n1182 3.5555555555555554
r1905 n1181 n1182 16.213333333333335
r1906 n1068 n1183 64
r1907 n1182 n1183 16.213333333333335
r1908 n1069 n1184 4
r1909 n1183 n1184 14.506666666666666
r1910 n1070 n1185 64
r1911 n1184 n1185 14.506666666666666
r1912 n1071 n1186 3.5555555555555554
r1913 n1185 n1186 16.213333333333335
r1914 n1072 n1187 64
r1915 n1186 n1187 16.213333333333335
r1916 n1073 n1188 4
r1917 n1187 n1188 14.506666666666666
r1918 n1074 n1189 64
r1919 n1188 n1189 14.506666666666666
r1920 n1075 n1190 8.5333333333333332
r1921 n1189 n1190 7.253333333333333
r1922 n1076 n1191 10.666666666666666
r1923 n1190 n1191 11.52
r1924 n1077 n1192 14.222222222222221
r1925 n1191 n1192 8.9600000000000009
r1926 n1078 n1193 64
r1927 n1192 n1193 4.6933333333333334
r1928 n1079 n1194 64
r1929 n1193 n1194 1.7066666666666668
r1930 n1080 n1195 16
r1931 n1194 n1195 4.2666666666666666
r1932 n1081 n1196 5.8181818181818183
r1933 n1195 n1196 12.800000000000001
r1934 n1082 n1197 128
r1935 n1196 n1197 9.8133333333333326
r1936 n1083 n1198 128
r1937 n1197 n1198 0.85333333333333339
r1938 n1084 n1199 128
r1939 n1198 n1199 0.85333333333333339
r1940 n1085 n1200 12.800000000000001
r1941 n1199 n1200 4.6933333333333334
r1942 n1086 n1201 10.666666666666666
r1943 n1200 n1201 9.3866666666666667
r1944 n1087 n1202 16
r1945 n1201 n1202 8.5333333333333332
r1946 n1088 n1203 64
r1947 n1202 n1203 4.2666666666666666
r1948 n1089 n1204 42.666666666666664
r1949 n1203 n1204 2.1333333333333333
r1950 n1090 n1205 64
r1951 n1204 n1205 2.1333333333333333
r1952 n1091 n1206 21.333333333333332
r1953 n1205 n1206 3.4133333333333336
r1954 n1092 n1207 10.666666666666666
r1955 n1206 n1207 7.6799999999999997
r1956 n1093 n1208 9.1428571428571423
r1957 n1207 n1208 11.093333333333334
r1958 n1094 n1209 64
r1959 n1208 n1209 6.8266666666666671
r1960 n1095 n1210 3.5555555555555554
r1961 n1209 n1210 16.213333333333335
r1962 n1096 n1211 64
r1963 n1210 n1211 16.213333333333335
r1964 n1097 n1212 4
r1965 n1211 n1212 14.506666666666666
r1966 n1098 n1213 64
r1967 n1212 n1213 14.506666666666666
r1968 n1099 n1214 3.5555555555555554
r1969 n1213 n1214 16.213333333333335
r1970 n1100 n1215 64
r1971 n1214 n1215 16.213333333333335
r1972 n1101 n1216 4
r1973 n1215 n1216 14.506666666666666
r1974 n1102 n1217 64
r1975 n1216 n1217 14.506666666666666
r1976 n1103 n1218 3.5555555555555554
r1977 n1217 n1218 16.213333333333335
r1978 n1104 n1219 64
r1979 n1218 n1219 16.213333333333335
r1980 n1105 n1220 4
r1981 n1219 n1220 14.506666666666666
r1982 n1106 n1221 64
r1983 n1220 n1221 14.506666666666666
r1984 n1107 n1222 3.5555555555555554
r1985 n1221 n1222 16.213333333333335
r1986 n1108 n1223 64
r1987 n1222 n1223 16.213333333333335
r1988 n1109 n1224 4
r1989 n1223 n1224 14.506666666666666
r1990 n1110 n1225 64
r1991 n1224 n1225 14.506666666666666
r1992 n1111 n1226 3.5555555555555554
r1993 n1225 n1226 16.213333333333335
r1994 n1112 n1227 64
r1995 n1226 n1227 16.213333333333335
r1996 n1113 n1228 4
r1997 n1227 n1228 14.506666666666666
r1998 n1114 n1229 64
r1999 n1228 n1229 14.506666666666666
r2000 n1115 n1230 3.5555555555555554
r2001 n1229 n1230 16.213333333333335
r2002 n1116 n1231 64
r2003 n1230 n1231 16.213333333333335
r2004 n1117 n1232 4
r2005 n1231 n1232 14.506666666666666
r2006 n1118 n1233 64
r2007 n1232 n1233 14.506666666666666
r2008 n1119 n1234 3.5555555555555554
r2009 n1233 n1234 16.213333333333335
r2010 n1120 n1235 64
r2011 n1234 n1235 16.213333333333335
r2012 n1121 n1236 4
r2013 n1235 n1236 14.506666666666666
r2014 n1122 n1237 64
r2015 n1236 n1237 14.506666666666666
r2016 n1123 n1238 10.666666666666666
r2017 n1237 n1238 5.9733333333333336
r2018 n1124 n1239 32
r2019 n1238 n1239 6.8266666666666671
r2020 n1125 n1240 3.7647058823529411
r2021 n1126 n1241 3.388235294117647
r2022 n1127 n1242 28.800000000000001
r2023 n1128 n1243 11.52
r2024 n1242 n1243 29.866666666666667
r2025 n1129 n1244 57.600000000000001
r2026 n1243 n1244 25.600000000000001
r2027 n1130 n1245 3.6000000000000001
r2028 n1244 n1245 72.533333333333331
r2029 n1131 n1246 57.600000000000001
r2030 n1245 n1246 72.533333333333331
r2031 n1132 n1247 3.2000000000000002
r2032 n1246 n1247 81.066666666666663
r2033 n1133 n1248 57.600000000000001
r2034 n1247 n1248 81.066666666666663
r2035 n1134 n1249 8.861538461538462
r2036 n1248 n1249 32
r2037 n1135 n1250 9.5999999999999996
r2038 n1249 n1250 53.333333333333336
r2039 n1136 n1251 16.457142857142856
r2040 n1250 n1251 40.533333333333331
r2041 n1137 n1252 57.600000000000001
r2042 n1251 n1252 19.199999999999999
r2043 n1138 n1253 28.800000000000001
r2044 n1252 n1253 12.800000000000001
r2045 n1139 n1254 12.800000000000001
r2046 n1253 n1254 27.733333333333334
r2047 n1140 n1255 5.4857142857142858
r2048 n1254 n1255 64
r2049 n1141 n1256 57.600000000000001
r2050 n1255 n1256 49.06666666666667
r2051 n1142 n1257 57.600000000000001
r2052 n1256 n1257 8.5333333333333332
r2053 n1143 n1258 12.800000000000001
r2054 n1257 n1258 23.466666666666665
r2055 n1144 n1259 9.5999999999999996
r2056 n1258 n1259 44.799999999999997
r2057 n1145 n1260 12.800000000000001
r2058 n1259 n1260 44.799999999999997
r2059 n1146 n1261 57.600000000000001
r2060 n1260 n1261 23.466666666666665
r2061 n1147 n1262 57.600000000000001
r2062 n1261 n1262 8.5333333333333332
r2063 n1148 n1263 5.4857142857142858
r2064 n1262 n1263 49.06666666666667
r2065 n1149 n1264 7.6799999999999997
r2066 n1263 n1264 76.799999999999997
r2067 n1150 n1265 57.600000000000001
r2068 n1264 n1265 36.266666666666666
r2069 n1151 n1266 3.6000000000000001
r2070 n1265 n1266 72.533333333333331
r2071 n1152 n1267 57.600000000000001
r2072 n1266 n1267 72.533333333333331
r2073 n1153 n1268 9.5999999999999996
r2074 n1267 n1268 29.866666666666667
r2075 n1154 n1269 28.800000000000001
r2076 n1268 n1269 34.133333333333333
r2077 n1155 n1270 3.388235294117647
r2078 n1156 n1271 3.388235294117647
r2079 n1157 n1272 28.800000000000001
r2080 n1158 n1273 11.52
r2081 n1272 n1273 29.866666666666667
r2082 n1159 n1274 57.600000000000001
r2083 n1273 n1274 25.600000000000001
r2084 n1160 n1275 3.6000000000000001
r2085 n1274 n1275 72.533333333333331
r2086 n1161 n1276 57.600000000000001
r2087 n1275 n1276 72.533333333333331
r2088 n1162 n1277 3.2000000000000002
r2089 n1276 n1277 81.066666666666663
r2090 n1163 n1278 57.600000000000001
r2091 n1277 n1278 81.066666666666663
r2092 n1164 n1279 3.6000000000000001
r2093 n1278 n1279 72.533333333333331
r2094 n1165 n1280 57.600000000000001
r2095 n1279 n1280 72.533333333333331
r2096 n1166 n1281 3.2000000000000002
r2097 n1280 n1281 81.066666666666663
r2098 n1167 n1282 57.600000000000001
r2099 n1281 n1282 81.066666666666663
r2100 n1168 n1283 3.6000000000000001
r2101 n1282 n1283 72.533333333333331
r2102 n1169 n1284 57.600000000000001
r2103 n1283 n1284 72.533333333333331
r2104 n1170 n1285 3.2000000000000002
r2105 n1284 n1285 81.066666666666663
r2106 n1171 n1286 57.600000000000001
r2107 n1285 n1286 81.066666666666663
r2108 n1172 n1287 3.6000000000000001
r2109 n1286 n1287 72.533333333333331
r2110 n1173 n1288 57.600000000000001
r2111 n1287 n1288 72.533333333333331
r2112 n1174 n1289 3.2000000000000002
r2113 n1288 n1289 81.066666666666663
r2114 n1175 n1290 57.600000000000001
r2115 n1289 n1290 81.066666666666663
r2116 n1176 n1291 3.6000000000000001
r2117 n1290 n1291 72.533333333333331
r2118 n1177 n1292 57.600000000000001
r2119 n1291 n1292 72.533333333333331
r2120 n1178 n1293 3.2000000000000002
r2121 n1292 n1293 81.066666666666663
r2122 n1179 n1294 57.600000000000001
r2123 n1293 n1294 81.066666666666663
r2124 n1180 n1295 3.6000000000000001
r2125 n1294 n1295 72.533333333333331
r2126 n1181 n1296 57.600000000000001
r2127 n1295 n1296 72.533333333333331
r2128 n1182 n1297 3.2000000000000002
r2129 n1296 n1297 81.066666666666663
r2130 n1183 n1298 57.600000000000001
r2131 n1297 n1298 81.066666666666663
r2132 n1184 n1299 3.6000000000000001
r2133 n1298 n1299 72.533333333333331
r2134 n1185 n1300 57.600000000000001
r2135 n1299 n1300 72.533333333333331
r2136 n1186 n1301 3.2000000000000002
r2137 n1300 n1301 81.066666666666663
r2138 n1187 n1302 57.600000000000001
r2139 n1301 n1302 81.066666666666663
r2140 n1188 n1303 3.6000000000000001
r2141 n1302 n1303 72.533333333333331
r2142 n1189 n1304 57.600000000000001
r2143 n1303 n1304 72.533333333333331
r2144 n1190 n1305 7.6799999999999997
r2145 n1304 n1305 36.266666666666666
r2146 n1191 n1306 9.5999999999999996
r2147 n1305 n1306 57.600000000000001
r2148 n1192 n1307 12.800000000000001
r2149 n1306 n1307 44.799999999999997
r2150 n1193 n1308 57.600000000000001
r2151 n1307 n1308 23.466666666666665
r2152 n1194 n1309 57.600000000000001
r2153 n1308 n1309 8.5333333333333332
r2154 n1195 n1310 14.4
r2155 n1309 n1310 21.333333333333332
r2156 n1196 n1311 5.2363636363636363
r2157 n1310 n1311 64
r2158 n1197 n1312 115.2
r2159 n1311 n1312 49.06666666666667
r2160 n1198 n1313 115.2
r2161 n1312 n1313 4.2666666666666666
r2162 n1199 n1314 115.2
r2163 n1313 n1314 4.2666666666666666
r2164 n1200 n1315 11.52
r2165 n1314 n1315 23.466666666666665
r2166 n1201 n1316 9.5999999999999996
r2167 n1315 n1316 46.93333333333333
r2168 n1202 n1317 14.4
r2169 n1316 n1317 42.666666666666664
r2170 n1203 n1318 57.600000000000001
r2171 n1317 n1318 21.333333333333332
r2172 n1204 n1319 38.399999999999999
r2173 n1318 n1319 10.666666666666666
r2174 n1205 n1320 57.600000000000001
r2175 n1319 n1320 10.666666666666666
r2176 n1206 n1321 19.199999999999999
r2177 n1320 n1321 17.066666666666666
r2178 n1207 n1322 9.5999999999999996
r2179 n1321 n1322 38.399999999999999
r2180 n1208 n1323 8.2285714285714278
r2181 n1322 n1323 55.466666666666669
r2182 n1209 n1324 57.600000000000001
r2183 n1323 n1324 34.133333333333333
r2184 n1210 n1325 3.2000000000000002
r2185 n1324 n1325 81.066666666666663
r2186 n1211 n1326 57.600000000000001
r2187 n1325 n1326 81.066666666666663
r2188 n1212 n1327 3.6000000000000001
r2189 n1326 n1327 72.533333333333331
r2190 n1213 n1328 57.600000000000001
r2191 n1327 n1328 72.533333333333331
r2192 n1214 n1329 3.2000000000000002
r2193 n1328 n1329 81.066666666666663
r2194 n1215 n1330 57.600000000000001
r2195 n1329 n1330 81.066666666666663
r2196 n1216 n1331 3.6000000000000001
r2197 n1330 n1331 72.533333333333331
r2198 n1217 n1332 57.600000000000001
r2199 n1331 n1332 72.533333333333331
r2200 n1218 n1333 3.2000000000000002
r2201 n1332 n1333 81.066666666666663
r2202 n1219 n1334 57.600000000000001
r2203 n1333 n1334 81.066666666666663
r2204 n1220 n1335 3.6000000000000001
r2205 n1334 n1335 72.533333333333331
r2206 n1221 n1336 57.600000000000001
r2207 n1335 n1336 72.533333333333331
r2208 n1222 n1337 3.2000000000000002
r2209 n1336 n1337 81.066666666666663
r2210 n1223 n1338 57.600000000000001
r2211 n1337 n1338 81.066666666666663
r2212 n1224 n1339 3.6000000000000001
r2213 n1338 n1339 72.533333333333331
r2214 n1225 n1340 57.600000000000001
r2215 n1339 n1340 72.533333333333331
r2216 n1226 n1341 3.2000000000000002
r2217 n1340 n1341 81.066666666666663
r2218 n1227 n1342 57.600000000000001
r2219 n1341 n1342 81.066666666666663
r2220 n1228 n1343 3.6000000000000001
r2221 n1342 n1343 72.533333333333331
r2222 n1229 n1344 57.600000000000001
r2223 n1343 n1344 72.533333333333331
r2224 n1230 n1345 3.2000000000000002
r2225 n1344 n1345 81.066666666666663
r2226 n1231 n1346 57.600000000000001
r2227 n1345 n1346 81.066666666666663
r2228 n1232 n1347 3.6000000000000001
r2229 n1346 n1347 72.533333333333331
r2230 n1233 n1348 57.600000000000001
r2231 n1347 n1348 72.533333333333331
r2232 n1234 n1349 3.2000000000000002
r2233 n1348 n1349 81.066666666666663
r2234 n1235 n1350 57.600000000000001
r2235 n1349 n1350 81.066666666666663
r2236 n1236 n1351 3.6000000000000001
r2237 n1350 n1351 72.533333333333331
r2238 n1237 n1352 57.600000000000001
r2239 n1351 n1352 72.533333333333331
r2240 n1238 n1353 9.5999999999999996
r2241 n1352 n1353 29.866666666666667
r2242 n1239 n1354 28.800000000000001
r2243 n1353 n1354 34.133333333333333
r2244 n1240 n1355 3.388235294117647
r2245 n1241 n1356 1.3176470588235294
r2246 n1242 n1357 11.199999999999999
r2247 n1243 n1358 4.4800000000000004
r2248 n1357 n1358 22.399999999999999
r2249 n1244 n1359 22.399999999999999
r2250 n1358 n1359 19.199999999999999
r2251 n1245 n1360 1.3999999999999999
r2252 n1359 n1360 54.399999999999999
r2253 n1246 n1361 22.399999999999999
r2254 n1360 n1361 54.399999999999999
r2255 n1247 n1362 1.2444444444444445
r2256 n1361 n1362 60.799999999999997
r2257 n1248 n1363 22.399999999999999
r2258 n1362 n1363 60.799999999999997
r2259 n1249 n1364 3.4461538461538463
r2260 n1363 n1364 24
r2261 n1250 n1365 3.7333333333333334
r2262 n1364 n1365 40
r2263 n1251 n1366 6.4000000000000004
r2264 n1365 n1366 30.399999999999999
r2265 n1252 n1367 22.399999999999999
r2266 n1366 n1367 14.4
r2267 n1253 n1368 11.199999999999999
r2268 n1367 n1368 9.5999999999999996
r2269 n1254 n1369 4.9777777777777779
r2270 n1368 n1369 20.800000000000001
r2271 n1255 n1370 2.1333333333333333
r2272 n1369 n1370 48
r2273 n1256 n1371 22.399999999999999
r2274 n1370 n1371 36.799999999999997
r2275 n1257 n1372 22.399999999999999
r2276 n1371 n1372 6.4000000000000004
r2277 n1258 n1373 4.9777777777777779
r2278 n1372 n1373 17.600000000000001
r2279 n1259 n1374 3.7333333333333334
r2280 n1373 n1374 33.600000000000001
r2281 n1260 n1375 4.9777777777777779
r2282 n1374 n1375 33.600000000000001
r2283 n1261 n1376 22.399999999999999
r2284 n1375 n1376 17.600000000000001
r2285 n1262 n1377 22.399999999999999
r2286 n1376 n1377 6.4000000000000004
r2287 n1263 n1378 2.1333333333333333
r2288 n1377 n1378 36.799999999999997
r2289 n1264 n1379 2.9866666666666668
r2290 n1378 n1379 57.600000000000001
r2291 n1265 n1380 22.399999999999999
r2292 n1379 n1380 27.199999999999999
r2293 n1266 n1381 1.3999999999999999
r2294 n1380 n1381 54.399999999999999
r2295 n1267 n1382 22.399999999999999
r2296 n1381 n1382 54.399999999999999
r2297 n1268 n1383 3.7333333333333334
r2298 n1382 n1383 22.399999999999999
r2299 n1269 n1384 11.199999999999999
r2300 n1383 n1384 25.600000000000001
r2301 n1270 n1385 1.3176470588235294
r2302 n1271 n1386 1.3176470588235294
r2303 n1272 n1387 11.199999999999999
r2304 n1273 n1388 4.4800000000000004
r2305 n1387 n1388 22.399999999999999
r2306 n1274 n1389 22.399999999999999
r2307 n1388 n1389 19.199999999999999
r2308 n1275 n1390 1.3999999999999999
r2309 n1389 n1390 54.399999999999999
r2310 n1276 n1391 22.399999999999999
r2311 n1390 n1391 54.399999999999999
r2312 n1277 n1392 1.2444444444444445
r2313 n1391 n1392 60.799999999999997
r2314 n1278 n1393 22.399999999999999
r2315 n1392 n1393 60.799999999999997
r2316 n1279 n1394 1.3999999999999999
r2317 n1393 n1394 54.399999999999999
r2318 n1280 n1395 22.399999999999999
r2319 n1394 n1395 54.399999999999999
r2320 n1281 n1396 1.2444444444444445
r2321 n1395 n1396 60.799999999999997
r2322 n1282 n1397 22.399999999999999
r2323 n1396 n1397 60.799999999999997
r2324 n1283 n1398 1.3999999999999999
r2325 n1397 n1398 54.399999999999999
r2326 n1284 n1399 22.399999999999999
r2327 n1398 n1399 54.399999999999999
r2328 n1285 n1400 1.2444444444444445
r2329 n1399 n1400 60.799999999999997
r2330 n1286 n1401 22.399999999999999
r2331 n1400 n1401 60.799999999999997
r2332 n1287 n1402 1.3999999999999999
r2333 n1401 n1402 54.399999999999999
r2334 n1288 n1403 22.399999999999999
r2335 n1402 n1403 54.399999999999999
r2336 n1289 n1404 1.2444444444444445
r2337 n1403 n1404 60.799999999999997
r2338 n1290 n1405 22.399999999999999
r2339 n1404 n1405 60.799999999999997
r2340 n1291 n1406 1.3999999999999999
r2341 n1405 n1406 54.399999999999999
r2342 n1292 n1407 22.399999999999999
r2343 n1406 n1407 54.399999999999999
r2344 n1293 n1408 1.2444444444444445
r2345 n1407 n1408 60.799999999999997
r2346 n1294 n1409 22.399999999999999
r2347 n1408 n1409 60.799999999999997
r2348 n1295 n1410 1.3999999999999999
r2349 n1409 n1410 54.399999999999999
r2350 n1296 n1411 22.399999999999999
r2351 n1410 n1411 54.399999999999999
r2352 n1297 n1412 1.2444444444444445
r2353 n1411 n1412 60.799999999999997
r2354 n1298 n1413 22.399999999999999
r2355 n1412 n1413 60.799999999999997
r2356 n1299 n1414 1.3999999999999999
r2357 n1413 n1414 54.399999999999999
r2358 n1300 n1415 22.399999999999999
r2359 n1414 n1415 54.399999999999999
r2360 n1301 n1416 1.2444444444444445
r2361 n1415 n1416 60.799999999999997
r2362 n1302 n1417 22.399999999999999
r2363 n1416 n1417 60.799999999999997
r2364 n1303 n1418 1.3999999999999999
r2365 n1417 n1418 54.399999999999999
r2366 n1304 n1419 22.399999999999999
r2367 n1418 n1419 54.399999999999999
r2368 n1305 n1420 2.9866666666666668
r2369 n1419 n1420 27.199999999999999
r2370 n1306 n1421 3.7333333333333334
r2371 n1420 n1421 43.200000000000003
r2372 n1307 n1422 4.9777777777777779
r2373 n1421 n1422 33.600000000000001
r2374 n1308 n1423 22.399999999999999
r2375 n1422 n1423 17.600000000000001
r2376 n1309 n1424 22.399999999999999
r2377 n1423 n1424 6.4000000000000004
r2378 n1310 n1425 5.5999999999999996
r2379 n1424 n1425 16
r2380 n1311 n1426 2.0363636363636362
r2381 n1425 n1426 48
r2382 n1312 n1427 44.799999999999997
r2383 n1426 n1427 36.799999999999997
r2384 n1313 n1428 44.799999999999997
r2385 n1427 n1428 3.2000000000000002
r2386 n1314 n1429 44.799999999999997
r2387 n1428 n1429 3.2000000000000002
r2388 n1315 n1430 4.4800000000000004
r2389 n1429 n1430 17.600000000000001
r2390 n1316 n1431 3.7333333333333334
r2391 n1430 n1431 35.200000000000003
r2392 n1317 n1432 5.5999999999999996
r2393 n1431 n1432 32
r2394 n1318 n1433 22.399999999999999
r2395 n1432 n1433 16
r2396 n1319 n1434 14.933333333333334
r2397 n1433 n1434 8
r2398 n1320 n1435 22.399999999999999
r2399 n1434 n1435 8
r2400 n1321 n1436 7.4666666666666668
r2401 n1435 n1436 12.800000000000001
r2402 n1322 n1437 3.7333333333333334
r2403 n1436 n1437 28.800000000000001
r2404 n1323 n1438 3.2000000000000002
r2405 n1437 n1438 41.600000000000001
r2406 n1324 n1439 22.399999999999999
r2407 n1438 n1439 25.600000000000001
r2408 n1325 n1440 1.2444444444444445
r2409 n1439 n1440 60.799999999999997
r2410 n1326 n1441 22.399999999999999
r2411 n1440 n1441 60.799999999999997
r2412 n1327 n1442 1.3999999999999999
r2413 n1441 n1442 54.399999999999999
r2414 n1328 n1443 22.399999999999999
r2415 n1442 n1443 54.399999999999999
r2416 n1329 n1444 1.2444444444444445
r2417 n1443 n1444 60.799999999999997
r2418 n1330 n1445 22.399999999999999
r2419 n1444 n1445 60.799999999999997
r2420 n1331 n1446 1.3999999999999999
r2421 n1445 n1446 54.399999999999999
r2422 n1332 n1447 22.399999999999999
r2423 n1446 n1447 54.399999999999999
r2424 n1333 n1448 1.2444444444444445
r2425 n1447 n1448 60.799999999999997
r2426 n1334 n1449 22.399999999999999
r2427 n1448 n1449 60.799999999999997
r2428 n1335 n1450 1.3999999999999999
r2429 n1449 n1450 54.399999999999999
r2430 n1336 n1451 22.399999999999999
r2431 n1450 n1451 54.399999999999999
r2432 n1337 n1452 1.2444444444444445
r2433 n1451 n1452 60.799999999999997
r2434 n1338 n1453 22.399999999999999
r2435 n1452 n1453 60.799999999999997
r2436 n1339 n1454 1.3999999999999999
r2437 n1453 n1454 54.399999999999999
r2438 n1340 n1455 22.399999999999999
r2439 n1454 n1455 54.399999999999999
r2440 n1341 n1456 1.2444444444444445
r2441 n1455 n1456 60.799999999999997
r2442 n1342 n1457 22.399999999999999
r2443 n1456 n1457 60.799999999999997
r2444 n1343 n1458 1.3999999999999999
r2445 n1457 n1458 54.399999999999999
r2446 n1344 n1459 22.399999999999999
r2447 n1458 n1459 54.399999999999999
r2448 n1345 n1460 1.2444444444444445
r2449 n1459 n1460 60.799999999999997
r2450 n1346 n1461 22.399999999999999
r2451 n1460 n1461 60.799999999999997
r2452 n1347 n1462 1.3999999999999999
r2453 n1461 n1462 54.399999999999999
r2454 n1348 n1463 22.399999999999999
r2455 n1462 n1463 54.399999999999999
r2456 n1349 n1464 1.2444444444444445
r2457 n1463 n1464 60.799999999999997
r2458 n1350 n1465 22.399999999999999
r2459 n1464 n1465 60.799999999999997
r2460 n1351 n1466 1.3999999999999999
r2461 n1465 n1466 54.399999999999999
r2462 n1352 n1467 22.399999999999999
r2463 n1466 n1467 54.399999999999999
r2464 n1353 n1468 3.7333333333333334
r2465 n1467 n1468 22.399999999999999
r2466 n1354 n1469 11.199999999999999
r2467 n1468 n1469 25.600000000000001
r2468 n1355 n1470 1.3176470588235294
r2469 n1356 n1471 1.3176470588235294
r2470 n1357 n1472 11.199999999999999
r2471 n1358 n1473 4.4800000000000004
r2472 n1472 n1473 29.866666666666667
r2473 n1359 n1474 22.399999999999999
r2474 n1473 n1474 25.600000000000001
r2475 n1360 n1475 1.3999999999999999
r2476 n1474 n1475 72.533333333333331
r2477 n1361 n1476 22.399999999999999
r2478 n1475 n1476 72.533333333333331
r2479 n1362 n1477 1.2444444444444445
r2480 n1476 n1477 81.066666666666663
r2481 n1363 n1478 22.399999999999999
r2482 n1477 n1478 81.066666666666663
r2483 n1364 n1479 3.4461538461538463
r2484 n1478 n1479 32
r2485 n1365 n1480 3.7333333333333334
r2486 n1479 n1480 53.333333333333336
r2487 n1366 n1481 6.4000000000000004
r2488 n1480 n1481 40.533333333333331
r2489 n1367 n1482 22.399999999999999
r2490 n1481 n1482 19.199999999999999
r2491 n1368 n1483 11.199999999999999
r2492 n1482 n1483 12.800000000000001
r2493 n1369 n1484 4.9777777777777779
r2494 n1483 n1484 27.733333333333334
r2495 n1370 n1485 2.1333333333333333
r2496 n1484 n1485 64
r2497 n1371 n1486 22.399999999999999
r2498 n1485 n1486 49.06666666666667
r2499 n1372 n1487 22.399999999999999
r2500 n1486 n1487 8.5333333333333332
r2501 n1373 n1488 4.9777777777777779
r2502 n1487 n1488 23.466666666666665
r2503 n1374 n1489 3.7333333333333334
r2504 n1488 n1489 44.799999999999997
r2505 n1375 n1490 4.9777777777777779
r2506 n1489 n1490 44.799999999999997
r2507 n1376 n1491 22.399999999999999
r2508 n1490 n1491 23.466666666666665
r2509 n1377 n1492 22.399999999999999
r2510 n1491 n1492 8.5333333333333332
r2511 n1378 n1493 2.1333333333333333
r2512 n1492 n1493 49.06666666666667
r2513 n1379 n1494 2.9866666666666668
r2514 n1493 n1494 76.799999999999997
r2515 n1380 n1495 22.399999999999999
r2516 n1494 n1495 36.266666666666666
r2517 n1381 n1496 1.3999999999999999
r2518 n1495 n1496 72.533333333333331
r2519 n1382 n1497 22.399999999999999
r2520 n1496 n1497 72.533333333333331
r2521 n1383 n1498 3.7333333333333334
r2522 n1497 n1498 29.866666666666667
r2523 n1384 n1499 11.199999999999999
r2524 n1498 n1499 34.133333333333333
r2525 n1500 n1501 21.333333333333332
r2526 n1501 n1502 64
r2527 n1502 n1503 51.200000000000003
r2528 n1385 n1504 1.3176470588235294
r2529 n1386 n1505 1.3176470588235294
r2530 n1387 n1506 11.199999999999999
r2531 n1388 n1507 4.4800000000000004
r2532 n1506 n1507 29.866666666666667
r2533 n1389 n1508 22.399999999999999
r2534 n1507 n1508 25.600000000000001
r2535 n1390 n1509 1.3999999999999999
r2536 n1508 n1509 72.533333333333331
r2537 n1391 n1510 22.399999999999999
r2538 n1509 n1510 72.533333333333331
r2539 n1392 n1511 1.2444444444444445
r2540 n1510 n1511 81.066666666666663
r2541 n1393 n1512 22.399999999999999
r2542 n1511 n1512 81.066666666666663
r2543 n1394 n1513 1.3999999999999999
r2544 n1512 n1513 72.533333333333331
r2545 n1395 n1514 22.399999999999999
r2546 n1513 n1514 72.533333333333331
r2547 n1396 n1515 1.2444444444444445
r2548 n1514 n1515 81.066666666666663
r2549 n1397 n1516 22.399999999999999
r2550 n1515 n1516 81.066666666666663
r2551 n1398 n1517 1.3999999999999999
r2552 n1516 n1517 72.533333333333331
r2553 n1399 n1518 22.399999999999999
r2554 n1517 n1518 72.533333333333331
r2555 n1400 n1519 1.2444444444444445
r2556 n1518 n1519 81.066666666666663
r2557 n1401 n1520 22.399999999999999
r2558 n1519 n1520 81.066666666666663
r2559 n1402 n1521 1.3999999999999999
r2560 n1520 n1521 72.533333333333331
r2561 n1403 n1522 22.399999999999999
r2562 n1521 n1522 72.533333333333331
r2563 n1404 n1523 1.2444444444444445
r2564 n1522 n1523 81.066666666666663
r2565 n1405 n1524 22.399999999999999
r2566 n1523 n1524 81.066666666666663
r2567 n1406 n1525 1.3999999999999999
r2568 n1524 n1525 72.533333333333331
r2569 n1407 n1526 22.399999999999999
r2570 n1525 n1526 72.533333333333331
r2571 n1408 n1527 1.2444444444444445
r2572 n1526 n1527 81.066666666666663
r2573 n1409 n1528 22.399999999999999
r2574 n1527 n1528 81.066666666666663
r2575 n1410 n1529 1.3999999999999999
r2576 n1528 n1529 72.533333333333331
r2577 n1411 n1530 22.399999999999999
r2578 n1529 n1530 72.533333333333331
r2579 n1412 n1531 1.2444444444444445
r2580 n1530 n1531 81.066666666666663
r2581 n1413 n1532 22.399999999999999
r2582 n1531 n1532 81.066666666666663
r2583 n1414 n1533 1.3999999999999999
r2584 n1532 n1533 72.533333333333331
r2585 n1415 n1534 22.399999999999999
r2586 n1533 n1534 72.533333333333331
r2587 n1416 n1535 1.2444444444444445
r2588 n1534 n1535 81.066666666666663
r2589 n1417 n1536 22.399999999999999
r2590 n1535 n1536 81.066666666666663
r2591 n1418 n1537 1.3999999999999999
r2592 n1536 n1537 72.533333333333331
r2593 n1419 n1538 22.399999999999999
r2594 n1537 n1538 72.533333333333331
r2595 n1420 n1539 2.9866666666666668
r2596 n1538 n1539 36.266666666666666
r2597 n1421 n1540 3.7333333333333334
r2598 n1539 n1540 57.600000000000001
r2599 n1422 n1541 4.9777777777777779
r2600 n1540 n1541 44.799999999999997
r2601 n1423 n1542 22.399999999999999
r2602 n1541 n1542 23.466666666666665
r2603 n1424 n1543 22.399999999999999
r2604 n1542 n1543 8.5333333333333332
r2605 n1425 n1544 5.5999999999999996
r2606 n1543 n1544 21.333333333333332
r2607 n1426 n1545 2.0363636363636362
r2608 n1544 n1545 64
r2609 n1427 n1546 44.799999999999997
r2610 n1545 n1546 49.06666666666667
r2611 n1428 n1547 44.799999999999997
r2612 n1546 n1547 4.2666666666666666
r2613 n1429 n1548 44.799999999999997
r2614 n1547 n1548 4.2666666666666666
r2615 n1430 n1549 4.4800000000000004
r2616 n1548 n1549 23.466666666666665
r2617 n1431 n1550 3.7333333333333334
r2618 n1549 n1550 46.93333333333333
r2619 n1432 n1551 5.5999999999999996
r2620 n1550 n1551 42.666666666666664
r2621 n1433 n1552 22.399999999999999
r2622 n1551 n1552 21.333333333333332
r2623 n1434 n1553 14.933333333333334
r2624 n1552 n1553 10.666666666666666
r2625 n1435 n1554 22.399999999999999
r2626 n1553 n1554 10.666666666666666
r2627 n1436 n1555 7.4666666666666668
r2628 n1554 n1555 17.066666666666666
r2629 n1437 n1556 3.7333333333333334
r2630 n1555 n1556 38.399999999999999
r2631 n1438 n1557 3.2000000000000002
r2632 n1556 n1557 55.466666666666669
r2633 n1439 n1558 22.399999999999999
r2634 n1557 n1558 34.133333333333333
r2635 n1440 n1559 1.2444444444444445
r2636 n1558 n1559 81.066666666666663
r2637 n1441 n1560 22.399999999999999
r2638 n1559 n1560 81.066666666666663
r2639 n1442 n1561 1.3999999999999999
r2640 n1560 n1561 72.533333333333331
r2641 n1443 n1562 22.399999999999999
r2642 n1561 n1562 72.533333333333331
r2643 n1444 n1563 1.2444444444444445
r2644 n1562 n1563 81.066666666666663
r2645 n1445 n1564 22.399999999999999
r2646 n1563 n1564 81.066666666666663
r2647 n1446 n1565 1.3999999999999999
r2648 n1564 n1565 72.533333333333331
r2649 n1447 n1566 22.399999999999999
r2650 n1565 n1566 72.533333333333331
r2651 n1448 n1567 1.2444444444444445
r2652 n1566 n1567 81.066666666666663
r2653 n1449 n1568 22.399999999999999
r2654 n1567 n1568 81.066666666666663
r2655 n1450 n1569 1.3999999999999999
r2656 n1568 n1569 72.533333333333331
r2657 n1451 n1570 22.399999999999999
r2658 n1569 n1570 72.533333333333331
r2659 n1452 n1571 1.2444444444444445
r2660 n1570 n1571 81.066666666666663
r2661 n1453 n1572 22.399999999999999
r2662 n1571 n1572 81.066666666666663
r2663 n1454 n1573 1.3999999999999999
r2664 n1572 n1573 72.533333333333331
r2665 n1455 n1574 22.399999999999999
r2666 n1573 n1574 72.533333333333331
r2667 n1456 n1575 1.2444444444444445
r2668 n1574 n1575 81.066666666666663
r2669 n1457 n1576 22.399999999999999
r2670 n1575 n1576 81.066666666666663
r2671 n1458 n1577 1.3999999999999999
r2672 n1576 n1577 72.533333333333331
r2673 n1459 n1578 22.399999999999999
r2674 n1577 n1578 72.533333333333331
r2675 n1460 n1579 1.2444444444444445
r2676 n1578 n1579 81.066666666666663
r2677 n1461 n1580 22.399999999999999
r2678 n1579 n1580 81.066666666666663
r2679 n1462 n1581 1.3999999999999999
r2680 n1580 n1581 72.533333333333331
r2681 n1463 n1582 22.399999999999999
r2682 n1581 n1582 72.533333333333331
r2683 n1464 n1583 1.2444444444444445
r2684 n1582 n1583 81.066666666666663
r2685 n1465 n1584 22.399999999999999
r2686 n1583 n1584 81.066666666666663
r2687 n1466 n1585 1.3999999999999999
r2688 n1584 n1585 72.533333333333331
r2689 n1467 n1586 22.399999999999999
r2690 n1585 n1586 72.533333333333331
r2691 n1468 n1587 3.7333333333333334
r2692 n1586 n1587 29.866666666666667
r2693 n1469 n1588 11.199999999999999
r2694 n1587 n1588 34.133333333333333
r2695 n1589 n1590 27.733333333333334
r2696 n1590 n1591 64
r2697 n1591 n1592 44.799999999999997
r2698 n1470 n1593 1.3176470588235294
r2699 n1471 n1594 0.94117647058823528
r2700 n1472 n1595 8
r2701 n1473 n1596 3.2000000000000002
r2702 n1595 n1596 44.799999999999997
r2703 n1474 n1597 16
r2704 n1596 n1597 38.399999999999999
r2705 n1475 n1598 1
r2706 n1597 n1598 108.8
r2707 n1476 n1599 16
r2708 n1598 n1599 108.8
r2709 n1477 n1600 0.88888888888888884
r2710 n1599 n1600 121.59999999999999
r2711 n1478 n1601 16
r2712 n1600 n1601 121.59999999999999
r2713 n1479 n1602 2.4615384615384617
r2714 n1601 n1602 48
r2715 n1480 n1603 2.6666666666666665
r2716 n1602 n1603 80
r2717 n1481 n1604 4.5714285714285712
r2718 n1603 n1604 60.799999999999997
r2719 n1482 n1605 16
r2720 n1604 n1605 28.800000000000001
r2721 n1483 n1606 8
r2722 n1605 n1606 19.199999999999999
r2723 n1484 n1607 3.5555555555555554
r2724 n1606 n1607 41.600000000000001
r2725 n1485 n1608 1.5238095238095237
r2726 n1607 n1608 96
r2727 n1486 n1609 16
r2728 n1608 n1609 73.599999999999994
r2729 n1487 n1610 16
r2730 n1609 n1610 12.800000000000001
r2731 n1488 n1611 3.5555555555555554
r2732 n1610 n1611 35.200000000000003
r2733 n1489 n1612 2.6666666666666665
r2734 n1611 n1612 67.200000000000003
r2735 n1490 n1613 3.5555555555555554
r2736 n1612 n1613 67.200000000000003
r2737 n1491 n1614 16
r2738 n1613 n1614 35.200000000000003
r2739 n1492 n1615 16
r2740 n1614 n1615 12.800000000000001
r2741 n1493 n1616 1.5238095238095237
r2742 n1615 n1616 73.599999999999994
r2743 n1494 n1617 2.1333333333333333
r2744 n1616 n1617 115.2
r2745 n1495 n1618 16
r2746 n1617 n1618 54.399999999999999
r2747 n1496 n1619 1
r2748 n1618 n1619 108.8
r2749 n1497 n1620 16
r2750 n1619 n1620 108.8
r2751 n1498 n1621 2.6666666666666665
r2752 n1620 n1621 44.799999999999997
r2753 n1499 n1622 8
r2754 n1621 n1622 51.200000000000003
r2755 n1500 n1623 16
r2756 n1501 n1624 4
r2757 n1623 n1624 32
r2758 n1502 n1625 1.4545454545454546
r2759 n1624 n1625 96
r2760 n1503 n1626 16
r2761 n1625 n1626 76.799999999999997
r2762 n1504 n1627 0.94117647058823528
r2763 n1505 n1628 0.94117647058823528
r2764 n1506 n1629 8
r2765 n1507 n1630 3.2000000000000002
r2766 n1629 n1630 44.799999999999997
r2767 n1508 n1631 16
r2768 n1630 n1631 38.399999999999999
r2769 n1509 n1632 1
r2770 n1631 n1632 108.8
r2771 n1510 n1633 16
r2772 n1632 n1633 108.8
r2773 n1511 n1634 0.88888888888888884
r2774 n1633 n1634 121.59999999999999
r2775 n1512 n1635 16
r2776 n1634 n1635 121.59999999999999
r2777 n1513 n1636 1
r2778 n1635 n1636 108.8
r2779 n1514 n1637 16
r2780 n1636 n1637 108.8
r2781 n1515 n1638 0.88888888888888884
r2782 n1637 n1638 121.59999999999999
r2783 n1516 n1639 16
r2784 n1638 n1639 121.59999999999999
r2785 n1517 n1640 1
r2786 n1639 n1640 108.8
r2787 n1518 n1641 16
r2788 n1640 n1641 108.8
r2789 n1519 n1642 0.88888888888888884
r2790 n1641 n1642 121.59999999999999
r2791 n1520 n1643 16
r2792 n1642 n1643 121.59999999999999
r2793 n1521 n1644 1
r2794 n1643 n1644 108.8
r2795 n1522 n1645 16
r2796 n1644 n1645 108.8
r2797 n1523 n1646 0.88888888888888884
r2798 n1645 n1646 121.59999999999999
r2799 n1524 n1647 16
r2800 n1646 n1647 121.59999999999999
r2801 n1525 n1648 1
r2802 n1647 n1648 108.8
r2803 n1526 n1649 16
r2804 n1648 n1649 108.8
r2805 n1527 n1650 0.88888888888888884
r2806 n1649 n1650 121.59999999999999
r2807 n1528 n1651 16
r2808 n1650 n1651 121.59999999999999
r2809 n1529 n1652 1
r2810 n1651 n1652 108.8
r2811 n1530 n1653 16
r2812 n1652 n1653 108.8
r2813 n1531 n1654 0.88888888888888884
r2814 n1653 n1654 121.59999999999999
r2815 n1532 n1655 16
r2816 n1654 n1655 121.59999999999999
r2817 n1533 n1656 1
r2818 n1655 n1656 108.8
r2819 n1534 n1657 16
r2820 n1656 n1657 108.8
r2821 n1535 n1658 0.88888888888888884
r2822 n1657 n1658 121.59999999999999
r2823 n1536 n1659 16
r2824 n1658 n1659 121.59999999999999
r2825 n1537 n1660 1
r2826 n1659 n1660 108.8
r2827 n1538 n1661 16
r2828 n1660 n1661 108.8
r2829 n1539 n1662 2.1333333333333333
r2830 n1661 n1662 54.399999999999999
r2831 n1540 n1663 2.6666666666666665
r2832 n1662 n1663 86.400000000000006
r2833 n1541 n1664 3.5555555555555554
r2834 n1663 n1664 67.200000000000003
r2835 n1542 n1665 16
r2836 n1664 n1665 35.200000000000003
r2837 n1543 n1666 16
r2838 n1665 n1666 12.800000000000001
r2839 n1544 n1667 4
r2840 n1666 n1667 32
r2841 n1545 n1668 1.4545454545454546
r2842 n1667 n1668 96
r2843 n1546 n1669 32
r2844 n1668 n1669 73.599999999999994
r2845 n1547 n1670 32
r2846 n1669 n1670 6.4000000000000004
r2847 n1548 n1671 32
r2848 n1670 n1671 6.4000000000000004
r2849 n1549 n1672 3.2000000000000002
r2850 n1671 n1672 35.200000000000003
r2851 n1550 n1673 2.6666666666666665
r2852 n1672 n1673 70.400000000000006
r2853 n1551 n1674 4
r2854 n1673 n1674 64
r2855 n1552 n1675 16
r2856 n1674 n1675 32
r2857 n1553 n1676 10.666666666666666
r2858 n1675 n1676 16
r2859 n1554 n1677 16
r2860 n1676 n1677 16
r2861 n1555 n1678 5.333333333333333
r2862 n1677 n1678 25.600000000000001
r2863 n1556 n1679 2.6666666666666665
r2864 n1678 n1679 57.600000000000001
r2865 n1557 n1680 2.2857142857142856
r2866 n1679 n1680 83.200000000000003
r2867 n1558 n1681 16
r2868 n1680 n1681 51.200000000000003
r2869 n1559 n1682 0.88888888888888884
r2870 n1681 n1682 121.59999999999999
r2871 n1560 n1683 16
r2872 n1682 n1683 121.59999999999999
r2873 n1561 n1684 1
r2874 n1683 n1684 108.8
r2875 n1562 n1685 16
r2876 n1684 n1685 108.8
r2877 n1563 n1686 0.88888888888888884
r2878 n1685 n1686 121.59999999999999
r2879 n1564 n1687 16
r2880 n1686 n1687 121.59999999999999
r2881 n1565 n1688 1
r2882 n1687 n1688 108.8
r2883 n1566 n1689 16
r2884 n1688 n1689 108.8
r2885 n1567 n1690 0.88888888888888884
r2886 n1689 n1690 121.59999999999999
r2887 n1568 n1691 16
r2888 n1690 n1691 121.59999999999999
r2889 n1569 n1692 1
r2890 n1691 n1692 108.8
r2891 n1570 n1693 16
r2892 n1692 n1693 108.8
r2893 n1571 n1694 0.88888888888888884
r2894 n1693 n1694 121.59999999999999
r2895 n1572 n1695 16
r2896 n1694 n1695 121.59999999999999
r2897 n1573 n1696 1
r2898 n1695 n1696 108.8
r2899 n1574 n1697 16
r2900 n1696 n1697 108.8
r2901 n1575 n1698 0.88888888888888884
r2902 n1697 n1698 121.59999999999999
r2903 n1576 n1699 16
r2904 n1698 n1699 121.59999999999999
r2905 n1577 n1700 1
r2906 n1699 n1700 108.8
r2907 n1578 n1701 16
r2908 n1700 n1701 108.8
r2909 n1579 n1702 0.88888888888888884
r2910 n1701 n1702 121.59999999999999
r2911 n1580 n1703 16
r2912 n1702 n1703 121.59999999999999
r2913 n1581 n1704 1
r2914 n1703 n1704 108.8
r2915 n1582 n1705 16
r2916 n1704 n1705 108.8
r2917 n1583 n1706 0.88888888888888884
r2918 n1705 n1706 121.59999999999999
r2919 n1584 n1707 16
r2920 n1706 n1707 121.59999999999999
r2921 n1585 n1708 1
r2922 n1707 n1708 108.8
r2923 n1586 n1709 16
r2924 n1708 n1709 108.8
r2925 n1587 n1710 2.6666666666666665
r2926 n1709 n1710 44.799999999999997
r2927 n1588 n1711 8
r2928 n1710 n1711 51.200000000000003
r2929 n1589 n1712 16
r2930 n1590 n1713 2.9090909090909092
r2931 n1712 n1713 41.600000000000001
r2932 n1591 n1714 1.6842105263157894
r2933 n1713 n1714 96
r2934 n1592 n1715 16
r2935 n1714 n1715 67.200000000000003
r2936 n1593 n1716 0.94117647058823528
r2937 n1594 n1717 1.5058823529411764
r2938 n1623 n1718 25.600000000000001
r2939 n1624 n1719 6.4000000000000004
r2940 n1718 n1719 10.666666666666666
r2941 n1625 n1720 2.3272727272727272
r2942 n1719 n1720 32
r2943 n1626 n1721 25.600000000000001
r2944 n1720 n1721 25.600000000000001
r2945 n1627 n1722 1.5058823529411764
r2946 n1628 n1723 1.5058823529411764
r2947 n1712 n1724 25.600000000000001
r2948 n1713 n1725 4.6545454545454543
r2949 n1724 n1725 13.866666666666667
r2950 n1714 n1726 2.6947368421052631
r2951 n1725 n1726 32
r2952 n1715 n1727 25.600000000000001
r2953 n1726 n1727 22.399999999999999
r2954 n1716 n1728 1.5058823529411764
r2955 n1717 n1729 1.5058823529411764
r2956 n1718 n1730 25.600000000000001
r2957 n1719 n1731 6.4000000000000004
r2958 n1730 n1731 32
r2959 n1720 n1732 2.3272727272727272
r2960 n1731 n1732 96
r2961 n1721 n1733 25.600000000000001
r2962 n1732 n1733 76.799999999999997
r2963 n1722 n1734 1.5058823529411764
r2964 n1723 n1735 1.5058823529411764
r2965 n1724 n1736 25.600000000000001
r2966 n1725 n1737 4.6545454545454543
r2967 n1736 n1737 41.600000000000001
r2968 n1726 n1738 2.6947368421052631
r2969 n1737 n1738 96
r2970 n1727 n1739 25.600000000000001
r2971 n1738 n1739 67.200000000000003
r2972 n1728 n1740 1.5058823529411764
r2973 n1729 n1741 0.94117647058823528
r2974 n1730 n1742 16
r2975 n1731 n1743 4
r2976 n1742 n1743 21.333333333333332
r2977 n1732 n1744 1.4545454545454546
r2978 n1743 n1744 64
r2979 n1733 n1745 16
r2980 n1744 n1745 51.200000000000003
r2981 n1734 n1746 0.94117647058823528
r2982 n1735 n1747 0.94117647058823528
r2983 n1736 n1748 16
r2984 n1737 n1749 2.9090909090909092
r2985 n1748 n1749 27.733333333333334
r2986 n1738 n1750 1.6842105263157894
r2987 n1749 n1750 64
r2988 n1739 n1751 16
r2989 n1750 n1751 44.799999999999997
r2990 n1740 n1752 0.94117647058823528
r2991 n1741 n1753 0.94117647058823528
r2992 n1742 n1754 16
r2993 n1743 n1755 4
r2994 n1754 n1755 32
r2995 n1744 n1756 1.4545454545454546
r2996 n1755 n1756 96
r2997 n1745 n1757 16
r2998 n1756 n1757 76.799999999999997
r2999 n1746 n1758 0.94117647058823528
r3000 n1747 n1759 0.94117647058823528
r3001 n1748 n1760 16
r3002 n1749 n1761 2.9090909090909092
r3003 n1760 n1761 41.600000000000001
r3004 n1750 n1762 1.6842105263157894
r3005 n1761 n1762 96
r3006 n1751 n1763 16
r3007 n1762 n1763 67.200000000000003
r3008 n1752 n1764 0.94117647058823528
r3009 n1753 n1765 6.0235294117647058
r3010 n1754 n1766 102.40000000000001
r3011 n1755 n1767 25.600000000000001
r3012 n1766 n1767 2.1333333333333333
r3013 n1756 n1768 9.3090909090909086
r3014 n1767 n1768 6.4000000000000004
r3015 n1757 n1769 102.40000000000001
r3016 n1768 n1769 5.1200000000000001
r3017 n1758 n1770 6.0235294117647058
r3018 n1759 n1771 6.0235294117647058
r3019 n1760 n1772 102.40000000000001
r3020 n1761 n1773 18.618181818181817
r3021 n1772 n1773 2.7733333333333334
r3022 n1762 n1774 10.778947368421052
r3023 n1773 n1774 6.4000000000000004
r3024 n1763 n1775 102.40000000000001
r3025 n1774 n1775 4.4800000000000004
r3026 n1764 n1776 6.0235294117647058
r3027 n1765 n1777 6.0235294117647058
r3028 n1766 n1778 102.40000000000001
r3029 n1767 n1779 25.600000000000001
r3030 n1778 n1779 32
r3031 n1768 n1780 9.3090909090909086
r3032 n1779 n1780 96
r3033 n1769 n1781 102.40000000000001
r3034 n1780 n1781 76.799999999999997
r3035 n1770 n1782 6.0235294117647058
r3036 n1771 n1783 6.0235294117647058
r3037 n1772 n1784 102.40000000000001
r3038 n1773 n1785 18.618181818181817
r3039 n1784 n1785 41.600000000000001
r3040 n1774 n1786 10.778947368421052
r3041 n1785 n1786 96
r3042 n1775 n1787 102.40000000000001
r3043 n1786 n1787 67.200000000000003
r3044 n1776 n1788 6.0235294117647058
r3045 n1777 n1789 0.94117647058823528
r3046 n1778 n1790 16
r3047 n1779 n1791 4
r3048 n1790 n1791 21.333333333333332
r3049 n1780 n1792 1.4545454545454546
r3050 n1791 n1792 64
r3051 n1781 n1793 16
r3052 n1792 n1793 51.200000000000003
r3053 n1782 n1794 0.94117647058823528
r3054 n1783 n1795 0.94117647058823528
r3055 n1784 n1796 16
r3056 n1785 n1797 2.9090909090909092
r3057 n1796 n1797 27.733333333333334
r3058 n1786 n1798 1.6842105263157894
r3059 n1797 n1798 64
r3060 n1787 n1799 16
r3061 n1798 n1799 44.799999999999997
r3062 n1788 n1800 0.94117647058823528
r3063 n1789 n1801 0.94117647058823528
r3064 n1790 n1802 16
r3065 n1791 n1803 4
r3066 n1802 n1803 32
r3067 n1792 n1804 1.4545454545454546
r3068 n1803 n1804 96
r3069 n1793 n1805 16
r3070 n1804 n1805 76.799999999999997
r3071 n1794 n1806 0.94117647058823528
r3072 n1795 n1807 0.94117647058823528
r3073 n1796 n1808 16
r3074 n1797 n1809 2.9090909090909092
r3075 n1808 n1809 41.600000000000001
r3076 n1798 n1810 1.6842105263157894
r3077 n1809 n1810 96
r3078 n1799 n1811 16
r3079 n1810 n1811 67.200000000000003
r3080 n1800 n1812 0.94117647058823528
r3081 n1801 n1813 1.5058823529411764
r3082 n1802 n1814 25.600000000000001
r3083 n1803 n1815 6.4000000000000004
r3084 n1814 n1815 10.666666666666666
r3085 n1804 n1816 2.3272727272727272
r3086 n1815 n1816 32
r3087 n1805 n1817 25.600000000000001
r3088 n1816 n1817 25.600000000000001
r3089 n1806 n1818 1.5058823529411764
r3090 n1807 n1819 1.5058823529411764
r3091 n1808 n1820 25.600000000000001
r3092 n1809 n1821 4.6545454545454543
r3093 n1820 n1821 13.866666666666667
r3094 n1810 n1822 2.6947368421052631
r3095 n1821 n1822 32
r3096 n1811 n1823 25.600000000000001
r3097 n1822 n1823 22.399999999999999
r3098 n1812 n1824 1.5058823529411764
r3099 n1813 n1825 1.5058823529411764
r3100 n1826 n1827 44.799999999999997
r3101 n1827 n1828 38.399999999999999
r3102 n1828 n1829 108.8
r3103 n1829 n1830 108.8
r3104 n1830 n1831 121.59999999999999
r3105 n1831 n1832 121.59999999999999
r3106 n1832 n1833 48
r3107 n1833 n1834 80
r3108 n1834 n1835 60.799999999999997
r3109 n1835 n1836 28.800000000000001
r3110 n1836 n1837 19.199999999999999
r3111 n1837 n1838 41.600000000000001
r3112 n1838 n1839 96
r3113 n1839 n1840 73.599999999999994
r3114 n1840 n1841 12.800000000000001
r3115 n1841 n1842 35.200000000000003
r3116 n1842 n1843 67.200000000000003
r3117 n1843 n1844 67.200000000000003
r3118 n1844 n1845 35.200000000000003
r3119 n1845 n1846 12.800000000000001
r3120 n1846 n1847 73.599999999999994
r3121 n1847 n1848 115.2
r3122 n1848 n1849 54.399999999999999
r3123 n1849 n1850 108.8
r3124 n1850 n1851 108.8
r3125 n1851 n1852 44.799999999999997
r3126 n1852 n1853 51.200000000000003
r3127 n1814 n1854 25.600000000000001
r3128 n1815 n1855 6.4000000000000004
r3129 n1854 n1855 32
r3130 n1816 n1856 2.3272727272727272
r3131 n1855 n1856 96
r3132 n1817 n1857 25.600000000000001
r3133 n1856 n1857 76.799999999999997
r3134 n1818 n1858 1.5058823529411764
r3135 n1819 n1859 1.5058823529411764
r3136 n1860 n1861 44.799999999999997
r3137 n1861 n1862 38.399999999999999
r3138 n1862 n1863 108.8
r3139 n1863 n1864 108.8
r3140 n1864 n1865 121.59999999999999
r3141 n1865 n1866 121.59999999999999
r3142 n1866 n1867 108.8
r3143 n1867 n1868 108.8
r3144 n1868 n1869 121.59999999999999
r3145 n1869 n1870 121.59999999999999
r3146 n1870 n1871 108.8
r3147 n1871 n1872 108.8
r3148 n1872 n1873 121.59999999999999
r3149 n1873 n1874 121.59999999999999
r3150 n1874 n1875 108.8
r3151 n1875 n1876 108.8
r3152 n1876 n1877 121.59999999999999
r3153 n1877 n1878 121.59999999999999
r3154 n1878 n1879 108.8
r3155 n1879 n1880 108.8
r3156 n1880 n1881 121.59999999999999
r3157 n1881 n1882 121.59999999999999
r3158 n1882 n1883 108.8
r3159 n1883 n1884 108.8
r3160 n1884 n1885 121.59999999999999
r3161 n1885 n1886 121.59999999999999
r3162 n1886 n1887 108.8
r3163 n1887 n1888 108.8
r3164 n1888 n1889 121.59999999999999
r3165 n1889 n1890 121.59999999999999
r3166 n1890 n1891 108.8
r3167 n1891 n1892 108.8
r3168 n1892 n1893 54.399999999999999
r3169 n1893 n1894 86.400000000000006
r3170 n1894 n1895 67.200000000000003
r3171 n1895 n1896 35.200000000000003
r3172 n1896 n1897 12.800000000000001
r3173 n1897 n1898 32
r3174 n1898 n1899 96
r3175 n1899 n1900 73.599999999999994
r3176 n1900 n1901 6.4000000000000004
r3177 n1901 n1902 6.4000000000000004
r3178 n1902 n1903 35.200000000000003
r3179 n1903 n1904 70.400000000000006
r3180 n1904 n1905 64
r3181 n1905 n1906 32
r3182 n1906 n1907 16
r3183 n1907 n1908 16
r3184 n1908 n1909 25.600000000000001
r3185 n1909 n1910 57.600000000000001
r3186 n1910 n1911 83.200000000000003
r3187 n1911 n1912 51.200000000000003
r3188 n1912 n1913 121.59999999999999
r3189 n1913 n1914 121.59999999999999
r3190 n1914 n1915 108.8
r3191 n1915 n1916 108.8
r3192 n1916 n1917 121.59999999999999
r3193 n1917 n1918 121.59999999999999
r3194 n1918 n1919 108.8
r3195 n1919 n1920 108.8
r3196 n1920 n1921 121.59999999999999
r3197 n1921 n1922 121.59999999999999
r3198 n1922 n1923 108.8
r3199 n1923 n1924 108.8
r3200 n1924 n1925 121.59999999999999
r3201 n1925 n1926 121.59999999999999
r3202 n1926 n1927 108.8
r3203 n1927 n1928 108.8
r3204 n1928 n1929 121.59999999999999
r3205 n1929 n1930 121.59999999999999
r3206 n1930 n1931 108.8
r3207 n1931 n1932 108.8
r3208 n1932 n1933 121.59999999999999
r3209 n1933 n1934 121.59999999999999
r3210 n1934 n1935 108.8
r3211 n1935 n1936 108.8
r3212 n1936 n1937 121.59999999999999
r3213 n1937 n1938 121.59999999999999
r3214 n1938 n1939 108.8
r3215 n1939 n1940 108.8
r3216 n1940 n1941 44.799999999999997
r3217 n1941 n1942 51.200000000000003
r3218 n1820 n1943 25.600000000000001
r3219 n1821 n1944 4.6545454545454543
r3220 n1943 n1944 41.600000000000001
r3221 n1822 n1945 2.6947368421052631
r3222 n1944 n1945 96
r3223 n1823 n1946 25.600000000000001
r3224 n1945 n1946 67.200000000000003
r3225 n1824 n1947 1.5058823529411764
r3226 n1825 n1948 0.94117647058823528
r3227 n1826 n1949 8
r3228 n1827 n1950 3.2000000000000002
r3229 n1949 n1950 29.866666666666667
r3230 n1828 n1951 16
r3231 n1950 n1951 25.600000000000001
r3232 n1829 n1952 1
r3233 n1951 n1952 72.533333333333331
r3234 n1830 n1953 16
r3235 n1952 n1953 72.533333333333331
r3236 n1831 n1954 0.88888888888888884
r3237 n1953 n1954 81.066666666666663
r3238 n1832 n1955 16
r3239 n1954 n1955 81.066666666666663
r3240 n1833 n1956 2.4615384615384617
r3241 n1955 n1956 32
r3242 n1834 n1957 2.6666666666666665
r3243 n1956 n1957 53.333333333333336
r3244 n1835 n1958 4.5714285714285712
r3245 n1957 n1958 40.533333333333331
r3246 n1836 n1959 16
r3247 n1958 n1959 19.199999999999999
r3248 n1837 n1960 8
r3249 n1959 n1960 12.800000000000001
r3250 n1838 n1961 3.5555555555555554
r3251 n1960 n1961 27.733333333333334
r3252 n1839 n1962 1.5238095238095237
r3253 n1961 n1962 64
r3254 n1840 n1963 16
r3255 n1962 n1963 49.06666666666667
r3256 n1841 n1964 16
r3257 n1963 n1964 8.5333333333333332
r3258 n1842 n1965 3.5555555555555554
r3259 n1964 n1965 23.466666666666665
r3260 n1843 n1966 2.6666666666666665
r3261 n1965 n1966 44.799999999999997
r3262 n1844 n1967 3.5555555555555554
r3263 n1966 n1967 44.799999999999997
r3264 n1845 n1968 16
r3265 n1967 n1968 23.466666666666665
r3266 n1846 n1969 16
r3267 n1968 n1969 8.5333333333333332
r3268 n1847 n1970 1.5238095238095237
r3269 n1969 n1970 49.06666666666667
r3270 n1848 n1971 2.1333333333333333
r3271 n1970 n1971 76.799999999999997
r3272 n1849 n1972 16
r3273 n1971 n1972 36.266666666666666
r3274 n1850 n1973 1
r3275 n1972 n1973 72.533333333333331
r3276 n1851 n1974 16
r3277 n1973 n1974 72.533333333333331
r3278 n1852 n1975 2.6666666666666665
r3279 n1974 n1975 29.866666666666667
r3280 n1853 n1976 8
r3281 n1975 n1976 34.133333333333333
r3282 n1854 n1977 16
r3283 n1855 n1978 4
r3284 n1977 n1978 21.333333333333332
r3285 n1856 n1979 1.4545454545454546
r3286 n1978 n1979 64
r3287 n1857 n1980 16
r3288 n1979 n1980 51.200000000000003
r3289 n1858 n1981 0.94117647058823528
r3290 n1859 n1982 0.94117647058823528
r3291 n1860 n1983 8
r3292 n1861 n1984 3.2000000000000002
r3293 n1983 n1984 29.866666666666667
r3294 n1862 n1985 16
r3295 n1984 n1985 25.600000000000001
r3296 n1863 n1986 1
r3297 n1985 n1986 72.533333333333331
r3298 n1864 n1987 16
r3299 n1986 n1987 72.533333333333331
r3300 n1865 n1988 0.88888888888888884
r3301 n1987 n1988 81.066666666666663
r3302 n1866 n1989 16
r3303 n1988 n1989 81.066666666666663
r3304 n1867 n1990 1
r3305 n1989 n1990 72.533333333333331
r3306 n1868 n1991 16
r3307 n1990 n1991 72.533333333333331
r3308 n1869 n1992 0.88888888888888884
r3309 n1991 n1992 81.066666666666663
r3310 n1870 n1993 16
r3311 n1992 n1993 81.066666666666663
r3312 n1871 n1994 1
r3313 n1993 n1994 72.533333333333331
r3314 n1872 n1995 16
r3315 n1994 n1995 72.533333333333331
r3316 n1873 n1996 0.88888888888888884
r3317 n1995 n1996 81.066666666666663
r3318 n1874 n1997 16
r3319 n1996 n1997 81.066666666666663
r3320 n1875 n1998 1
r3321 n1997 n1998 72.533333333333331
r3322 n1876 n1999 16
r3323 n1998 n1999 72.533333333333331
r3324 n1877 n2000 0.88888888888888884
r3325 n1999 n2000 81.066666666666663
r3326 n1878 n2001 16
r3327 n2000 n2001 81.066666666666663
r3328 n1879 n2002 1
r3329 n2001 n2002 72.533333333333331
r3330 n1880 n2003 16
r3331 n2002 n2003 72.533333333333331
r3332 n1881 n2004 0.88888888888888884
r3333 n2003 n2004 81.066666666666663
r3334 n1882 n2005 16
r3335 n2004 n2005 81.066666666666663
r3336 n1883 n2006 1
r3337 n2005 n2006 72.533333333333331
r3338 n1884 n2007 16
r3339 n2006 n2007 72.533333333333331
r3340 n1885 n2008 0.88888888888888884
r3341 n2007 n2008 81.066666666666663
r3342 n1886 n2009 16
r3343 n2008 n2009 81.066666666666663
r3344 n1887 n2010 1
r3345 n2009 n2010 72.533333333333331
r3346 n1888 n2011 16
r3347 n2010 n2011 72.533333333333331
r3348 n1889 n2012 0.88888888888888884
r3349 n2011 n2012 81.066666666666663
r3350 n1890 n2013 16
r3351 n2012 n2013 81.066666666666663
r3352 n1891 n2014 1
r3353 n2013 n2014 72.533333333333331
r3354 n1892 n2015 16
r3355 n2014 n2015 72.533333333333331
r3356 n1893 n2016 2.1333333333333333
r3357 n2015 n2016 36.266666666666666
r3358 n1894 n2017 2.6666666666666665
r3359 n2016 n2017 57.600000000000001
r3360 n1895 n2018 3.5555555555555554
r3361 n2017 n2018 44.799999999999997
r3362 n1896 n2019 16
r3363 n2018 n2019 23.466666666666665
r3364 n1897 n2020 16
r3365 n2019 n2020 8.5333333333333332
r3366 n1898 n2021 4
r3367 n2020 n2021 21.333333333333332
r3368 n1899 n2022 1.4545454545454546
r3369 n2021 n2022 64
r3370 n1900 n2023 32
r3371 n2022 n2023 49.06666666666667
r3372 n1901 n2024 32
r3373 n2023 n2024 4.2666666666666666
r3374 n1902 n2025 32
r3375 n2024 n2025 4.2666666666666666
r3376 n1903 n2026 3.2000000000000002
r3377 n2025 n2026 23.466666666666665
r3378 n1904 n2027 2.6666666666666665
r3379 n2026 n2027 46.93333333333333
r3380 n1905 n2028 4
r3381 n2027 n2028 42.666666666666664
r3382 n1906 n2029 16
r3383 n2028 n2029 21.333333333333332
r3384 n1907 n2030 10.666666666666666
r3385 n2029 n2030 10.666666666666666
r3386 n1908 n2031 16
r3387 n2030 n2031 10.666666666666666
r3388 n1909 n2032 5.333333333333333
r3389 n2031 n2032 17.066666666666666
r3390 n1910 n2033 2.6666666666666665
r3391 n2032 n2033 38.399999999999999
r3392 n1911 n2034 2.2857142857142856
r3393 n2033 n2034 55.466666666666669
r3394 n1912 n2035 16
r3395 n2034 n2035 34.133333333333333
r3396 n1913 n2036 0.88888888888888884
r3397 n2035 n2036 81.066666666666663
r3398 n1914 n2037 16
r3399 n2036 n2037 81.066666666666663
r3400 n1915 n2038 1
r3401 n2037 n2038 72.533333333333331
r3402 n1916 n2039 16
r3403 n2038 n2039 72.533333333333331
r3404 n1917 n2040 0.88888888888888884
r3405 n2039 n2040 81.066666666666663
r3406 n1918 n2041 16
r3407 n2040 n2041 81.066666666666663
r3408 n1919 n2042 1
r3409 n2041 n2042 72.533333333333331
r3410 n1920 n2043 16
r3411 n2042 n2043 72.533333333333331
r3412 n1921 n2044 0.88888888888888884
r3413 n2043 n2044 81.066666666666663
r3414 n1922 n2045 16
r3415 n2044 n2045 81.066666666666663
r3416 n1923 n2046 1
r3417 n2045 n2046 72.533333333333331
r3418 n1924 n2047 16
r3419 n2046 n2047 72.533333333333331
r3420 n1925 n2048 0.88888888888888884
r3421 n2047 n2048 81.066666666666663
r3422 n1926 n2049 16
r3423 n2048 n2049 81.066666666666663
r3424 n1927 n2050 1
r3425 n2049 n2050 72.533333333333331
r3426 n1928 n2051 16
r3427 n2050 n2051 72.533333333333331
r3428 n1929 n2052 0.88888888888888884
r3429 n2051 n2052 81.066666666666663
r3430 n1930 n2053 16
r3431 n2052 n2053 81.066666666666663
r3432 n1931 n2054 1
r3433 n2053 n2054 72.533333333333331
r3434 n1932 n2055 16
r3435 n2054 n2055 72.533333333333331
r3436 n1933 n2056 0.88888888888888884
r3437 n2055 n2056 81.066666666666663
r3438 n1934 n2057 16
r3439 n2056 n2057 81.066666666666663
r3440 n1935 n2058 1
r3441 n2057 n2058 72.533333333333331
r3442 n1936 n2059 16
r3443 n2058 n2059 72.533333333333331
r3444 n1937 n2060 0.88888888888888884
r3445 n2059 n2060 81.066666666666663
r3446 n1938 n2061 16
r3447 n2060 n2061 81.066666666666663
r3448 n1939 n2062 1
r3449 n2061 n2062 72.533333333333331
r3450 n1940 n2063 16
r3451 n2062 n2063 72.533333333333331
r3452 n1941 n2064 2.6666666666666665
r3453 n2063 n2064 29.866666666666667
r3454 n1942 n2065 8
r3455 n2064 n2065 34.133333333333333
r3456 n1943 n2066 16
r3457 n1944 n2067 2.9090909090909092
r3458 n2066 n2067 27.733333333333334
r3459 n1945 n2068 1.6842105263157894
r3460 n2067 n2068 64
r3461 n1946 n2069 16
r3462 n2068 n2069 44.799999999999997
r3463 n1947 n2070 0.94117647058823528
r3464 n1948 n2071 1.3176470588235294
r3465 n1949 n2072 11.199999999999999
r3466 n1950 n2073 4.4800000000000004
r3467 n2072 n2073 22.399999999999999
r3468 n1951 n2074 22.399999999999999
r3469 n2073 n2074 19.199999999999999
r3470 n1952 n2075 1.3999999999999999
r3471 n2074 n2075 54.399999999999999
r3472 n1953 n2076 22.399999999999999
r3473 n2075 n2076 54.399999999999999
r3474 n1954 n2077 1.2444444444444445
r3475 n2076 n2077 60.799999999999997
r3476 n1955 n2078 22.399999999999999
r3477 n2077 n2078 60.799999999999997
r3478 n1956 n2079 3.4461538461538463
r3479 n2078 n2079 24
r3480 n1957 n2080 3.7333333333333334
r3481 n2079 n2080 40
r3482 n1958 n2081 6.4000000000000004
r3483 n2080 n2081 30.399999999999999
r3484 n1959 n2082 22.399999999999999
r3485 n2081 n2082 14.4
r3486 n1960 n2083 11.199999999999999
r3487 n2082 n2083 9.5999999999999996
r3488 n1961 n2084 4.9777777777777779
r3489 n2083 n2084 20.800000000000001
r3490 n1962 n2085 2.1333333333333333
r3491 n2084 n2085 48
r3492 n1963 n2086 22.399999999999999
r3493 n2085 n2086 36.799999999999997
r3494 n1964 n2087 22.399999999999999
r3495 n2086 n2087 6.4000000000000004
r3496 n1965 n2088 4.9777777777777779
r3497 n2087 n2088 17.600000000000001
r3498 n1966 n2089 3.7333333333333334
r3499 n2088 n2089 33.600000000000001
r3500 n1967 n2090 4.9777777777777779
r3501 n2089 n2090 33.600000000000001
r3502 n1968 n2091 22.399999999999999
r3503 n2090 n2091 17.600000000000001
r3504 n1969 n2092 22.399999999999999
r3505 n2091 n2092 6.4000000000000004
r3506 n1970 n2093 2.1333333333333333
r3507 n2092 n2093 36.799999999999997
r3508 n1971 n2094 2.9866666666666668
r3509 n2093 n2094 57.600000000000001
r3510 n1972 n2095 22.399999999999999
r3511 n2094 n2095 27.199999999999999
r3512 n1973 n2096 1.3999999999999999
r3513 n2095 n2096 54.399999999999999
r3514 n1974 n2097 22.399999999999999
r3515 n2096 n2097 54.399999999999999
r3516 n1975 n2098 3.7333333333333334
r3517 n2097 n2098 22.399999999999999
r3518 n1976 n2099 11.199999999999999
r3519 n2098 n2099 25.600000000000001
r3520 n1981 n2100 1.3176470588235294
r3521 n1982 n2101 1.3176470588235294
r3522 n1983 n2102 11.199999999999999
r3523 n1984 n2103 4.4800000000000004
r3524 n2102 n2103 22.399999999999999
r3525 n1985 n2104 22.399999999999999
r3526 n2103 n2104 19.199999999999999
r3527 n1986 n2105 1.3999999999999999
r3528 n2104 n2105 54.399999999999999
r3529 n1987 n2106 22.399999999999999
r3530 n2105 n2106 54.399999999999999
r3531 n1988 n2107 1.2444444444444445
r3532 n2106 n2107 60.799999999999997
r3533 n1989 n2108 22.399999999999999
r3534 n2107 n2108 60.799999999999997
r3535 n1990 n2109 1.3999999999999999
r3536 n2108 n2109 54.399999999999999
r3537 n1991 n2110 22.399999999999999
r3538 n2109 n2110 54.399999999999999
r3539 n1992 n2111 1.2444444444444445
r3540 n2110 n2111 60.799999999999997
r3541 n1993 n2112 22.399999999999999
r3542 n2111 n2112 60.799999999999997
r3543 n1994 n2113 1.3999999999999999
r3544 n2112 n2113 54.399999999999999
r3545 n1995 n2114 22.399999999999999
r3546 n2113 n2114 54.399999999999999
r3547 n1996 n2115 1.2444444444444445
r3548 n2114 n2115 60.799999999999997
r3549 n1997 n2116 22.399999999999999
r3550 n2115 n2116 60.799999999999997
r3551 n1998 n2117 1.3999999999999999
r3552 n2116 n2117 54.399999999999999
r3553 n1999 n2118 22.399999999999999
r3554 n2117 n2118 54.399999999999999
r3555 n2000 n2119 1.2444444444444445
r3556 n2118 n2119 60.799999999999997
r3557 n2001 n2120 22.399999999999999
r3558 n2119 n2120 60.799999999999997
r3559 n2002 n2121 1.3999999999999999
r3560 n2120 n2121 54.399999999999999
r3561 n2003 n2122 22.399999999999999
r3562 n2121 n2122 54.399999999999999
r3563 n2004 n2123 1.2444444444444445
r3564 n2122 n2123 60.799999999999997
r3565 n2005 n2124 22.399999999999999
r3566 n2123 n2124 60.799999999999997
r3567 n2006 n2125 1.3999999999999999
r3568 n2124 n2125 54.399999999999999
r3569 n2007 n2126 22.399999999999999
r3570 n2125 n2126 54.399999999999999
r3571 n2008 n2127 1.2444444444444445
r3572 n2126 n2127 60.799999999999997
r3573 n2009 n2128 22.399999999999999
r3574 n2127 n2128 60.799999999999997
r3575 n2010 n2129 1.3999999999999999
r3576 n2128 n2129 54.399999999999999
r3577 n2011 n2130 22.399999999999999
r3578 n2129 n2130 54.399999999999999
r3579 n2012 n2131 1.2444444444444445
r3580 n2130 n2131 60.799999999999997
r3581 n2013 n2132 22.399999999999999
r3582 n2131 n2132 60.799999999999997
r3583 n2014 n2133 1.3999999999999999
r3584 n2132 n2133 54.399999999999999
r3585 n2015 n2134 22.399999999999999
r3586 n2133 n2134 54.399999999999999
r3587 n2016 n2135 2.9866666666666668
r3588 n2134 n2135 27.199999999999999
r3589 n2017 n2136 3.7333333333333334
r3590 n2135 n2136 43.200000000000003
r3591 n2018 n2137 4.9777777777777779
r3592 n2136 n2137 33.600000000000001
r3593 n2019 n2138 22.399999999999999
r3594 n2137 n2138 17.600000000000001
r3595 n2020 n2139 22.399999999999999
r3596 n2138 n2139 6.4000000000000004
r3597 n2021 n2140 5.5999999999999996
r3598 n2139 n2140 16
r3599 n2022 n2141 2.0363636363636362
r3600 n2140 n2141 48
r3601 n2023 n2142 44.799999999999997
r3602 n2141 n2142 36.799999999999997
r3603 n2024 n2143 44.799999999999997
r3604 n2142 n2143 3.2000000000000002
r3605 n2025 n2144 44.799999999999997
r3606 n2143 n2144 3.2000000000000002
r3607 n2026 n2145 4.4800000000000004
r3608 n2144 n2145 17.600000000000001
r3609 n2027 n2146 3.7333333333333334
r3610 n2145 n2146 35.200000000000003
r3611 n2028 n2147 5.5999999999999996
r3612 n2146 n2147 32
r3613 n2029 n2148 22.399999999999999
r3614 n2147 n2148 16
r3615 n2030 n2149 14.933333333333334
r3616 n2148 n2149 8
r3617 n2031 n2150 22.399999999999999
r3618 n2149 n2150 8
r3619 n2032 n2151 7.4666666666666668
r3620 n2150 n2151 12.800000000000001
r3621 n2033 n2152 3.7333333333333334
r3622 n2151 n2152 28.800000000000001
r3623 n2034 n2153 3.2000000000000002
r3624 n2152 n2153 41.600000000000001
r3625 n2035 n2154 22.399999999999999
r3626 n2153 n2154 25.600000000000001
r3627 n2036 n2155 1.2444444444444445
r3628 n2154 n2155 60.799999999999997
r3629 n2037 n2156 22.399999999999999
r3630 n2155 n2156 60.799999999999997
r3631 n2038 n2157 1.3999999999999999
r3632 n2156 n2157 54.399999999999999
r3633 n2039 n2158 22.399999999999999
r3634 n2157 n2158 54.399999999999999
r3635 n2040 n2159 1.2444444444444445
r3636 n2158 n2159 60.799999999999997
r3637 n2041 n2160 22.399999999999999
r3638 n2159 n2160 60.799999999999997
r3639 n2042 n2161 1.3999999999999999
r3640 n2160 n2161 54.399999999999999
r3641 n2043 n2162 22.399999999999999
r3642 n2161 n2162 54.399999999999999
r3643 n2044 n2163 1.2444444444444445
r3644 n2162 n2163 60.799999999999997
r3645 n2045 n2164 22.399999999999999
r3646 n2163 n2164 60.799999999999997
r3647 n2046 n2165 1.3999999999999999
r3648 n2164 n2165 54.399999999999999
r3649 n2047 n2166 22.399999999999999
r3650 n2165 n2166 54.399999999999999
r3651 n2048 n2167 1.2444444444444445
r3652 n2166 n2167 60.799999999999997
r3653 n2049 n2168 22.399999999999999
r3654 n2167 n2168 60.799999999999997
r3655 n2050 n2169 1.3999999999999999
r3656 n2168 n2169 54.399999999999999
r3657 n2051 n2170 22.399999999999999
r3658 n2169 n2170 54.399999999999999
r3659 n2052 n2171 1.2444444444444445
r3660 n2170 n2171 60.799999999999997
r3661 n2053 n2172 22.399999999999999
r3662 n2171 n2172 60.799999999999997
r3663 n2054 n2173 1.3999999999999999
r3664 n2172 n2173 54.399999999999999
r3665 n2055 n2174 22.399999999999999
r3666 n2173 n2174 54.399999999999999
r3667 n2056 n2175 1.2444444444444445
r3668 n2174 n2175 60.799999999999997
r3669 n2057 n2176 22.399999999999999
r3670 n2175 n2176 60.799999999999997
r3671 n2058 n2177 1.3999999999999999
r3672 n2176 n2177 54.399999999999999
r3673 n2059 n2178 22.399999999999999
r3674 n2177 n2178 54.399999999999999
r3675 n2060 n2179 1.2444444444444445
r3676 n2178 n2179 60.799999999999997
r3677 n2061 n2180 22.399999999999999
r3678 n2179 n2180 60.799999999999997
r3679 n2062 n2181 1.3999999999999999
r3680 n2180 n2181 54.399999999999999
r3681 n2063 n2182 22.399999999999999
r3682 n2181 n2182 54.399999999999999
r3683 n2064 n2183 3.7333333333333334
r3684 n2182 n2183 22.399999999999999
r3685 n2065 n2184 11.199999999999999
r3686 n2183 n2184 25.600000000000001
r3687 n2070 n2185 1.3176470588235294
r3688 n2071 n2186 1.3176470588235294
r3689 n2072 n2187 11.199999999999999
r3690 n2073 n2188 4.4800000000000004
r3691 n2187 n2188 29.866666666666667
r3692 n2074 n2189 22.399999999999999
r3693 n2188 n2189 25.600000000000001
r3694 n2075 n2190 1.3999999999999999
r3695 n2189 n2190 72.533333333333331
r3696 n2076 n2191 22.399999999999999
r3697 n2190 n2191 72.533333333333331
r3698 n2077 n2192 1.2444444444444445
r3699 n2191 n2192 81.066666666666663
r3700 n2078 n2193 22.399999999999999
r3701 n2192 n2193 81.066666666666663
r3702 n2079 n2194 3.4461538461538463
r3703 n2193 n2194 32
r3704 n2080 n2195 3.7333333333333334
r3705 n2194 n2195 53.333333333333336
r3706 n2081 n2196 6.4000000000000004
r3707 n2195 n2196 40.533333333333331
r3708 n2082 n2197 22.399999999999999
r3709 n2196 n2197 19.199999999999999
r3710 n2083 n2198 11.199999999999999
r3711 n2197 n2198 12.800000000000001
r3712 n2084 n2199 4.9777777777777779
r3713 n2198 n2199 27.733333333333334
r3714 n2085 n2200 2.1333333333333333
r3715 n2199 n2200 64
r3716 n2086 n2201 22.399999999999999
r3717 n2200 n2201 49.06666666666667
r3718 n2087 n2202 22.399999999999999
r3719 n2201 n2202 8.5333333333333332
r3720 n2088 n2203 4.9777777777777779
r3721 n2202 n2203 23.466666666666665
r3722 n2089 n2204 3.7333333333333334
r3723 n2203 n2204 44.799999999999997
r3724 n2090 n2205 4.9777777777777779
r3725 n2204 n2205 44.799999999999997
r3726 n2091 n2206 22.399999999999999
r3727 n2205 n2206 23.466666666666665
r3728 n2092 n2207 22.399999999999999
r3729 n2206 n2207 8.5333333333333332
r3730 n2093 n2208 2.1333333333333333
r3731 n2207 n2208 49.06666666666667
r3732 n2094 n2209 2.9866666666666668
r3733 n2208 n2209 76.799999999999997
r3734 n2095 n2210 22.399999999999999
r3735 n2209 n2210 36.266666666666666
r3736 n2096 n2211 1.3999999999999999
r3737 n2210 n2211 72.533333333333331
r3738 n2097 n2212 22.399999999999999
r3739 n2211 n2212 72.533333333333331
r3740 n2098 n2213 3.7333333333333334
r3741 n2212 n2213 29.866666666666667
r3742 n2099 n2214 11.199999999999999
r3743 n2213 n2214 34.133333333333333
r3744 n2100 n2215 1.3176470588235294
r3745 n2101 n2216 1.3176470588235294
r3746 n2102 n2217 11.199999999999999
r3747 n2103 n2218 4.4800000000000004
r3748 n2217 n2218 29.866666666666667
r3749 n2104 n2219 22.399999999999999
r3750 n2218 n2219 25.600000000000001
r3751 n2105 n2220 1.3999999999999999
r3752 n2219 n2220 72.533333333333331
r3753 n2106 n2221 22.399999999999999
r3754 n2220 n2221 72.533333333333331
r3755 n2107 n2222 1.2444444444444445
r3756 n2221 n2222 81.066666666666663
r3757 n2108 n2223 22.399999999999999
r3758 n2222 n2223 81.066666666666663
r3759 n2109 n2224 1.3999999999999999
r3760 n2223 n2224 72.533333333333331
r3761 n2110 n2225 22.399999999999999
r3762 n2224 n2225 72.533333333333331
r3763 n2111 n2226 1.2444444444444445
r3764 n2225 n2226 81.066666666666663
r3765 n2112 n2227 22.399999999999999
r3766 n2226 n2227 81.066666666666663
r3767 n2113 n2228 1.3999999999999999
r3768 n2227 n2228 72.533333333333331
r3769 n2114 n2229 22.399999999999999
r3770 n2228 n2229 72.533333333333331
r3771 n2115 n2230 1.2444444444444445
r3772 n2229 n2230 81.066666666666663
r3773 n2116 n2231 22.399999999999999
r3774 n2230 n2231 81.066666666666663
r3775 n2117 n2232 1.3999999999999999
r3776 n2231 n2232 72.533333333333331
r3777 n2118 n2233 22.399999999999999
r3778 n2232 n2233 72.533333333333331
r3779 n2119 n2234 1.2444444444444445
r3780 n2233 n2234 81.066666666666663
r3781 n2120 n2235 22.399999999999999
r3782 n2234 n2235 81.066666666666663
r3783 n2121 n2236 1.3999999999999999
r3784 n2235 n2236 72.533333333333331
r3785 n2122 n2237 22.399999999999999
r3786 n2236 n2237 72.533333333333331
r3787 n2123 n2238 1.2444444444444445
r3788 n2237 n2238 81.066666666666663
r3789 n2124 n2239 22.399999999999999
r3790 n2238 n2239 81.066666666666663
r3791 n2125 n2240 1.3999999999999999
r3792 n2239 n2240 72.533333333333331
r3793 n2126 n2241 22.399999999999999
r3794 n2240 n2241 72.533333333333331
r3795 n2127 n2242 1.2444444444444445
r3796 n2241 n2242 81.066666666666663
r3797 n2128 n2243 22.399999999999999
r3798 n2242 n2243 81.066666666666663
r3799 n2129 n2244 1.3999999999999999
r3800 n2243 n2244 72.533333333333331
r3801 n2130 n2245 22.399999999999999
r3802 n2244 n2245 72.533333333333331
r3803 n2131 n2246 1.2444444444444445
r3804 n2245 n2246 81.066666666666663
r3805 n2132 n2247 22.399999999999999
r3806 n2246 n2247 81.066666666666663
r3807 n2133 n2248 1.3999999999999999
r3808 n2247 n2248 72.533333333333331
r3809 n2134 n2249 22.399999999999999
r3810 n2248 n2249 72.533333333333331
r3811 n2135 n2250 2.9866666666666668
r3812 n2249 n2250 36.266666666666666
r3813 n2136 n2251 3.7333333333333334
r3814 n2250 n2251 57.600000000000001
r3815 n2137 n2252 4.9777777777777779
r3816 n2251 n2252 44.799999999999997
r3817 n2138 n2253 22.399999999999999
r3818 n2252 n2253 23.466666666666665
r3819 n2139 n2254 22.399999999999999
r3820 n2253 n2254 8.5333333333333332
r3821 n2140 n2255 5.5999999999999996
r3822 n2254 n2255 21.333333333333332
r3823 n2141 n2256 2.0363636363636362
r3824 n2255 n2256 64
r3825 n2142 n2257 44.799999999999997
r3826 n2256 n2257 49.06666666666667
r3827 n2143 n2258 44.799999999999997
r3828 n2257 n2258 4.2666666666666666
r3829 n2144 n2259 44.799999999999997
r3830 n2258 n2259 4.2666666666666666
r3831 n2145 n2260 4.4800000000000004
r3832 n2259 n2260 23.466666666666665
r3833 n2146 n2261 3.7333333333333334
r3834 n2260 n2261 46.93333333333333
r3835 n2147 n2262 5.5999999999999996
r3836 n2261 n2262 42.666666666666664
r3837 n2148 n2263 22.399999999999999
r3838 n2262 n2263 21.333333333333332
r3839 n2149 n2264 14.933333333333334
r3840 n2263 n2264 10.666666666666666
r3841 n2150 n2265 22.399999999999999
r3842 n2264 n2265 10.666666666666666
r3843 n2151 n2266 7.4666666666666668
r3844 n2265 n2266 17.066666666666666
r3845 n2152 n2267 3.7333333333333334
r3846 n2266 n2267 38.399999999999999
r3847 n2153 n2268 3.2000000000000002
r3848 n2267 n2268 55.466666666666669
r3849 n2154 n2269 22.399999999999999
r3850 n2268 n2269 34.133333333333333
r3851 n2155 n2270 1.2444444444444445
r3852 n2269 n2270 81.066666666666663
r3853 n2156 n2271 22.399999999999999
r3854 n2270 n2271 81.066666666666663
r3855 n2157 n2272 1.3999999999999999
r3856 n2271 n2272 72.533333333333331
r3857 n2158 n2273 22.399999999999999
r3858 n2272 n2273 72.533333333333331
r3859 n2159 n2274 1.2444444444444445
r3860 n2273 n2274 81.066666666666663
r3861 n2160 n2275 22.399999999999999
r3862 n2274 n2275 81.066666666666663
r3863 n2161 n2276 1.3999999999999999
r3864 n2275 n2276 72.533333333333331
r3865 n2162 n2277 22.399999999999999
r3866 n2276 n2277 72.533333333333331
r3867 n2163 n2278 1.2444444444444445
r3868 n2277 n2278 81.066666666666663
r3869 n2164 n2279 22.399999999999999
r3870 n2278 n2279 81.066666666666663
r3871 n2165 n2280 1.3999999999999999
r3872 n2279 n2280 72.533333333333331
r3873 n2166 n2281 22.399999999999999
r3874 n2280 n2281 72.533333333333331
r3875 n2167 n2282 1.2444444444444445
r3876 n2281 n2282 81.066666666666663
r3877 n2168 n2283 22.399999999999999
r3878 n2282 n2283 81.066666666666663
r3879 n2169 n2284 1.3999999999999999
r3880 n2283 n2284 72.533333333333331
r3881 n2170 n2285 22.399999999999999
r3882 n2284 n2285 72.533333333333331
r3883 n2171 n2286 1.2444444444444445
r3884 n2285 n2286 81.066666666666663
r3885 n2172 n2287 22.399999999999999
r3886 n2286 n2287 81.066666666666663
r3887 n2173 n2288 1.3999999999999999
r3888 n2287 n2288 72.533333333333331
r3889 n2174 n2289 22.399999999999999
r3890 n2288 n2289 72.533333333333331
r3891 n2175 n2290 1.2444444444444445
r3892 n2289 n2290 81.066666666666663
r3893 n2176 n2291 22.399999999999999
r3894 n2290 n2291 81.066666666666663
r3895 n2177 n2292 1.3999999999999999
r3896 n2291 n2292 72.533333333333331
r3897 n2178 n2293 22.399999999999999
r3898 n2292 n2293 72.533333333333331
r3899 n2179 n2294 1.2444444444444445
r3900 n2293 n2294 81.066666666666663
r3901 n2180 n2295 22.399999999999999
r3902 n2294 n2295 81.066666666666663
r3903 n2181 n2296 1.3999999999999999
r3904 n2295 n2296 72.533333333333331
r3905 n2182 n2297 22.399999999999999
r3906 n2296 n2297 72.533333333333331
r3907 n2183 n2298 3.7333333333333334
r3908 n2297 n2298 29.866666666666667
r3909 n2184 n2299 11.199999999999999
r3910 n2298 n2299 34.133333333333333
r3911 n2185 n2300 1.3176470588235294
r3912 n2186 n2301 3.388235294117647
r3913 n2187 n2302 28.800000000000001
r3914 n2188 n2303 11.52
r3915 n2302 n2303 5.9733333333333336
r3916 n2189 n2304 57.600000000000001
r3917 n2303 n2304 5.1200000000000001
r3918 n2190 n2305 3.6000000000000001
r3919 n2304 n2305 14.506666666666666
r3920 n2191 n2306 57.600000000000001
r3921 n2305 n2306 14.506666666666666
r3922 n2192 n2307 3.2000000000000002
r3923 n2306 n2307 16.213333333333335
r3924 n2193 n2308 57.600000000000001
r3925 n2307 n2308 16.213333333333335
r3926 n2194 n2309 8.861538461538462
r3927 n2308 n2309 6.4000000000000004
r3928 n2195 n2310 9.5999999999999996
r3929 n2309 n2310 10.666666666666666
r3930 n2196 n2311 16.457142857142856
r3931 n2310 n2311 8.1066666666666674
r3932 n2197 n2312 57.600000000000001
r3933 n2311 n2312 3.8399999999999999
r3934 n2198 n2313 28.800000000000001
r3935 n2312 n2313 2.5600000000000001
r3936 n2199 n2314 12.800000000000001
r3937 n2313 n2314 5.5466666666666669
r3938 n2200 n2315 5.4857142857142858
r3939 n2314 n2315 12.800000000000001
r3940 n2201 n2316 57.600000000000001
r3941 n2315 n2316 9.8133333333333326
r3942 n2202 n2317 57.600000000000001
r3943 n2316 n2317 1.7066666666666668
r3944 n2203 n2318 12.800000000000001
r3945 n2317 n2318 4.6933333333333334
r3946 n2204 n2319 9.5999999999999996
r3947 n2318 n2319 8.9600000000000009
r3948 n2205 n2320 12.800000000000001
r3949 n2319 n2320 8.9600000000000009
r3950 n2206 n2321 57.600000000000001
r3951 n2320 n2321 4.6933333333333334
r3952 n2207 n2322 57.600000000000001
r3953 n2321 n2322 1.7066666666666668
r3954 n2208 n2323 5.4857142857142858
r3955 n2322 n2323 9.8133333333333326
r3956 n2209 n2324 7.6799999999999997
r3957 n2323 n2324 15.359999999999999
r3958 n2210 n2325 57.600000000000001
r3959 n2324 n2325 7.253333333333333
r3960 n2211 n2326 3.6000000000000001
r3961 n2325 n2326 14.506666666666666
r3962 n2212 n2327 57.600000000000001
r3963 n2326 n2327 14.506666666666666
r3964 n2213 n2328 9.5999999999999996
r3965 n2327 n2328 5.9733333333333336
r3966 n2214 n2329 28.800000000000001
r3967 n2328 n2329 6.8266666666666671
r3968 n2215 n2330 3.388235294117647
r3969 n2216 n2331 3.388235294117647
r3970 n2217 n2332 28.800000000000001
r3971 n2218 n2333 11.52
r3972 n2332 n2333 5.9733333333333336
r3973 n2219 n2334 57.600000000000001
r3974 n2333 n2334 5.1200000000000001
r3975 n2220 n2335 3.6000000000000001
r3976 n2334 n2335 14.506666666666666
r3977 n2221 n2336 57.600000000000001
r3978 n2335 n2336 14.506666666666666
r3979 n2222 n2337 3.2000000000000002
r3980 n2336 n2337 16.213333333333335
r3981 n2223 n2338 57.600000000000001
r3982 n2337 n2338 16.213333333333335
r3983 n2224 n2339 3.6000000000000001
r3984 n2338 n2339 14.506666666666666
r3985 n2225 n2340 57.600000000000001
r3986 n2339 n2340 14.506666666666666
r3987 n2226 n2341 3.2000000000000002
r3988 n2340 n2341 16.213333333333335
r3989 n2227 n2342 57.600000000000001
r3990 n2341 n2342 16.213333333333335
r3991 n2228 n2343 3.6000000000000001
r3992 n2342 n2343 14.506666666666666
r3993 n2229 n2344 57.600000000000001
r3994 n2343 n2344 14.506666666666666
r3995 n2230 n2345 3.2000000000000002
r3996 n2344 n2345 16.213333333333335
r3997 n2231 n2346 57.600000000000001
r3998 n2345 n2346 16.213333333333335
r3999 n2232 n2347 3.6000000000000001
r4000 n2346 n2347 14.506666666666666
r4001 n2233 n2348 57.600000000000001
r4002 n2347 n2348 14.506666666666666
r4003 n2234 n2349 3.2000000000000002
r4004 n2348 n2349 16.213333333333335
r4005 n2235 n2350 57.600000000000001
r4006 n2349 n2350 16.213333333333335
r4007 n2236 n2351 3.6000000000000001
r4008 n2350 n2351 14.506666666666666
r4009 n2237 n2352 57.600000000000001
r4010 n2351 n2352 14.506666666666666
r4011 n2238 n2353 3.2000000000000002
r4012 n2352 n2353 16.213333333333335
r4013 n2239 n2354 57.600000000000001
r4014 n2353 n2354 16.213333333333335
r4015 n2240 n2355 3.6000000000000001
r4016 n2354 n2355 14.506666666666666
r4017 n2241 n2356 57.600000000000001
r4018 n2355 n2356 14.506666666666666
r4019 n2242 n2357 3.2000000000000002
r4020 n2356 n2357 16.213333333333335
r4021 n2243 n2358 57.600000000000001
r4022 n2357 n2358 16.213333333333335
r4023 n2244 n2359 3.6000000000000001
r4024 n2358 n2359 14.506666666666666
r4025 n2245 n2360 57.600000000000001
r4026 n2359 n2360 14.506666666666666
r4027 n2246 n2361 3.2000000000000002
r4028 n2360 n2361 16.213333333333335
r4029 n2247 n2362 57.600000000000001
r4030 n2361 n2362 16.213333333333335
r4031 n2248 n2363 3.6000000000000001
r4032 n2362 n2363 14.506666666666666
r4033 n2249 n2364 57.600000000000001
r4034 n2363 n2364 14.506666666666666
r4035 n2250 n2365 7.6799999999999997
r4036 n2364 n2365 7.253333333333333
r4037 n2251 n2366 9.5999999999999996
r4038 n2365 n2366 11.52
r4039 n2252 n2367 12.800000000000001
r4040 n2366 n2367 8.9600000000000009
r4041 n2253 n2368 57.600000000000001
r4042 n2367 n2368 4.6933333333333334
r4043 n2254 n2369 57.600000000000001
r4044 n2368 n2369 1.7066666666666668
r4045 n2255 n2370 14.4
r4046 n2369 n2370 4.2666666666666666
r4047 n2256 n2371 5.2363636363636363
r4048 n2370 n2371 12.800000000000001
r4049 n2257 n2372 115.2
r4050 n2371 n2372 9.8133333333333326
r4051 n2258 n2373 115.2
r4052 n2372 n2373 0.85333333333333339
r4053 n2259 n2374 115.2
r4054 n2373 n2374 0.85333333333333339
r4055 n2260 n2375 11.52
r4056 n2374 n2375 4.6933333333333334
r4057 n2261 n2376 9.5999999999999996
r4058 n2375 n2376 9.3866666666666667
r4059 n2262 n2377 14.4
r4060 n2376 n2377 8.5333333333333332
r4061 n2263 n2378 57.600000000000001
r4062 n2377 n2378 4.2666666666666666
r4063 n2264 n2379 38.399999999999999
r4064 n2378 n2379 2.1333333333333333
r4065 n2265 n2380 57.600000000000001
r4066 n2379 n2380 2.1333333333333333
r4067 n2266 n2381 19.199999999999999
r4068 n2380 n2381 3.4133333333333336
r4069 n2267 n2382 9.5999999999999996
r4070 n2381 n2382 7.6799999999999997
r4071 n2268 n2383 8.2285714285714278
r4072 n2382 n2383 11.093333333333334
r4073 n2269 n2384 57.600000000000001
r4074 n2383 n2384 6.8266666666666671
r4075 n2270 n2385 3.2000000000000002
r4076 n2384 n2385 16.213333333333335
r4077 n2271 n2386 57.600000000000001
r4078 n2385 n2386 16.213333333333335
r4079 n2272 n2387 3.6000000000000001
r4080 n2386 n2387 14.506666666666666
r4081 n2273 n2388 57.600000000000001
r4082 n2387 n2388 14.506666666666666
r4083 n2274 n2389 3.2000000000000002
r4084 n2388 n2389 16.213333333333335
r4085 n2275 n2390 57.600000000000001
r4086 n2389 n2390 16.213333333333335
r4087 n2276 n2391 3.6000000000000001
r4088 n2390 n2391 14.506666666666666
r4089 n2277 n2392 57.600000000000001
r4090 n2391 n2392 14.506666666666666
r4091 n2278 n2393 3.2000000000000002
r4092 n2392 n2393 16.213333333333335
r4093 n2279 n2394 57.600000000000001
r4094 n2393 n2394 16.213333333333335
r4095 n2280 n2395 3.6000000000000001
r4096 n2394 n2395 14.506666666666666
r4097 n2281 n2396 57.600000000000001
r4098 n2395 n2396 14.506666666666666
r4099 n2282 n2397 3.2000000000000002
r4100 n2396 n2397 16.213333333333335
r4101 n2283 n2398 57.600000000000001
r4102 n2397 n2398 16.213333333333335
r4103 n2284 n2399 3.6000000000000001
r4104 n2398 n2399 14.506666666666666
r4105 n2285 n2400 57.600000000000001
r4106 n2399 n2400 14.506666666666666
r4107 n2286 n2401 3.2000000000000002
r4108 n2400 n2401 16.213333333333335
r4109 n2287 n2402 57.600000000000001
r4110 n2401 n2402 16.213333333333335
r4111 n2288 n2403 3.6000000000000001
r4112 n2402 n2403 14.506666666666666
r4113 n2289 n2404 57.600000000000001
r4114 n2403 n2404 14.506666666666666
r4115 n2290 n2405 3.2000000000000002
r4116 n2404 n2405 16.213333333333335
r4117 n2291 n2406 57.600000000000001
r4118 n2405 n2406 16.213333333333335
r4119 n2292 n2407 3.6000000000000001
r4120 n2406 n2407 14.506666666666666
r4121 n2293 n2408 57.600000000000001
r4122 n2407 n2408 14.506666666666666
r4123 n2294 n2409 3.2000000000000002
r4124 n2408 n2409 16.213333333333335
r4125 n2295 n2410 57.600000000000001
r4126 n2409 n2410 16.213333333333335
r4127 n2296 n2411 3.6000000000000001
r4128 n2410 n2411 14.506666666666666
r4129 n2297 n2412 57.600000000000001
r4130 n2411 n2412 14.506666666666666
r4131 n2298 n2413 9.5999999999999996
r4132 n2412 n2413 5.9733333333333336
r4133 n2299 n2414 28.800000000000001
r4134 n2413 n2414 6.8266666666666671
r4135 n2300 n2415 3.388235294117647
r4136 n2301 n2416 3.7647058823529411
r4137 n2302 n2417 32
r4138 n2303 n2418 12.800000000000001
r4139 n2417 n2418 17.920000000000002
r4140 n2304 n2419 64
r4141 n2418 n2419 15.359999999999999
r4142 n2305 n2420 4
r4143 n2419 n2420 43.520000000000003
r4144 n2306 n2421 64
r4145 n2420 n2421 43.520000000000003
r4146 n2307 n2422 3.5555555555555554
r4147 n2421 n2422 48.640000000000001
r4148 n2308 n2423 64
r4149 n2422 n2423 48.640000000000001
r4150 n2309 n2424 9.8461538461538467
r4151 n2423 n2424 19.199999999999999
r4152 n2310 n2425 10.666666666666666
r4153 n2424 n2425 32
r4154 n2311 n2426 18.285714285714285
r4155 n2425 n2426 24.32
r4156 n2312 n2427 64
r4157 n2426 n2427 11.52
r4158 n2313 n2428 32
r4159 n2427 n2428 7.6799999999999997
r4160 n2314 n2429 14.222222222222221
r4161 n2428 n2429 16.640000000000001
r4162 n2315 n2430 6.0952380952380949
r4163 n2429 n2430 38.399999999999999
r4164 n2316 n2431 64
r4165 n2430 n2431 29.440000000000001
r4166 n2317 n2432 64
r4167 n2431 n2432 5.1200000000000001
r4168 n2318 n2433 14.222222222222221
r4169 n2432 n2433 14.08
r4170 n2319 n2434 10.666666666666666
r4171 n2433 n2434 26.879999999999999
r4172 n2320 n2435 14.222222222222221
r4173 n2434 n2435 26.879999999999999
r4174 n2321 n2436 64
r4175 n2435 n2436 14.08
r4176 n2322 n2437 64
r4177 n2436 n2437 5.1200000000000001
r4178 n2323 n2438 6.0952380952380949
r4179 n2437 n2438 29.440000000000001
r4180 n2324 n2439 8.5333333333333332
r4181 n2438 n2439 46.079999999999998
r4182 n2325 n2440 64
r4183 n2439 n2440 21.760000000000002
r4184 n2326 n2441 4
r4185 n2440 n2441 43.520000000000003
r4186 n2327 n2442 64
r4187 n2441 n2442 43.520000000000003
r4188 n2328 n2443 10.666666666666666
r4189 n2442 n2443 17.920000000000002
r4190 n2329 n2444 32
r4191 n2443 n2444 20.48
r4192 n2330 n2445 3.7647058823529411
r4193 n2331 n2446 3.7647058823529411
r4194 n2332 n2447 32
r4195 n2333 n2448 12.800000000000001
r4196 n2447 n2448 17.920000000000002
r4197 n2334 n2449 64
r4198 n2448 n2449 15.359999999999999
r4199 n2335 n2450 4
r4200 n2449 n2450 43.520000000000003
r4201 n2336 n2451 64
r4202 n2450 n2451 43.520000000000003
r4203 n2337 n2452 3.5555555555555554
r4204 n2451 n2452 48.640000000000001
r4205 n2338 n2453 64
r4206 n2452 n2453 48.640000000000001
r4207 n2339 n2454 4
r4208 n2453 n2454 43.520000000000003
r4209 n2340 n2455 64
r4210 n2454 n2455 43.520000000000003
r4211 n2341 n2456 3.5555555555555554
r4212 n2455 n2456 48.640000000000001
r4213 n2342 n2457 64
r4214 n2456 n2457 48.640000000000001
r4215 n2343 n2458 4
r4216 n2457 n2458 43.520000000000003
r4217 n2344 n2459 64
r4218 n2458 n2459 43.520000000000003
r4219 n2345 n2460 3.5555555555555554
r4220 n2459 n2460 48.640000000000001
r4221 n2346 n2461 64
r4222 n2460 n2461 48.640000000000001
r4223 n2347 n2462 4
r4224 n2461 n2462 43.520000000000003
r4225 n2348 n2463 64
r4226 n2462 n2463 43.520000000000003
r4227 n2349 n2464 3.5555555555555554
r4228 n2463 n2464 48.640000000000001
r4229 n2350 n2465 64
r4230 n2464 n2465 48.640000000000001
r4231 n2351 n2466 4
r4232 n2465 n2466 43.520000000000003
r4233 n2352 n2467 64
r4234 n2466 n2467 43.520000000000003
r4235 n2353 n2468 3.5555555555555554
r4236 n2467 n2468 48.640000000000001
r4237 n2354 n2469 64
r4238 n2468 n2469 48.640000000000001
r4239 n2355 n2470 4
r4240 n2469 n2470 43.520000000000003
r4241 n2356 n2471 64
r4242 n2470 n2471 43.520000000000003
r4243 n2357 n2472 3.5555555555555554
r4244 n2471 n2472 48.640000000000001
r4245 n2358 n2473 64
r4246 n2472 n2473 48.640000000000001
r4247 n2359 n2474 4
r4248 n2473 n2474 43.520000000000003
r4249 n2360 n2475 64
r4250 n2474 n2475 43.520000000000003
r4251 n2361 n2476 3.5555555555555554
r4252 n2475 n2476 48.640000000000001
r4253 n2362 n2477 64
r4254 n2476 n2477 48.640000000000001
r4255 n2363 n2478 4
r4256 n2477 n2478 43.520000000000003
r4257 n2364 n2479 64
r4258 n2478 n2479 43.520000000000003
r4259 n2365 n2480 8.5333333333333332
r4260 n2479 n2480 21.760000000000002
r4261 n2366 n2481 10.666666666666666
r4262 n2480 n2481 34.560000000000002
r4263 n2367 n2482 14.222222222222221
r4264 n2481 n2482 26.879999999999999
r4265 n2368 n2483 64
r4266 n2482 n2483 14.08
r4267 n2369 n2484 64
r4268 n2483 n2484 5.1200000000000001
r4269 n2370 n2485 16
r4270 n2484 n2485 12.800000000000001
r4271 n2371 n2486 5.8181818181818183
r4272 n2485 n2486 38.399999999999999
r4273 n2372 n2487 128
r4274 n2486 n2487 29.440000000000001
r4275 n2373 n2488 128
r4276 n2487 n2488 2.5600000000000001
r4277 n2374 n2489 128
r4278 n2488 n2489 2.5600000000000001
r4279 n2375 n2490 12.800000000000001
r4280 n2489 n2490 14.08
r4281 n2376 n2491 10.666666666666666
r4282 n2490 n2491 28.16
r4283 n2377 n2492 16
r4284 n2491 n2492 25.600000000000001
r4285 n2378 n2493 64
r4286 n2492 n2493 12.800000000000001
r4287 n2379 n2494 42.666666666666664
r4288 n2493 n2494 6.4000000000000004
r4289 n2380 n2495 64
r4290 n2494 n2495 6.4000000000000004
r4291 n2381 n2496 21.333333333333332
r4292 n2495 n2496 10.24
r4293 n2382 n2497 10.666666666666666
r4294 n2496 n2497 23.039999999999999
r4295 n2383 n2498 9.1428571428571423
r4296 n2497 n2498 33.280000000000001
r4297 n2384 n2499 64
r4298 n2498 n2499 20.48
r4299 n2385 n2500 3.5555555555555554
r4300 n2499 n2500 48.640000000000001
r4301 n2386 n2501 64
r4302 n2500 n2501 48.640000000000001
r4303 n2387 n2502 4
r4304 n2501 n2502 43.520000000000003
r4305 n2388 n2503 64
r4306 n2502 n2503 43.520000000000003
r4307 n2389 n2504 3.5555555555555554
r4308 n2503 n2504 48.640000000000001
r4309 n2390 n2505 64
r4310 n2504 n2505 48.640000000000001
r4311 n2391 n2506 4
r4312 n2505 n2506 43.520000000000003
r4313 n2392 n2507 64
r4314 n2506 n2507 43.520000000000003
r4315 n2393 n2508 3.5555555555555554
r4316 n2507 n2508 48.640000000000001
r4317 n2394 n2509 64
r4318 n2508 n2509 48.640000000000001
r4319 n2395 n2510 4
r4320 n2509 n2510 43.520000000000003
r4321 n2396 n2511 64
r4322 n2510 n2511 43.520000000000003
r4323 n2397 n2512 3.5555555555555554
r4324 n2511 n2512 48.640000000000001
r4325 n2398 n2513 64
r4326 n2512 n2513 48.640000000000001
r4327 n2399 n2514 4
r4328 n2513 n2514 43.520000000000003
r4329 n2400 n2515 64
r4330 n2514 n2515 43.520000000000003
r4331 n2401 n2516 3.5555555555555554
r4332 n2515 n2516 48.640000000000001
r4333 n2402 n2517 64
r4334 n2516 n2517 48.640000000000001
r4335 n2403 n2518 4
r4336 n2517 n2518 43.520000000000003
r4337 n2404 n2519 64
r4338 n2518 n2519 43.520000000000003
r4339 n2405 n2520 3.5555555555555554
r4340 n2519 n2520 48.640000000000001
r4341 n2406 n2521 64
r4342 n2520 n2521 48.640000000000001
r4343 n2407 n2522 4
r4344 n2521 n2522 43.520000000000003
r4345 n2408 n2523 64
r4346 n2522 n2523 43.520000000000003
r4347 n2409 n2524 3.5555555555555554
r4348 n2523 n2524 48.640000000000001
r4349 n2410 n2525 64
r4350 n2524 n2525 48.640000000000001
r4351 n2411 n2526 4
r4352 n2525 n2526 43.520000000000003
r4353 n2412 n2527 64
r4354 n2526 n2527 43.520000000000003
r4355 n2413 n2528 10.666666666666666
r4356 n2527 n2528 17.920000000000002
r4357 n2414 n2529 32
r4358 n2528 n2529 20.48
r4359 n2415 n2530 3.7647058823529411
r4360 n2416 n2531 1.3176470588235294
r4361 n2417 n2532 11.199999999999999
r4362 n2418 n2533 4.4800000000000004
r4363 n2532 n2533 44.799999999999997
r4364 n2419 n2534 22.399999999999999
r4365 n2533 n2534 38.399999999999999
r4366 n2420 n2535 1.3999999999999999
r4367 n2534 n2535 108.8
r4368 n2421 n2536 22.399999999999999
r4369 n2535 n2536 108.8
r4370 n2422 n2537 1.2444444444444445
r4371 n2536 n2537 121.59999999999999
r4372 n2423 n2538 22.399999999999999
r4373 n2537 n2538 121.59999999999999
r4374 n2424 n2539 3.4461538461538463
r4375 n2538 n2539 48
r4376 n2425 n2540 3.7333333333333334
r4377 n2539 n2540 80
r4378 n2426 n2541 6.4000000000000004
r4379 n2540 n2541 60.799999999999997
r4380 n2427 n2542 22.399999999999999
r4381 n2541 n2542 28.800000000000001
r4382 n2428 n2543 11.199999999999999
r4383 n2542 n2543 19.199999999999999
r4384 n2429 n2544 4.9777777777777779
r4385 n2543 n2544 41.600000000000001
r4386 n2430 n2545 2.1333333333333333
r4387 n2544 n2545 96
r4388 n2431 n2546 22.399999999999999
r4389 n2545 n2546 73.599999999999994
r4390 n2432 n2547 22.399999999999999
r4391 n2546 n2547 12.800000000000001
r4392 n2433 n2548 4.9777777777777779
r4393 n2547 n2548 35.200000000000003
r4394 n2434 n2549 3.7333333333333334
r4395 n2548 n2549 67.200000000000003
r4396 n2435 n2550 4.9777777777777779
r4397 n2549 n2550 67.200000000000003
r4398 n2436 n2551 22.399999999999999
r4399 n2550 n2551 35.200000000000003
r4400 n2437 n2552 22.399999999999999
r4401 n2551 n2552 12.800000000000001
r4402 n2438 n2553 2.1333333333333333
r4403 n2552 n2553 73.599999999999994
r4404 n2439 n2554 2.9866666666666668
r4405 n2553 n2554 115.2
r4406 n2440 n2555 22.399999999999999
r4407 n2554 n2555 54.399999999999999
r4408 n2441 n2556 1.3999999999999999
r4409 n2555 n2556 108.8
r4410 n2442 n2557 22.399999999999999
r4411 n2556 n2557 108.8
r4412 n2443 n2558 3.7333333333333334
r4413 n2557 n2558 44.799999999999997
r4414 n2444 n2559 11.199999999999999
r4415 n2558 n2559 51.200000000000003
r4416 n2445 n2560 1.3176470588235294
r4417 n2446 n2561 1.3176470588235294
r4418 n2447 n2562 11.199999999999999
r4419 n2448 n2563 4.4800000000000004
r4420 n2562 n2563 44.799999999999997
r4421 n2449 n2564 22.399999999999999
r4422 n2563 n2564 38.399999999999999
r4423 n2450 n2565 1.3999999999999999
r4424 n2564 n2565 108.8
r4425 n2451 n2566 22.399999999999999
r4426 n2565 n2566 108.8
r4427 n2452 n2567 1.2444444444444445
r4428 n2566 n2567 121.59999999999999
r4429 n2453 n2568 22.399999999999999
r4430 n2567 n2568 121.59999999999999
r4431 n2454 n2569 1.3999999999999999
r4432 n2568 n2569 108.8
r4433 n2455 n2570 22.399999999999999
r4434 n2569 n2570 108.8
r4435 n2456 n2571 1.2444444444444445
r4436 n2570 n2571 121.59999999999999
r4437 n2457 n2572 22.399999999999999
r4438 n2571 n2572 121.59999999999999
r4439 n2458 n2573 1.3999999999999999
r4440 n2572 n2573 108.8
r4441 n2459 n2574 22.399999999999999
r4442 n2573 n2574 108.8
r4443 n2460 n2575 1.2444444444444445
r4444 n2574 n2575 121.59999999999999
r4445 n2461 n2576 22.399999999999999
r4446 n2575 n2576 121.59999999999999
r4447 n2462 n2577 1.3999999999999999
r4448 n2576 n2577 108.8
r4449 n2463 n2578 22.399999999999999
r4450 n2577 n2578 108.8
r4451 n2464 n2579 1.2444444444444445
r4452 n2578 n2579 121.59999999999999
r4453 n2465 n2580 22.399999999999999
r4454 n2579 n2580 121.59999999999999
r4455 n2466 n2581 1.3999999999999999
r4456 n2580 n2581 108.8
r4457 n2467 n2582 22.399999999999999
r4458 n2581 n2582 108.8
r4459 n2468 n2583 1.2444444444444445
r4460 n2582 n2583 121.59999999999999
r4461 n2469 n2584 22.399999999999999
r4462 n2583 n2584 121.59999999999999
r4463 n2470 n2585 1.3999999999999999
r4464 n2584 n2585 108.8
r4465 n2471 n2586 22.399999999999999
r4466 n2585 n2586 108.8
r4467 n2472 n2587 1.2444444444444445
r4468 n2586 n2587 121.59999999999999
r4469 n2473 n2588 22.399999999999999
r4470 n2587 n2588 121.59999999999999
r4471 n2474 n2589 1.3999999999999999
r4472 n2588 n2589 108.8
r4473 n2475 n2590 22.399999999999999
r4474 n2589 n2590 108.8
r4475 n2476 n2591 1.2444444444444445
r4476 n2590 n2591 121.59999999999999
r4477 n2477 n2592 22.399999999999999
r4478 n2591 n2592 121.59999999999999
r4479 n2478 n2593 1.3999999999999999
r4480 n2592 n2593 108.8
r4481 n2479 n2594 22.399999999999999
r4482 n2593 n2594 108.8
r4483 n2480 n2595 2.9866666666666668
r4484 n2594 n2595 54.399999999999999
r4485 n2481 n2596 3.7333333333333334
r4486 n2595 n2596 86.400000000000006
r4487 n2482 n2597 4.9777777777777779
r4488 n2596 n2597 67.200000000000003
r4489 n2483 n2598 22.399999999999999
r4490 n2597 n2598 35.200000000000003
r4491 n2484 n2599 22.399999999999999
r4492 n2598 n2599 12.800000000000001
r4493 n2485 n2600 5.5999999999999996
r4494 n2599 n2600 32
r4495 n2486 n2601 2.0363636363636362
r4496 n2600 n2601 96
r4497 n2487 n2602 44.799999999999997
r4498 n2601 n2602 73.599999999999994
r4499 n2488 n2603 44.799999999999997
r4500 n2602 n2603 6.4000000000000004
r4501 n2489 n2604 44.799999999999997
r4502 n2603 n2604 6.4000000000000004
r4503 n2490 n2605 4.4800000000000004
r4504 n2604 n2605 35.200000000000003
r4505 n2491 n2606 3.7333333333333334
r4506 n2605 n2606 70.400000000000006
r4507 n2492 n2607 5.5999999999999996
r4508 n2606 n2607 64
r4509 n2493 n2608 22.399999999999999
r4510 n2607 n2608 32
r4511 n2494 n2609 14.933333333333334
r4512 n2608 n2609 16
r4513 n2495 n2610 22.399999999999999
r4514 n2609 n2610 16
r4515 n2496 n2611 7.4666666666666668
r4516 n2610 n2611 25.600000000000001
r4517 n2497 n2612 3.7333333333333334
r4518 n2611 n2612 57.600000000000001
r4519 n2498 n2613 3.2000000000000002
r4520 n2612 n2613 83.200000000000003
r4521 n2499 n2614 22.399999999999999
r4522 n2613 n2614 51.200000000000003
r4523 n2500 n2615 1.2444444444444445
r4524 n2614 n2615 121.59999999999999
r4525 n2501 n2616 22.399999999999999
r4526 n2615 n2616 121.59999999999999
r4527 n2502 n2617 1.3999999999999999
r4528 n2616 n2617 108.8
r4529 n2503 n2618 22.399999999999999
r4530 n2617 n2618 108.8
r4531 n2504 n2619 1.2444444444444445
r4532 n2618 n2619 121.59999999999999
r4533 n2505 n2620 22.399999999999999
r4534 n2619 n2620 121.59999999999999
r4535 n2506 n2621 1.3999999999999999
r4536 n2620 n2621 108.8
r4537 n2507 n2622 22.399999999999999
r4538 n2621 n2622 108.8
r4539 n2508 n2623 1.2444444444444445
r4540 n2622 n2623 121.59999999999999
r4541 n2509 n2624 22.399999999999999
r4542 n2623 n2624 121.59999999999999
r4543 n2510 n2625 1.3999999999999999
r4544 n2624 n2625 108.8
r4545 n2511 n2626 22.399999999999999
r4546 n2625 n2626 108.8
r4547 n2512 n2627 1.2444444444444445
r4548 n2626 n2627 121.59999999999999
r4549 n2513 n2628 22.399999999999999
r4550 n2627 n2628 121.59999999999999
r4551 n2514 n2629 1.3999999999999999
r4552 n2628 n2629 108.8
r4553 n2515 n2630 22.399999999999999
r4554 n2629 n2630 108.8
r4555 n2516 n2631 1.2444444444444445
r4556 n2630 n2631 121.59999999999999
r4557 n2517 n2632 22.399999999999999
r4558 n2631 n2632 121.59999999999999
r4559 n2518 n2633 1.3999999999999999
r4560 n2632 n2633 108.8
r4561 n2519 n2634 22.399999999999999
r4562 n2633 n2634 108.8
r4563 n2520 n2635 1.2444444444444445
r4564 n2634 n2635 121.59999999999999
r4565 n2521 n2636 22.399999999999999
r4566 n2635 n2636 121.59999999999999
r4567 n2522 n2637 1.3999999999999999
r4568 n2636 n2637 108.8
r4569 n2523 n2638 22.399999999999999
r4570 n2637 n2638 108.8
r4571 n2524 n2639 1.2444444444444445
r4572 n2638 n2639 121.59999999999999
r4573 n2525 n2640 22.399999999999999
r4574 n2639 n2640 121.59999999999999
r4575 n2526 n2641 1.3999999999999999
r4576 n2640 n2641 108.8
r4577 n2527 n2642 22.399999999999999
r4578 n2641 n2642 108.8
r4579 n2528 n2643 3.7333333333333334
r4580 n2642 n2643 44.799999999999997
r4581 n2529 n2644 11.199999999999999
r4582 n2643 n2644 51.200000000000003
r4583 n2530 n2645 1.3176470588235294
r4584 n2531 n2646 1.5058823529411764
r4585 n2560 n2647 1.5058823529411764
r4586 n2561 n2648 1.5058823529411764
r4587 n2645 n2649 1.5058823529411764
r4588 n2646 n2650 2.447058823529412
r4589 n2647 n2651 2.447058823529412
r4590 n2648 n2652 2.447058823529412
r4591 n2649 n2653 2.447058823529412
r4592 n2650 n2654 3.9529411764705884
r4593 n2651 n2655 3.9529411764705884
r4594 n2652 n2656 3.9529411764705884
r4595 n2653 n2657 3.9529411764705884
r4596 n2654 n2658 9.7129411764705882
r4597 n2655 n2659 9.7129411764705882
r4598 n2656 n2660 9.7129411764705882
r4599 n2657 n2661 9.7129411764705882
r4600 n2658 n2662 14.117647058823529
r4601 n2659 n2663 14.117647058823529
r4602 n2660 n2664 14.117647058823529
r4603 n2661 n2665 14.117647058823529
r4604 n2662 n2666 13.440000000000001
r4605 n2666 n2667 12.235294117647058
r4606 n2667 n2668 11.670588235294117
r4607 n2668 n2669 12.235294117647058
r4608 n2669 n2670 10.91764705882353
r4609 n2670 n2671 5.2705882352941176
r4610 n2671 n2672 2.6352941176470588
r4611 n2672 n2673 2.2588235294117647
r4612 n2673 n2674 6.4000000000000004
r4613 n2674 n2675 6.4000000000000004
r4614 n2675 n2676 7.1529411764705886
r4615 n2676 n2677 7.1529411764705886
r4616 n2677 n2678 2.8235294117647061
r4617 n2678 n2679 4.7058823529411766
r4618 n2679 n2680 3.5764705882352943
r4619 n2680 n2681 1.6941176470588235
r4620 n2681 n2682 1.1294117647058823
r4621 n2682 n2683 2.447058823529412
r4622 n2683 n2684 5.6470588235294121
r4623 n2684 n2685 4.3294117647058821
r4624 n2685 n2686 0.75294117647058822
r4625 n2686 n2687 2.0705882352941178
r4626 n2687 n2688 3.9529411764705884
r4627 n2688 n2689 3.9529411764705884
r4628 n2689 n2690 2.0705882352941178
r4629 n2690 n2691 0.75294117647058822
r4630 n2691 n2692 4.3294117647058821
r4631 n2692 n2693 6.776470588235294
r4632 n2693 n2694 3.2000000000000002
r4633 n2694 n2695 6.4000000000000004
r4634 n2695 n2696 6.4000000000000004
r4635 n2696 n2697 2.6352941176470588
r4636 n2697 n2698 3.0117647058823529
r4637 n2698 n2699 4.5176470588235293
r4638 n2699 n2700 10.164705882352941
r4639 n2700 n2701 7.341176470588235
r4640 n2701 n2702 2.8235294117647061
r4641 n2702 n2703 3.2000000000000002
r4642 n2703 n2704 1.8823529411764706
r4643 n2704 n2705 1.1294117647058823
r4644 n2705 n2706 0.94117647058823528
r4645 n2706 n2707 1.8823529411764706
r4646 n2707 n2708 5.6470588235294121
r4647 n2708 n2709 4.5176470588235293
r4648 n2709 n2710 0.94117647058823528
r4649 n2710 n2711 1.1294117647058823
r4650 n2711 n2712 1.3176470588235294
r4651 n2712 n2713 1.3176470588235294
r4652 n2713 n2714 2.447058823529412
r4653 n2714 n2715 11.105882352941176
r4654 n2663 n2716 13.440000000000001
r4655 n2715 n2716 15.623529411764705
r4656 n2664 n2717 13.440000000000001
r4657 n2717 n2718 12.047058823529412
r4658 n2718 n2719 11.294117647058824
r4659 n2719 n2720 12.047058823529412
r4660 n2720 n2721 10.91764705882353
r4661 n2721 n2722 5.2705882352941176
r4662 n2722 n2723 2.6352941176470588
r4663 n2723 n2724 2.2588235294117647
r4664 n2724 n2725 6.4000000000000004
r4665 n2725 n2726 6.4000000000000004
r4666 n2726 n2727 7.1529411764705886
r4667 n2727 n2728 7.1529411764705886
r4668 n2728 n2729 6.4000000000000004
r4669 n2729 n2730 6.4000000000000004
r4670 n2730 n2731 7.1529411764705886
r4671 n2731 n2732 7.1529411764705886
r4672 n2732 n2733 6.4000000000000004
r4673 n2733 n2734 6.4000000000000004
r4674 n2734 n2735 7.1529411764705886
r4675 n2735 n2736 7.1529411764705886
r4676 n2736 n2737 6.4000000000000004
r4677 n2737 n2738 6.4000000000000004
r4678 n2738 n2739 7.1529411764705886
r4679 n2739 n2740 7.1529411764705886
r4680 n2740 n2741 6.4000000000000004
r4681 n2741 n2742 6.4000000000000004
r4682 n2742 n2743 7.1529411764705886
r4683 n2743 n2744 7.1529411764705886
r4684 n2744 n2745 6.4000000000000004
r4685 n2745 n2746 6.4000000000000004
r4686 n2746 n2747 7.1529411764705886
r4687 n2747 n2748 7.1529411764705886
r4688 n2748 n2749 6.4000000000000004
r4689 n2749 n2750 6.4000000000000004
r4690 n2750 n2751 7.1529411764705886
r4691 n2751 n2752 7.1529411764705886
r4692 n2752 n2753 6.4000000000000004
r4693 n2753 n2754 6.4000000000000004
r4694 n2754 n2755 3.2000000000000002
r4695 n2755 n2756 5.0823529411764703
r4696 n2756 n2757 3.9529411764705884
r4697 n2757 n2758 2.0705882352941178
r4698 n2758 n2759 0.75294117647058822
r4699 n2759 n2760 1.8823529411764706
r4700 n2760 n2761 5.6470588235294121
r4701 n2761 n2762 4.3294117647058821
r4702 n2762 n2763 0.37647058823529411
r4703 n2763 n2764 0.37647058823529411
r4704 n2764 n2765 2.0705882352941178
r4705 n2765 n2766 4.1411764705882357
r4706 n2766 n2767 3.7647058823529411
r4707 n2767 n2768 1.8823529411764706
r4708 n2768 n2769 0.94117647058823528
r4709 n2769 n2770 0.94117647058823528
r4710 n2770 n2771 1.5058823529411764
r4711 n2771 n2772 3.388235294117647
r4712 n2772 n2773 4.8941176470588239
r4713 n2773 n2774 3.0117647058823529
r4714 n2774 n2775 7.1529411764705886
r4715 n2775 n2776 7.1529411764705886
r4716 n2776 n2777 6.4000000000000004
r4717 n2777 n2778 6.4000000000000004
r4718 n2778 n2779 7.1529411764705886
r4719 n2779 n2780 7.1529411764705886
r4720 n2780 n2781 6.4000000000000004
r4721 n2781 n2782 6.4000000000000004
r4722 n2782 n2783 7.1529411764705886
r4723 n2783 n2784 7.1529411764705886
r4724 n2784 n2785 6.4000000000000004
r4725 n2785 n2786 6.4000000000000004
r4726 n2786 n2787 7.1529411764705886
r4727 n2787 n2788 7.1529411764705886
r4728 n2788 n2789 6.4000000000000004
r4729 n2789 n2790 6.4000000000000004
r4730 n2790 n2791 7.1529411764705886
r4731 n2791 n2792 7.1529411764705886
r4732 n2792 n2793 6.4000000000000004
r4733 n2793 n2794 6.4000000000000004
r4734 n2794 n2795 7.1529411764705886
r4735 n2795 n2796 7.1529411764705886
r4736 n2796 n2797 6.4000000000000004
r4737 n2797 n2798 6.4000000000000004
r4738 n2798 n2799 7.1529411764705886
r4739 n2799 n2800 7.1529411764705886
r4740 n2800 n2801 6.4000000000000004
r4741 n2801 n2802 6.4000000000000004
r4742 n2802 n2803 2.6352941176470588
r4743 n2803 n2804 3.0117647058823529
r4744 n2804 n2805 4.5176470588235293
r4745 n2805 n2806 10.164705882352941
r4746 n2806 n2807 6.776470588235294
r4747 n2807 n2808 2.2588235294117647
r4748 n2808 n2809 3.2000000000000002
r4749 n2809 n2810 1.8823529411764706
r4750 n2810 n2811 1.1294117647058823
r4751 n2811 n2812 0.94117647058823528
r4752 n2812 n2813 2.447058823529412
r4753 n2813 n2814 5.6470588235294121
r4754 n2814 n2815 3.9529411764705884
r4755 n2815 n2816 0.94117647058823528
r4756 n2816 n2817 1.1294117647058823
r4757 n2817 n2818 1.8823529411764706
r4758 n2818 n2819 3.2000000000000002
r4759 n2819 n2820 11.105882352941176
r4760 n2665 n2821 13.440000000000001
r4761 n2820 n2821 15.623529411764705
r4762 n2876 n2877 0.029069767441860465
r4763 n2877 n2878 0.047965116279069769
r4764 n2878 n2879 0.036337209302325583
r4765 n2879 n2880 0.046511627906976744
r4766 n2880 n2881 0.046511627906976744
r4767 n2881 n2882 0.036337209302325583
r4768 n2882 n2883 0.047965116279069769
r4769 n2883 n2884 0.029069767441860465
r4770 n2885 n2886 0.029069767441860465
r4771 n2886 n2887 0.047965116279069769
r4772 n2887 n2888 0.036337209302325583
r4773 n2888 n2889 0.046511627906976744
r4774 n2889 n2890 0.046511627906976744
r4775 n2890 n2891 0.036337209302325583
r4776 n2891 n2892 0.047965116279069769
r4777 n2892 n2893 0.029069767441860465
r4778 n2876 n2894 0.48125000000000001
r4779 n2877 n2895 0.48125000000000001
r4780 n2894 n2895 0.036764705882352942
r4781 n2878 n2896 0.20923913043478262
r4782 n2895 n2896 0.060661764705882353
r4783 n2879 n2897 2.40625
r4784 n2896 n2897 0.04595588235294118
r4785 n2880 n2898 0.16041666666666668
r4786 n2897 n2898 0.058823529411764705
r4787 n2881 n2899 2.40625
r4788 n2898 n2899 0.058823529411764705
r4789 n2882 n2900 0.20923913043478262
r4790 n2899 n2900 0.04595588235294118
r4791 n2883 n2901 0.48125000000000001
r4792 n2900 n2901 0.060661764705882353
r4793 n2884 n2902 0.48125000000000001
r4794 n2901 n2902 0.036764705882352942
r4795 n2885 n2903 0.48125000000000001
r4796 n2886 n2904 0.48125000000000001
r4797 n2903 n2904 0.036764705882352942
r4798 n2887 n2905 0.20923913043478262
r4799 n2904 n2905 0.060661764705882353
r4800 n2888 n2906 2.40625
r4801 n2905 n2906 0.04595588235294118
r4802 n2889 n2907 0.16041666666666668
r4803 n2906 n2907 0.058823529411764705
r4804 n2890 n2908 2.40625
r4805 n2907 n2908 0.058823529411764705
r4806 n2891 n2909 0.20923913043478262
r4807 n2908 n2909 0.04595588235294118
r4808 n2892 n2910 0.48125000000000001
r4809 n2909 n2910 0.060661764705882353
r4810 n2893 n2911 0.48125000000000001
r4811 n2910 n2911 0.036764705882352942
r4812 n2894 n2912 0.48125000000000001
r4813 n2895 n2913 0.48125000000000001
r4814 n2912 n2913 0.029069767441860465
r4815 n2896 n2914 0.20923913043478262
r4816 n2913 n2914 0.047965116279069769
r4817 n2897 n2915 2.40625
r4818 n2914 n2915 0.036337209302325583
r4819 n2898 n2916 0.16041666666666668
r4820 n2915 n2916 0.046511627906976744
r4821 n2899 n2917 2.40625
r4822 n2916 n2917 0.046511627906976744
r4823 n2900 n2918 0.20923913043478262
r4824 n2917 n2918 0.036337209302325583
r4825 n2901 n2919 0.48125000000000001
r4826 n2918 n2919 0.047965116279069769
r4827 n2902 n2920 0.48125000000000001
r4828 n2919 n2920 0.029069767441860465
r4829 n2903 n2921 0.48125000000000001
r4830 n2904 n2922 0.48125000000000001
r4831 n2921 n2922 0.029069767441860465
r4832 n2905 n2923 0.20923913043478262
r4833 n2922 n2923 0.047965116279069769
r4834 n2906 n2924 2.40625
r4835 n2923 n2924 0.036337209302325583
r4836 n2907 n2925 0.16041666666666668
r4837 n2924 n2925 0.046511627906976744
r4838 n2908 n2926 2.40625
r4839 n2925 n2926 0.046511627906976744
r4840 n2909 n2927 0.20923913043478262
r4841 n2926 n2927 0.036337209302325583
r4842 n2910 n2928 0.48125000000000001
r4843 n2927 n2928 0.047965116279069769
r4844 n2911 n2929 0.48125000000000001
r4845 n2928 n2929 0.029069767441860465
r4846 n2914 n2930 0.22554347826086957
r4847 n2915 n2931 2.59375
r4848 n2930 n2931 0.0390625
r4849 n2916 n2932 0.17291666666666666
r4850 n2931 n2932 0.050000000000000003
r4851 n2917 n2933 2.59375
r4852 n2932 n2933 0.050000000000000003
r4853 n2918 n2934 0.22554347826086957
r4854 n2933 n2934 0.0390625
r4855 n2923 n2935 0.22554347826086957
r4856 n2924 n2936 2.59375
r4857 n2935 n2936 0.0390625
r4858 n2925 n2937 0.17291666666666666
r4859 n2936 n2937 0.050000000000000003
r4860 n2926 n2938 2.59375
r4861 n2937 n2938 0.050000000000000003
r4862 n2927 n2939 0.22554347826086957
r4863 n2938 n2939 0.0390625
r4864 n2930 n2940 0.21739130434782608
r4865 n2931 n2941 2.5
r4866 n2940 n2941 0.0390625
r4867 n2932 n2942 0.16666666666666666
r4868 n2941 n2942 0.050000000000000003
r4869 n2933 n2943 2.5
r4870 n2942 n2943 0.050000000000000003
r4871 n2934 n2944 0.21739130434782608
r4872 n2943 n2944 0.0390625
r4873 n2935 n2945 0.21739130434782608
r4874 n2936 n2946 2.5
r4875 n2945 n2946 0.0390625
r4876 n2937 n2947 0.16666666666666666
r4877 n2946 n2947 0.050000000000000003
r4878 n2938 n2948 2.5
r4879 n2947 n2948 0.050000000000000003
r4880 n2939 n2949 0.21739130434782608
r4881 n2948 n2949 0.0390625
r4882 n2940 n2950 0.23097826086956522
r4883 n2941 n2951 2.65625
r4884 n2950 n2951 0.034722222222222224
r4885 n2942 n2952 0.17708333333333334
r4886 n2951 n2952 0.044444444444444446
r4887 n2943 n2953 2.65625
r4888 n2952 n2953 0.044444444444444446
r4889 n2944 n2954 0.23097826086956522
r4890 n2953 n2954 0.034722222222222224
r4891 n2945 n2955 0.23097826086956522
r4892 n2946 n2956 2.65625
r4893 n2955 n2956 0.034722222222222224
r4894 n2947 n2957 0.17708333333333334
r4895 n2956 n2957 0.044444444444444446
r4896 n2948 n2958 2.65625
r4897 n2957 n2958 0.044444444444444446
r4898 n2949 n2959 0.23097826086956522
r4899 n2958 n2959 0.034722222222222224
r4900 n2950 n2960 0.20380434782608695
r4901 n2951 n2961 2.34375
r4902 n2960 n2961 0.052083333333333336
r4903 n2952 n2962 0.15625
r4904 n2961 n2962 0.066666666666666666
r4905 n2953 n2963 2.34375
r4906 n2962 n2963 0.066666666666666666
r4907 n2954 n2964 0.20380434782608695
r4908 n2963 n2964 0.052083333333333336
r4909 n2955 n2965 0.20380434782608695
r4910 n2956 n2966 2.34375
r4911 n2965 n2966 0.052083333333333336
r4912 n2957 n2967 0.15625
r4913 n2966 n2967 0.066666666666666666
r4914 n2958 n2968 2.34375
r4915 n2967 n2968 0.066666666666666666
r4916 n2959 n2969 0.20380434782608695
r4917 n2968 n2969 0.052083333333333336
r4918 n2960 n2970 0.14945652173913043
r4919 n2961 n2971 1.71875
r4920 n2970 n2971 0.0625
r4921 n2962 n2972 0.11458333333333333
r4922 n2971 n2972 0.080000000000000002
r4923 n2963 n2973 1.71875
r4924 n2972 n2973 0.080000000000000002
r4925 n2964 n2974 0.14945652173913043
r4926 n2973 n2974 0.0625
r4927 n2965 n2975 0.14945652173913043
r4928 n2966 n2976 1.71875
r4929 n2975 n2976 0.0625
r4930 n2967 n2977 0.11458333333333333
r4931 n2976 n2977 0.080000000000000002
r4932 n2968 n2978 1.71875
r4933 n2977 n2978 0.080000000000000002
r4934 n2969 n2979 0.14945652173913043
r4935 n2978 n2979 0.0625
r4936 n2980 n2981 0.71875
r4937 n2981 n2982 0.125
r4938 n2982 n2983 0.34375
r4939 n2983 n2984 0.65625
r4940 n2984 n2985 0.65625
r4941 n2985 n2986 0.34375
r4942 n2986 n2987 0.125
r4943 n2987 n2988 0.71875
r4944 n2989 n2990 0.71875
r4945 n2990 n2991 0.0625
r4946 n2991 n2992 0.0625
r4947 n2992 n2993 0.34375
r4948 n2993 n2994 0.6875
r4949 n2994 n2995 0.625
r4950 n2995 n2996 0.3125
r4951 n2996 n2997 0.15625
r4952 n2997 n2998 0.15625
r4953 n2998 n2999 0.25
r4954 n2999 n3000 0.5625
r4955 n2980 n3001 0.038690476190476192
r4956 n2981 n3002 0.40625
r4957 n3001 n3002 0.13068181818181818
r4958 n2982 n3003 0.40625
r4959 n3002 n3003 0.022727272727272728
r4960 n2983 n3004 0.090277777777777776
r4961 n3003 n3004 0.0625
r4962 n2984 n3005 0.067708333333333329
r4963 n3004 n3005 0.11931818181818182
r4964 n2985 n3006 0.090277777777777776
r4965 n3005 n3006 0.11931818181818182
r4966 n2986 n3007 0.40625
r4967 n3006 n3007 0.0625
r4968 n2987 n3008 0.40625
r4969 n3007 n3008 0.022727272727272728
r4970 n2988 n3009 0.038690476190476192
r4971 n3008 n3009 0.13068181818181818
r4972 n2989 n3010 0.036931818181818184
r4973 n2990 n3011 0.8125
r4974 n3010 n3011 0.13068181818181818
r4975 n2991 n3012 0.8125
r4976 n3011 n3012 0.011363636363636364
r4977 n2992 n3013 0.8125
r4978 n3012 n3013 0.011363636363636364
r4979 n2993 n3014 0.081250000000000003
r4980 n3013 n3014 0.0625
r4981 n2994 n3015 0.067708333333333329
r4982 n3014 n3015 0.125
r4983 n2995 n3016 0.1015625
r4984 n3015 n3016 0.11363636363636363
r4985 n2996 n3017 0.40625
r4986 n3016 n3017 0.056818181818181816
r4987 n2997 n3018 0.27083333333333331
r4988 n3017 n3018 0.028409090909090908
r4989 n2998 n3019 0.40625
r4990 n3018 n3019 0.028409090909090908
r4991 n2999 n3020 0.13541666666666666
r4992 n3019 n3020 0.045454545454545456
r4993 n3000 n3021 0.067708333333333329
r4994 n3020 n3021 0.10227272727272728
r4995 n3001 n3022 0.038690476190476192
r4996 n3002 n3023 0.40625
r4997 n3022 n3023 0.71875
r4998 n3003 n3024 0.40625
r4999 n3023 n3024 0.125
r5000 n3004 n3025 0.090277777777777776
r5001 n3024 n3025 0.34375
r5002 n3005 n3026 0.067708333333333329
r5003 n3025 n3026 0.65625
r5004 n3006 n3027 0.090277777777777776
r5005 n3026 n3027 0.65625
r5006 n3007 n3028 0.40625
r5007 n3027 n3028 0.34375
r5008 n3008 n3029 0.40625
r5009 n3028 n3029 0.125
r5010 n3009 n3030 0.038690476190476192
r5011 n3029 n3030 0.71875
r5012 n3010 n3031 0.036931818181818184
r5013 n3011 n3032 0.8125
r5014 n3031 n3032 0.71875
r5015 n3012 n3033 0.8125
r5016 n3032 n3033 0.0625
r5017 n3013 n3034 0.8125
r5018 n3033 n3034 0.0625
r5019 n3014 n3035 0.081250000000000003
r5020 n3034 n3035 0.34375
r5021 n3015 n3036 0.067708333333333329
r5022 n3035 n3036 0.6875
r5023 n3016 n3037 0.1015625
r5024 n3036 n3037 0.625
r5025 n3017 n3038 0.40625
r5026 n3037 n3038 0.3125
r5027 n3018 n3039 0.27083333333333331
r5028 n3038 n3039 0.15625
r5029 n3019 n3040 0.40625
r5030 n3039 n3040 0.15625
r5031 n3020 n3041 0.13541666666666666
r5032 n3040 n3041 0.25
r5033 n3021 n3042 0.067708333333333329
r5034 n3041 n3042 0.5625
r5035 n3022 n3043 0.095238095238095233
r5036 n3023 n3044 1
r5037 n3043 n3044 0.04791666666666667
r5038 n3024 n3045 1
r5039 n3044 n3045 0.0083333333333333332
r5040 n3025 n3046 0.22222222222222221
r5041 n3045 n3046 0.022916666666666665
r5042 n3026 n3047 0.16666666666666666
r5043 n3046 n3047 0.043749999999999997
r5044 n3027 n3048 0.22222222222222221
r5045 n3047 n3048 0.043749999999999997
r5046 n3028 n3049 1
r5047 n3048 n3049 0.022916666666666665
r5048 n3029 n3050 1
r5049 n3049 n3050 0.0083333333333333332
r5050 n3030 n3051 0.095238095238095233
r5051 n3050 n3051 0.04791666666666667
r5052 n3031 n3052 0.090909090909090912
r5053 n3032 n3053 2
r5054 n3052 n3053 0.04791666666666667
r5055 n3033 n3054 2
r5056 n3053 n3054 0.0041666666666666666
r5057 n3034 n3055 2
r5058 n3054 n3055 0.0041666666666666666
r5059 n3035 n3056 0.20000000000000001
r5060 n3055 n3056 0.022916666666666665
r5061 n3036 n3057 0.16666666666666666
r5062 n3056 n3057 0.04583333333333333
r5063 n3037 n3058 0.25
r5064 n3057 n3058 0.041666666666666664
r5065 n3038 n3059 1
r5066 n3058 n3059 0.020833333333333332
r5067 n3039 n3060 0.66666666666666663
r5068 n3059 n3060 0.010416666666666666
r5069 n3040 n3061 1
r5070 n3060 n3061 0.010416666666666666
r5071 n3041 n3062 0.33333333333333331
r5072 n3061 n3062 0.016666666666666666
r5073 n3042 n3063 0.16666666666666666
r5074 n3062 n3063 0.037499999999999999
r5075 n3043 n3064 0.095238095238095233
r5076 n3044 n3065 1
r5077 n3064 n3065 0.71875
r5078 n3045 n3066 1
r5079 n3065 n3066 0.125
r5080 n3046 n3067 0.22222222222222221
r5081 n3066 n3067 0.34375
r5082 n3047 n3068 0.16666666666666666
r5083 n3067 n3068 0.65625
r5084 n3048 n3069 0.22222222222222221
r5085 n3068 n3069 0.65625
r5086 n3049 n3070 1
r5087 n3069 n3070 0.34375
r5088 n3050 n3071 1
r5089 n3070 n3071 0.125
r5090 n3051 n3072 0.095238095238095233
r5091 n3071 n3072 0.71875
r5092 n3052 n3073 0.090909090909090912
r5093 n3053 n3074 2
r5094 n3073 n3074 0.71875
r5095 n3054 n3075 2
r5096 n3074 n3075 0.0625
r5097 n3055 n3076 2
r5098 n3075 n3076 0.0625
r5099 n3056 n3077 0.20000000000000001
r5100 n3076 n3077 0.34375
r5101 n3057 n3078 0.16666666666666666
r5102 n3077 n3078 0.6875
r5103 n3058 n3079 0.25
r5104 n3078 n3079 0.625
r5105 n3059 n3080 1
r5106 n3079 n3080 0.3125
r5107 n3060 n3081 0.66666666666666663
r5108 n3080 n3081 0.15625
r5109 n3061 n3082 1
r5110 n3081 n3082 0.15625
r5111 n3062 n3083 0.33333333333333331
r5112 n3082 n3083 0.25
r5113 n3063 n3084 0.16666666666666666
r5114 n3083 n3084 0.5625
r5115 n3064 n3085 0.038690476190476192
r5116 n3065 n3086 0.40625
r5117 n3085 n3086 0.13068181818181818
r5118 n3066 n3087 0.40625
r5119 n3086 n3087 0.022727272727272728
r5120 n3067 n3088 0.090277777777777776
r5121 n3087 n3088 0.0625
r5122 n3068 n3089 0.067708333333333329
r5123 n3088 n3089 0.11931818181818182
r5124 n3069 n3090 0.090277777777777776
r5125 n3089 n3090 0.11931818181818182
r5126 n3070 n3091 0.40625
r5127 n3090 n3091 0.0625
r5128 n3071 n3092 0.40625
r5129 n3091 n3092 0.022727272727272728
r5130 n3072 n3093 0.038690476190476192
r5131 n3092 n3093 0.13068181818181818
r5132 n3073 n3094 0.036931818181818184
r5133 n3074 n3095 0.8125
r5134 n3094 n3095 0.13068181818181818
r5135 n3075 n3096 0.8125
r5136 n3095 n3096 0.011363636363636364
r5137 n3076 n3097 0.8125
r5138 n3096 n3097 0.011363636363636364
r5139 n3077 n3098 0.081250000000000003
r5140 n3097 n3098 0.0625
r5141 n3078 n3099 0.067708333333333329
r5142 n3098 n3099 0.125
r5143 n3079 n3100 0.1015625
r5144 n3099 n3100 0.11363636363636363
r5145 n3080 n3101 0.40625
r5146 n3100 n3101 0.056818181818181816
r5147 n3081 n3102 0.27083333333333331
r5148 n3101 n3102 0.028409090909090908
r5149 n3082 n3103 0.40625
r5150 n3102 n3103 0.028409090909090908
r5151 n3083 n3104 0.13541666666666666
r5152 n3103 n3104 0.045454545454545456
r5153 n3084 n3105 0.067708333333333329
r5154 n3104 n3105 0.10227272727272728
r5155 n3085 n3106 0.038690476190476192
r5156 n3086 n3107 0.40625
r5157 n3106 n3107 0.71875
r5158 n3087 n3108 0.40625
r5159 n3107 n3108 0.125
r5160 n3088 n3109 0.090277777777777776
r5161 n3108 n3109 0.34375
r5162 n3089 n3110 0.067708333333333329
r5163 n3109 n3110 0.65625
r5164 n3090 n3111 0.090277777777777776
r5165 n3110 n3111 0.65625
r5166 n3091 n3112 0.40625
r5167 n3111 n3112 0.34375
r5168 n3092 n3113 0.40625
r5169 n3112 n3113 0.125
r5170 n3093 n3114 0.038690476190476192
r5171 n3113 n3114 0.71875
r5172 n3094 n3115 0.036931818181818184
r5173 n3095 n3116 0.8125
r5174 n3115 n3116 0.71875
r5175 n3096 n3117 0.8125
r5176 n3116 n3117 0.0625
r5177 n3097 n3118 0.8125
r5178 n3117 n3118 0.0625
r5179 n3098 n3119 0.081250000000000003
r5180 n3118 n3119 0.34375
r5181 n3099 n3120 0.067708333333333329
r5182 n3119 n3120 0.6875
r5183 n3100 n3121 0.1015625
r5184 n3120 n3121 0.625
r5185 n3101 n3122 0.40625
r5186 n3121 n3122 0.3125
r5187 n3102 n3123 0.27083333333333331
r5188 n3122 n3123 0.15625
r5189 n3103 n3124 0.40625
r5190 n3123 n3124 0.15625
r5191 n3104 n3125 0.13541666666666666
r5192 n3124 n3125 0.25
r5193 n3105 n3126 0.067708333333333329
r5194 n3125 n3126 0.5625
r5195 n3127 n3128 0.59375
r5196 n3128 n3129 0.28125
r5197 n3129 n3130 0.1875
r5198 n3130 n3131 0.40625
r5199 n3131 n3132 0.9375
r5200 n3132 n3133 0.71875
r5201 n3133 n3134 0.125
r5202 n3134 n3135 0.34375
r5203 n3135 n3136 0.65625
r5204 n3137 n3138 0.65625
r5205 n3138 n3139 0.34375
r5206 n3139 n3140 0.125
r5207 n3140 n3141 0.3125
r5208 n3141 n3142 0.9375
r5209 n3142 n3143 0.71875
r5210 n3143 n3144 0.0625
r5211 n3144 n3145 0.0625
r5212 n3145 n3146 0.34375
r5213 n3146 n3147 0.6875
r5214 n3127 n3148 0.036458333333333336
r5215 n3128 n3149 0.0625
r5216 n3148 n3149 0.23749999999999999
r5217 n3129 n3150 0.21875
r5218 n3149 n3150 0.1125
r5219 n3130 n3151 0.109375
r5220 n3150 n3151 0.074999999999999997
r5221 n3131 n3152 0.048611111111111112
r5222 n3151 n3152 0.16250000000000001
r5223 n3132 n3153 0.020833333333333332
r5224 n3152 n3153 0.375
r5225 n3133 n3154 0.21875
r5226 n3153 n3154 0.28749999999999998
r5227 n3134 n3155 0.21875
r5228 n3154 n3155 0.050000000000000003
r5229 n3135 n3156 0.048611111111111112
r5230 n3155 n3156 0.13750000000000001
r5231 n3136 n3157 0.036458333333333336
r5232 n3156 n3157 0.26250000000000001
r5233 n3137 n3158 0.036458333333333336
r5234 n3138 n3159 0.048611111111111112
r5235 n3158 n3159 0.26250000000000001
r5236 n3139 n3160 0.21875
r5237 n3159 n3160 0.13750000000000001
r5238 n3140 n3161 0.21875
r5239 n3160 n3161 0.050000000000000003
r5240 n3141 n3162 0.0546875
r5241 n3161 n3162 0.125
r5242 n3142 n3163 0.019886363636363636
r5243 n3162 n3163 0.375
r5244 n3143 n3164 0.4375
r5245 n3163 n3164 0.28749999999999998
r5246 n3144 n3165 0.4375
r5247 n3164 n3165 0.025000000000000001
r5248 n3145 n3166 0.4375
r5249 n3165 n3166 0.025000000000000001
r5250 n3146 n3167 0.043749999999999997
r5251 n3166 n3167 0.13750000000000001
r5252 n3147 n3168 0.036458333333333336
r5253 n3167 n3168 0.27500000000000002
r5254 n3169 n3170 0.125
r5255 n3170 n3171 0.35416666666666669
r5256 n3171 n3172 0.35416666666666669
r5257 n3172 n3173 0.39583333333333331
r5258 n3173 n3174 0.39583333333333331
r5259 n3174 n3175 0.15625
r5260 n3148 n3176 0.057291666666666664
r5261 n3175 n3176 0.26041666666666669
r5262 n3149 n3177 0.098214285714285712
r5263 n3176 n3177 0.19791666666666666
r5264 n3150 n3178 0.34375
r5265 n3177 n3178 0.09375
r5266 n3151 n3179 0.171875
r5267 n3178 n3179 0.0625
r5268 n3152 n3180 0.076388888888888895
r5269 n3179 n3180 0.13541666666666666
r5270 n3153 n3181 0.03273809523809524
r5271 n3180 n3181 0.3125
r5272 n3154 n3182 0.34375
r5273 n3181 n3182 0.23958333333333334
r5274 n3155 n3183 0.34375
r5275 n3182 n3183 0.041666666666666664
r5276 n3156 n3184 0.076388888888888895
r5277 n3183 n3184 0.11458333333333333
r5278 n3157 n3185 0.057291666666666664
r5279 n3184 n3185 0.21875
r5280 n3185 n3186 0.21875
r5281 n3186 n3187 0.11458333333333333
r5282 n3187 n3188 0.041666666666666664
r5283 n3188 n3189 0.23958333333333334
r5284 n3189 n3190 0.375
r5285 n3190 n3191 0.17708333333333334
r5286 n3191 n3192 0.35416666666666669
r5287 n3192 n3193 0.35416666666666669
r5288 n3193 n3194 0.14583333333333334
r5289 n3195 n3196 0.125
r5290 n3196 n3197 0.35416666666666669
r5291 n3197 n3198 0.35416666666666669
r5292 n3198 n3199 0.39583333333333331
r5293 n3199 n3200 0.39583333333333331
r5294 n3200 n3201 0.35416666666666669
r5295 n3201 n3202 0.35416666666666669
r5296 n3202 n3203 0.39583333333333331
r5297 n3203 n3204 0.39583333333333331
r5298 n3204 n3205 0.35416666666666669
r5299 n3205 n3206 0.35416666666666669
r5300 n3206 n3207 0.39583333333333331
r5301 n3207 n3208 0.39583333333333331
r5302 n3208 n3209 0.35416666666666669
r5303 n3209 n3210 0.35416666666666669
r5304 n3210 n3211 0.39583333333333331
r5305 n3211 n3212 0.39583333333333331
r5306 n3212 n3213 0.35416666666666669
r5307 n3213 n3214 0.35416666666666669
r5308 n3214 n3215 0.39583333333333331
r5309 n3215 n3216 0.39583333333333331
r5310 n3216 n3217 0.35416666666666669
r5311 n3217 n3218 0.35416666666666669
r5312 n3218 n3219 0.39583333333333331
r5313 n3219 n3220 0.39583333333333331
r5314 n3220 n3221 0.35416666666666669
r5315 n3221 n3222 0.35416666666666669
r5316 n3222 n3223 0.39583333333333331
r5317 n3223 n3224 0.39583333333333331
r5318 n3224 n3225 0.35416666666666669
r5319 n3225 n3226 0.35416666666666669
r5320 n3226 n3227 0.17708333333333334
r5321 n3158 n3228 0.057291666666666664
r5322 n3227 n3228 0.28125
r5323 n3159 n3229 0.076388888888888895
r5324 n3228 n3229 0.21875
r5325 n3160 n3230 0.34375
r5326 n3229 n3230 0.11458333333333333
r5327 n3161 n3231 0.34375
r5328 n3230 n3231 0.041666666666666664
r5329 n3162 n3232 0.0859375
r5330 n3231 n3232 0.10416666666666667
r5331 n3163 n3233 0.03125
r5332 n3232 n3233 0.3125
r5333 n3164 n3234 0.6875
r5334 n3233 n3234 0.23958333333333334
r5335 n3165 n3235 0.6875
r5336 n3234 n3235 0.020833333333333332
r5337 n3166 n3236 0.6875
r5338 n3235 n3236 0.020833333333333332
r5339 n3167 n3237 0.068750000000000006
r5340 n3236 n3237 0.11458333333333333
r5341 n3168 n3238 0.057291666666666664
r5342 n3237 n3238 0.22916666666666666
r5343 n3238 n3239 0.20833333333333334
r5344 n3239 n3240 0.10416666666666667
r5345 n3240 n3241 0.052083333333333336
r5346 n3241 n3242 0.052083333333333336
r5347 n3242 n3243 0.083333333333333329
r5348 n3243 n3244 0.1875
r5349 n3244 n3245 0.27083333333333331
r5350 n3245 n3246 0.16666666666666666
r5351 n3246 n3247 0.39583333333333331
r5352 n3247 n3248 0.39583333333333331
r5353 n3248 n3249 0.35416666666666669
r5354 n3249 n3250 0.35416666666666669
r5355 n3250 n3251 0.39583333333333331
r5356 n3251 n3252 0.39583333333333331
r5357 n3252 n3253 0.35416666666666669
r5358 n3253 n3254 0.35416666666666669
r5359 n3254 n3255 0.39583333333333331
r5360 n3255 n3256 0.39583333333333331
r5361 n3256 n3257 0.35416666666666669
r5362 n3257 n3258 0.35416666666666669
r5363 n3258 n3259 0.39583333333333331
r5364 n3259 n3260 0.39583333333333331
r5365 n3260 n3261 0.35416666666666669
r5366 n3261 n3262 0.35416666666666669
r5367 n3262 n3263 0.39583333333333331
r5368 n3263 n3264 0.39583333333333331
r5369 n3264 n3265 0.35416666666666669
r5370 n3265 n3266 0.35416666666666669
r5371 n3266 n3267 0.39583333333333331
r5372 n3267 n3268 0.39583333333333331
r5373 n3268 n3269 0.35416666666666669
r5374 n3269 n3270 0.35416666666666669
r5375 n3270 n3271 0.39583333333333331
r5376 n3271 n3272 0.39583333333333331
r5377 n3272 n3273 0.35416666666666669
r5378 n3273 n3274 0.35416666666666669
r5379 n3274 n3275 0.14583333333333334
r5380 n3169 n3276 0.050000000000000003
r5381 n3170 n3277 0.25
r5382 n3276 n3277 0.375
r5383 n3171 n3278 0.015625
r5384 n3277 n3278 1.0625
r5385 n3172 n3279 0.25
r5386 n3278 n3279 1.0625
r5387 n3173 n3280 0.013888888888888888
r5388 n3279 n3280 1.1875
r5389 n3174 n3281 0.25
r5390 n3280 n3281 1.1875
r5391 n3175 n3282 0.038461538461538464
r5392 n3281 n3282 0.46875
r5393 n3176 n3283 0.041666666666666664
r5394 n3282 n3283 0.78125
r5395 n3177 n3284 0.071428571428571425
r5396 n3283 n3284 0.59375
r5397 n3178 n3285 0.25
r5398 n3284 n3285 0.28125
r5399 n3179 n3286 0.125
r5400 n3285 n3286 0.1875
r5401 n3180 n3287 0.055555555555555552
r5402 n3286 n3287 0.40625
r5403 n3181 n3288 0.023809523809523808
r5404 n3287 n3288 0.9375
r5405 n3182 n3289 0.25
r5406 n3288 n3289 0.71875
r5407 n3183 n3290 0.25
r5408 n3289 n3290 0.125
r5409 n3184 n3291 0.055555555555555552
r5410 n3290 n3291 0.34375
r5411 n3185 n3292 0.041666666666666664
r5412 n3291 n3292 0.65625
r5413 n3186 n3293 0.055555555555555552
r5414 n3292 n3293 0.65625
r5415 n3187 n3294 0.25
r5416 n3293 n3294 0.34375
r5417 n3188 n3295 0.25
r5418 n3294 n3295 0.125
r5419 n3189 n3296 0.023809523809523808
r5420 n3295 n3296 0.71875
r5421 n3190 n3297 0.033333333333333333
r5422 n3296 n3297 1.125
r5423 n3191 n3298 0.25
r5424 n3297 n3298 0.53125
r5425 n3192 n3299 0.015625
r5426 n3298 n3299 1.0625
r5427 n3193 n3300 0.25
r5428 n3299 n3300 1.0625
r5429 n3194 n3301 0.041666666666666664
r5430 n3300 n3301 0.4375
r5431 n3195 n3302 0.050000000000000003
r5432 n3196 n3303 0.25
r5433 n3302 n3303 0.375
r5434 n3197 n3304 0.015625
r5435 n3303 n3304 1.0625
r5436 n3198 n3305 0.25
r5437 n3304 n3305 1.0625
r5438 n3199 n3306 0.013888888888888888
r5439 n3305 n3306 1.1875
r5440 n3200 n3307 0.25
r5441 n3306 n3307 1.1875
r5442 n3201 n3308 0.015625
r5443 n3307 n3308 1.0625
r5444 n3202 n3309 0.25
r5445 n3308 n3309 1.0625
r5446 n3203 n3310 0.013888888888888888
r5447 n3309 n3310 1.1875
r5448 n3204 n3311 0.25
r5449 n3310 n3311 1.1875
r5450 n3205 n3312 0.015625
r5451 n3311 n3312 1.0625
r5452 n3206 n3313 0.25
r5453 n3312 n3313 1.0625
r5454 n3207 n3314 0.013888888888888888
r5455 n3313 n3314 1.1875
r5456 n3208 n3315 0.25
r5457 n3314 n3315 1.1875
r5458 n3209 n3316 0.015625
r5459 n3315 n3316 1.0625
r5460 n3210 n3317 0.25
r5461 n3316 n3317 1.0625
r5462 n3211 n3318 0.013888888888888888
r5463 n3317 n3318 1.1875
r5464 n3212 n3319 0.25
r5465 n3318 n3319 1.1875
r5466 n3213 n3320 0.015625
r5467 n3319 n3320 1.0625
r5468 n3214 n3321 0.25
r5469 n3320 n3321 1.0625
r5470 n3215 n3322 0.013888888888888888
r5471 n3321 n3322 1.1875
r5472 n3216 n3323 0.25
r5473 n3322 n3323 1.1875
r5474 n3217 n3324 0.015625
r5475 n3323 n3324 1.0625
r5476 n3218 n3325 0.25
r5477 n3324 n3325 1.0625
r5478 n3219 n3326 0.013888888888888888
r5479 n3325 n3326 1.1875
r5480 n3220 n3327 0.25
r5481 n3326 n3327 1.1875
r5482 n3221 n3328 0.015625
r5483 n3327 n3328 1.0625
r5484 n3222 n3329 0.25
r5485 n3328 n3329 1.0625
r5486 n3223 n3330 0.013888888888888888
r5487 n3329 n3330 1.1875
r5488 n3224 n3331 0.25
r5489 n3330 n3331 1.1875
r5490 n3225 n3332 0.015625
r5491 n3331 n3332 1.0625
r5492 n3226 n3333 0.25
r5493 n3332 n3333 1.0625
r5494 n3227 n3334 0.033333333333333333
r5495 n3333 n3334 0.53125
r5496 n3228 n3335 0.041666666666666664
r5497 n3334 n3335 0.84375
r5498 n3229 n3336 0.055555555555555552
r5499 n3335 n3336 0.65625
r5500 n3230 n3337 0.25
r5501 n3336 n3337 0.34375
r5502 n3231 n3338 0.25
r5503 n3337 n3338 0.125
r5504 n3232 n3339 0.0625
r5505 n3338 n3339 0.3125
r5506 n3233 n3340 0.022727272727272728
r5507 n3339 n3340 0.9375
r5508 n3234 n3341 0.5
r5509 n3340 n3341 0.71875
r5510 n3235 n3342 0.5
r5511 n3341 n3342 0.0625
r5512 n3236 n3343 0.5
r5513 n3342 n3343 0.0625
r5514 n3237 n3344 0.050000000000000003
r5515 n3343 n3344 0.34375
r5516 n3238 n3345 0.041666666666666664
r5517 n3344 n3345 0.6875
r5518 n3239 n3346 0.0625
r5519 n3345 n3346 0.625
r5520 n3240 n3347 0.25
r5521 n3346 n3347 0.3125
r5522 n3241 n3348 0.16666666666666666
r5523 n3347 n3348 0.15625
r5524 n3242 n3349 0.25
r5525 n3348 n3349 0.15625
r5526 n3243 n3350 0.083333333333333329
r5527 n3349 n3350 0.25
r5528 n3244 n3351 0.041666666666666664
r5529 n3350 n3351 0.5625
r5530 n3245 n3352 0.035714285714285712
r5531 n3351 n3352 0.8125
r5532 n3246 n3353 0.25
r5533 n3352 n3353 0.5
r5534 n3247 n3354 0.013888888888888888
r5535 n3353 n3354 1.1875
r5536 n3248 n3355 0.25
r5537 n3354 n3355 1.1875
r5538 n3249 n3356 0.015625
r5539 n3355 n3356 1.0625
r5540 n3250 n3357 0.25
r5541 n3356 n3357 1.0625
r5542 n3251 n3358 0.013888888888888888
r5543 n3357 n3358 1.1875
r5544 n3252 n3359 0.25
r5545 n3358 n3359 1.1875
r5546 n3253 n3360 0.015625
r5547 n3359 n3360 1.0625
r5548 n3254 n3361 0.25
r5549 n3360 n3361 1.0625
r5550 n3255 n3362 0.013888888888888888
r5551 n3361 n3362 1.1875
r5552 n3256 n3363 0.25
r5553 n3362 n3363 1.1875
r5554 n3257 n3364 0.015625
r5555 n3363 n3364 1.0625
r5556 n3258 n3365 0.25
r5557 n3364 n3365 1.0625
r5558 n3259 n3366 0.013888888888888888
r5559 n3365 n3366 1.1875
r5560 n3260 n3367 0.25
r5561 n3366 n3367 1.1875
r5562 n3261 n3368 0.015625
r5563 n3367 n3368 1.0625
r5564 n3262 n3369 0.25
r5565 n3368 n3369 1.0625
r5566 n3263 n3370 0.013888888888888888
r5567 n3369 n3370 1.1875
r5568 n3264 n3371 0.25
r5569 n3370 n3371 1.1875
r5570 n3265 n3372 0.015625
r5571 n3371 n3372 1.0625
r5572 n3266 n3373 0.25
r5573 n3372 n3373 1.0625
r5574 n3267 n3374 0.013888888888888888
r5575 n3373 n3374 1.1875
r5576 n3268 n3375 0.25
r5577 n3374 n3375 1.1875
r5578 n3269 n3376 0.015625
r5579 n3375 n3376 1.0625
r5580 n3270 n3377 0.25
r5581 n3376 n3377 1.0625
r5582 n3271 n3378 0.013888888888888888
r5583 n3377 n3378 1.1875
r5584 n3272 n3379 0.25
r5585 n3378 n3379 1.1875
r5586 n3273 n3380 0.015625
r5587 n3379 n3380 1.0625
r5588 n3274 n3381 0.25
r5589 n3380 n3381 1.0625
r5590 n3275 n3382 0.041666666666666664
r5591 n3381 n3382 0.4375
r5592 n3276 n3383 0.043749999999999997
r5593 n3277 n3384 0.21875
r5594 n3383 n3384 0.14999999999999999
r5595 n3278 n3385 0.013671875
r5596 n3384 n3385 0.42499999999999999
r5597 n3279 n3386 0.21875
r5598 n3385 n3386 0.42499999999999999
r5599 n3280 n3387 0.012152777777777778
r5600 n3386 n3387 0.47499999999999998
r5601 n3281 n3388 0.21875
r5602 n3387 n3388 0.47499999999999998
r5603 n3282 n3389 0.033653846153846152
r5604 n3388 n3389 0.1875
r5605 n3283 n3390 0.036458333333333336
r5606 n3389 n3390 0.3125
r5607 n3284 n3391 0.0625
r5608 n3390 n3391 0.23749999999999999
r5609 n3285 n3392 0.21875
r5610 n3391 n3392 0.1125
r5611 n3286 n3393 0.109375
r5612 n3392 n3393 0.074999999999999997
r5613 n3287 n3394 0.048611111111111112
r5614 n3393 n3394 0.16250000000000001
r5615 n3288 n3395 0.020833333333333332
r5616 n3394 n3395 0.375
r5617 n3289 n3396 0.21875
r5618 n3395 n3396 0.28749999999999998
r5619 n3290 n3397 0.21875
r5620 n3396 n3397 0.050000000000000003
r5621 n3291 n3398 0.048611111111111112
r5622 n3397 n3398 0.13750000000000001
r5623 n3292 n3399 0.036458333333333336
r5624 n3398 n3399 0.26250000000000001
r5625 n3293 n3400 0.048611111111111112
r5626 n3399 n3400 0.26250000000000001
r5627 n3294 n3401 0.21875
r5628 n3400 n3401 0.13750000000000001
r5629 n3295 n3402 0.21875
r5630 n3401 n3402 0.050000000000000003
r5631 n3296 n3403 0.020833333333333332
r5632 n3402 n3403 0.28749999999999998
r5633 n3297 n3404 0.029166666666666667
r5634 n3403 n3404 0.45000000000000001
r5635 n3298 n3405 0.21875
r5636 n3404 n3405 0.21249999999999999
r5637 n3299 n3406 0.013671875
r5638 n3405 n3406 0.42499999999999999
r5639 n3300 n3407 0.21875
r5640 n3406 n3407 0.42499999999999999
r5641 n3301 n3408 0.036458333333333336
r5642 n3407 n3408 0.17499999999999999
r5643 n3302 n3409 0.043749999999999997
r5644 n3303 n3410 0.21875
r5645 n3409 n3410 0.14999999999999999
r5646 n3304 n3411 0.013671875
r5647 n3410 n3411 0.42499999999999999
r5648 n3305 n3412 0.21875
r5649 n3411 n3412 0.42499999999999999
r5650 n3306 n3413 0.012152777777777778
r5651 n3412 n3413 0.47499999999999998
r5652 n3307 n3414 0.21875
r5653 n3413 n3414 0.47499999999999998
r5654 n3308 n3415 0.013671875
r5655 n3414 n3415 0.42499999999999999
r5656 n3309 n3416 0.21875
r5657 n3415 n3416 0.42499999999999999
r5658 n3310 n3417 0.012152777777777778
r5659 n3416 n3417 0.47499999999999998
r5660 n3311 n3418 0.21875
r5661 n3417 n3418 0.47499999999999998
r5662 n3312 n3419 0.013671875
r5663 n3418 n3419 0.42499999999999999
r5664 n3313 n3420 0.21875
r5665 n3419 n3420 0.42499999999999999
r5666 n3314 n3421 0.012152777777777778
r5667 n3420 n3421 0.47499999999999998
r5668 n3315 n3422 0.21875
r5669 n3421 n3422 0.47499999999999998
r5670 n3316 n3423 0.013671875
r5671 n3422 n3423 0.42499999999999999
r5672 n3317 n3424 0.21875
r5673 n3423 n3424 0.42499999999999999
r5674 n3318 n3425 0.012152777777777778
r5675 n3424 n3425 0.47499999999999998
r5676 n3319 n3426 0.21875
r5677 n3425 n3426 0.47499999999999998
r5678 n3320 n3427 0.013671875
r5679 n3426 n3427 0.42499999999999999
r5680 n3321 n3428 0.21875
r5681 n3427 n3428 0.42499999999999999
r5682 n3322 n3429 0.012152777777777778
r5683 n3428 n3429 0.47499999999999998
r5684 n3323 n3430 0.21875
r5685 n3429 n3430 0.47499999999999998
r5686 n3324 n3431 0.013671875
r5687 n3430 n3431 0.42499999999999999
r5688 n3325 n3432 0.21875
r5689 n3431 n3432 0.42499999999999999
r5690 n3326 n3433 0.012152777777777778
r5691 n3432 n3433 0.47499999999999998
r5692 n3327 n3434 0.21875
r5693 n3433 n3434 0.47499999999999998
r5694 n3328 n3435 0.013671875
r5695 n3434 n3435 0.42499999999999999
r5696 n3329 n3436 0.21875
r5697 n3435 n3436 0.42499999999999999
r5698 n3330 n3437 0.012152777777777778
r5699 n3436 n3437 0.47499999999999998
r5700 n3331 n3438 0.21875
r5701 n3437 n3438 0.47499999999999998
r5702 n3332 n3439 0.013671875
r5703 n3438 n3439 0.42499999999999999
r5704 n3333 n3440 0.21875
r5705 n3439 n3440 0.42499999999999999
r5706 n3334 n3441 0.029166666666666667
r5707 n3440 n3441 0.21249999999999999
r5708 n3335 n3442 0.036458333333333336
r5709 n3441 n3442 0.33750000000000002
r5710 n3336 n3443 0.048611111111111112
r5711 n3442 n3443 0.26250000000000001
r5712 n3337 n3444 0.21875
r5713 n3443 n3444 0.13750000000000001
r5714 n3338 n3445 0.21875
r5715 n3444 n3445 0.050000000000000003
r5716 n3339 n3446 0.0546875
r5717 n3445 n3446 0.125
r5718 n3340 n3447 0.019886363636363636
r5719 n3446 n3447 0.375
r5720 n3341 n3448 0.4375
r5721 n3447 n3448 0.28749999999999998
r5722 n3342 n3449 0.4375
r5723 n3448 n3449 0.025000000000000001
r5724 n3343 n3450 0.4375
r5725 n3449 n3450 0.025000000000000001
r5726 n3344 n3451 0.043749999999999997
r5727 n3450 n3451 0.13750000000000001
r5728 n3345 n3452 0.036458333333333336
r5729 n3451 n3452 0.27500000000000002
r5730 n3346 n3453 0.0546875
r5731 n3452 n3453 0.25
r5732 n3347 n3454 0.21875
r5733 n3453 n3454 0.125
r5734 n3348 n3455 0.14583333333333334
r5735 n3454 n3455 0.0625
r5736 n3349 n3456 0.21875
r5737 n3455 n3456 0.0625
r5738 n3350 n3457 0.072916666666666671
r5739 n3456 n3457 0.10000000000000001
r5740 n3351 n3458 0.036458333333333336
r5741 n3457 n3458 0.22500000000000001
r5742 n3352 n3459 0.03125
r5743 n3458 n3459 0.32500000000000001
r5744 n3353 n3460 0.21875
r5745 n3459 n3460 0.20000000000000001
r5746 n3354 n3461 0.012152777777777778
r5747 n3460 n3461 0.47499999999999998
r5748 n3355 n3462 0.21875
r5749 n3461 n3462 0.47499999999999998
r5750 n3356 n3463 0.013671875
r5751 n3462 n3463 0.42499999999999999
r5752 n3357 n3464 0.21875
r5753 n3463 n3464 0.42499999999999999
r5754 n3358 n3465 0.012152777777777778
r5755 n3464 n3465 0.47499999999999998
r5756 n3359 n3466 0.21875
r5757 n3465 n3466 0.47499999999999998
r5758 n3360 n3467 0.013671875
r5759 n3466 n3467 0.42499999999999999
r5760 n3361 n3468 0.21875
r5761 n3467 n3468 0.42499999999999999
r5762 n3362 n3469 0.012152777777777778
r5763 n3468 n3469 0.47499999999999998
r5764 n3363 n3470 0.21875
r5765 n3469 n3470 0.47499999999999998
r5766 n3364 n3471 0.013671875
r5767 n3470 n3471 0.42499999999999999
r5768 n3365 n3472 0.21875
r5769 n3471 n3472 0.42499999999999999
r5770 n3366 n3473 0.012152777777777778
r5771 n3472 n3473 0.47499999999999998
r5772 n3367 n3474 0.21875
r5773 n3473 n3474 0.47499999999999998
r5774 n3368 n3475 0.013671875
r5775 n3474 n3475 0.42499999999999999
r5776 n3369 n3476 0.21875
r5777 n3475 n3476 0.42499999999999999
r5778 n3370 n3477 0.012152777777777778
r5779 n3476 n3477 0.47499999999999998
r5780 n3371 n3478 0.21875
r5781 n3477 n3478 0.47499999999999998
r5782 n3372 n3479 0.013671875
r5783 n3478 n3479 0.42499999999999999
r5784 n3373 n3480 0.21875
r5785 n3479 n3480 0.42499999999999999
r5786 n3374 n3481 0.012152777777777778
r5787 n3480 n3481 0.47499999999999998
r5788 n3375 n3482 0.21875
r5789 n3481 n3482 0.47499999999999998
r5790 n3376 n3483 0.013671875
r5791 n3482 n3483 0.42499999999999999
r5792 n3377 n3484 0.21875
r5793 n3483 n3484 0.42499999999999999
r5794 n3378 n3485 0.012152777777777778
r5795 n3484 n3485 0.47499999999999998
r5796 n3379 n3486 0.21875
r5797 n3485 n3486 0.47499999999999998
r5798 n3380 n3487 0.013671875
r5799 n3486 n3487 0.42499999999999999
r5800 n3381 n3488 0.21875
r5801 n3487 n3488 0.42499999999999999
r5802 n3382 n3489 0.036458333333333336
r5803 n3488 n3489 0.17499999999999999
r5804 n3383 n3490 0.125
r5805 n3384 n3491 0.625
r5806 n3490 n3491 0.050000000000000003
r5807 n3385 n3492 0.0390625
r5808 n3491 n3492 0.14166666666666666
r5809 n3386 n3493 0.625
r5810 n3492 n3493 0.14166666666666666
r5811 n3387 n3494 0.034722222222222224
r5812 n3493 n3494 0.15833333333333333
r5813 n3388 n3495 0.625
r5814 n3494 n3495 0.15833333333333333
r5815 n3389 n3496 0.096153846153846159
r5816 n3495 n3496 0.0625
r5817 n3390 n3497 0.10416666666666667
r5818 n3496 n3497 0.10416666666666667
r5819 n3391 n3498 0.17857142857142858
r5820 n3497 n3498 0.079166666666666663
r5821 n3392 n3499 0.625
r5822 n3498 n3499 0.037499999999999999
r5823 n3393 n3500 0.3125
r5824 n3499 n3500 0.025000000000000001
r5825 n3394 n3501 0.1388888888888889
r5826 n3500 n3501 0.054166666666666669
r5827 n3395 n3502 0.059523809523809521
r5828 n3501 n3502 0.125
r5829 n3396 n3503 0.625
r5830 n3502 n3503 0.09583333333333334
r5831 n3397 n3504 0.625
r5832 n3503 n3504 0.016666666666666666
r5833 n3398 n3505 0.1388888888888889
r5834 n3504 n3505 0.04583333333333333
r5835 n3399 n3506 0.10416666666666667
r5836 n3505 n3506 0.087499999999999994
r5837 n3400 n3507 0.1388888888888889
r5838 n3506 n3507 0.087499999999999994
r5839 n3401 n3508 0.625
r5840 n3507 n3508 0.04583333333333333
r5841 n3402 n3509 0.625
r5842 n3508 n3509 0.016666666666666666
r5843 n3403 n3510 0.059523809523809521
r5844 n3509 n3510 0.09583333333333334
r5845 n3404 n3511 0.083333333333333329
r5846 n3510 n3511 0.14999999999999999
r5847 n3405 n3512 0.625
r5848 n3511 n3512 0.070833333333333331
r5849 n3406 n3513 0.0390625
r5850 n3512 n3513 0.14166666666666666
r5851 n3407 n3514 0.625
r5852 n3513 n3514 0.14166666666666666
r5853 n3408 n3515 0.10416666666666667
r5854 n3514 n3515 0.058333333333333334
r5855 n3409 n3516 0.125
r5856 n3410 n3517 0.625
r5857 n3516 n3517 0.050000000000000003
r5858 n3411 n3518 0.0390625
r5859 n3517 n3518 0.14166666666666666
r5860 n3412 n3519 0.625
r5861 n3518 n3519 0.14166666666666666
r5862 n3413 n3520 0.034722222222222224
r5863 n3519 n3520 0.15833333333333333
r5864 n3414 n3521 0.625
r5865 n3520 n3521 0.15833333333333333
r5866 n3415 n3522 0.0390625
r5867 n3521 n3522 0.14166666666666666
r5868 n3416 n3523 0.625
r5869 n3522 n3523 0.14166666666666666
r5870 n3417 n3524 0.034722222222222224
r5871 n3523 n3524 0.15833333333333333
r5872 n3418 n3525 0.625
r5873 n3524 n3525 0.15833333333333333
r5874 n3419 n3526 0.0390625
r5875 n3525 n3526 0.14166666666666666
r5876 n3420 n3527 0.625
r5877 n3526 n3527 0.14166666666666666
r5878 n3421 n3528 0.034722222222222224
r5879 n3527 n3528 0.15833333333333333
r5880 n3422 n3529 0.625
r5881 n3528 n3529 0.15833333333333333
r5882 n3423 n3530 0.0390625
r5883 n3529 n3530 0.14166666666666666
r5884 n3424 n3531 0.625
r5885 n3530 n3531 0.14166666666666666
r5886 n3425 n3532 0.034722222222222224
r5887 n3531 n3532 0.15833333333333333
r5888 n3426 n3533 0.625
r5889 n3532 n3533 0.15833333333333333
r5890 n3427 n3534 0.0390625
r5891 n3533 n3534 0.14166666666666666
r5892 n3428 n3535 0.625
r5893 n3534 n3535 0.14166666666666666
r5894 n3429 n3536 0.034722222222222224
r5895 n3535 n3536 0.15833333333333333
r5896 n3430 n3537 0.625
r5897 n3536 n3537 0.15833333333333333
r5898 n3431 n3538 0.0390625
r5899 n3537 n3538 0.14166666666666666
r5900 n3432 n3539 0.625
r5901 n3538 n3539 0.14166666666666666
r5902 n3433 n3540 0.034722222222222224
r5903 n3539 n3540 0.15833333333333333
r5904 n3434 n3541 0.625
r5905 n3540 n3541 0.15833333333333333
r5906 n3435 n3542 0.0390625
r5907 n3541 n3542 0.14166666666666666
r5908 n3436 n3543 0.625
r5909 n3542 n3543 0.14166666666666666
r5910 n3437 n3544 0.034722222222222224
r5911 n3543 n3544 0.15833333333333333
r5912 n3438 n3545 0.625
r5913 n3544 n3545 0.15833333333333333
r5914 n3439 n3546 0.0390625
r5915 n3545 n3546 0.14166666666666666
r5916 n3440 n3547 0.625
r5917 n3546 n3547 0.14166666666666666
r5918 n3441 n3548 0.083333333333333329
r5919 n3547 n3548 0.070833333333333331
r5920 n3442 n3549 0.10416666666666667
r5921 n3548 n3549 0.1125
r5922 n3443 n3550 0.1388888888888889
r5923 n3549 n3550 0.087499999999999994
r5924 n3444 n3551 0.625
r5925 n3550 n3551 0.04583333333333333
r5926 n3445 n3552 0.625
r5927 n3551 n3552 0.016666666666666666
r5928 n3446 n3553 0.15625
r5929 n3552 n3553 0.041666666666666664
r5930 n3447 n3554 0.056818181818181816
r5931 n3553 n3554 0.125
r5932 n3448 n3555 1.25
r5933 n3554 n3555 0.09583333333333334
r5934 n3449 n3556 1.25
r5935 n3555 n3556 0.0083333333333333332
r5936 n3450 n3557 1.25
r5937 n3556 n3557 0.0083333333333333332
r5938 n3451 n3558 0.125
r5939 n3557 n3558 0.04583333333333333
r5940 n3452 n3559 0.10416666666666667
r5941 n3558 n3559 0.09166666666666666
r5942 n3453 n3560 0.15625
r5943 n3559 n3560 0.083333333333333329
r5944 n3454 n3561 0.625
r5945 n3560 n3561 0.041666666666666664
r5946 n3455 n3562 0.41666666666666669
r5947 n3561 n3562 0.020833333333333332
r5948 n3456 n3563 0.625
r5949 n3562 n3563 0.020833333333333332
r5950 n3457 n3564 0.20833333333333334
r5951 n3563 n3564 0.033333333333333333
r5952 n3458 n3565 0.10416666666666667
r5953 n3564 n3565 0.074999999999999997
r5954 n3459 n3566 0.089285714285714288
r5955 n3565 n3566 0.10833333333333334
r5956 n3460 n3567 0.625
r5957 n3566 n3567 0.066666666666666666
r5958 n3461 n3568 0.034722222222222224
r5959 n3567 n3568 0.15833333333333333
r5960 n3462 n3569 0.625
r5961 n3568 n3569 0.15833333333333333
r5962 n3463 n3570 0.0390625
r5963 n3569 n3570 0.14166666666666666
r5964 n3464 n3571 0.625
r5965 n3570 n3571 0.14166666666666666
r5966 n3465 n3572 0.034722222222222224
r5967 n3571 n3572 0.15833333333333333
r5968 n3466 n3573 0.625
r5969 n3572 n3573 0.15833333333333333
r5970 n3467 n3574 0.0390625
r5971 n3573 n3574 0.14166666666666666
r5972 n3468 n3575 0.625
r5973 n3574 n3575 0.14166666666666666
r5974 n3469 n3576 0.034722222222222224
r5975 n3575 n3576 0.15833333333333333
r5976 n3470 n3577 0.625
r5977 n3576 n3577 0.15833333333333333
r5978 n3471 n3578 0.0390625
r5979 n3577 n3578 0.14166666666666666
r5980 n3472 n3579 0.625
r5981 n3578 n3579 0.14166666666666666
r5982 n3473 n3580 0.034722222222222224
r5983 n3579 n3580 0.15833333333333333
r5984 n3474 n3581 0.625
r5985 n3580 n3581 0.15833333333333333
r5986 n3475 n3582 0.0390625
r5987 n3581 n3582 0.14166666666666666
r5988 n3476 n3583 0.625
r5989 n3582 n3583 0.14166666666666666
r5990 n3477 n3584 0.034722222222222224
r5991 n3583 n3584 0.15833333333333333
r5992 n3478 n3585 0.625
r5993 n3584 n3585 0.15833333333333333
r5994 n3479 n3586 0.0390625
r5995 n3585 n3586 0.14166666666666666
r5996 n3480 n3587 0.625
r5997 n3586 n3587 0.14166666666666666
r5998 n3481 n3588 0.034722222222222224
r5999 n3587 n3588 0.15833333333333333
r6000 n3482 n3589 0.625
r6001 n3588 n3589 0.15833333333333333
r6002 n3483 n3590 0.0390625
r6003 n3589 n3590 0.14166666666666666
r6004 n3484 n3591 0.625
r6005 n3590 n3591 0.14166666666666666
r6006 n3485 n3592 0.034722222222222224
r6007 n3591 n3592 0.15833333333333333
r6008 n3486 n3593 0.625
r6009 n3592 n3593 0.15833333333333333
r6010 n3487 n3594 0.0390625
r6011 n3593 n3594 0.14166666666666666
r6012 n3488 n3595 0.625
r6013 n3594 n3595 0.14166666666666666
r6014 n3489 n3596 0.10416666666666667
r6015 n3595 n3596 0.058333333333333334
r6016 n3490 n3597 0.1125
r6017 n3491 n3598 0.5625
r6018 n3597 n3598 0.25
r6019 n3492 n3599 0.03515625
r6020 n3598 n3599 0.70833333333333337
r6021 n3493 n3600 0.5625
r6022 n3599 n3600 0.70833333333333337
r6023 n3494 n3601 0.03125
r6024 n3600 n3601 0.79166666666666663
r6025 n3495 n3602 0.5625
r6026 n3601 n3602 0.79166666666666663
r6027 n3496 n3603 0.086538461538461536
r6028 n3602 n3603 0.3125
r6029 n3497 n3604 0.09375
r6030 n3603 n3604 0.52083333333333337
r6031 n3498 n3605 0.16071428571428573
r6032 n3604 n3605 0.39583333333333331
r6033 n3499 n3606 0.5625
r6034 n3605 n3606 0.1875
r6035 n3500 n3607 0.28125
r6036 n3606 n3607 0.125
r6037 n3501 n3608 0.125
r6038 n3607 n3608 0.27083333333333331
r6039 n3502 n3609 0.053571428571428568
r6040 n3608 n3609 0.625
r6041 n3503 n3610 0.5625
r6042 n3609 n3610 0.47916666666666669
r6043 n3504 n3611 0.5625
r6044 n3610 n3611 0.083333333333333329
r6045 n3505 n3612 0.125
r6046 n3611 n3612 0.22916666666666666
r6047 n3506 n3613 0.09375
r6048 n3612 n3613 0.4375
r6049 n3507 n3614 0.125
r6050 n3613 n3614 0.4375
r6051 n3508 n3615 0.5625
r6052 n3614 n3615 0.22916666666666666
r6053 n3509 n3616 0.5625
r6054 n3615 n3616 0.083333333333333329
r6055 n3510 n3617 0.053571428571428568
r6056 n3616 n3617 0.47916666666666669
r6057 n3511 n3618 0.074999999999999997
r6058 n3617 n3618 0.75
r6059 n3512 n3619 0.5625
r6060 n3618 n3619 0.35416666666666669
r6061 n3513 n3620 0.03515625
r6062 n3619 n3620 0.70833333333333337
r6063 n3514 n3621 0.5625
r6064 n3620 n3621 0.70833333333333337
r6065 n3515 n3622 0.09375
r6066 n3621 n3622 0.29166666666666669
r6067 n3516 n3623 0.1125
r6068 n3517 n3624 0.5625
r6069 n3623 n3624 0.25
r6070 n3518 n3625 0.03515625
r6071 n3624 n3625 0.70833333333333337
r6072 n3519 n3626 0.5625
r6073 n3625 n3626 0.70833333333333337
r6074 n3520 n3627 0.03125
r6075 n3626 n3627 0.79166666666666663
r6076 n3521 n3628 0.5625
r6077 n3627 n3628 0.79166666666666663
r6078 n3522 n3629 0.03515625
r6079 n3628 n3629 0.70833333333333337
r6080 n3523 n3630 0.5625
r6081 n3629 n3630 0.70833333333333337
r6082 n3524 n3631 0.03125
r6083 n3630 n3631 0.79166666666666663
r6084 n3525 n3632 0.5625
r6085 n3631 n3632 0.79166666666666663
r6086 n3526 n3633 0.03515625
r6087 n3632 n3633 0.70833333333333337
r6088 n3527 n3634 0.5625
r6089 n3633 n3634 0.70833333333333337
r6090 n3528 n3635 0.03125
r6091 n3634 n3635 0.79166666666666663
r6092 n3529 n3636 0.5625
r6093 n3635 n3636 0.79166666666666663
r6094 n3530 n3637 0.03515625
r6095 n3636 n3637 0.70833333333333337
r6096 n3531 n3638 0.5625
r6097 n3637 n3638 0.70833333333333337
r6098 n3532 n3639 0.03125
r6099 n3638 n3639 0.79166666666666663
r6100 n3533 n3640 0.5625
r6101 n3639 n3640 0.79166666666666663
r6102 n3534 n3641 0.03515625
r6103 n3640 n3641 0.70833333333333337
r6104 n3535 n3642 0.5625
r6105 n3641 n3642 0.70833333333333337
r6106 n3536 n3643 0.03125
r6107 n3642 n3643 0.79166666666666663
r6108 n3537 n3644 0.5625
r6109 n3643 n3644 0.79166666666666663
r6110 n3538 n3645 0.03515625
r6111 n3644 n3645 0.70833333333333337
r6112 n3539 n3646 0.5625
r6113 n3645 n3646 0.70833333333333337
r6114 n3540 n3647 0.03125
r6115 n3646 n3647 0.79166666666666663
r6116 n3541 n3648 0.5625
r6117 n3647 n3648 0.79166666666666663
r6118 n3542 n3649 0.03515625
r6119 n3648 n3649 0.70833333333333337
r6120 n3543 n3650 0.5625
r6121 n3649 n3650 0.70833333333333337
r6122 n3544 n3651 0.03125
r6123 n3650 n3651 0.79166666666666663
r6124 n3545 n3652 0.5625
r6125 n3651 n3652 0.79166666666666663
r6126 n3546 n3653 0.03515625
r6127 n3652 n3653 0.70833333333333337
r6128 n3547 n3654 0.5625
r6129 n3653 n3654 0.70833333333333337
r6130 n3548 n3655 0.074999999999999997
r6131 n3654 n3655 0.35416666666666669
r6132 n3549 n3656 0.09375
r6133 n3655 n3656 0.5625
r6134 n3550 n3657 0.125
r6135 n3656 n3657 0.4375
r6136 n3551 n3658 0.5625
r6137 n3657 n3658 0.22916666666666666
r6138 n3552 n3659 0.5625
r6139 n3658 n3659 0.083333333333333329
r6140 n3553 n3660 0.140625
r6141 n3659 n3660 0.20833333333333334
r6142 n3554 n3661 0.05113636363636364
r6143 n3660 n3661 0.625
r6144 n3555 n3662 1.125
r6145 n3661 n3662 0.47916666666666669
r6146 n3556 n3663 1.125
r6147 n3662 n3663 0.041666666666666664
r6148 n3557 n3664 1.125
r6149 n3663 n3664 0.041666666666666664
r6150 n3558 n3665 0.1125
r6151 n3664 n3665 0.22916666666666666
r6152 n3559 n3666 0.09375
r6153 n3665 n3666 0.45833333333333331
r6154 n3560 n3667 0.140625
r6155 n3666 n3667 0.41666666666666669
r6156 n3561 n3668 0.5625
r6157 n3667 n3668 0.20833333333333334
r6158 n3562 n3669 0.375
r6159 n3668 n3669 0.10416666666666667
r6160 n3563 n3670 0.5625
r6161 n3669 n3670 0.10416666666666667
r6162 n3564 n3671 0.1875
r6163 n3670 n3671 0.16666666666666666
r6164 n3565 n3672 0.09375
r6165 n3671 n3672 0.375
r6166 n3566 n3673 0.080357142857142863
r6167 n3672 n3673 0.54166666666666663
r6168 n3567 n3674 0.5625
r6169 n3673 n3674 0.33333333333333331
r6170 n3568 n3675 0.03125
r6171 n3674 n3675 0.79166666666666663
r6172 n3569 n3676 0.5625
r6173 n3675 n3676 0.79166666666666663
r6174 n3570 n3677 0.03515625
r6175 n3676 n3677 0.70833333333333337
r6176 n3571 n3678 0.5625
r6177 n3677 n3678 0.70833333333333337
r6178 n3572 n3679 0.03125
r6179 n3678 n3679 0.79166666666666663
r6180 n3573 n3680 0.5625
r6181 n3679 n3680 0.79166666666666663
r6182 n3574 n3681 0.03515625
r6183 n3680 n3681 0.70833333333333337
r6184 n3575 n3682 0.5625
r6185 n3681 n3682 0.70833333333333337
r6186 n3576 n3683 0.03125
r6187 n3682 n3683 0.79166666666666663
r6188 n3577 n3684 0.5625
r6189 n3683 n3684 0.79166666666666663
r6190 n3578 n3685 0.03515625
r6191 n3684 n3685 0.70833333333333337
r6192 n3579 n3686 0.5625
r6193 n3685 n3686 0.70833333333333337
r6194 n3580 n3687 0.03125
r6195 n3686 n3687 0.79166666666666663
r6196 n3581 n3688 0.5625
r6197 n3687 n3688 0.79166666666666663
r6198 n3582 n3689 0.03515625
r6199 n3688 n3689 0.70833333333333337
r6200 n3583 n3690 0.5625
r6201 n3689 n3690 0.70833333333333337
r6202 n3584 n3691 0.03125
r6203 n3690 n3691 0.79166666666666663
r6204 n3585 n3692 0.5625
r6205 n3691 n3692 0.79166666666666663
r6206 n3586 n3693 0.03515625
r6207 n3692 n3693 0.70833333333333337
r6208 n3587 n3694 0.5625
r6209 n3693 n3694 0.70833333333333337
r6210 n3588 n3695 0.03125
r6211 n3694 n3695 0.79166666666666663
r6212 n3589 n3696 0.5625
r6213 n3695 n3696 0.79166666666666663
r6214 n3590 n3697 0.03515625
r6215 n3696 n3697 0.70833333333333337
r6216 n3591 n3698 0.5625
r6217 n3697 n3698 0.70833333333333337
r6218 n3592 n3699 0.03125
r6219 n3698 n3699 0.79166666666666663
r6220 n3593 n3700 0.5625
r6221 n3699 n3700 0.79166666666666663
r6222 n3594 n3701 0.03515625
r6223 n3700 n3701 0.70833333333333337
r6224 n3595 n3702 0.5625
r6225 n3701 n3702 0.70833333333333337
r6226 n3596 n3703 0.09375
r6227 n3702 n3703 0.29166666666666669
r6228 n3597 n3704 0.043749999999999997
r6229 n3598 n3705 0.21875
r6230 n3704 n3705 0.1875
r6231 n3599 n3706 0.013671875
r6232 n3705 n3706 0.53125
r6233 n3600 n3707 0.21875
r6234 n3706 n3707 0.53125
r6235 n3601 n3708 0.012152777777777778
r6236 n3707 n3708 0.59375
r6237 n3602 n3709 0.21875
r6238 n3708 n3709 0.59375
r6239 n3603 n3710 0.033653846153846152
r6240 n3709 n3710 0.234375
r6241 n3604 n3711 0.036458333333333336
r6242 n3710 n3711 0.390625
r6243 n3605 n3712 0.0625
r6244 n3711 n3712 0.296875
r6245 n3606 n3713 0.21875
r6246 n3712 n3713 0.140625
r6247 n3607 n3714 0.109375
r6248 n3713 n3714 0.09375
r6249 n3608 n3715 0.048611111111111112
r6250 n3714 n3715 0.203125
r6251 n3609 n3716 0.020833333333333332
r6252 n3715 n3716 0.46875
r6253 n3610 n3717 0.21875
r6254 n3716 n3717 0.359375
r6255 n3611 n3718 0.21875
r6256 n3717 n3718 0.0625
r6257 n3612 n3719 0.048611111111111112
r6258 n3718 n3719 0.171875
r6259 n3613 n3720 0.036458333333333336
r6260 n3719 n3720 0.328125
r6261 n3614 n3721 0.048611111111111112
r6262 n3720 n3721 0.328125
r6263 n3615 n3722 0.21875
r6264 n3721 n3722 0.171875
r6265 n3616 n3723 0.21875
r6266 n3722 n3723 0.0625
r6267 n3617 n3724 0.020833333333333332
r6268 n3723 n3724 0.359375
r6269 n3618 n3725 0.029166666666666667
r6270 n3724 n3725 0.5625
r6271 n3619 n3726 0.21875
r6272 n3725 n3726 0.265625
r6273 n3620 n3727 0.013671875
r6274 n3726 n3727 0.53125
r6275 n3621 n3728 0.21875
r6276 n3727 n3728 0.53125
r6277 n3622 n3729 0.036458333333333336
r6278 n3728 n3729 0.21875
r6279 n3730 n3731 0.09375
r6280 n3731 n3732 0.078125
r6281 n3732 n3733 0.15625
r6282 n3733 n3734 0.46875
r6283 n3734 n3735 0.375
r6284 n3735 n3736 0.078125
r6285 n3736 n3737 0.09375
r6286 n3623 n3738 0.043749999999999997
r6287 n3624 n3739 0.21875
r6288 n3738 n3739 0.1875
r6289 n3625 n3740 0.013671875
r6290 n3739 n3740 0.53125
r6291 n3626 n3741 0.21875
r6292 n3740 n3741 0.53125
r6293 n3627 n3742 0.012152777777777778
r6294 n3741 n3742 0.59375
r6295 n3628 n3743 0.21875
r6296 n3742 n3743 0.59375
r6297 n3629 n3744 0.013671875
r6298 n3743 n3744 0.53125
r6299 n3630 n3745 0.21875
r6300 n3744 n3745 0.53125
r6301 n3631 n3746 0.012152777777777778
r6302 n3745 n3746 0.59375
r6303 n3632 n3747 0.21875
r6304 n3746 n3747 0.59375
r6305 n3633 n3748 0.013671875
r6306 n3747 n3748 0.53125
r6307 n3634 n3749 0.21875
r6308 n3748 n3749 0.53125
r6309 n3635 n3750 0.012152777777777778
r6310 n3749 n3750 0.59375
r6311 n3636 n3751 0.21875
r6312 n3750 n3751 0.59375
r6313 n3637 n3752 0.013671875
r6314 n3751 n3752 0.53125
r6315 n3638 n3753 0.21875
r6316 n3752 n3753 0.53125
r6317 n3639 n3754 0.012152777777777778
r6318 n3753 n3754 0.59375
r6319 n3640 n3755 0.21875
r6320 n3754 n3755 0.59375
r6321 n3641 n3756 0.013671875
r6322 n3755 n3756 0.53125
r6323 n3642 n3757 0.21875
r6324 n3756 n3757 0.53125
r6325 n3643 n3758 0.012152777777777778
r6326 n3757 n3758 0.59375
r6327 n3644 n3759 0.21875
r6328 n3758 n3759 0.59375
r6329 n3645 n3760 0.013671875
r6330 n3759 n3760 0.53125
r6331 n3646 n3761 0.21875
r6332 n3760 n3761 0.53125
r6333 n3647 n3762 0.012152777777777778
r6334 n3761 n3762 0.59375
r6335 n3648 n3763 0.21875
r6336 n3762 n3763 0.59375
r6337 n3649 n3764 0.013671875
r6338 n3763 n3764 0.53125
r6339 n3650 n3765 0.21875
r6340 n3764 n3765 0.53125
r6341 n3651 n3766 0.012152777777777778
r6342 n3765 n3766 0.59375
r6343 n3652 n3767 0.21875
r6344 n3766 n3767 0.59375
r6345 n3653 n3768 0.013671875
r6346 n3767 n3768 0.53125
r6347 n3654 n3769 0.21875
r6348 n3768 n3769 0.53125
r6349 n3655 n3770 0.029166666666666667
r6350 n3769 n3770 0.265625
r6351 n3656 n3771 0.036458333333333336
r6352 n3770 n3771 0.421875
r6353 n3657 n3772 0.048611111111111112
r6354 n3771 n3772 0.328125
r6355 n3658 n3773 0.21875
r6356 n3772 n3773 0.171875
r6357 n3659 n3774 0.21875
r6358 n3773 n3774 0.0625
r6359 n3660 n3775 0.0546875
r6360 n3774 n3775 0.15625
r6361 n3661 n3776 0.019886363636363636
r6362 n3775 n3776 0.46875
r6363 n3662 n3777 0.4375
r6364 n3776 n3777 0.359375
r6365 n3663 n3778 0.4375
r6366 n3777 n3778 0.03125
r6367 n3664 n3779 0.4375
r6368 n3778 n3779 0.03125
r6369 n3665 n3780 0.043749999999999997
r6370 n3779 n3780 0.171875
r6371 n3666 n3781 0.036458333333333336
r6372 n3780 n3781 0.34375
r6373 n3667 n3782 0.0546875
r6374 n3781 n3782 0.3125
r6375 n3668 n3783 0.21875
r6376 n3782 n3783 0.15625
r6377 n3669 n3784 0.14583333333333334
r6378 n3783 n3784 0.078125
r6379 n3670 n3785 0.21875
r6380 n3784 n3785 0.078125
r6381 n3671 n3786 0.072916666666666671
r6382 n3785 n3786 0.125
r6383 n3672 n3787 0.036458333333333336
r6384 n3786 n3787 0.28125
r6385 n3673 n3788 0.03125
r6386 n3787 n3788 0.40625
r6387 n3674 n3789 0.21875
r6388 n3788 n3789 0.25
r6389 n3675 n3790 0.012152777777777778
r6390 n3789 n3790 0.59375
r6391 n3676 n3791 0.21875
r6392 n3790 n3791 0.59375
r6393 n3677 n3792 0.013671875
r6394 n3791 n3792 0.53125
r6395 n3678 n3793 0.21875
r6396 n3792 n3793 0.53125
r6397 n3679 n3794 0.012152777777777778
r6398 n3793 n3794 0.59375
r6399 n3680 n3795 0.21875
r6400 n3794 n3795 0.59375
r6401 n3681 n3796 0.013671875
r6402 n3795 n3796 0.53125
r6403 n3682 n3797 0.21875
r6404 n3796 n3797 0.53125
r6405 n3683 n3798 0.012152777777777778
r6406 n3797 n3798 0.59375
r6407 n3684 n3799 0.21875
r6408 n3798 n3799 0.59375
r6409 n3685 n3800 0.013671875
r6410 n3799 n3800 0.53125
r6411 n3686 n3801 0.21875
r6412 n3800 n3801 0.53125
r6413 n3687 n3802 0.012152777777777778
r6414 n3801 n3802 0.59375
r6415 n3688 n3803 0.21875
r6416 n3802 n3803 0.59375
r6417 n3689 n3804 0.013671875
r6418 n3803 n3804 0.53125
r6419 n3690 n3805 0.21875
r6420 n3804 n3805 0.53125
r6421 n3691 n3806 0.012152777777777778
r6422 n3805 n3806 0.59375
r6423 n3692 n3807 0.21875
r6424 n3806 n3807 0.59375
r6425 n3693 n3808 0.013671875
r6426 n3807 n3808 0.53125
r6427 n3694 n3809 0.21875
r6428 n3808 n3809 0.53125
r6429 n3695 n3810 0.012152777777777778
r6430 n3809 n3810 0.59375
r6431 n3696 n3811 0.21875
r6432 n3810 n3811 0.59375
r6433 n3697 n3812 0.013671875
r6434 n3811 n3812 0.53125
r6435 n3698 n3813 0.21875
r6436 n3812 n3813 0.53125
r6437 n3699 n3814 0.012152777777777778
r6438 n3813 n3814 0.59375
r6439 n3700 n3815 0.21875
r6440 n3814 n3815 0.59375
r6441 n3701 n3816 0.013671875
r6442 n3815 n3816 0.53125
r6443 n3702 n3817 0.21875
r6444 n3816 n3817 0.53125
r6445 n3703 n3818 0.036458333333333336
r6446 n3817 n3818 0.21875
r6447 n3819 n3820 0.09375
r6448 n3820 n3821 0.078125
r6449 n3821 n3822 0.203125
r6450 n3822 n3823 0.46875
r6451 n3823 n3824 0.328125
r6452 n3824 n3825 0.078125
r6453 n3825 n3826 0.09375
r6454 n3704 n3827 0.043749999999999997
r6455 n3705 n3828 0.21875
r6456 n3827 n3828 0.25
r6457 n3706 n3829 0.013671875
r6458 n3828 n3829 0.70833333333333337
r6459 n3707 n3830 0.21875
r6460 n3829 n3830 0.70833333333333337
r6461 n3708 n3831 0.012152777777777778
r6462 n3830 n3831 0.79166666666666663
r6463 n3709 n3832 0.21875
r6464 n3831 n3832 0.79166666666666663
r6465 n3710 n3833 0.033653846153846152
r6466 n3832 n3833 0.3125
r6467 n3711 n3834 0.036458333333333336
r6468 n3833 n3834 0.52083333333333337
r6469 n3712 n3835 0.0625
r6470 n3834 n3835 0.39583333333333331
r6471 n3713 n3836 0.21875
r6472 n3835 n3836 0.1875
r6473 n3714 n3837 0.109375
r6474 n3836 n3837 0.125
r6475 n3715 n3838 0.048611111111111112
r6476 n3837 n3838 0.27083333333333331
r6477 n3716 n3839 0.020833333333333332
r6478 n3838 n3839 0.625
r6479 n3717 n3840 0.21875
r6480 n3839 n3840 0.47916666666666669
r6481 n3718 n3841 0.21875
r6482 n3840 n3841 0.083333333333333329
r6483 n3719 n3842 0.048611111111111112
r6484 n3841 n3842 0.22916666666666666
r6485 n3720 n3843 0.036458333333333336
r6486 n3842 n3843 0.4375
r6487 n3721 n3844 0.048611111111111112
r6488 n3843 n3844 0.4375
r6489 n3722 n3845 0.21875
r6490 n3844 n3845 0.22916666666666666
r6491 n3723 n3846 0.21875
r6492 n3845 n3846 0.083333333333333329
r6493 n3724 n3847 0.020833333333333332
r6494 n3846 n3847 0.47916666666666669
r6495 n3725 n3848 0.029166666666666667
r6496 n3847 n3848 0.75
r6497 n3726 n3849 0.21875
r6498 n3848 n3849 0.35416666666666669
r6499 n3727 n3850 0.013671875
r6500 n3849 n3850 0.70833333333333337
r6501 n3728 n3851 0.21875
r6502 n3850 n3851 0.70833333333333337
r6503 n3729 n3852 0.036458333333333336
r6504 n3851 n3852 0.29166666666666669
r6505 n3730 n3853 0.14583333333333334
r6506 n3731 n3854 0.14583333333333334
r6507 n3853 n3854 0.125
r6508 n3732 n3855 0.21875
r6509 n3854 n3855 0.10416666666666667
r6510 n3733 n3856 0.0546875
r6511 n3855 n3856 0.20833333333333334
r6512 n3734 n3857 0.019886363636363636
r6513 n3856 n3857 0.625
r6514 n3735 n3858 0.21875
r6515 n3857 n3858 0.5
r6516 n3736 n3859 0.14583333333333334
r6517 n3858 n3859 0.10416666666666667
r6518 n3737 n3860 0.14583333333333334
r6519 n3859 n3860 0.125
r6520 n3738 n3861 0.043749999999999997
r6521 n3739 n3862 0.21875
r6522 n3861 n3862 0.25
r6523 n3740 n3863 0.013671875
r6524 n3862 n3863 0.70833333333333337
r6525 n3741 n3864 0.21875
r6526 n3863 n3864 0.70833333333333337
r6527 n3742 n3865 0.012152777777777778
r6528 n3864 n3865 0.79166666666666663
r6529 n3743 n3866 0.21875
r6530 n3865 n3866 0.79166666666666663
r6531 n3744 n3867 0.013671875
r6532 n3866 n3867 0.70833333333333337
r6533 n3745 n3868 0.21875
r6534 n3867 n3868 0.70833333333333337
r6535 n3746 n3869 0.012152777777777778
r6536 n3868 n3869 0.79166666666666663
r6537 n3747 n3870 0.21875
r6538 n3869 n3870 0.79166666666666663
r6539 n3748 n3871 0.013671875
r6540 n3870 n3871 0.70833333333333337
r6541 n3749 n3872 0.21875
r6542 n3871 n3872 0.70833333333333337
r6543 n3750 n3873 0.012152777777777778
r6544 n3872 n3873 0.79166666666666663
r6545 n3751 n3874 0.21875
r6546 n3873 n3874 0.79166666666666663
r6547 n3752 n3875 0.013671875
r6548 n3874 n3875 0.70833333333333337
r6549 n3753 n3876 0.21875
r6550 n3875 n3876 0.70833333333333337
r6551 n3754 n3877 0.012152777777777778
r6552 n3876 n3877 0.79166666666666663
r6553 n3755 n3878 0.21875
r6554 n3877 n3878 0.79166666666666663
r6555 n3756 n3879 0.013671875
r6556 n3878 n3879 0.70833333333333337
r6557 n3757 n3880 0.21875
r6558 n3879 n3880 0.70833333333333337
r6559 n3758 n3881 0.012152777777777778
r6560 n3880 n3881 0.79166666666666663
r6561 n3759 n3882 0.21875
r6562 n3881 n3882 0.79166666666666663
r6563 n3760 n3883 0.013671875
r6564 n3882 n3883 0.70833333333333337
r6565 n3761 n3884 0.21875
r6566 n3883 n3884 0.70833333333333337
r6567 n3762 n3885 0.012152777777777778
r6568 n3884 n3885 0.79166666666666663
r6569 n3763 n3886 0.21875
r6570 n3885 n3886 0.79166666666666663
r6571 n3764 n3887 0.013671875
r6572 n3886 n3887 0.70833333333333337
r6573 n3765 n3888 0.21875
r6574 n3887 n3888 0.70833333333333337
r6575 n3766 n3889 0.012152777777777778
r6576 n3888 n3889 0.79166666666666663
r6577 n3767 n3890 0.21875
r6578 n3889 n3890 0.79166666666666663
r6579 n3768 n3891 0.013671875
r6580 n3890 n3891 0.70833333333333337
r6581 n3769 n3892 0.21875
r6582 n3891 n3892 0.70833333333333337
r6583 n3770 n3893 0.029166666666666667
r6584 n3892 n3893 0.35416666666666669
r6585 n3771 n3894 0.036458333333333336
r6586 n3893 n3894 0.5625
r6587 n3772 n3895 0.048611111111111112
r6588 n3894 n3895 0.4375
r6589 n3773 n3896 0.21875
r6590 n3895 n3896 0.22916666666666666
r6591 n3774 n3897 0.21875
r6592 n3896 n3897 0.083333333333333329
r6593 n3775 n3898 0.0546875
r6594 n3897 n3898 0.20833333333333334
r6595 n3776 n3899 0.019886363636363636
r6596 n3898 n3899 0.625
r6597 n3777 n3900 0.4375
r6598 n3899 n3900 0.47916666666666669
r6599 n3778 n3901 0.4375
r6600 n3900 n3901 0.041666666666666664
r6601 n3779 n3902 0.4375
r6602 n3901 n3902 0.041666666666666664
r6603 n3780 n3903 0.043749999999999997
r6604 n3902 n3903 0.22916666666666666
r6605 n3781 n3904 0.036458333333333336
r6606 n3903 n3904 0.45833333333333331
r6607 n3782 n3905 0.0546875
r6608 n3904 n3905 0.41666666666666669
r6609 n3783 n3906 0.21875
r6610 n3905 n3906 0.20833333333333334
r6611 n3784 n3907 0.14583333333333334
r6612 n3906 n3907 0.10416666666666667
r6613 n3785 n3908 0.21875
r6614 n3907 n3908 0.10416666666666667
r6615 n3786 n3909 0.072916666666666671
r6616 n3908 n3909 0.16666666666666666
r6617 n3787 n3910 0.036458333333333336
r6618 n3909 n3910 0.375
r6619 n3788 n3911 0.03125
r6620 n3910 n3911 0.54166666666666663
r6621 n3789 n3912 0.21875
r6622 n3911 n3912 0.33333333333333331
r6623 n3790 n3913 0.012152777777777778
r6624 n3912 n3913 0.79166666666666663
r6625 n3791 n3914 0.21875
r6626 n3913 n3914 0.79166666666666663
r6627 n3792 n3915 0.013671875
r6628 n3914 n3915 0.70833333333333337
r6629 n3793 n3916 0.21875
r6630 n3915 n3916 0.70833333333333337
r6631 n3794 n3917 0.012152777777777778
r6632 n3916 n3917 0.79166666666666663
r6633 n3795 n3918 0.21875
r6634 n3917 n3918 0.79166666666666663
r6635 n3796 n3919 0.013671875
r6636 n3918 n3919 0.70833333333333337
r6637 n3797 n3920 0.21875
r6638 n3919 n3920 0.70833333333333337
r6639 n3798 n3921 0.012152777777777778
r6640 n3920 n3921 0.79166666666666663
r6641 n3799 n3922 0.21875
r6642 n3921 n3922 0.79166666666666663
r6643 n3800 n3923 0.013671875
r6644 n3922 n3923 0.70833333333333337
r6645 n3801 n3924 0.21875
r6646 n3923 n3924 0.70833333333333337
r6647 n3802 n3925 0.012152777777777778
r6648 n3924 n3925 0.79166666666666663
r6649 n3803 n3926 0.21875
r6650 n3925 n3926 0.79166666666666663
r6651 n3804 n3927 0.013671875
r6652 n3926 n3927 0.70833333333333337
r6653 n3805 n3928 0.21875
r6654 n3927 n3928 0.70833333333333337
r6655 n3806 n3929 0.012152777777777778
r6656 n3928 n3929 0.79166666666666663
r6657 n3807 n3930 0.21875
r6658 n3929 n3930 0.79166666666666663
r6659 n3808 n3931 0.013671875
r6660 n3930 n3931 0.70833333333333337
r6661 n3809 n3932 0.21875
r6662 n3931 n3932 0.70833333333333337
r6663 n3810 n3933 0.012152777777777778
r6664 n3932 n3933 0.79166666666666663
r6665 n3811 n3934 0.21875
r6666 n3933 n3934 0.79166666666666663
r6667 n3812 n3935 0.013671875
r6668 n3934 n3935 0.70833333333333337
r6669 n3813 n3936 0.21875
r6670 n3935 n3936 0.70833333333333337
r6671 n3814 n3937 0.012152777777777778
r6672 n3936 n3937 0.79166666666666663
r6673 n3815 n3938 0.21875
r6674 n3937 n3938 0.79166666666666663
r6675 n3816 n3939 0.013671875
r6676 n3938 n3939 0.70833333333333337
r6677 n3817 n3940 0.21875
r6678 n3939 n3940 0.70833333333333337
r6679 n3818 n3941 0.036458333333333336
r6680 n3940 n3941 0.29166666666666669
r6681 n3819 n3942 0.14583333333333334
r6682 n3820 n3943 0.14583333333333334
r6683 n3942 n3943 0.125
r6684 n3821 n3944 0.21875
r6685 n3943 n3944 0.10416666666666667
r6686 n3822 n3945 0.039772727272727272
r6687 n3944 n3945 0.27083333333333331
r6688 n3823 n3946 0.023026315789473683
r6689 n3945 n3946 0.625
r6690 n3824 n3947 0.21875
r6691 n3946 n3947 0.4375
r6692 n3825 n3948 0.14583333333333334
r6693 n3947 n3948 0.10416666666666667
r6694 n3826 n3949 0.14583333333333334
r6695 n3948 n3949 0.125
r6696 n3827 n3950 0.03125
r6697 n3828 n3951 0.15625
r6698 n3950 n3951 0.375
r6699 n3829 n3952 0.009765625
r6700 n3951 n3952 1.0625
r6701 n3830 n3953 0.15625
r6702 n3952 n3953 1.0625
r6703 n3831 n3954 0.0086805555555555559
r6704 n3953 n3954 1.1875
r6705 n3832 n3955 0.15625
r6706 n3954 n3955 1.1875
r6707 n3833 n3956 0.02403846153846154
r6708 n3955 n3956 0.46875
r6709 n3834 n3957 0.026041666666666668
r6710 n3956 n3957 0.78125
r6711 n3835 n3958 0.044642857142857144
r6712 n3957 n3958 0.59375
r6713 n3836 n3959 0.15625
r6714 n3958 n3959 0.28125
r6715 n3837 n3960 0.078125
r6716 n3959 n3960 0.1875
r6717 n3838 n3961 0.034722222222222224
r6718 n3960 n3961 0.40625
r6719 n3839 n3962 0.01488095238095238
r6720 n3961 n3962 0.9375
r6721 n3840 n3963 0.15625
r6722 n3962 n3963 0.71875
r6723 n3841 n3964 0.15625
r6724 n3963 n3964 0.125
r6725 n3842 n3965 0.034722222222222224
r6726 n3964 n3965 0.34375
r6727 n3843 n3966 0.026041666666666668
r6728 n3965 n3966 0.65625
r6729 n3844 n3967 0.034722222222222224
r6730 n3966 n3967 0.65625
r6731 n3845 n3968 0.15625
r6732 n3967 n3968 0.34375
r6733 n3846 n3969 0.15625
r6734 n3968 n3969 0.125
r6735 n3847 n3970 0.01488095238095238
r6736 n3969 n3970 0.71875
r6737 n3848 n3971 0.020833333333333332
r6738 n3970 n3971 1.125
r6739 n3849 n3972 0.15625
r6740 n3971 n3972 0.53125
r6741 n3850 n3973 0.009765625
r6742 n3972 n3973 1.0625
r6743 n3851 n3974 0.15625
r6744 n3973 n3974 1.0625
r6745 n3852 n3975 0.026041666666666668
r6746 n3974 n3975 0.4375
r6747 n3976 n3977 0.53125
r6748 n3853 n3978 0.10416666666666667
r6749 n3977 n3978 0.3125
r6750 n3854 n3979 0.10416666666666667
r6751 n3978 n3979 0.1875
r6752 n3855 n3980 0.15625
r6753 n3979 n3980 0.15625
r6754 n3856 n3981 0.0390625
r6755 n3980 n3981 0.3125
r6756 n3857 n3982 0.014204545454545454
r6757 n3981 n3982 0.9375
r6758 n3858 n3983 0.15625
r6759 n3982 n3983 0.75
r6760 n3859 n3984 0.10416666666666667
r6761 n3983 n3984 0.15625
r6762 n3860 n3985 0.10416666666666667
r6763 n3984 n3985 0.1875
r6764 n3985 n3986 0.21875
r6765 n3986 n3987 0.21875
r6766 n3987 n3988 0.40625
r6767 n3861 n3989 0.03125
r6768 n3862 n3990 0.15625
r6769 n3989 n3990 0.375
r6770 n3863 n3991 0.009765625
r6771 n3990 n3991 1.0625
r6772 n3864 n3992 0.15625
r6773 n3991 n3992 1.0625
r6774 n3865 n3993 0.0086805555555555559
r6775 n3992 n3993 1.1875
r6776 n3866 n3994 0.15625
r6777 n3993 n3994 1.1875
r6778 n3867 n3995 0.009765625
r6779 n3994 n3995 1.0625
r6780 n3868 n3996 0.15625
r6781 n3995 n3996 1.0625
r6782 n3869 n3997 0.0086805555555555559
r6783 n3996 n3997 1.1875
r6784 n3870 n3998 0.15625
r6785 n3997 n3998 1.1875
r6786 n3871 n3999 0.009765625
r6787 n3998 n3999 1.0625
r6788 n3872 n4000 0.15625
r6789 n3999 n4000 1.0625
r6790 n3873 n4001 0.0086805555555555559
r6791 n4000 n4001 1.1875
r6792 n3874 n4002 0.15625
r6793 n4001 n4002 1.1875
r6794 n3875 n4003 0.009765625
r6795 n4002 n4003 1.0625
r6796 n3876 n4004 0.15625
r6797 n4003 n4004 1.0625
r6798 n3877 n4005 0.0086805555555555559
r6799 n4004 n4005 1.1875
r6800 n3878 n4006 0.15625
r6801 n4005 n4006 1.1875
r6802 n3879 n4007 0.009765625
r6803 n4006 n4007 1.0625
r6804 n3880 n4008 0.15625
r6805 n4007 n4008 1.0625
r6806 n3881 n4009 0.0086805555555555559
r6807 n4008 n4009 1.1875
r6808 n3882 n4010 0.15625
r6809 n4009 n4010 1.1875
r6810 n3883 n4011 0.009765625
r6811 n4010 n4011 1.0625
r6812 n3884 n4012 0.15625
r6813 n4011 n4012 1.0625
r6814 n3885 n4013 0.0086805555555555559
r6815 n4012 n4013 1.1875
r6816 n3886 n4014 0.15625
r6817 n4013 n4014 1.1875
r6818 n3887 n4015 0.009765625
r6819 n4014 n4015 1.0625
r6820 n3888 n4016 0.15625
r6821 n4015 n4016 1.0625
r6822 n3889 n4017 0.0086805555555555559
r6823 n4016 n4017 1.1875
r6824 n3890 n4018 0.15625
r6825 n4017 n4018 1.1875
r6826 n3891 n4019 0.009765625
r6827 n4018 n4019 1.0625
r6828 n3892 n4020 0.15625
r6829 n4019 n4020 1.0625
r6830 n3893 n4021 0.020833333333333332
r6831 n4020 n4021 0.53125
r6832 n3894 n4022 0.026041666666666668
r6833 n4021 n4022 0.84375
r6834 n3895 n4023 0.034722222222222224
r6835 n4022 n4023 0.65625
r6836 n3896 n4024 0.15625
r6837 n4023 n4024 0.34375
r6838 n3897 n4025 0.15625
r6839 n4024 n4025 0.125
r6840 n3898 n4026 0.0390625
r6841 n4025 n4026 0.3125
r6842 n3899 n4027 0.014204545454545454
r6843 n4026 n4027 0.9375
r6844 n3900 n4028 0.3125
r6845 n4027 n4028 0.71875
r6846 n3901 n4029 0.3125
r6847 n4028 n4029 0.0625
r6848 n3902 n4030 0.3125
r6849 n4029 n4030 0.0625
r6850 n3903 n4031 0.03125
r6851 n4030 n4031 0.34375
r6852 n3904 n4032 0.026041666666666668
r6853 n4031 n4032 0.6875
r6854 n3905 n4033 0.0390625
r6855 n4032 n4033 0.625
r6856 n3906 n4034 0.15625
r6857 n4033 n4034 0.3125
r6858 n3907 n4035 0.10416666666666667
r6859 n4034 n4035 0.15625
r6860 n3908 n4036 0.15625
r6861 n4035 n4036 0.15625
r6862 n3909 n4037 0.052083333333333336
r6863 n4036 n4037 0.25
r6864 n3910 n4038 0.026041666666666668
r6865 n4037 n4038 0.5625
r6866 n3911 n4039 0.022321428571428572
r6867 n4038 n4039 0.8125
r6868 n3912 n4040 0.15625
r6869 n4039 n4040 0.5
r6870 n3913 n4041 0.0086805555555555559
r6871 n4040 n4041 1.1875
r6872 n3914 n4042 0.15625
r6873 n4041 n4042 1.1875
r6874 n3915 n4043 0.009765625
r6875 n4042 n4043 1.0625
r6876 n3916 n4044 0.15625
r6877 n4043 n4044 1.0625
r6878 n3917 n4045 0.0086805555555555559
r6879 n4044 n4045 1.1875
r6880 n3918 n4046 0.15625
r6881 n4045 n4046 1.1875
r6882 n3919 n4047 0.009765625
r6883 n4046 n4047 1.0625
r6884 n3920 n4048 0.15625
r6885 n4047 n4048 1.0625
r6886 n3921 n4049 0.0086805555555555559
r6887 n4048 n4049 1.1875
r6888 n3922 n4050 0.15625
r6889 n4049 n4050 1.1875
r6890 n3923 n4051 0.009765625
r6891 n4050 n4051 1.0625
r6892 n3924 n4052 0.15625
r6893 n4051 n4052 1.0625
r6894 n3925 n4053 0.0086805555555555559
r6895 n4052 n4053 1.1875
r6896 n3926 n4054 0.15625
r6897 n4053 n4054 1.1875
r6898 n3927 n4055 0.009765625
r6899 n4054 n4055 1.0625
r6900 n3928 n4056 0.15625
r6901 n4055 n4056 1.0625
r6902 n3929 n4057 0.0086805555555555559
r6903 n4056 n4057 1.1875
r6904 n3930 n4058 0.15625
r6905 n4057 n4058 1.1875
r6906 n3931 n4059 0.009765625
r6907 n4058 n4059 1.0625
r6908 n3932 n4060 0.15625
r6909 n4059 n4060 1.0625
r6910 n3933 n4061 0.0086805555555555559
r6911 n4060 n4061 1.1875
r6912 n3934 n4062 0.15625
r6913 n4061 n4062 1.1875
r6914 n3935 n4063 0.009765625
r6915 n4062 n4063 1.0625
r6916 n3936 n4064 0.15625
r6917 n4063 n4064 1.0625
r6918 n3937 n4065 0.0086805555555555559
r6919 n4064 n4065 1.1875
r6920 n3938 n4066 0.15625
r6921 n4065 n4066 1.1875
r6922 n3939 n4067 0.009765625
r6923 n4066 n4067 1.0625
r6924 n3940 n4068 0.15625
r6925 n4067 n4068 1.0625
r6926 n3941 n4069 0.026041666666666668
r6927 n4068 n4069 0.4375
r6928 n4070 n4071 0.53125
r6929 n3942 n4072 0.10416666666666667
r6930 n4071 n4072 0.3125
r6931 n3943 n4073 0.10416666666666667
r6932 n4072 n4073 0.1875
r6933 n3944 n4074 0.15625
r6934 n4073 n4074 0.15625
r6935 n3945 n4075 0.028409090909090908
r6936 n4074 n4075 0.40625
r6937 n3946 n4076 0.016447368421052631
r6938 n4075 n4076 0.9375
r6939 n3947 n4077 0.15625
r6940 n4076 n4077 0.65625
r6941 n3948 n4078 0.10416666666666667
r6942 n4077 n4078 0.15625
r6943 n3949 n4079 0.10416666666666667
r6944 n4078 n4079 0.1875
r6945 n4079 n4080 0.3125
r6946 n4080 n4081 0.53125
r6947 n3950 n4082 0.050000000000000003
r6948 n3951 n4083 0.25
r6949 n4082 n4083 0.125
r6950 n3952 n4084 0.015625
r6951 n4083 n4084 0.35416666666666669
r6952 n3953 n4085 0.25
r6953 n4084 n4085 0.35416666666666669
r6954 n3954 n4086 0.013888888888888888
r6955 n4085 n4086 0.39583333333333331
r6956 n3955 n4087 0.25
r6957 n4086 n4087 0.39583333333333331
r6958 n3956 n4088 0.038461538461538464
r6959 n4087 n4088 0.15625
r6960 n3957 n4089 0.041666666666666664
r6961 n4088 n4089 0.26041666666666669
r6962 n3958 n4090 0.071428571428571425
r6963 n4089 n4090 0.19791666666666666
r6964 n3959 n4091 0.25
r6965 n4090 n4091 0.09375
r6966 n3960 n4092 0.125
r6967 n4091 n4092 0.0625
r6968 n3961 n4093 0.055555555555555552
r6969 n4092 n4093 0.13541666666666666
r6970 n3962 n4094 0.023809523809523808
r6971 n4093 n4094 0.3125
r6972 n3963 n4095 0.25
r6973 n4094 n4095 0.23958333333333334
r6974 n3964 n4096 0.25
r6975 n4095 n4096 0.041666666666666664
r6976 n3965 n4097 0.055555555555555552
r6977 n4096 n4097 0.11458333333333333
r6978 n3966 n4098 0.041666666666666664
r6979 n4097 n4098 0.21875
r6980 n3967 n4099 0.055555555555555552
r6981 n4098 n4099 0.21875
r6982 n3968 n4100 0.25
r6983 n4099 n4100 0.11458333333333333
r6984 n3969 n4101 0.25
r6985 n4100 n4101 0.041666666666666664
r6986 n3970 n4102 0.023809523809523808
r6987 n4101 n4102 0.23958333333333334
r6988 n3971 n4103 0.033333333333333333
r6989 n4102 n4103 0.375
r6990 n3972 n4104 0.25
r6991 n4103 n4104 0.17708333333333334
r6992 n3973 n4105 0.015625
r6993 n4104 n4105 0.35416666666666669
r6994 n3974 n4106 0.25
r6995 n4105 n4106 0.35416666666666669
r6996 n3975 n4107 0.041666666666666664
r6997 n4106 n4107 0.14583333333333334
r6998 n3976 n4108 0.050000000000000003
r6999 n3977 n4109 0.071428571428571425
r7000 n4108 n4109 0.17708333333333334
r7001 n3978 n4110 0.16666666666666666
r7002 n4109 n4110 0.10416666666666667
r7003 n3979 n4111 0.16666666666666666
r7004 n4110 n4111 0.0625
r7005 n3980 n4112 0.25
r7006 n4111 n4112 0.052083333333333336
r7007 n3981 n4113 0.0625
r7008 n4112 n4113 0.10416666666666667
r7009 n3982 n4114 0.022727272727272728
r7010 n4113 n4114 0.3125
r7011 n3983 n4115 0.25
r7012 n4114 n4115 0.25
r7013 n3984 n4116 0.16666666666666666
r7014 n4115 n4116 0.052083333333333336
r7015 n3985 n4117 0.16666666666666666
r7016 n4116 n4117 0.0625
r7017 n3986 n4118 0.125
r7018 n4117 n4118 0.072916666666666671
r7019 n3987 n4119 0.16666666666666666
r7020 n4118 n4119 0.072916666666666671
r7021 n3988 n4120 0.050000000000000003
r7022 n4119 n4120 0.13541666666666666
r7023 n3989 n4121 0.050000000000000003
r7024 n3990 n4122 0.25
r7025 n4121 n4122 0.125
r7026 n3991 n4123 0.015625
r7027 n4122 n4123 0.35416666666666669
r7028 n3992 n4124 0.25
r7029 n4123 n4124 0.35416666666666669
r7030 n3993 n4125 0.013888888888888888
r7031 n4124 n4125 0.39583333333333331
r7032 n3994 n4126 0.25
r7033 n4125 n4126 0.39583333333333331
r7034 n3995 n4127 0.015625
r7035 n4126 n4127 0.35416666666666669
r7036 n3996 n4128 0.25
r7037 n4127 n4128 0.35416666666666669
r7038 n3997 n4129 0.013888888888888888
r7039 n4128 n4129 0.39583333333333331
r7040 n3998 n4130 0.25
r7041 n4129 n4130 0.39583333333333331
r7042 n3999 n4131 0.015625
r7043 n4130 n4131 0.35416666666666669
r7044 n4000 n4132 0.25
r7045 n4131 n4132 0.35416666666666669
r7046 n4001 n4133 0.013888888888888888
r7047 n4132 n4133 0.39583333333333331
r7048 n4002 n4134 0.25
r7049 n4133 n4134 0.39583333333333331
r7050 n4003 n4135 0.015625
r7051 n4134 n4135 0.35416666666666669
r7052 n4004 n4136 0.25
r7053 n4135 n4136 0.35416666666666669
r7054 n4005 n4137 0.013888888888888888
r7055 n4136 n4137 0.39583333333333331
r7056 n4006 n4138 0.25
r7057 n4137 n4138 0.39583333333333331
r7058 n4007 n4139 0.015625
r7059 n4138 n4139 0.35416666666666669
r7060 n4008 n4140 0.25
r7061 n4139 n4140 0.35416666666666669
r7062 n4009 n4141 0.013888888888888888
r7063 n4140 n4141 0.39583333333333331
r7064 n4010 n4142 0.25
r7065 n4141 n4142 0.39583333333333331
r7066 n4011 n4143 0.015625
r7067 n4142 n4143 0.35416666666666669
r7068 n4012 n4144 0.25
r7069 n4143 n4144 0.35416666666666669
r7070 n4013 n4145 0.013888888888888888
r7071 n4144 n4145 0.39583333333333331
r7072 n4014 n4146 0.25
r7073 n4145 n4146 0.39583333333333331
r7074 n4015 n4147 0.015625
r7075 n4146 n4147 0.35416666666666669
r7076 n4016 n4148 0.25
r7077 n4147 n4148 0.35416666666666669
r7078 n4017 n4149 0.013888888888888888
r7079 n4148 n4149 0.39583333333333331
r7080 n4018 n4150 0.25
r7081 n4149 n4150 0.39583333333333331
r7082 n4019 n4151 0.015625
r7083 n4150 n4151 0.35416666666666669
r7084 n4020 n4152 0.25
r7085 n4151 n4152 0.35416666666666669
r7086 n4021 n4153 0.033333333333333333
r7087 n4152 n4153 0.17708333333333334
r7088 n4022 n4154 0.041666666666666664
r7089 n4153 n4154 0.28125
r7090 n4023 n4155 0.055555555555555552
r7091 n4154 n4155 0.21875
r7092 n4024 n4156 0.25
r7093 n4155 n4156 0.11458333333333333
r7094 n4025 n4157 0.25
r7095 n4156 n4157 0.041666666666666664
r7096 n4026 n4158 0.0625
r7097 n4157 n4158 0.10416666666666667
r7098 n4027 n4159 0.022727272727272728
r7099 n4158 n4159 0.3125
r7100 n4028 n4160 0.5
r7101 n4159 n4160 0.23958333333333334
r7102 n4029 n4161 0.5
r7103 n4160 n4161 0.020833333333333332
r7104 n4030 n4162 0.5
r7105 n4161 n4162 0.020833333333333332
r7106 n4031 n4163 0.050000000000000003
r7107 n4162 n4163 0.11458333333333333
r7108 n4032 n4164 0.041666666666666664
r7109 n4163 n4164 0.22916666666666666
r7110 n4033 n4165 0.0625
r7111 n4164 n4165 0.20833333333333334
r7112 n4034 n4166 0.25
r7113 n4165 n4166 0.10416666666666667
r7114 n4035 n4167 0.16666666666666666
r7115 n4166 n4167 0.052083333333333336
r7116 n4036 n4168 0.25
r7117 n4167 n4168 0.052083333333333336
r7118 n4037 n4169 0.083333333333333329
r7119 n4168 n4169 0.083333333333333329
r7120 n4038 n4170 0.041666666666666664
r7121 n4169 n4170 0.1875
r7122 n4039 n4171 0.035714285714285712
r7123 n4170 n4171 0.27083333333333331
r7124 n4040 n4172 0.25
r7125 n4171 n4172 0.16666666666666666
r7126 n4041 n4173 0.013888888888888888
r7127 n4172 n4173 0.39583333333333331
r7128 n4042 n4174 0.25
r7129 n4173 n4174 0.39583333333333331
r7130 n4043 n4175 0.015625
r7131 n4174 n4175 0.35416666666666669
r7132 n4044 n4176 0.25
r7133 n4175 n4176 0.35416666666666669
r7134 n4045 n4177 0.013888888888888888
r7135 n4176 n4177 0.39583333333333331
r7136 n4046 n4178 0.25
r7137 n4177 n4178 0.39583333333333331
r7138 n4047 n4179 0.015625
r7139 n4178 n4179 0.35416666666666669
r7140 n4048 n4180 0.25
r7141 n4179 n4180 0.35416666666666669
r7142 n4049 n4181 0.013888888888888888
r7143 n4180 n4181 0.39583333333333331
r7144 n4050 n4182 0.25
r7145 n4181 n4182 0.39583333333333331
r7146 n4051 n4183 0.015625
r7147 n4182 n4183 0.35416666666666669
r7148 n4052 n4184 0.25
r7149 n4183 n4184 0.35416666666666669
r7150 n4053 n4185 0.013888888888888888
r7151 n4184 n4185 0.39583333333333331
r7152 n4054 n4186 0.25
r7153 n4185 n4186 0.39583333333333331
r7154 n4055 n4187 0.015625
r7155 n4186 n4187 0.35416666666666669
r7156 n4056 n4188 0.25
r7157 n4187 n4188 0.35416666666666669
r7158 n4057 n4189 0.013888888888888888
r7159 n4188 n4189 0.39583333333333331
r7160 n4058 n4190 0.25
r7161 n4189 n4190 0.39583333333333331
r7162 n4059 n4191 0.015625
r7163 n4190 n4191 0.35416666666666669
r7164 n4060 n4192 0.25
r7165 n4191 n4192 0.35416666666666669
r7166 n4061 n4193 0.013888888888888888
r7167 n4192 n4193 0.39583333333333331
r7168 n4062 n4194 0.25
r7169 n4193 n4194 0.39583333333333331
r7170 n4063 n4195 0.015625
r7171 n4194 n4195 0.35416666666666669
r7172 n4064 n4196 0.25
r7173 n4195 n4196 0.35416666666666669
r7174 n4065 n4197 0.013888888888888888
r7175 n4196 n4197 0.39583333333333331
r7176 n4066 n4198 0.25
r7177 n4197 n4198 0.39583333333333331
r7178 n4067 n4199 0.015625
r7179 n4198 n4199 0.35416666666666669
r7180 n4068 n4200 0.25
r7181 n4199 n4200 0.35416666666666669
r7182 n4069 n4201 0.041666666666666664
r7183 n4200 n4201 0.14583333333333334
r7184 n4070 n4202 0.050000000000000003
r7185 n4071 n4203 0.071428571428571425
r7186 n4202 n4203 0.17708333333333334
r7187 n4072 n4204 0.16666666666666666
r7188 n4203 n4204 0.10416666666666667
r7189 n4073 n4205 0.16666666666666666
r7190 n4204 n4205 0.0625
r7191 n4074 n4206 0.25
r7192 n4205 n4206 0.052083333333333336
r7193 n4075 n4207 0.045454545454545456
r7194 n4206 n4207 0.13541666666666666
r7195 n4076 n4208 0.026315789473684209
r7196 n4207 n4208 0.3125
r7197 n4077 n4209 0.25
r7198 n4208 n4209 0.21875
r7199 n4078 n4210 0.16666666666666666
r7200 n4209 n4210 0.052083333333333336
r7201 n4079 n4211 0.16666666666666666
r7202 n4210 n4211 0.0625
r7203 n4080 n4212 0.071428571428571425
r7204 n4211 n4212 0.10416666666666667
r7205 n4081 n4213 0.050000000000000003
r7206 n4212 n4213 0.17708333333333334
r7207 n4089 n4214 0.041666666666666664
r7208 n4090 n4215 0.071428571428571425
r7209 n4214 n4215 0.59375
r7210 n4091 n4216 0.25
r7211 n4215 n4216 0.28125
r7212 n4092 n4217 0.125
r7213 n4216 n4217 0.1875
r7214 n4093 n4218 0.055555555555555552
r7215 n4217 n4218 0.40625
r7216 n4094 n4219 0.023809523809523808
r7217 n4218 n4219 0.9375
r7218 n4095 n4220 0.25
r7219 n4219 n4220 0.71875
r7220 n4096 n4221 0.25
r7221 n4220 n4221 0.125
r7222 n4097 n4222 0.055555555555555552
r7223 n4221 n4222 0.34375
r7224 n4098 n4223 0.041666666666666664
r7225 n4222 n4223 0.65625
r7226 n4108 n4224 0.050000000000000003
r7227 n4109 n4225 0.071428571428571425
r7228 n4224 n4225 0.53125
r7229 n4110 n4226 0.16666666666666666
r7230 n4225 n4226 0.3125
r7231 n4111 n4227 0.16666666666666666
r7232 n4226 n4227 0.1875
r7233 n4112 n4228 0.25
r7234 n4227 n4228 0.15625
r7235 n4113 n4229 0.0625
r7236 n4228 n4229 0.3125
r7237 n4114 n4230 0.022727272727272728
r7238 n4229 n4230 0.9375
r7239 n4115 n4231 0.25
r7240 n4230 n4231 0.75
r7241 n4116 n4232 0.16666666666666666
r7242 n4231 n4232 0.15625
r7243 n4117 n4233 0.16666666666666666
r7244 n4232 n4233 0.1875
r7245 n4118 n4234 0.125
r7246 n4233 n4234 0.21875
r7247 n4119 n4235 0.16666666666666666
r7248 n4234 n4235 0.21875
r7249 n4120 n4236 0.050000000000000003
r7250 n4235 n4236 0.40625
r7251 n4154 n4237 0.041666666666666664
r7252 n4155 n4238 0.055555555555555552
r7253 n4237 n4238 0.65625
r7254 n4156 n4239 0.25
r7255 n4238 n4239 0.34375
r7256 n4157 n4240 0.25
r7257 n4239 n4240 0.125
r7258 n4158 n4241 0.0625
r7259 n4240 n4241 0.3125
r7260 n4159 n4242 0.022727272727272728
r7261 n4241 n4242 0.9375
r7262 n4160 n4243 0.5
r7263 n4242 n4243 0.71875
r7264 n4161 n4244 0.5
r7265 n4243 n4244 0.0625
r7266 n4162 n4245 0.5
r7267 n4244 n4245 0.0625
r7268 n4163 n4246 0.050000000000000003
r7269 n4245 n4246 0.34375
r7270 n4164 n4247 0.041666666666666664
r7271 n4246 n4247 0.6875
r7272 n4202 n4248 0.050000000000000003
r7273 n4203 n4249 0.071428571428571425
r7274 n4248 n4249 0.53125
r7275 n4204 n4250 0.16666666666666666
r7276 n4249 n4250 0.3125
r7277 n4205 n4251 0.16666666666666666
r7278 n4250 n4251 0.1875
r7279 n4206 n4252 0.25
r7280 n4251 n4252 0.15625
r7281 n4207 n4253 0.045454545454545456
r7282 n4252 n4253 0.40625
r7283 n4208 n4254 0.026315789473684209
r7284 n4253 n4254 0.9375
r7285 n4209 n4255 0.25
r7286 n4254 n4255 0.65625
r7287 n4210 n4256 0.16666666666666666
r7288 n4255 n4256 0.15625
r7289 n4211 n4257 0.16666666666666666
r7290 n4256 n4257 0.1875
r7291 n4212 n4258 0.071428571428571425
r7292 n4257 n4258 0.3125
r7293 n4213 n4259 0.050000000000000003
r7294 n4258 n4259 0.53125
r7295 n4214 n4260 0.026041666666666668
r7296 n4215 n4261 0.044642857142857144
r7297 n4260 n4261 0.39583333333333331
r7298 n4216 n4262 0.15625
r7299 n4261 n4262 0.1875
r7300 n4217 n4263 0.078125
r7301 n4262 n4263 0.125
r7302 n4218 n4264 0.034722222222222224
r7303 n4263 n4264 0.27083333333333331
r7304 n4219 n4265 0.01488095238095238
r7305 n4264 n4265 0.625
r7306 n4220 n4266 0.15625
r7307 n4265 n4266 0.47916666666666669
r7308 n4221 n4267 0.15625
r7309 n4266 n4267 0.083333333333333329
r7310 n4222 n4268 0.034722222222222224
r7311 n4267 n4268 0.22916666666666666
r7312 n4223 n4269 0.026041666666666668
r7313 n4268 n4269 0.4375
r7314 n4224 n4270 0.03125
r7315 n4225 n4271 0.044642857142857144
r7316 n4270 n4271 0.35416666666666669
r7317 n4226 n4272 0.10416666666666667
r7318 n4271 n4272 0.20833333333333334
r7319 n4227 n4273 0.10416666666666667
r7320 n4272 n4273 0.125
r7321 n4228 n4274 0.15625
r7322 n4273 n4274 0.10416666666666667
r7323 n4229 n4275 0.0390625
r7324 n4274 n4275 0.20833333333333334
r7325 n4230 n4276 0.014204545454545454
r7326 n4275 n4276 0.625
r7327 n4231 n4277 0.15625
r7328 n4276 n4277 0.5
r7329 n4232 n4278 0.10416666666666667
r7330 n4277 n4278 0.10416666666666667
r7331 n4233 n4279 0.10416666666666667
r7332 n4278 n4279 0.125
r7333 n4234 n4280 0.078125
r7334 n4279 n4280 0.14583333333333334
r7335 n4235 n4281 0.10416666666666667
r7336 n4280 n4281 0.14583333333333334
r7337 n4236 n4282 0.03125
r7338 n4281 n4282 0.27083333333333331
r7339 n4237 n4283 0.026041666666666668
r7340 n4238 n4284 0.034722222222222224
r7341 n4283 n4284 0.4375
r7342 n4239 n4285 0.15625
r7343 n4284 n4285 0.22916666666666666
r7344 n4240 n4286 0.15625
r7345 n4285 n4286 0.083333333333333329
r7346 n4241 n4287 0.0390625
r7347 n4286 n4287 0.20833333333333334
r7348 n4242 n4288 0.014204545454545454
r7349 n4287 n4288 0.625
r7350 n4243 n4289 0.3125
r7351 n4288 n4289 0.47916666666666669
r7352 n4244 n4290 0.3125
r7353 n4289 n4290 0.041666666666666664
r7354 n4245 n4291 0.3125
r7355 n4290 n4291 0.041666666666666664
r7356 n4246 n4292 0.03125
r7357 n4291 n4292 0.22916666666666666
r7358 n4247 n4293 0.026041666666666668
r7359 n4292 n4293 0.45833333333333331
r7360 n4248 n4294 0.03125
r7361 n4249 n4295 0.044642857142857144
r7362 n4294 n4295 0.35416666666666669
r7363 n4250 n4296 0.10416666666666667
r7364 n4295 n4296 0.20833333333333334
r7365 n4251 n4297 0.10416666666666667
r7366 n4296 n4297 0.125
r7367 n4252 n4298 0.15625
r7368 n4297 n4298 0.10416666666666667
r7369 n4253 n4299 0.028409090909090908
r7370 n4298 n4299 0.27083333333333331
r7371 n4254 n4300 0.016447368421052631
r7372 n4299 n4300 0.625
r7373 n4255 n4301 0.15625
r7374 n4300 n4301 0.4375
r7375 n4256 n4302 0.10416666666666667
r7376 n4301 n4302 0.10416666666666667
r7377 n4257 n4303 0.10416666666666667
r7378 n4302 n4303 0.125
r7379 n4258 n4304 0.044642857142857144
r7380 n4303 n4304 0.20833333333333334
r7381 n4259 n4305 0.03125
r7382 n4304 n4305 0.35416666666666669
r7383 n4260 n4306 0.026041666666666668
r7384 n4261 n4307 0.044642857142857144
r7385 n4306 n4307 0.59375
r7386 n4262 n4308 0.15625
r7387 n4307 n4308 0.28125
r7388 n4263 n4309 0.078125
r7389 n4308 n4309 0.1875
r7390 n4264 n4310 0.034722222222222224
r7391 n4309 n4310 0.40625
r7392 n4265 n4311 0.01488095238095238
r7393 n4310 n4311 0.9375
r7394 n4266 n4312 0.15625
r7395 n4311 n4312 0.71875
r7396 n4267 n4313 0.15625
r7397 n4312 n4313 0.125
r7398 n4268 n4314 0.034722222222222224
r7399 n4313 n4314 0.34375
r7400 n4269 n4315 0.026041666666666668
r7401 n4314 n4315 0.65625
r7402 n4270 n4316 0.03125
r7403 n4271 n4317 0.044642857142857144
r7404 n4316 n4317 0.53125
r7405 n4272 n4318 0.10416666666666667
r7406 n4317 n4318 0.3125
r7407 n4273 n4319 0.10416666666666667
r7408 n4318 n4319 0.1875
r7409 n4274 n4320 0.15625
r7410 n4319 n4320 0.15625
r7411 n4275 n4321 0.0390625
r7412 n4320 n4321 0.3125
r7413 n4276 n4322 0.014204545454545454
r7414 n4321 n4322 0.9375
r7415 n4277 n4323 0.15625
r7416 n4322 n4323 0.75
r7417 n4278 n4324 0.10416666666666667
r7418 n4323 n4324 0.15625
r7419 n4279 n4325 0.10416666666666667
r7420 n4324 n4325 0.1875
r7421 n4280 n4326 0.078125
r7422 n4325 n4326 0.21875
r7423 n4281 n4327 0.10416666666666667
r7424 n4326 n4327 0.21875
r7425 n4282 n4328 0.03125
r7426 n4327 n4328 0.40625
r7427 n4283 n4329 0.026041666666666668
r7428 n4284 n4330 0.034722222222222224
r7429 n4329 n4330 0.65625
r7430 n4285 n4331 0.15625
r7431 n4330 n4331 0.34375
r7432 n4286 n4332 0.15625
r7433 n4331 n4332 0.125
r7434 n4287 n4333 0.0390625
r7435 n4332 n4333 0.3125
r7436 n4288 n4334 0.014204545454545454
r7437 n4333 n4334 0.9375
r7438 n4289 n4335 0.3125
r7439 n4334 n4335 0.71875
r7440 n4290 n4336 0.3125
r7441 n4335 n4336 0.0625
r7442 n4291 n4337 0.3125
r7443 n4336 n4337 0.0625
r7444 n4292 n4338 0.03125
r7445 n4337 n4338 0.34375
r7446 n4293 n4339 0.026041666666666668
r7447 n4338 n4339 0.6875
r7448 n4294 n4340 0.03125
r7449 n4295 n4341 0.044642857142857144
r7450 n4340 n4341 0.53125
r7451 n4296 n4342 0.10416666666666667
r7452 n4341 n4342 0.3125
r7453 n4297 n4343 0.10416666666666667
r7454 n4342 n4343 0.1875
r7455 n4298 n4344 0.15625
r7456 n4343 n4344 0.15625
r7457 n4299 n4345 0.028409090909090908
r7458 n4344 n4345 0.40625
r7459 n4300 n4346 0.016447368421052631
r7460 n4345 n4346 0.9375
r7461 n4301 n4347 0.15625
r7462 n4346 n4347 0.65625
r7463 n4302 n4348 0.10416666666666667
r7464 n4347 n4348 0.15625
r7465 n4303 n4349 0.10416666666666667
r7466 n4348 n4349 0.1875
r7467 n4304 n4350 0.044642857142857144
r7468 n4349 n4350 0.3125
r7469 n4305 n4351 0.03125
r7470 n4350 n4351 0.53125
r7471 n4316 n4352 0.20000000000000001
r7472 n4317 n4353 0.2857142857142857
r7473 n4352 n4353 0.035416666666666666
r7474 n4318 n4354 0.66666666666666663
r7475 n4353 n4354 0.020833333333333332
r7476 n4319 n4355 0.66666666666666663
r7477 n4354 n4355 0.012500000000000001
r7478 n4320 n4356 1
r7479 n4355 n4356 0.010416666666666666
r7480 n4321 n4357 0.25
r7481 n4356 n4357 0.020833333333333332
r7482 n4322 n4358 0.090909090909090912
r7483 n4357 n4358 0.0625
r7484 n4323 n4359 1
r7485 n4358 n4359 0.050000000000000003
r7486 n4324 n4360 0.66666666666666663
r7487 n4359 n4360 0.010416666666666666
r7488 n4325 n4361 0.66666666666666663
r7489 n4360 n4361 0.012500000000000001
r7490 n4326 n4362 0.5
r7491 n4361 n4362 0.014583333333333334
r7492 n4327 n4363 0.66666666666666663
r7493 n4362 n4363 0.014583333333333334
r7494 n4328 n4364 0.20000000000000001
r7495 n4363 n4364 0.027083333333333334
r7496 n4340 n4365 0.20000000000000001
r7497 n4341 n4366 0.2857142857142857
r7498 n4365 n4366 0.035416666666666666
r7499 n4342 n4367 0.66666666666666663
r7500 n4366 n4367 0.020833333333333332
r7501 n4343 n4368 0.66666666666666663
r7502 n4367 n4368 0.012500000000000001
r7503 n4344 n4369 1
r7504 n4368 n4369 0.010416666666666666
r7505 n4345 n4370 0.18181818181818182
r7506 n4369 n4370 0.027083333333333334
r7507 n4346 n4371 0.10526315789473684
r7508 n4370 n4371 0.0625
r7509 n4347 n4372 1
r7510 n4371 n4372 0.043749999999999997
r7511 n4348 n4373 0.66666666666666663
r7512 n4372 n4373 0.010416666666666666
r7513 n4349 n4374 0.66666666666666663
r7514 n4373 n4374 0.012500000000000001
r7515 n4350 n4375 0.2857142857142857
r7516 n4374 n4375 0.020833333333333332
r7517 n4351 n4376 0.20000000000000001
r7518 n4375 n4376 0.035416666666666666
r7519 n4377 n4378 0.59375
r7520 n4378 n4379 0.28125
r7521 n4379 n4380 0.1875
r7522 n4380 n4381 0.40625
r7523 n4381 n4382 0.9375
r7524 n4382 n4383 0.71875
r7525 n4383 n4384 0.125
r7526 n4384 n4385 0.34375
r7527 n4385 n4386 0.65625
r7528 n4352 n4387 0.20000000000000001
r7529 n4353 n4388 0.2857142857142857
r7530 n4387 n4388 0.53125
r7531 n4354 n4389 0.66666666666666663
r7532 n4388 n4389 0.3125
r7533 n4355 n4390 0.66666666666666663
r7534 n4389 n4390 0.1875
r7535 n4356 n4391 1
r7536 n4390 n4391 0.15625
r7537 n4357 n4392 0.25
r7538 n4391 n4392 0.3125
r7539 n4358 n4393 0.090909090909090912
r7540 n4392 n4393 0.9375
r7541 n4359 n4394 1
r7542 n4393 n4394 0.75
r7543 n4360 n4395 0.66666666666666663
r7544 n4394 n4395 0.15625
r7545 n4361 n4396 0.66666666666666663
r7546 n4395 n4396 0.1875
r7547 n4362 n4397 0.5
r7548 n4396 n4397 0.21875
r7549 n4363 n4398 0.66666666666666663
r7550 n4397 n4398 0.21875
r7551 n4364 n4399 0.20000000000000001
r7552 n4398 n4399 0.40625
r7553 n4400 n4401 0.65625
r7554 n4401 n4402 0.34375
r7555 n4402 n4403 0.125
r7556 n4403 n4404 0.3125
r7557 n4404 n4405 0.9375
r7558 n4405 n4406 0.71875
r7559 n4406 n4407 0.0625
r7560 n4407 n4408 0.0625
r7561 n4408 n4409 0.34375
r7562 n4409 n4410 0.6875
r7563 n4365 n4411 0.20000000000000001
r7564 n4366 n4412 0.2857142857142857
r7565 n4411 n4412 0.53125
r7566 n4367 n4413 0.66666666666666663
r7567 n4412 n4413 0.3125
r7568 n4368 n4414 0.66666666666666663
r7569 n4413 n4414 0.1875
r7570 n4369 n4415 1
r7571 n4414 n4415 0.15625
r7572 n4370 n4416 0.18181818181818182
r7573 n4415 n4416 0.40625
r7574 n4371 n4417 0.10526315789473684
r7575 n4416 n4417 0.9375
r7576 n4372 n4418 1
r7577 n4417 n4418 0.65625
r7578 n4373 n4419 0.66666666666666663
r7579 n4418 n4419 0.15625
r7580 n4374 n4420 0.66666666666666663
r7581 n4419 n4420 0.1875
r7582 n4375 n4421 0.2857142857142857
r7583 n4420 n4421 0.3125
r7584 n4376 n4422 0.20000000000000001
r7585 n4421 n4422 0.53125
r7586 n4377 n4423 0.026041666666666668
r7587 n4378 n4424 0.044642857142857144
r7588 n4423 n4424 0.39583333333333331
r7589 n4379 n4425 0.15625
r7590 n4424 n4425 0.1875
r7591 n4380 n4426 0.078125
r7592 n4425 n4426 0.125
r7593 n4381 n4427 0.034722222222222224
r7594 n4426 n4427 0.27083333333333331
r7595 n4382 n4428 0.01488095238095238
r7596 n4427 n4428 0.625
r7597 n4383 n4429 0.15625
r7598 n4428 n4429 0.47916666666666669
r7599 n4384 n4430 0.15625
r7600 n4429 n4430 0.083333333333333329
r7601 n4385 n4431 0.034722222222222224
r7602 n4430 n4431 0.22916666666666666
r7603 n4386 n4432 0.026041666666666668
r7604 n4431 n4432 0.4375
r7605 n4387 n4433 0.03125
r7606 n4388 n4434 0.044642857142857144
r7607 n4433 n4434 0.35416666666666669
r7608 n4389 n4435 0.10416666666666667
r7609 n4434 n4435 0.20833333333333334
r7610 n4390 n4436 0.10416666666666667
r7611 n4435 n4436 0.125
r7612 n4391 n4437 0.15625
r7613 n4436 n4437 0.10416666666666667
r7614 n4392 n4438 0.0390625
r7615 n4437 n4438 0.20833333333333334
r7616 n4393 n4439 0.014204545454545454
r7617 n4438 n4439 0.625
r7618 n4394 n4440 0.15625
r7619 n4439 n4440 0.5
r7620 n4395 n4441 0.10416666666666667
r7621 n4440 n4441 0.10416666666666667
r7622 n4396 n4442 0.10416666666666667
r7623 n4441 n4442 0.125
r7624 n4397 n4443 0.078125
r7625 n4442 n4443 0.14583333333333334
r7626 n4398 n4444 0.10416666666666667
r7627 n4443 n4444 0.14583333333333334
r7628 n4399 n4445 0.03125
r7629 n4444 n4445 0.27083333333333331
r7630 n4400 n4446 0.026041666666666668
r7631 n4401 n4447 0.034722222222222224
r7632 n4446 n4447 0.4375
r7633 n4402 n4448 0.15625
r7634 n4447 n4448 0.22916666666666666
r7635 n4403 n4449 0.15625
r7636 n4448 n4449 0.083333333333333329
r7637 n4404 n4450 0.0390625
r7638 n4449 n4450 0.20833333333333334
r7639 n4405 n4451 0.014204545454545454
r7640 n4450 n4451 0.625
r7641 n4406 n4452 0.3125
r7642 n4451 n4452 0.47916666666666669
r7643 n4407 n4453 0.3125
r7644 n4452 n4453 0.041666666666666664
r7645 n4408 n4454 0.3125
r7646 n4453 n4454 0.041666666666666664
r7647 n4409 n4455 0.03125
r7648 n4454 n4455 0.22916666666666666
r7649 n4410 n4456 0.026041666666666668
r7650 n4455 n4456 0.45833333333333331
r7651 n4411 n4457 0.03125
r7652 n4412 n4458 0.044642857142857144
r7653 n4457 n4458 0.35416666666666669
r7654 n4413 n4459 0.10416666666666667
r7655 n4458 n4459 0.20833333333333334
r7656 n4414 n4460 0.10416666666666667
r7657 n4459 n4460 0.125
r7658 n4415 n4461 0.15625
r7659 n4460 n4461 0.10416666666666667
r7660 n4416 n4462 0.028409090909090908
r7661 n4461 n4462 0.27083333333333331
r7662 n4417 n4463 0.016447368421052631
r7663 n4462 n4463 0.625
r7664 n4418 n4464 0.15625
r7665 n4463 n4464 0.4375
r7666 n4419 n4465 0.10416666666666667
r7667 n4464 n4465 0.10416666666666667
r7668 n4420 n4466 0.10416666666666667
r7669 n4465 n4466 0.125
r7670 n4421 n4467 0.044642857142857144
r7671 n4466 n4467 0.20833333333333334
r7672 n4422 n4468 0.03125
r7673 n4467 n4468 0.35416666666666669
r7674 n4423 n4469 0.026041666666666668
r7675 n4424 n4470 0.044642857142857144
r7676 n4469 n4470 0.59375
r7677 n4425 n4471 0.15625
r7678 n4470 n4471 0.28125
r7679 n4426 n4472 0.078125
r7680 n4471 n4472 0.1875
r7681 n4427 n4473 0.034722222222222224
r7682 n4472 n4473 0.40625
r7683 n4428 n4474 0.01488095238095238
r7684 n4473 n4474 0.9375
r7685 n4429 n4475 0.15625
r7686 n4474 n4475 0.71875
r7687 n4430 n4476 0.15625
r7688 n4475 n4476 0.125
r7689 n4431 n4477 0.034722222222222224
r7690 n4476 n4477 0.34375
r7691 n4432 n4478 0.026041666666666668
r7692 n4477 n4478 0.65625
r7693 n4433 n4479 0.03125
r7694 n4434 n4480 0.044642857142857144
r7695 n4479 n4480 0.53125
r7696 n4435 n4481 0.10416666666666667
r7697 n4480 n4481 0.3125
r7698 n4436 n4482 0.10416666666666667
r7699 n4481 n4482 0.1875
r7700 n4437 n4483 0.15625
r7701 n4482 n4483 0.15625
r7702 n4438 n4484 0.0390625
r7703 n4483 n4484 0.3125
r7704 n4439 n4485 0.014204545454545454
r7705 n4484 n4485 0.9375
r7706 n4440 n4486 0.15625
r7707 n4485 n4486 0.75
r7708 n4441 n4487 0.10416666666666667
r7709 n4486 n4487 0.15625
r7710 n4442 n4488 0.10416666666666667
r7711 n4487 n4488 0.1875
r7712 n4443 n4489 0.078125
r7713 n4488 n4489 0.21875
r7714 n4444 n4490 0.10416666666666667
r7715 n4489 n4490 0.21875
r7716 n4445 n4491 0.03125
r7717 n4490 n4491 0.40625
r7718 n4446 n4492 0.026041666666666668
r7719 n4447 n4493 0.034722222222222224
r7720 n4492 n4493 0.65625
r7721 n4448 n4494 0.15625
r7722 n4493 n4494 0.34375
r7723 n4449 n4495 0.15625
r7724 n4494 n4495 0.125
r7725 n4450 n4496 0.0390625
r7726 n4495 n4496 0.3125
r7727 n4451 n4497 0.014204545454545454
r7728 n4496 n4497 0.9375
r7729 n4452 n4498 0.3125
r7730 n4497 n4498 0.71875
r7731 n4453 n4499 0.3125
r7732 n4498 n4499 0.0625
r7733 n4454 n4500 0.3125
r7734 n4499 n4500 0.0625
r7735 n4455 n4501 0.03125
r7736 n4500 n4501 0.34375
r7737 n4456 n4502 0.026041666666666668
r7738 n4501 n4502 0.6875
r7739 n4457 n4503 0.03125
r7740 n4458 n4504 0.044642857142857144
r7741 n4503 n4504 0.53125
r7742 n4459 n4505 0.10416666666666667
r7743 n4504 n4505 0.3125
r7744 n4460 n4506 0.10416666666666667
r7745 n4505 n4506 0.1875
r7746 n4461 n4507 0.15625
r7747 n4506 n4507 0.15625
r7748 n4462 n4508 0.028409090909090908
r7749 n4507 n4508 0.40625
r7750 n4463 n4509 0.016447368421052631
r7751 n4508 n4509 0.9375
r7752 n4464 n4510 0.15625
r7753 n4509 n4510 0.65625
r7754 n4465 n4511 0.10416666666666667
r7755 n4510 n4511 0.15625
r7756 n4466 n4512 0.10416666666666667
r7757 n4511 n4512 0.1875
r7758 n4467 n4513 0.044642857142857144
r7759 n4512 n4513 0.3125
r7760 n4468 n4514 0.03125
r7761 n4513 n4514 0.53125
r7762 n4515 n4516 0.125
r7763 n4516 n4517 0.35416666666666669
r7764 n4517 n4518 0.35416666666666669
r7765 n4518 n4519 0.39583333333333331
r7766 n4519 n4520 0.39583333333333331
r7767 n4520 n4521 0.15625
r7768 n4469 n4522 0.041666666666666664
r7769 n4521 n4522 0.26041666666666669
r7770 n4470 n4523 0.071428571428571425
r7771 n4522 n4523 0.19791666666666666
r7772 n4471 n4524 0.25
r7773 n4523 n4524 0.09375
r7774 n4472 n4525 0.125
r7775 n4524 n4525 0.0625
r7776 n4473 n4526 0.055555555555555552
r7777 n4525 n4526 0.13541666666666666
r7778 n4474 n4527 0.023809523809523808
r7779 n4526 n4527 0.3125
r7780 n4475 n4528 0.25
r7781 n4527 n4528 0.23958333333333334
r7782 n4476 n4529 0.25
r7783 n4528 n4529 0.041666666666666664
r7784 n4477 n4530 0.055555555555555552
r7785 n4529 n4530 0.11458333333333333
r7786 n4478 n4531 0.041666666666666664
r7787 n4530 n4531 0.21875
r7788 n4531 n4532 0.21875
r7789 n4532 n4533 0.11458333333333333
r7790 n4533 n4534 0.041666666666666664
r7791 n4534 n4535 0.23958333333333334
r7792 n4535 n4536 0.375
r7793 n4536 n4537 0.17708333333333334
r7794 n4537 n4538 0.35416666666666669
r7795 n4538 n4539 0.35416666666666669
r7796 n4539 n4540 0.14583333333333334
r7797 n4479 n4541 0.050000000000000003
r7798 n4480 n4542 0.071428571428571425
r7799 n4541 n4542 0.17708333333333334
r7800 n4481 n4543 0.16666666666666666
r7801 n4542 n4543 0.10416666666666667
r7802 n4482 n4544 0.16666666666666666
r7803 n4543 n4544 0.0625
r7804 n4483 n4545 0.25
r7805 n4544 n4545 0.052083333333333336
r7806 n4484 n4546 0.0625
r7807 n4545 n4546 0.10416666666666667
r7808 n4485 n4547 0.022727272727272728
r7809 n4546 n4547 0.3125
r7810 n4486 n4548 0.25
r7811 n4547 n4548 0.25
r7812 n4487 n4549 0.16666666666666666
r7813 n4548 n4549 0.052083333333333336
r7814 n4488 n4550 0.16666666666666666
r7815 n4549 n4550 0.0625
r7816 n4489 n4551 0.125
r7817 n4550 n4551 0.072916666666666671
r7818 n4490 n4552 0.16666666666666666
r7819 n4551 n4552 0.072916666666666671
r7820 n4491 n4553 0.050000000000000003
r7821 n4552 n4553 0.13541666666666666
r7822 n4554 n4555 0.125
r7823 n4555 n4556 0.35416666666666669
r7824 n4556 n4557 0.35416666666666669
r7825 n4557 n4558 0.39583333333333331
r7826 n4558 n4559 0.39583333333333331
r7827 n4559 n4560 0.35416666666666669
r7828 n4560 n4561 0.35416666666666669
r7829 n4561 n4562 0.39583333333333331
r7830 n4562 n4563 0.39583333333333331
r7831 n4563 n4564 0.35416666666666669
r7832 n4564 n4565 0.35416666666666669
r7833 n4565 n4566 0.39583333333333331
r7834 n4566 n4567 0.39583333333333331
r7835 n4567 n4568 0.35416666666666669
r7836 n4568 n4569 0.35416666666666669
r7837 n4569 n4570 0.39583333333333331
r7838 n4570 n4571 0.39583333333333331
r7839 n4571 n4572 0.35416666666666669
r7840 n4572 n4573 0.35416666666666669
r7841 n4573 n4574 0.39583333333333331
r7842 n4574 n4575 0.39583333333333331
r7843 n4575 n4576 0.35416666666666669
r7844 n4576 n4577 0.35416666666666669
r7845 n4577 n4578 0.39583333333333331
r7846 n4578 n4579 0.39583333333333331
r7847 n4579 n4580 0.35416666666666669
r7848 n4580 n4581 0.35416666666666669
r7849 n4581 n4582 0.39583333333333331
r7850 n4582 n4583 0.39583333333333331
r7851 n4583 n4584 0.35416666666666669
r7852 n4584 n4585 0.35416666666666669
r7853 n4585 n4586 0.17708333333333334
r7854 n4492 n4587 0.041666666666666664
r7855 n4586 n4587 0.28125
r7856 n4493 n4588 0.055555555555555552
r7857 n4587 n4588 0.21875
r7858 n4494 n4589 0.25
r7859 n4588 n4589 0.11458333333333333
r7860 n4495 n4590 0.25
r7861 n4589 n4590 0.041666666666666664
r7862 n4496 n4591 0.0625
r7863 n4590 n4591 0.10416666666666667
r7864 n4497 n4592 0.022727272727272728
r7865 n4591 n4592 0.3125
r7866 n4498 n4593 0.5
r7867 n4592 n4593 0.23958333333333334
r7868 n4499 n4594 0.5
r7869 n4593 n4594 0.020833333333333332
r7870 n4500 n4595 0.5
r7871 n4594 n4595 0.020833333333333332
r7872 n4501 n4596 0.050000000000000003
r7873 n4595 n4596 0.11458333333333333
r7874 n4502 n4597 0.041666666666666664
r7875 n4596 n4597 0.22916666666666666
r7876 n4597 n4598 0.20833333333333334
r7877 n4598 n4599 0.10416666666666667
r7878 n4599 n4600 0.052083333333333336
r7879 n4600 n4601 0.052083333333333336
r7880 n4601 n4602 0.083333333333333329
r7881 n4602 n4603 0.1875
r7882 n4603 n4604 0.27083333333333331
r7883 n4604 n4605 0.16666666666666666
r7884 n4605 n4606 0.39583333333333331
r7885 n4606 n4607 0.39583333333333331
r7886 n4607 n4608 0.35416666666666669
r7887 n4608 n4609 0.35416666666666669
r7888 n4609 n4610 0.39583333333333331
r7889 n4610 n4611 0.39583333333333331
r7890 n4611 n4612 0.35416666666666669
r7891 n4612 n4613 0.35416666666666669
r7892 n4613 n4614 0.39583333333333331
r7893 n4614 n4615 0.39583333333333331
r7894 n4615 n4616 0.35416666666666669
r7895 n4616 n4617 0.35416666666666669
r7896 n4617 n4618 0.39583333333333331
r7897 n4618 n4619 0.39583333333333331
r7898 n4619 n4620 0.35416666666666669
r7899 n4620 n4621 0.35416666666666669
r7900 n4621 n4622 0.39583333333333331
r7901 n4622 n4623 0.39583333333333331
r7902 n4623 n4624 0.35416666666666669
r7903 n4624 n4625 0.35416666666666669
r7904 n4625 n4626 0.39583333333333331
r7905 n4626 n4627 0.39583333333333331
r7906 n4627 n4628 0.35416666666666669
r7907 n4628 n4629 0.35416666666666669
r7908 n4629 n4630 0.39583333333333331
r7909 n4630 n4631 0.39583333333333331
r7910 n4631 n4632 0.35416666666666669
r7911 n4632 n4633 0.35416666666666669
r7912 n4633 n4634 0.14583333333333334
r7913 n4503 n4635 0.050000000000000003
r7914 n4504 n4636 0.071428571428571425
r7915 n4635 n4636 0.17708333333333334
r7916 n4505 n4637 0.16666666666666666
r7917 n4636 n4637 0.10416666666666667
r7918 n4506 n4638 0.16666666666666666
r7919 n4637 n4638 0.0625
r7920 n4507 n4639 0.25
r7921 n4638 n4639 0.052083333333333336
r7922 n4508 n4640 0.045454545454545456
r7923 n4639 n4640 0.13541666666666666
r7924 n4509 n4641 0.026315789473684209
r7925 n4640 n4641 0.3125
r7926 n4510 n4642 0.25
r7927 n4641 n4642 0.21875
r7928 n4511 n4643 0.16666666666666666
r7929 n4642 n4643 0.052083333333333336
r7930 n4512 n4644 0.16666666666666666
r7931 n4643 n4644 0.0625
r7932 n4513 n4645 0.071428571428571425
r7933 n4644 n4645 0.10416666666666667
r7934 n4514 n4646 0.050000000000000003
r7935 n4645 n4646 0.17708333333333334
r7936 n4515 n4647 0.050000000000000003
r7937 n4516 n4648 0.25
r7938 n4647 n4648 0.375
r7939 n4517 n4649 0.015625
r7940 n4648 n4649 1.0625
r7941 n4518 n4650 0.25
r7942 n4649 n4650 1.0625
r7943 n4519 n4651 0.013888888888888888
r7944 n4650 n4651 1.1875
r7945 n4520 n4652 0.25
r7946 n4651 n4652 1.1875
r7947 n4521 n4653 0.038461538461538464
r7948 n4652 n4653 0.46875
r7949 n4522 n4654 0.041666666666666664
r7950 n4653 n4654 0.78125
r7951 n4523 n4655 0.071428571428571425
r7952 n4654 n4655 0.59375
r7953 n4524 n4656 0.25
r7954 n4655 n4656 0.28125
r7955 n4525 n4657 0.125
r7956 n4656 n4657 0.1875
r7957 n4526 n4658 0.055555555555555552
r7958 n4657 n4658 0.40625
r7959 n4527 n4659 0.023809523809523808
r7960 n4658 n4659 0.9375
r7961 n4528 n4660 0.25
r7962 n4659 n4660 0.71875
r7963 n4529 n4661 0.25
r7964 n4660 n4661 0.125
r7965 n4530 n4662 0.055555555555555552
r7966 n4661 n4662 0.34375
r7967 n4531 n4663 0.041666666666666664
r7968 n4662 n4663 0.65625
r7969 n4532 n4664 0.055555555555555552
r7970 n4663 n4664 0.65625
r7971 n4533 n4665 0.25
r7972 n4664 n4665 0.34375
r7973 n4534 n4666 0.25
r7974 n4665 n4666 0.125
r7975 n4535 n4667 0.023809523809523808
r7976 n4666 n4667 0.71875
r7977 n4536 n4668 0.033333333333333333
r7978 n4667 n4668 1.125
r7979 n4537 n4669 0.25
r7980 n4668 n4669 0.53125
r7981 n4538 n4670 0.015625
r7982 n4669 n4670 1.0625
r7983 n4539 n4671 0.25
r7984 n4670 n4671 1.0625
r7985 n4540 n4672 0.041666666666666664
r7986 n4671 n4672 0.4375
r7987 n4541 n4673 0.050000000000000003
r7988 n4542 n4674 0.071428571428571425
r7989 n4673 n4674 0.53125
r7990 n4543 n4675 0.16666666666666666
r7991 n4674 n4675 0.3125
r7992 n4544 n4676 0.16666666666666666
r7993 n4675 n4676 0.1875
r7994 n4545 n4677 0.25
r7995 n4676 n4677 0.15625
r7996 n4546 n4678 0.0625
r7997 n4677 n4678 0.3125
r7998 n4547 n4679 0.022727272727272728
r7999 n4678 n4679 0.9375
r8000 n4548 n4680 0.25
r8001 n4679 n4680 0.75
r8002 n4549 n4681 0.16666666666666666
r8003 n4680 n4681 0.15625
r8004 n4550 n4682 0.16666666666666666
r8005 n4681 n4682 0.1875
r8006 n4551 n4683 0.125
r8007 n4682 n4683 0.21875
r8008 n4552 n4684 0.16666666666666666
r8009 n4683 n4684 0.21875
r8010 n4553 n4685 0.050000000000000003
r8011 n4684 n4685 0.40625
r8012 n4554 n4686 0.050000000000000003
r8013 n4555 n4687 0.25
r8014 n4686 n4687 0.375
r8015 n4556 n4688 0.015625
r8016 n4687 n4688 1.0625
r8017 n4557 n4689 0.25
r8018 n4688 n4689 1.0625
r8019 n4558 n4690 0.013888888888888888
r8020 n4689 n4690 1.1875
r8021 n4559 n4691 0.25
r8022 n4690 n4691 1.1875
r8023 n4560 n4692 0.015625
r8024 n4691 n4692 1.0625
r8025 n4561 n4693 0.25
r8026 n4692 n4693 1.0625
r8027 n4562 n4694 0.013888888888888888
r8028 n4693 n4694 1.1875
r8029 n4563 n4695 0.25
r8030 n4694 n4695 1.1875
r8031 n4564 n4696 0.015625
r8032 n4695 n4696 1.0625
r8033 n4565 n4697 0.25
r8034 n4696 n4697 1.0625
r8035 n4566 n4698 0.013888888888888888
r8036 n4697 n4698 1.1875
r8037 n4567 n4699 0.25
r8038 n4698 n4699 1.1875
r8039 n4568 n4700 0.015625
r8040 n4699 n4700 1.0625
r8041 n4569 n4701 0.25
r8042 n4700 n4701 1.0625
r8043 n4570 n4702 0.013888888888888888
r8044 n4701 n4702 1.1875
r8045 n4571 n4703 0.25
r8046 n4702 n4703 1.1875
r8047 n4572 n4704 0.015625
r8048 n4703 n4704 1.0625
r8049 n4573 n4705 0.25
r8050 n4704 n4705 1.0625
r8051 n4574 n4706 0.013888888888888888
r8052 n4705 n4706 1.1875
r8053 n4575 n4707 0.25
r8054 n4706 n4707 1.1875
r8055 n4576 n4708 0.015625
r8056 n4707 n4708 1.0625
r8057 n4577 n4709 0.25
r8058 n4708 n4709 1.0625
r8059 n4578 n4710 0.013888888888888888
r8060 n4709 n4710 1.1875
r8061 n4579 n4711 0.25
r8062 n4710 n4711 1.1875
r8063 n4580 n4712 0.015625
r8064 n4711 n4712 1.0625
r8065 n4581 n4713 0.25
r8066 n4712 n4713 1.0625
r8067 n4582 n4714 0.013888888888888888
r8068 n4713 n4714 1.1875
r8069 n4583 n4715 0.25
r8070 n4714 n4715 1.1875
r8071 n4584 n4716 0.015625
r8072 n4715 n4716 1.0625
r8073 n4585 n4717 0.25
r8074 n4716 n4717 1.0625
r8075 n4586 n4718 0.033333333333333333
r8076 n4717 n4718 0.53125
r8077 n4587 n4719 0.041666666666666664
r8078 n4718 n4719 0.84375
r8079 n4588 n4720 0.055555555555555552
r8080 n4719 n4720 0.65625
r8081 n4589 n4721 0.25
r8082 n4720 n4721 0.34375
r8083 n4590 n4722 0.25
r8084 n4721 n4722 0.125
r8085 n4591 n4723 0.0625
r8086 n4722 n4723 0.3125
r8087 n4592 n4724 0.022727272727272728
r8088 n4723 n4724 0.9375
r8089 n4593 n4725 0.5
r8090 n4724 n4725 0.71875
r8091 n4594 n4726 0.5
r8092 n4725 n4726 0.0625
r8093 n4595 n4727 0.5
r8094 n4726 n4727 0.0625
r8095 n4596 n4728 0.050000000000000003
r8096 n4727 n4728 0.34375
r8097 n4597 n4729 0.041666666666666664
r8098 n4728 n4729 0.6875
r8099 n4598 n4730 0.0625
r8100 n4729 n4730 0.625
r8101 n4599 n4731 0.25
r8102 n4730 n4731 0.3125
r8103 n4600 n4732 0.16666666666666666
r8104 n4731 n4732 0.15625
r8105 n4601 n4733 0.25
r8106 n4732 n4733 0.15625
r8107 n4602 n4734 0.083333333333333329
r8108 n4733 n4734 0.25
r8109 n4603 n4735 0.041666666666666664
r8110 n4734 n4735 0.5625
r8111 n4604 n4736 0.035714285714285712
r8112 n4735 n4736 0.8125
r8113 n4605 n4737 0.25
r8114 n4736 n4737 0.5
r8115 n4606 n4738 0.013888888888888888
r8116 n4737 n4738 1.1875
r8117 n4607 n4739 0.25
r8118 n4738 n4739 1.1875
r8119 n4608 n4740 0.015625
r8120 n4739 n4740 1.0625
r8121 n4609 n4741 0.25
r8122 n4740 n4741 1.0625
r8123 n4610 n4742 0.013888888888888888
r8124 n4741 n4742 1.1875
r8125 n4611 n4743 0.25
r8126 n4742 n4743 1.1875
r8127 n4612 n4744 0.015625
r8128 n4743 n4744 1.0625
r8129 n4613 n4745 0.25
r8130 n4744 n4745 1.0625
r8131 n4614 n4746 0.013888888888888888
r8132 n4745 n4746 1.1875
r8133 n4615 n4747 0.25
r8134 n4746 n4747 1.1875
r8135 n4616 n4748 0.015625
r8136 n4747 n4748 1.0625
r8137 n4617 n4749 0.25
r8138 n4748 n4749 1.0625
r8139 n4618 n4750 0.013888888888888888
r8140 n4749 n4750 1.1875
r8141 n4619 n4751 0.25
r8142 n4750 n4751 1.1875
r8143 n4620 n4752 0.015625
r8144 n4751 n4752 1.0625
r8145 n4621 n4753 0.25
r8146 n4752 n4753 1.0625
r8147 n4622 n4754 0.013888888888888888
r8148 n4753 n4754 1.1875
r8149 n4623 n4755 0.25
r8150 n4754 n4755 1.1875
r8151 n4624 n4756 0.015625
r8152 n4755 n4756 1.0625
r8153 n4625 n4757 0.25
r8154 n4756 n4757 1.0625
r8155 n4626 n4758 0.013888888888888888
r8156 n4757 n4758 1.1875
r8157 n4627 n4759 0.25
r8158 n4758 n4759 1.1875
r8159 n4628 n4760 0.015625
r8160 n4759 n4760 1.0625
r8161 n4629 n4761 0.25
r8162 n4760 n4761 1.0625
r8163 n4630 n4762 0.013888888888888888
r8164 n4761 n4762 1.1875
r8165 n4631 n4763 0.25
r8166 n4762 n4763 1.1875
r8167 n4632 n4764 0.015625
r8168 n4763 n4764 1.0625
r8169 n4633 n4765 0.25
r8170 n4764 n4765 1.0625
r8171 n4634 n4766 0.041666666666666664
r8172 n4765 n4766 0.4375
r8173 n4635 n4767 0.050000000000000003
r8174 n4636 n4768 0.071428571428571425
r8175 n4767 n4768 0.53125
r8176 n4637 n4769 0.16666666666666666
r8177 n4768 n4769 0.3125
r8178 n4638 n4770 0.16666666666666666
r8179 n4769 n4770 0.1875
r8180 n4639 n4771 0.25
r8181 n4770 n4771 0.15625
r8182 n4640 n4772 0.045454545454545456
r8183 n4771 n4772 0.40625
r8184 n4641 n4773 0.026315789473684209
r8185 n4772 n4773 0.9375
r8186 n4642 n4774 0.25
r8187 n4773 n4774 0.65625
r8188 n4643 n4775 0.16666666666666666
r8189 n4774 n4775 0.15625
r8190 n4644 n4776 0.16666666666666666
r8191 n4775 n4776 0.1875
r8192 n4645 n4777 0.071428571428571425
r8193 n4776 n4777 0.3125
r8194 n4646 n4778 0.050000000000000003
r8195 n4777 n4778 0.53125
r8196 n4647 n4779 0.03125
r8197 n4648 n4780 0.15625
r8198 n4779 n4780 0.25
r8199 n4649 n4781 0.009765625
r8200 n4780 n4781 0.70833333333333337
r8201 n4650 n4782 0.15625
r8202 n4781 n4782 0.70833333333333337
r8203 n4651 n4783 0.0086805555555555559
r8204 n4782 n4783 0.79166666666666663
r8205 n4652 n4784 0.15625
r8206 n4783 n4784 0.79166666666666663
r8207 n4653 n4785 0.02403846153846154
r8208 n4784 n4785 0.3125
r8209 n4654 n4786 0.026041666666666668
r8210 n4785 n4786 0.52083333333333337
r8211 n4655 n4787 0.044642857142857144
r8212 n4786 n4787 0.39583333333333331
r8213 n4656 n4788 0.15625
r8214 n4787 n4788 0.1875
r8215 n4657 n4789 0.078125
r8216 n4788 n4789 0.125
r8217 n4658 n4790 0.034722222222222224
r8218 n4789 n4790 0.27083333333333331
r8219 n4659 n4791 0.01488095238095238
r8220 n4790 n4791 0.625
r8221 n4660 n4792 0.15625
r8222 n4791 n4792 0.47916666666666669
r8223 n4661 n4793 0.15625
r8224 n4792 n4793 0.083333333333333329
r8225 n4662 n4794 0.034722222222222224
r8226 n4793 n4794 0.22916666666666666
r8227 n4663 n4795 0.026041666666666668
r8228 n4794 n4795 0.4375
r8229 n4664 n4796 0.034722222222222224
r8230 n4795 n4796 0.4375
r8231 n4665 n4797 0.15625
r8232 n4796 n4797 0.22916666666666666
r8233 n4666 n4798 0.15625
r8234 n4797 n4798 0.083333333333333329
r8235 n4667 n4799 0.01488095238095238
r8236 n4798 n4799 0.47916666666666669
r8237 n4668 n4800 0.020833333333333332
r8238 n4799 n4800 0.75
r8239 n4669 n4801 0.15625
r8240 n4800 n4801 0.35416666666666669
r8241 n4670 n4802 0.009765625
r8242 n4801 n4802 0.70833333333333337
r8243 n4671 n4803 0.15625
r8244 n4802 n4803 0.70833333333333337
r8245 n4672 n4804 0.026041666666666668
r8246 n4803 n4804 0.29166666666666669
r8247 n4675 n4805 0.10416666666666667
r8248 n4676 n4806 0.10416666666666667
r8249 n4805 n4806 0.125
r8250 n4677 n4807 0.15625
r8251 n4806 n4807 0.10416666666666667
r8252 n4678 n4808 0.0390625
r8253 n4807 n4808 0.20833333333333334
r8254 n4679 n4809 0.014204545454545454
r8255 n4808 n4809 0.625
r8256 n4680 n4810 0.15625
r8257 n4809 n4810 0.5
r8258 n4681 n4811 0.10416666666666667
r8259 n4810 n4811 0.10416666666666667
r8260 n4682 n4812 0.10416666666666667
r8261 n4811 n4812 0.125
r8262 n4686 n4813 0.03125
r8263 n4687 n4814 0.15625
r8264 n4813 n4814 0.25
r8265 n4688 n4815 0.009765625
r8266 n4814 n4815 0.70833333333333337
r8267 n4689 n4816 0.15625
r8268 n4815 n4816 0.70833333333333337
r8269 n4690 n4817 0.0086805555555555559
r8270 n4816 n4817 0.79166666666666663
r8271 n4691 n4818 0.15625
r8272 n4817 n4818 0.79166666666666663
r8273 n4692 n4819 0.009765625
r8274 n4818 n4819 0.70833333333333337
r8275 n4693 n4820 0.15625
r8276 n4819 n4820 0.70833333333333337
r8277 n4694 n4821 0.0086805555555555559
r8278 n4820 n4821 0.79166666666666663
r8279 n4695 n4822 0.15625
r8280 n4821 n4822 0.79166666666666663
r8281 n4696 n4823 0.009765625
r8282 n4822 n4823 0.70833333333333337
r8283 n4697 n4824 0.15625
r8284 n4823 n4824 0.70833333333333337
r8285 n4698 n4825 0.0086805555555555559
r8286 n4824 n4825 0.79166666666666663
r8287 n4699 n4826 0.15625
r8288 n4825 n4826 0.79166666666666663
r8289 n4700 n4827 0.009765625
r8290 n4826 n4827 0.70833333333333337
r8291 n4701 n4828 0.15625
r8292 n4827 n4828 0.70833333333333337
r8293 n4702 n4829 0.0086805555555555559
r8294 n4828 n4829 0.79166666666666663
r8295 n4703 n4830 0.15625
r8296 n4829 n4830 0.79166666666666663
r8297 n4704 n4831 0.009765625
r8298 n4830 n4831 0.70833333333333337
r8299 n4705 n4832 0.15625
r8300 n4831 n4832 0.70833333333333337
r8301 n4706 n4833 0.0086805555555555559
r8302 n4832 n4833 0.79166666666666663
r8303 n4707 n4834 0.15625
r8304 n4833 n4834 0.79166666666666663
r8305 n4708 n4835 0.009765625
r8306 n4834 n4835 0.70833333333333337
r8307 n4709 n4836 0.15625
r8308 n4835 n4836 0.70833333333333337
r8309 n4710 n4837 0.0086805555555555559
r8310 n4836 n4837 0.79166666666666663
r8311 n4711 n4838 0.15625
r8312 n4837 n4838 0.79166666666666663
r8313 n4712 n4839 0.009765625
r8314 n4838 n4839 0.70833333333333337
r8315 n4713 n4840 0.15625
r8316 n4839 n4840 0.70833333333333337
r8317 n4714 n4841 0.0086805555555555559
r8318 n4840 n4841 0.79166666666666663
r8319 n4715 n4842 0.15625
r8320 n4841 n4842 0.79166666666666663
r8321 n4716 n4843 0.009765625
r8322 n4842 n4843 0.70833333333333337
r8323 n4717 n4844 0.15625
r8324 n4843 n4844 0.70833333333333337
r8325 n4718 n4845 0.020833333333333332
r8326 n4844 n4845 0.35416666666666669
r8327 n4719 n4846 0.026041666666666668
r8328 n4845 n4846 0.5625
r8329 n4720 n4847 0.034722222222222224
r8330 n4846 n4847 0.4375
r8331 n4721 n4848 0.15625
r8332 n4847 n4848 0.22916666666666666
r8333 n4722 n4849 0.15625
r8334 n4848 n4849 0.083333333333333329
r8335 n4723 n4850 0.0390625
r8336 n4849 n4850 0.20833333333333334
r8337 n4724 n4851 0.014204545454545454
r8338 n4850 n4851 0.625
r8339 n4725 n4852 0.3125
r8340 n4851 n4852 0.47916666666666669
r8341 n4726 n4853 0.3125
r8342 n4852 n4853 0.041666666666666664
r8343 n4727 n4854 0.3125
r8344 n4853 n4854 0.041666666666666664
r8345 n4728 n4855 0.03125
r8346 n4854 n4855 0.22916666666666666
r8347 n4729 n4856 0.026041666666666668
r8348 n4855 n4856 0.45833333333333331
r8349 n4730 n4857 0.0390625
r8350 n4856 n4857 0.41666666666666669
r8351 n4731 n4858 0.15625
r8352 n4857 n4858 0.20833333333333334
r8353 n4732 n4859 0.10416666666666667
r8354 n4858 n4859 0.10416666666666667
r8355 n4733 n4860 0.15625
r8356 n4859 n4860 0.10416666666666667
r8357 n4734 n4861 0.052083333333333336
r8358 n4860 n4861 0.16666666666666666
r8359 n4735 n4862 0.026041666666666668
r8360 n4861 n4862 0.375
r8361 n4736 n4863 0.022321428571428572
r8362 n4862 n4863 0.54166666666666663
r8363 n4737 n4864 0.15625
r8364 n4863 n4864 0.33333333333333331
r8365 n4738 n4865 0.0086805555555555559
r8366 n4864 n4865 0.79166666666666663
r8367 n4739 n4866 0.15625
r8368 n4865 n4866 0.79166666666666663
r8369 n4740 n4867 0.009765625
r8370 n4866 n4867 0.70833333333333337
r8371 n4741 n4868 0.15625
r8372 n4867 n4868 0.70833333333333337
r8373 n4742 n4869 0.0086805555555555559
r8374 n4868 n4869 0.79166666666666663
r8375 n4743 n4870 0.15625
r8376 n4869 n4870 0.79166666666666663
r8377 n4744 n4871 0.009765625
r8378 n4870 n4871 0.70833333333333337
r8379 n4745 n4872 0.15625
r8380 n4871 n4872 0.70833333333333337
r8381 n4746 n4873 0.0086805555555555559
r8382 n4872 n4873 0.79166666666666663
r8383 n4747 n4874 0.15625
r8384 n4873 n4874 0.79166666666666663
r8385 n4748 n4875 0.009765625
r8386 n4874 n4875 0.70833333333333337
r8387 n4749 n4876 0.15625
r8388 n4875 n4876 0.70833333333333337
r8389 n4750 n4877 0.0086805555555555559
r8390 n4876 n4877 0.79166666666666663
r8391 n4751 n4878 0.15625
r8392 n4877 n4878 0.79166666666666663
r8393 n4752 n4879 0.009765625
r8394 n4878 n4879 0.70833333333333337
r8395 n4753 n4880 0.15625
r8396 n4879 n4880 0.70833333333333337
r8397 n4754 n4881 0.0086805555555555559
r8398 n4880 n4881 0.79166666666666663
r8399 n4755 n4882 0.15625
r8400 n4881 n4882 0.79166666666666663
r8401 n4756 n4883 0.009765625
r8402 n4882 n4883 0.70833333333333337
r8403 n4757 n4884 0.15625
r8404 n4883 n4884 0.70833333333333337
r8405 n4758 n4885 0.0086805555555555559
r8406 n4884 n4885 0.79166666666666663
r8407 n4759 n4886 0.15625
r8408 n4885 n4886 0.79166666666666663
r8409 n4760 n4887 0.009765625
r8410 n4886 n4887 0.70833333333333337
r8411 n4761 n4888 0.15625
r8412 n4887 n4888 0.70833333333333337
r8413 n4762 n4889 0.0086805555555555559
r8414 n4888 n4889 0.79166666666666663
r8415 n4763 n4890 0.15625
r8416 n4889 n4890 0.79166666666666663
r8417 n4764 n4891 0.009765625
r8418 n4890 n4891 0.70833333333333337
r8419 n4765 n4892 0.15625
r8420 n4891 n4892 0.70833333333333337
r8421 n4766 n4893 0.026041666666666668
r8422 n4892 n4893 0.29166666666666669
r8423 n4769 n4894 0.10416666666666667
r8424 n4770 n4895 0.10416666666666667
r8425 n4894 n4895 0.125
r8426 n4771 n4896 0.15625
r8427 n4895 n4896 0.10416666666666667
r8428 n4772 n4897 0.028409090909090908
r8429 n4896 n4897 0.27083333333333331
r8430 n4773 n4898 0.016447368421052631
r8431 n4897 n4898 0.625
r8432 n4774 n4899 0.15625
r8433 n4898 n4899 0.4375
r8434 n4775 n4900 0.10416666666666667
r8435 n4899 n4900 0.10416666666666667
r8436 n4776 n4901 0.10416666666666667
r8437 n4900 n4901 0.125
r8438 n4779 n4902 0.043749999999999997
r8439 n4780 n4903 0.21875
r8440 n4902 n4903 0.1875
r8441 n4781 n4904 0.013671875
r8442 n4903 n4904 0.53125
r8443 n4782 n4905 0.21875
r8444 n4904 n4905 0.53125
r8445 n4783 n4906 0.012152777777777778
r8446 n4905 n4906 0.59375
r8447 n4784 n4907 0.21875
r8448 n4906 n4907 0.59375
r8449 n4785 n4908 0.033653846153846152
r8450 n4907 n4908 0.234375
r8451 n4786 n4909 0.036458333333333336
r8452 n4908 n4909 0.390625
r8453 n4787 n4910 0.0625
r8454 n4909 n4910 0.296875
r8455 n4788 n4911 0.21875
r8456 n4910 n4911 0.140625
r8457 n4789 n4912 0.109375
r8458 n4911 n4912 0.09375
r8459 n4790 n4913 0.048611111111111112
r8460 n4912 n4913 0.203125
r8461 n4791 n4914 0.020833333333333332
r8462 n4913 n4914 0.46875
r8463 n4792 n4915 0.21875
r8464 n4914 n4915 0.359375
r8465 n4793 n4916 0.21875
r8466 n4915 n4916 0.0625
r8467 n4794 n4917 0.048611111111111112
r8468 n4916 n4917 0.171875
r8469 n4795 n4918 0.036458333333333336
r8470 n4917 n4918 0.328125
r8471 n4796 n4919 0.048611111111111112
r8472 n4918 n4919 0.328125
r8473 n4797 n4920 0.21875
r8474 n4919 n4920 0.171875
r8475 n4798 n4921 0.21875
r8476 n4920 n4921 0.0625
r8477 n4799 n4922 0.020833333333333332
r8478 n4921 n4922 0.359375
r8479 n4800 n4923 0.029166666666666667
r8480 n4922 n4923 0.5625
r8481 n4801 n4924 0.21875
r8482 n4923 n4924 0.265625
r8483 n4802 n4925 0.013671875
r8484 n4924 n4925 0.53125
r8485 n4803 n4926 0.21875
r8486 n4925 n4926 0.53125
r8487 n4804 n4927 0.036458333333333336
r8488 n4926 n4927 0.21875
r8489 n4805 n4928 0.14583333333333334
r8490 n4806 n4929 0.14583333333333334
r8491 n4928 n4929 0.09375
r8492 n4807 n4930 0.21875
r8493 n4929 n4930 0.078125
r8494 n4808 n4931 0.0546875
r8495 n4930 n4931 0.15625
r8496 n4809 n4932 0.019886363636363636
r8497 n4931 n4932 0.46875
r8498 n4810 n4933 0.21875
r8499 n4932 n4933 0.375
r8500 n4811 n4934 0.14583333333333334
r8501 n4933 n4934 0.078125
r8502 n4812 n4935 0.14583333333333334
r8503 n4934 n4935 0.09375
r8504 n4813 n4936 0.043749999999999997
r8505 n4814 n4937 0.21875
r8506 n4936 n4937 0.1875
r8507 n4815 n4938 0.013671875
r8508 n4937 n4938 0.53125
r8509 n4816 n4939 0.21875
r8510 n4938 n4939 0.53125
r8511 n4817 n4940 0.012152777777777778
r8512 n4939 n4940 0.59375
r8513 n4818 n4941 0.21875
r8514 n4940 n4941 0.59375
r8515 n4819 n4942 0.013671875
r8516 n4941 n4942 0.53125
r8517 n4820 n4943 0.21875
r8518 n4942 n4943 0.53125
r8519 n4821 n4944 0.012152777777777778
r8520 n4943 n4944 0.59375
r8521 n4822 n4945 0.21875
r8522 n4944 n4945 0.59375
r8523 n4823 n4946 0.013671875
r8524 n4945 n4946 0.53125
r8525 n4824 n4947 0.21875
r8526 n4946 n4947 0.53125
r8527 n4825 n4948 0.012152777777777778
r8528 n4947 n4948 0.59375
r8529 n4826 n4949 0.21875
r8530 n4948 n4949 0.59375
r8531 n4827 n4950 0.013671875
r8532 n4949 n4950 0.53125
r8533 n4828 n4951 0.21875
r8534 n4950 n4951 0.53125
r8535 n4829 n4952 0.012152777777777778
r8536 n4951 n4952 0.59375
r8537 n4830 n4953 0.21875
r8538 n4952 n4953 0.59375
r8539 n4831 n4954 0.013671875
r8540 n4953 n4954 0.53125
r8541 n4832 n4955 0.21875
r8542 n4954 n4955 0.53125
r8543 n4833 n4956 0.012152777777777778
r8544 n4955 n4956 0.59375
r8545 n4834 n4957 0.21875
r8546 n4956 n4957 0.59375
r8547 n4835 n4958 0.013671875
r8548 n4957 n4958 0.53125
r8549 n4836 n4959 0.21875
r8550 n4958 n4959 0.53125
r8551 n4837 n4960 0.012152777777777778
r8552 n4959 n4960 0.59375
r8553 n4838 n4961 0.21875
r8554 n4960 n4961 0.59375
r8555 n4839 n4962 0.013671875
r8556 n4961 n4962 0.53125
r8557 n4840 n4963 0.21875
r8558 n4962 n4963 0.53125
r8559 n4841 n4964 0.012152777777777778
r8560 n4963 n4964 0.59375
r8561 n4842 n4965 0.21875
r8562 n4964 n4965 0.59375
r8563 n4843 n4966 0.013671875
r8564 n4965 n4966 0.53125
r8565 n4844 n4967 0.21875
r8566 n4966 n4967 0.53125
r8567 n4845 n4968 0.029166666666666667
r8568 n4967 n4968 0.265625
r8569 n4846 n4969 0.036458333333333336
r8570 n4968 n4969 0.421875
r8571 n4847 n4970 0.048611111111111112
r8572 n4969 n4970 0.328125
r8573 n4848 n4971 0.21875
r8574 n4970 n4971 0.171875
r8575 n4849 n4972 0.21875
r8576 n4971 n4972 0.0625
r8577 n4850 n4973 0.0546875
r8578 n4972 n4973 0.15625
r8579 n4851 n4974 0.019886363636363636
r8580 n4973 n4974 0.46875
r8581 n4852 n4975 0.4375
r8582 n4974 n4975 0.359375
r8583 n4853 n4976 0.4375
r8584 n4975 n4976 0.03125
r8585 n4854 n4977 0.4375
r8586 n4976 n4977 0.03125
r8587 n4855 n4978 0.043749999999999997
r8588 n4977 n4978 0.171875
r8589 n4856 n4979 0.036458333333333336
r8590 n4978 n4979 0.34375
r8591 n4857 n4980 0.0546875
r8592 n4979 n4980 0.3125
r8593 n4858 n4981 0.21875
r8594 n4980 n4981 0.15625
r8595 n4859 n4982 0.14583333333333334
r8596 n4981 n4982 0.078125
r8597 n4860 n4983 0.21875
r8598 n4982 n4983 0.078125
r8599 n4861 n4984 0.072916666666666671
r8600 n4983 n4984 0.125
r8601 n4862 n4985 0.036458333333333336
r8602 n4984 n4985 0.28125
r8603 n4863 n4986 0.03125
r8604 n4985 n4986 0.40625
r8605 n4864 n4987 0.21875
r8606 n4986 n4987 0.25
r8607 n4865 n4988 0.012152777777777778
r8608 n4987 n4988 0.59375
r8609 n4866 n4989 0.21875
r8610 n4988 n4989 0.59375
r8611 n4867 n4990 0.013671875
r8612 n4989 n4990 0.53125
r8613 n4868 n4991 0.21875
r8614 n4990 n4991 0.53125
r8615 n4869 n4992 0.012152777777777778
r8616 n4991 n4992 0.59375
r8617 n4870 n4993 0.21875
r8618 n4992 n4993 0.59375
r8619 n4871 n4994 0.013671875
r8620 n4993 n4994 0.53125
r8621 n4872 n4995 0.21875
r8622 n4994 n4995 0.53125
r8623 n4873 n4996 0.012152777777777778
r8624 n4995 n4996 0.59375
r8625 n4874 n4997 0.21875
r8626 n4996 n4997 0.59375
r8627 n4875 n4998 0.013671875
r8628 n4997 n4998 0.53125
r8629 n4876 n4999 0.21875
r8630 n4998 n4999 0.53125
r8631 n4877 n5000 0.012152777777777778
r8632 n4999 n5000 0.59375
r8633 n4878 n5001 0.21875
r8634 n5000 n5001 0.59375
r8635 n4879 n5002 0.013671875
r8636 n5001 n5002 0.53125
r8637 n4880 n5003 0.21875
r8638 n5002 n5003 0.53125
r8639 n4881 n5004 0.012152777777777778
r8640 n5003 n5004 0.59375
r8641 n4882 n5005 0.21875
r8642 n5004 n5005 0.59375
r8643 n4883 n5006 0.013671875
r8644 n5005 n5006 0.53125
r8645 n4884 n5007 0.21875
r8646 n5006 n5007 0.53125
r8647 n4885 n5008 0.012152777777777778
r8648 n5007 n5008 0.59375
r8649 n4886 n5009 0.21875
r8650 n5008 n5009 0.59375
r8651 n4887 n5010 0.013671875
r8652 n5009 n5010 0.53125
r8653 n4888 n5011 0.21875
r8654 n5010 n5011 0.53125
r8655 n4889 n5012 0.012152777777777778
r8656 n5011 n5012 0.59375
r8657 n4890 n5013 0.21875
r8658 n5012 n5013 0.59375
r8659 n4891 n5014 0.013671875
r8660 n5013 n5014 0.53125
r8661 n4892 n5015 0.21875
r8662 n5014 n5015 0.53125
r8663 n4893 n5016 0.036458333333333336
r8664 n5015 n5016 0.21875
r8665 n4894 n5017 0.14583333333333334
r8666 n4895 n5018 0.14583333333333334
r8667 n5017 n5018 0.09375
r8668 n4896 n5019 0.21875
r8669 n5018 n5019 0.078125
r8670 n4897 n5020 0.039772727272727272
r8671 n5019 n5020 0.203125
r8672 n4898 n5021 0.023026315789473683
r8673 n5020 n5021 0.46875
r8674 n4899 n5022 0.21875
r8675 n5021 n5022 0.328125
r8676 n4900 n5023 0.14583333333333334
r8677 n5022 n5023 0.078125
r8678 n4901 n5024 0.14583333333333334
r8679 n5023 n5024 0.09375
r8680 n4902 n5025 0.043749999999999997
r8681 n4903 n5026 0.21875
r8682 n5025 n5026 0.25
r8683 n4904 n5027 0.013671875
r8684 n5026 n5027 0.70833333333333337
r8685 n4905 n5028 0.21875
r8686 n5027 n5028 0.70833333333333337
r8687 n4906 n5029 0.012152777777777778
r8688 n5028 n5029 0.79166666666666663
r8689 n4907 n5030 0.21875
r8690 n5029 n5030 0.79166666666666663
r8691 n4908 n5031 0.033653846153846152
r8692 n5030 n5031 0.3125
r8693 n4909 n5032 0.036458333333333336
r8694 n5031 n5032 0.52083333333333337
r8695 n4910 n5033 0.0625
r8696 n5032 n5033 0.39583333333333331
r8697 n4911 n5034 0.21875
r8698 n5033 n5034 0.1875
r8699 n4912 n5035 0.109375
r8700 n5034 n5035 0.125
r8701 n4913 n5036 0.048611111111111112
r8702 n5035 n5036 0.27083333333333331
r8703 n4914 n5037 0.020833333333333332
r8704 n5036 n5037 0.625
r8705 n4915 n5038 0.21875
r8706 n5037 n5038 0.47916666666666669
r8707 n4916 n5039 0.21875
r8708 n5038 n5039 0.083333333333333329
r8709 n4917 n5040 0.048611111111111112
r8710 n5039 n5040 0.22916666666666666
r8711 n4918 n5041 0.036458333333333336
r8712 n5040 n5041 0.4375
r8713 n4919 n5042 0.048611111111111112
r8714 n5041 n5042 0.4375
r8715 n4920 n5043 0.21875
r8716 n5042 n5043 0.22916666666666666
r8717 n4921 n5044 0.21875
r8718 n5043 n5044 0.083333333333333329
r8719 n4922 n5045 0.020833333333333332
r8720 n5044 n5045 0.47916666666666669
r8721 n4923 n5046 0.029166666666666667
r8722 n5045 n5046 0.75
r8723 n4924 n5047 0.21875
r8724 n5046 n5047 0.35416666666666669
r8725 n4925 n5048 0.013671875
r8726 n5047 n5048 0.70833333333333337
r8727 n4926 n5049 0.21875
r8728 n5048 n5049 0.70833333333333337
r8729 n4927 n5050 0.036458333333333336
r8730 n5049 n5050 0.29166666666666669
r8731 n4936 n5051 0.043749999999999997
r8732 n4937 n5052 0.21875
r8733 n5051 n5052 0.25
r8734 n4938 n5053 0.013671875
r8735 n5052 n5053 0.70833333333333337
r8736 n4939 n5054 0.21875
r8737 n5053 n5054 0.70833333333333337
r8738 n4940 n5055 0.012152777777777778
r8739 n5054 n5055 0.79166666666666663
r8740 n4941 n5056 0.21875
r8741 n5055 n5056 0.79166666666666663
r8742 n4942 n5057 0.013671875
r8743 n5056 n5057 0.70833333333333337
r8744 n4943 n5058 0.21875
r8745 n5057 n5058 0.70833333333333337
r8746 n4944 n5059 0.012152777777777778
r8747 n5058 n5059 0.79166666666666663
r8748 n4945 n5060 0.21875
r8749 n5059 n5060 0.79166666666666663
r8750 n4946 n5061 0.013671875
r8751 n5060 n5061 0.70833333333333337
r8752 n4947 n5062 0.21875
r8753 n5061 n5062 0.70833333333333337
r8754 n4948 n5063 0.012152777777777778
r8755 n5062 n5063 0.79166666666666663
r8756 n4949 n5064 0.21875
r8757 n5063 n5064 0.79166666666666663
r8758 n4950 n5065 0.013671875
r8759 n5064 n5065 0.70833333333333337
r8760 n4951 n5066 0.21875
r8761 n5065 n5066 0.70833333333333337
r8762 n4952 n5067 0.012152777777777778
r8763 n5066 n5067 0.79166666666666663
r8764 n4953 n5068 0.21875
r8765 n5067 n5068 0.79166666666666663
r8766 n4954 n5069 0.013671875
r8767 n5068 n5069 0.70833333333333337
r8768 n4955 n5070 0.21875
r8769 n5069 n5070 0.70833333333333337
r8770 n4956 n5071 0.012152777777777778
r8771 n5070 n5071 0.79166666666666663
r8772 n4957 n5072 0.21875
r8773 n5071 n5072 0.79166666666666663
r8774 n4958 n5073 0.013671875
r8775 n5072 n5073 0.70833333333333337
r8776 n4959 n5074 0.21875
r8777 n5073 n5074 0.70833333333333337
r8778 n4960 n5075 0.012152777777777778
r8779 n5074 n5075 0.79166666666666663
r8780 n4961 n5076 0.21875
r8781 n5075 n5076 0.79166666666666663
r8782 n4962 n5077 0.013671875
r8783 n5076 n5077 0.70833333333333337
r8784 n4963 n5078 0.21875
r8785 n5077 n5078 0.70833333333333337
r8786 n4964 n5079 0.012152777777777778
r8787 n5078 n5079 0.79166666666666663
r8788 n4965 n5080 0.21875
r8789 n5079 n5080 0.79166666666666663
r8790 n4966 n5081 0.013671875
r8791 n5080 n5081 0.70833333333333337
r8792 n4967 n5082 0.21875
r8793 n5081 n5082 0.70833333333333337
r8794 n4968 n5083 0.029166666666666667
r8795 n5082 n5083 0.35416666666666669
r8796 n4969 n5084 0.036458333333333336
r8797 n5083 n5084 0.5625
r8798 n4970 n5085 0.048611111111111112
r8799 n5084 n5085 0.4375
r8800 n4971 n5086 0.21875
r8801 n5085 n5086 0.22916666666666666
r8802 n4972 n5087 0.21875
r8803 n5086 n5087 0.083333333333333329
r8804 n4973 n5088 0.0546875
r8805 n5087 n5088 0.20833333333333334
r8806 n4974 n5089 0.019886363636363636
r8807 n5088 n5089 0.625
r8808 n4975 n5090 0.4375
r8809 n5089 n5090 0.47916666666666669
r8810 n4976 n5091 0.4375
r8811 n5090 n5091 0.041666666666666664
r8812 n4977 n5092 0.4375
r8813 n5091 n5092 0.041666666666666664
r8814 n4978 n5093 0.043749999999999997
r8815 n5092 n5093 0.22916666666666666
r8816 n4979 n5094 0.036458333333333336
r8817 n5093 n5094 0.45833333333333331
r8818 n4980 n5095 0.0546875
r8819 n5094 n5095 0.41666666666666669
r8820 n4981 n5096 0.21875
r8821 n5095 n5096 0.20833333333333334
r8822 n4982 n5097 0.14583333333333334
r8823 n5096 n5097 0.10416666666666667
r8824 n4983 n5098 0.21875
r8825 n5097 n5098 0.10416666666666667
r8826 n4984 n5099 0.072916666666666671
r8827 n5098 n5099 0.16666666666666666
r8828 n4985 n5100 0.036458333333333336
r8829 n5099 n5100 0.375
r8830 n4986 n5101 0.03125
r8831 n5100 n5101 0.54166666666666663
r8832 n4987 n5102 0.21875
r8833 n5101 n5102 0.33333333333333331
r8834 n4988 n5103 0.012152777777777778
r8835 n5102 n5103 0.79166666666666663
r8836 n4989 n5104 0.21875
r8837 n5103 n5104 0.79166666666666663
r8838 n4990 n5105 0.013671875
r8839 n5104 n5105 0.70833333333333337
r8840 n4991 n5106 0.21875
r8841 n5105 n5106 0.70833333333333337
r8842 n4992 n5107 0.012152777777777778
r8843 n5106 n5107 0.79166666666666663
r8844 n4993 n5108 0.21875
r8845 n5107 n5108 0.79166666666666663
r8846 n4994 n5109 0.013671875
r8847 n5108 n5109 0.70833333333333337
r8848 n4995 n5110 0.21875
r8849 n5109 n5110 0.70833333333333337
r8850 n4996 n5111 0.012152777777777778
r8851 n5110 n5111 0.79166666666666663
r8852 n4997 n5112 0.21875
r8853 n5111 n5112 0.79166666666666663
r8854 n4998 n5113 0.013671875
r8855 n5112 n5113 0.70833333333333337
r8856 n4999 n5114 0.21875
r8857 n5113 n5114 0.70833333333333337
r8858 n5000 n5115 0.012152777777777778
r8859 n5114 n5115 0.79166666666666663
r8860 n5001 n5116 0.21875
r8861 n5115 n5116 0.79166666666666663
r8862 n5002 n5117 0.013671875
r8863 n5116 n5117 0.70833333333333337
r8864 n5003 n5118 0.21875
r8865 n5117 n5118 0.70833333333333337
r8866 n5004 n5119 0.012152777777777778
r8867 n5118 n5119 0.79166666666666663
r8868 n5005 n5120 0.21875
r8869 n5119 n5120 0.79166666666666663
r8870 n5006 n5121 0.013671875
r8871 n5120 n5121 0.70833333333333337
r8872 n5007 n5122 0.21875
r8873 n5121 n5122 0.70833333333333337
r8874 n5008 n5123 0.012152777777777778
r8875 n5122 n5123 0.79166666666666663
r8876 n5009 n5124 0.21875
r8877 n5123 n5124 0.79166666666666663
r8878 n5010 n5125 0.013671875
r8879 n5124 n5125 0.70833333333333337
r8880 n5011 n5126 0.21875
r8881 n5125 n5126 0.70833333333333337
r8882 n5012 n5127 0.012152777777777778
r8883 n5126 n5127 0.79166666666666663
r8884 n5013 n5128 0.21875
r8885 n5127 n5128 0.79166666666666663
r8886 n5014 n5129 0.013671875
r8887 n5128 n5129 0.70833333333333337
r8888 n5015 n5130 0.21875
r8889 n5129 n5130 0.70833333333333337
r8890 n5016 n5131 0.036458333333333336
r8891 n5130 n5131 0.29166666666666669
r8892 n5025 n5132 0.1125
r8893 n5026 n5133 0.5625
r8894 n5132 n5133 0.050000000000000003
r8895 n5027 n5134 0.03515625
r8896 n5133 n5134 0.14166666666666666
r8897 n5028 n5135 0.5625
r8898 n5134 n5135 0.14166666666666666
r8899 n5029 n5136 0.03125
r8900 n5135 n5136 0.15833333333333333
r8901 n5030 n5137 0.5625
r8902 n5136 n5137 0.15833333333333333
r8903 n5031 n5138 0.086538461538461536
r8904 n5137 n5138 0.0625
r8905 n5032 n5139 0.09375
r8906 n5138 n5139 0.10416666666666667
r8907 n5033 n5140 0.16071428571428573
r8908 n5139 n5140 0.079166666666666663
r8909 n5034 n5141 0.5625
r8910 n5140 n5141 0.037499999999999999
r8911 n5035 n5142 0.28125
r8912 n5141 n5142 0.025000000000000001
r8913 n5036 n5143 0.125
r8914 n5142 n5143 0.054166666666666669
r8915 n5037 n5144 0.053571428571428568
r8916 n5143 n5144 0.125
r8917 n5038 n5145 0.5625
r8918 n5144 n5145 0.09583333333333334
r8919 n5039 n5146 0.5625
r8920 n5145 n5146 0.016666666666666666
r8921 n5040 n5147 0.125
r8922 n5146 n5147 0.04583333333333333
r8923 n5041 n5148 0.09375
r8924 n5147 n5148 0.087499999999999994
r8925 n5042 n5149 0.125
r8926 n5148 n5149 0.087499999999999994
r8927 n5043 n5150 0.5625
r8928 n5149 n5150 0.04583333333333333
r8929 n5044 n5151 0.5625
r8930 n5150 n5151 0.016666666666666666
r8931 n5045 n5152 0.053571428571428568
r8932 n5151 n5152 0.09583333333333334
r8933 n5046 n5153 0.074999999999999997
r8934 n5152 n5153 0.14999999999999999
r8935 n5047 n5154 0.5625
r8936 n5153 n5154 0.070833333333333331
r8937 n5048 n5155 0.03515625
r8938 n5154 n5155 0.14166666666666666
r8939 n5049 n5156 0.5625
r8940 n5155 n5156 0.14166666666666666
r8941 n5050 n5157 0.09375
r8942 n5156 n5157 0.058333333333333334
r8943 n5051 n5158 0.1125
r8944 n5052 n5159 0.5625
r8945 n5158 n5159 0.050000000000000003
r8946 n5053 n5160 0.03515625
r8947 n5159 n5160 0.14166666666666666
r8948 n5054 n5161 0.5625
r8949 n5160 n5161 0.14166666666666666
r8950 n5055 n5162 0.03125
r8951 n5161 n5162 0.15833333333333333
r8952 n5056 n5163 0.5625
r8953 n5162 n5163 0.15833333333333333
r8954 n5057 n5164 0.03515625
r8955 n5163 n5164 0.14166666666666666
r8956 n5058 n5165 0.5625
r8957 n5164 n5165 0.14166666666666666
r8958 n5059 n5166 0.03125
r8959 n5165 n5166 0.15833333333333333
r8960 n5060 n5167 0.5625
r8961 n5166 n5167 0.15833333333333333
r8962 n5061 n5168 0.03515625
r8963 n5167 n5168 0.14166666666666666
r8964 n5062 n5169 0.5625
r8965 n5168 n5169 0.14166666666666666
r8966 n5063 n5170 0.03125
r8967 n5169 n5170 0.15833333333333333
r8968 n5064 n5171 0.5625
r8969 n5170 n5171 0.15833333333333333
r8970 n5065 n5172 0.03515625
r8971 n5171 n5172 0.14166666666666666
r8972 n5066 n5173 0.5625
r8973 n5172 n5173 0.14166666666666666
r8974 n5067 n5174 0.03125
r8975 n5173 n5174 0.15833333333333333
r8976 n5068 n5175 0.5625
r8977 n5174 n5175 0.15833333333333333
r8978 n5069 n5176 0.03515625
r8979 n5175 n5176 0.14166666666666666
r8980 n5070 n5177 0.5625
r8981 n5176 n5177 0.14166666666666666
r8982 n5071 n5178 0.03125
r8983 n5177 n5178 0.15833333333333333
r8984 n5072 n5179 0.5625
r8985 n5178 n5179 0.15833333333333333
r8986 n5073 n5180 0.03515625
r8987 n5179 n5180 0.14166666666666666
r8988 n5074 n5181 0.5625
r8989 n5180 n5181 0.14166666666666666
r8990 n5075 n5182 0.03125
r8991 n5181 n5182 0.15833333333333333
r8992 n5076 n5183 0.5625
r8993 n5182 n5183 0.15833333333333333
r8994 n5077 n5184 0.03515625
r8995 n5183 n5184 0.14166666666666666
r8996 n5078 n5185 0.5625
r8997 n5184 n5185 0.14166666666666666
r8998 n5079 n5186 0.03125
r8999 n5185 n5186 0.15833333333333333
r9000 n5080 n5187 0.5625
r9001 n5186 n5187 0.15833333333333333
r9002 n5081 n5188 0.03515625
r9003 n5187 n5188 0.14166666666666666
r9004 n5082 n5189 0.5625
r9005 n5188 n5189 0.14166666666666666
r9006 n5083 n5190 0.074999999999999997
r9007 n5189 n5190 0.070833333333333331
r9008 n5084 n5191 0.09375
r9009 n5190 n5191 0.1125
r9010 n5085 n5192 0.125
r9011 n5191 n5192 0.087499999999999994
r9012 n5086 n5193 0.5625
r9013 n5192 n5193 0.04583333333333333
r9014 n5087 n5194 0.5625
r9015 n5193 n5194 0.016666666666666666
r9016 n5088 n5195 0.140625
r9017 n5194 n5195 0.041666666666666664
r9018 n5089 n5196 0.05113636363636364
r9019 n5195 n5196 0.125
r9020 n5090 n5197 1.125
r9021 n5196 n5197 0.09583333333333334
r9022 n5091 n5198 1.125
r9023 n5197 n5198 0.0083333333333333332
r9024 n5092 n5199 1.125
r9025 n5198 n5199 0.0083333333333333332
r9026 n5093 n5200 0.1125
r9027 n5199 n5200 0.04583333333333333
r9028 n5094 n5201 0.09375
r9029 n5200 n5201 0.09166666666666666
r9030 n5095 n5202 0.140625
r9031 n5201 n5202 0.083333333333333329
r9032 n5096 n5203 0.5625
r9033 n5202 n5203 0.041666666666666664
r9034 n5097 n5204 0.375
r9035 n5203 n5204 0.020833333333333332
r9036 n5098 n5205 0.5625
r9037 n5204 n5205 0.020833333333333332
r9038 n5099 n5206 0.1875
r9039 n5205 n5206 0.033333333333333333
r9040 n5100 n5207 0.09375
r9041 n5206 n5207 0.074999999999999997
r9042 n5101 n5208 0.080357142857142863
r9043 n5207 n5208 0.10833333333333334
r9044 n5102 n5209 0.5625
r9045 n5208 n5209 0.066666666666666666
r9046 n5103 n5210 0.03125
r9047 n5209 n5210 0.15833333333333333
r9048 n5104 n5211 0.5625
r9049 n5210 n5211 0.15833333333333333
r9050 n5105 n5212 0.03515625
r9051 n5211 n5212 0.14166666666666666
r9052 n5106 n5213 0.5625
r9053 n5212 n5213 0.14166666666666666
r9054 n5107 n5214 0.03125
r9055 n5213 n5214 0.15833333333333333
r9056 n5108 n5215 0.5625
r9057 n5214 n5215 0.15833333333333333
r9058 n5109 n5216 0.03515625
r9059 n5215 n5216 0.14166666666666666
r9060 n5110 n5217 0.5625
r9061 n5216 n5217 0.14166666666666666
r9062 n5111 n5218 0.03125
r9063 n5217 n5218 0.15833333333333333
r9064 n5112 n5219 0.5625
r9065 n5218 n5219 0.15833333333333333
r9066 n5113 n5220 0.03515625
r9067 n5219 n5220 0.14166666666666666
r9068 n5114 n5221 0.5625
r9069 n5220 n5221 0.14166666666666666
r9070 n5115 n5222 0.03125
r9071 n5221 n5222 0.15833333333333333
r9072 n5116 n5223 0.5625
r9073 n5222 n5223 0.15833333333333333
r9074 n5117 n5224 0.03515625
r9075 n5223 n5224 0.14166666666666666
r9076 n5118 n5225 0.5625
r9077 n5224 n5225 0.14166666666666666
r9078 n5119 n5226 0.03125
r9079 n5225 n5226 0.15833333333333333
r9080 n5120 n5227 0.5625
r9081 n5226 n5227 0.15833333333333333
r9082 n5121 n5228 0.03515625
r9083 n5227 n5228 0.14166666666666666
r9084 n5122 n5229 0.5625
r9085 n5228 n5229 0.14166666666666666
r9086 n5123 n5230 0.03125
r9087 n5229 n5230 0.15833333333333333
r9088 n5124 n5231 0.5625
r9089 n5230 n5231 0.15833333333333333
r9090 n5125 n5232 0.03515625
r9091 n5231 n5232 0.14166666666666666
r9092 n5126 n5233 0.5625
r9093 n5232 n5233 0.14166666666666666
r9094 n5127 n5234 0.03125
r9095 n5233 n5234 0.15833333333333333
r9096 n5128 n5235 0.5625
r9097 n5234 n5235 0.15833333333333333
r9098 n5129 n5236 0.03515625
r9099 n5235 n5236 0.14166666666666666
r9100 n5130 n5237 0.5625
r9101 n5236 n5237 0.14166666666666666
r9102 n5131 n5238 0.09375
r9103 n5237 n5238 0.058333333333333334
r9104 n5132 n5239 0.125
r9105 n5133 n5240 0.625
r9106 n5239 n5240 0.14999999999999999
r9107 n5134 n5241 0.0390625
r9108 n5240 n5241 0.42499999999999999
r9109 n5135 n5242 0.625
r9110 n5241 n5242 0.42499999999999999
r9111 n5136 n5243 0.034722222222222224
r9112 n5242 n5243 0.47499999999999998
r9113 n5137 n5244 0.625
r9114 n5243 n5244 0.47499999999999998
r9115 n5138 n5245 0.096153846153846159
r9116 n5244 n5245 0.1875
r9117 n5139 n5246 0.10416666666666667
r9118 n5245 n5246 0.3125
r9119 n5140 n5247 0.17857142857142858
r9120 n5246 n5247 0.23749999999999999
r9121 n5141 n5248 0.625
r9122 n5247 n5248 0.1125
r9123 n5142 n5249 0.3125
r9124 n5248 n5249 0.074999999999999997
r9125 n5143 n5250 0.1388888888888889
r9126 n5249 n5250 0.16250000000000001
r9127 n5144 n5251 0.059523809523809521
r9128 n5250 n5251 0.375
r9129 n5145 n5252 0.625
r9130 n5251 n5252 0.28749999999999998
r9131 n5146 n5253 0.625
r9132 n5252 n5253 0.050000000000000003
r9133 n5147 n5254 0.1388888888888889
r9134 n5253 n5254 0.13750000000000001
r9135 n5148 n5255 0.10416666666666667
r9136 n5254 n5255 0.26250000000000001
r9137 n5149 n5256 0.1388888888888889
r9138 n5255 n5256 0.26250000000000001
r9139 n5150 n5257 0.625
r9140 n5256 n5257 0.13750000000000001
r9141 n5151 n5258 0.625
r9142 n5257 n5258 0.050000000000000003
r9143 n5152 n5259 0.059523809523809521
r9144 n5258 n5259 0.28749999999999998
r9145 n5153 n5260 0.083333333333333329
r9146 n5259 n5260 0.45000000000000001
r9147 n5154 n5261 0.625
r9148 n5260 n5261 0.21249999999999999
r9149 n5155 n5262 0.0390625
r9150 n5261 n5262 0.42499999999999999
r9151 n5156 n5263 0.625
r9152 n5262 n5263 0.42499999999999999
r9153 n5157 n5264 0.10416666666666667
r9154 n5263 n5264 0.17499999999999999
r9155 n5158 n5265 0.125
r9156 n5159 n5266 0.625
r9157 n5265 n5266 0.14999999999999999
r9158 n5160 n5267 0.0390625
r9159 n5266 n5267 0.42499999999999999
r9160 n5161 n5268 0.625
r9161 n5267 n5268 0.42499999999999999
r9162 n5162 n5269 0.034722222222222224
r9163 n5268 n5269 0.47499999999999998
r9164 n5163 n5270 0.625
r9165 n5269 n5270 0.47499999999999998
r9166 n5164 n5271 0.0390625
r9167 n5270 n5271 0.42499999999999999
r9168 n5165 n5272 0.625
r9169 n5271 n5272 0.42499999999999999
r9170 n5166 n5273 0.034722222222222224
r9171 n5272 n5273 0.47499999999999998
r9172 n5167 n5274 0.625
r9173 n5273 n5274 0.47499999999999998
r9174 n5168 n5275 0.0390625
r9175 n5274 n5275 0.42499999999999999
r9176 n5169 n5276 0.625
r9177 n5275 n5276 0.42499999999999999
r9178 n5170 n5277 0.034722222222222224
r9179 n5276 n5277 0.47499999999999998
r9180 n5171 n5278 0.625
r9181 n5277 n5278 0.47499999999999998
r9182 n5172 n5279 0.0390625
r9183 n5278 n5279 0.42499999999999999
r9184 n5173 n5280 0.625
r9185 n5279 n5280 0.42499999999999999
r9186 n5174 n5281 0.034722222222222224
r9187 n5280 n5281 0.47499999999999998
r9188 n5175 n5282 0.625
r9189 n5281 n5282 0.47499999999999998
r9190 n5176 n5283 0.0390625
r9191 n5282 n5283 0.42499999999999999
r9192 n5177 n5284 0.625
r9193 n5283 n5284 0.42499999999999999
r9194 n5178 n5285 0.034722222222222224
r9195 n5284 n5285 0.47499999999999998
r9196 n5179 n5286 0.625
r9197 n5285 n5286 0.47499999999999998
r9198 n5180 n5287 0.0390625
r9199 n5286 n5287 0.42499999999999999
r9200 n5181 n5288 0.625
r9201 n5287 n5288 0.42499999999999999
r9202 n5182 n5289 0.034722222222222224
r9203 n5288 n5289 0.47499999999999998
r9204 n5183 n5290 0.625
r9205 n5289 n5290 0.47499999999999998
r9206 n5184 n5291 0.0390625
r9207 n5290 n5291 0.42499999999999999
r9208 n5185 n5292 0.625
r9209 n5291 n5292 0.42499999999999999
r9210 n5186 n5293 0.034722222222222224
r9211 n5292 n5293 0.47499999999999998
r9212 n5187 n5294 0.625
r9213 n5293 n5294 0.47499999999999998
r9214 n5188 n5295 0.0390625
r9215 n5294 n5295 0.42499999999999999
r9216 n5189 n5296 0.625
r9217 n5295 n5296 0.42499999999999999
r9218 n5190 n5297 0.083333333333333329
r9219 n5296 n5297 0.21249999999999999
r9220 n5191 n5298 0.10416666666666667
r9221 n5297 n5298 0.33750000000000002
r9222 n5192 n5299 0.1388888888888889
r9223 n5298 n5299 0.26250000000000001
r9224 n5193 n5300 0.625
r9225 n5299 n5300 0.13750000000000001
r9226 n5194 n5301 0.625
r9227 n5300 n5301 0.050000000000000003
r9228 n5195 n5302 0.15625
r9229 n5301 n5302 0.125
r9230 n5196 n5303 0.056818181818181816
r9231 n5302 n5303 0.375
r9232 n5197 n5304 1.25
r9233 n5303 n5304 0.28749999999999998
r9234 n5198 n5305 1.25
r9235 n5304 n5305 0.025000000000000001
r9236 n5199 n5306 1.25
r9237 n5305 n5306 0.025000000000000001
r9238 n5200 n5307 0.125
r9239 n5306 n5307 0.13750000000000001
r9240 n5201 n5308 0.10416666666666667
r9241 n5307 n5308 0.27500000000000002
r9242 n5202 n5309 0.15625
r9243 n5308 n5309 0.25
r9244 n5203 n5310 0.625
r9245 n5309 n5310 0.125
r9246 n5204 n5311 0.41666666666666669
r9247 n5310 n5311 0.0625
r9248 n5205 n5312 0.625
r9249 n5311 n5312 0.0625
r9250 n5206 n5313 0.20833333333333334
r9251 n5312 n5313 0.10000000000000001
r9252 n5207 n5314 0.10416666666666667
r9253 n5313 n5314 0.22500000000000001
r9254 n5208 n5315 0.089285714285714288
r9255 n5314 n5315 0.32500000000000001
r9256 n5209 n5316 0.625
r9257 n5315 n5316 0.20000000000000001
r9258 n5210 n5317 0.034722222222222224
r9259 n5316 n5317 0.47499999999999998
r9260 n5211 n5318 0.625
r9261 n5317 n5318 0.47499999999999998
r9262 n5212 n5319 0.0390625
r9263 n5318 n5319 0.42499999999999999
r9264 n5213 n5320 0.625
r9265 n5319 n5320 0.42499999999999999
r9266 n5214 n5321 0.034722222222222224
r9267 n5320 n5321 0.47499999999999998
r9268 n5215 n5322 0.625
r9269 n5321 n5322 0.47499999999999998
r9270 n5216 n5323 0.0390625
r9271 n5322 n5323 0.42499999999999999
r9272 n5217 n5324 0.625
r9273 n5323 n5324 0.42499999999999999
r9274 n5218 n5325 0.034722222222222224
r9275 n5324 n5325 0.47499999999999998
r9276 n5219 n5326 0.625
r9277 n5325 n5326 0.47499999999999998
r9278 n5220 n5327 0.0390625
r9279 n5326 n5327 0.42499999999999999
r9280 n5221 n5328 0.625
r9281 n5327 n5328 0.42499999999999999
r9282 n5222 n5329 0.034722222222222224
r9283 n5328 n5329 0.47499999999999998
r9284 n5223 n5330 0.625
r9285 n5329 n5330 0.47499999999999998
r9286 n5224 n5331 0.0390625
r9287 n5330 n5331 0.42499999999999999
r9288 n5225 n5332 0.625
r9289 n5331 n5332 0.42499999999999999
r9290 n5226 n5333 0.034722222222222224
r9291 n5332 n5333 0.47499999999999998
r9292 n5227 n5334 0.625
r9293 n5333 n5334 0.47499999999999998
r9294 n5228 n5335 0.0390625
r9295 n5334 n5335 0.42499999999999999
r9296 n5229 n5336 0.625
r9297 n5335 n5336 0.42499999999999999
r9298 n5230 n5337 0.034722222222222224
r9299 n5336 n5337 0.47499999999999998
r9300 n5231 n5338 0.625
r9301 n5337 n5338 0.47499999999999998
r9302 n5232 n5339 0.0390625
r9303 n5338 n5339 0.42499999999999999
r9304 n5233 n5340 0.625
r9305 n5339 n5340 0.42499999999999999
r9306 n5234 n5341 0.034722222222222224
r9307 n5340 n5341 0.47499999999999998
r9308 n5235 n5342 0.625
r9309 n5341 n5342 0.47499999999999998
r9310 n5236 n5343 0.0390625
r9311 n5342 n5343 0.42499999999999999
r9312 n5237 n5344 0.625
r9313 n5343 n5344 0.42499999999999999
r9314 n5238 n5345 0.10416666666666667
r9315 n5344 n5345 0.17499999999999999
r9316 n5239 n5346 0.043749999999999997
r9317 n5240 n5347 0.21875
r9318 n5346 n5347 0.375
r9319 n5241 n5348 0.013671875
r9320 n5347 n5348 1.0625
r9321 n5242 n5349 0.21875
r9322 n5348 n5349 1.0625
r9323 n5243 n5350 0.012152777777777778
r9324 n5349 n5350 1.1875
r9325 n5244 n5351 0.21875
r9326 n5350 n5351 1.1875
r9327 n5245 n5352 0.033653846153846152
r9328 n5351 n5352 0.46875
r9329 n5246 n5353 0.036458333333333336
r9330 n5352 n5353 0.78125
r9331 n5247 n5354 0.0625
r9332 n5353 n5354 0.59375
r9333 n5248 n5355 0.21875
r9334 n5354 n5355 0.28125
r9335 n5249 n5356 0.109375
r9336 n5355 n5356 0.1875
r9337 n5250 n5357 0.048611111111111112
r9338 n5356 n5357 0.40625
r9339 n5251 n5358 0.020833333333333332
r9340 n5357 n5358 0.9375
r9341 n5252 n5359 0.21875
r9342 n5358 n5359 0.71875
r9343 n5253 n5360 0.21875
r9344 n5359 n5360 0.125
r9345 n5254 n5361 0.048611111111111112
r9346 n5360 n5361 0.34375
r9347 n5255 n5362 0.036458333333333336
r9348 n5361 n5362 0.65625
r9349 n5256 n5363 0.048611111111111112
r9350 n5362 n5363 0.65625
r9351 n5257 n5364 0.21875
r9352 n5363 n5364 0.34375
r9353 n5258 n5365 0.21875
r9354 n5364 n5365 0.125
r9355 n5259 n5366 0.020833333333333332
r9356 n5365 n5366 0.71875
r9357 n5260 n5367 0.029166666666666667
r9358 n5366 n5367 1.125
r9359 n5261 n5368 0.21875
r9360 n5367 n5368 0.53125
r9361 n5262 n5369 0.013671875
r9362 n5368 n5369 1.0625
r9363 n5263 n5370 0.21875
r9364 n5369 n5370 1.0625
r9365 n5264 n5371 0.036458333333333336
r9366 n5370 n5371 0.4375
r9367 n5265 n5372 0.043749999999999997
r9368 n5266 n5373 0.21875
r9369 n5372 n5373 0.375
r9370 n5267 n5374 0.013671875
r9371 n5373 n5374 1.0625
r9372 n5268 n5375 0.21875
r9373 n5374 n5375 1.0625
r9374 n5269 n5376 0.012152777777777778
r9375 n5375 n5376 1.1875
r9376 n5270 n5377 0.21875
r9377 n5376 n5377 1.1875
r9378 n5271 n5378 0.013671875
r9379 n5377 n5378 1.0625
r9380 n5272 n5379 0.21875
r9381 n5378 n5379 1.0625
r9382 n5273 n5380 0.012152777777777778
r9383 n5379 n5380 1.1875
r9384 n5274 n5381 0.21875
r9385 n5380 n5381 1.1875
r9386 n5275 n5382 0.013671875
r9387 n5381 n5382 1.0625
r9388 n5276 n5383 0.21875
r9389 n5382 n5383 1.0625
r9390 n5277 n5384 0.012152777777777778
r9391 n5383 n5384 1.1875
r9392 n5278 n5385 0.21875
r9393 n5384 n5385 1.1875
r9394 n5279 n5386 0.013671875
r9395 n5385 n5386 1.0625
r9396 n5280 n5387 0.21875
r9397 n5386 n5387 1.0625
r9398 n5281 n5388 0.012152777777777778
r9399 n5387 n5388 1.1875
r9400 n5282 n5389 0.21875
r9401 n5388 n5389 1.1875
r9402 n5283 n5390 0.013671875
r9403 n5389 n5390 1.0625
r9404 n5284 n5391 0.21875
r9405 n5390 n5391 1.0625
r9406 n5285 n5392 0.012152777777777778
r9407 n5391 n5392 1.1875
r9408 n5286 n5393 0.21875
r9409 n5392 n5393 1.1875
r9410 n5287 n5394 0.013671875
r9411 n5393 n5394 1.0625
r9412 n5288 n5395 0.21875
r9413 n5394 n5395 1.0625
r9414 n5289 n5396 0.012152777777777778
r9415 n5395 n5396 1.1875
r9416 n5290 n5397 0.21875
r9417 n5396 n5397 1.1875
r9418 n5291 n5398 0.013671875
r9419 n5397 n5398 1.0625
r9420 n5292 n5399 0.21875
r9421 n5398 n5399 1.0625
r9422 n5293 n5400 0.012152777777777778
r9423 n5399 n5400 1.1875
r9424 n5294 n5401 0.21875
r9425 n5400 n5401 1.1875
r9426 n5295 n5402 0.013671875
r9427 n5401 n5402 1.0625
r9428 n5296 n5403 0.21875
r9429 n5402 n5403 1.0625
r9430 n5297 n5404 0.029166666666666667
r9431 n5403 n5404 0.53125
r9432 n5298 n5405 0.036458333333333336
r9433 n5404 n5405 0.84375
r9434 n5299 n5406 0.048611111111111112
r9435 n5405 n5406 0.65625
r9436 n5300 n5407 0.21875
r9437 n5406 n5407 0.34375
r9438 n5301 n5408 0.21875
r9439 n5407 n5408 0.125
r9440 n5302 n5409 0.0546875
r9441 n5408 n5409 0.3125
r9442 n5303 n5410 0.019886363636363636
r9443 n5409 n5410 0.9375
r9444 n5304 n5411 0.4375
r9445 n5410 n5411 0.71875
r9446 n5305 n5412 0.4375
r9447 n5411 n5412 0.0625
r9448 n5306 n5413 0.4375
r9449 n5412 n5413 0.0625
r9450 n5307 n5414 0.043749999999999997
r9451 n5413 n5414 0.34375
r9452 n5308 n5415 0.036458333333333336
r9453 n5414 n5415 0.6875
r9454 n5309 n5416 0.0546875
r9455 n5415 n5416 0.625
r9456 n5310 n5417 0.21875
r9457 n5416 n5417 0.3125
r9458 n5311 n5418 0.14583333333333334
r9459 n5417 n5418 0.15625
r9460 n5312 n5419 0.21875
r9461 n5418 n5419 0.15625
r9462 n5313 n5420 0.072916666666666671
r9463 n5419 n5420 0.25
r9464 n5314 n5421 0.036458333333333336
r9465 n5420 n5421 0.5625
r9466 n5315 n5422 0.03125
r9467 n5421 n5422 0.8125
r9468 n5316 n5423 0.21875
r9469 n5422 n5423 0.5
r9470 n5317 n5424 0.012152777777777778
r9471 n5423 n5424 1.1875
r9472 n5318 n5425 0.21875
r9473 n5424 n5425 1.1875
r9474 n5319 n5426 0.013671875
r9475 n5425 n5426 1.0625
r9476 n5320 n5427 0.21875
r9477 n5426 n5427 1.0625
r9478 n5321 n5428 0.012152777777777778
r9479 n5427 n5428 1.1875
r9480 n5322 n5429 0.21875
r9481 n5428 n5429 1.1875
r9482 n5323 n5430 0.013671875
r9483 n5429 n5430 1.0625
r9484 n5324 n5431 0.21875
r9485 n5430 n5431 1.0625
r9486 n5325 n5432 0.012152777777777778
r9487 n5431 n5432 1.1875
r9488 n5326 n5433 0.21875
r9489 n5432 n5433 1.1875
r9490 n5327 n5434 0.013671875
r9491 n5433 n5434 1.0625
r9492 n5328 n5435 0.21875
r9493 n5434 n5435 1.0625
r9494 n5329 n5436 0.012152777777777778
r9495 n5435 n5436 1.1875
r9496 n5330 n5437 0.21875
r9497 n5436 n5437 1.1875
r9498 n5331 n5438 0.013671875
r9499 n5437 n5438 1.0625
r9500 n5332 n5439 0.21875
r9501 n5438 n5439 1.0625
r9502 n5333 n5440 0.012152777777777778
r9503 n5439 n5440 1.1875
r9504 n5334 n5441 0.21875
r9505 n5440 n5441 1.1875
r9506 n5335 n5442 0.013671875
r9507 n5441 n5442 1.0625
r9508 n5336 n5443 0.21875
r9509 n5442 n5443 1.0625
r9510 n5337 n5444 0.012152777777777778
r9511 n5443 n5444 1.1875
r9512 n5338 n5445 0.21875
r9513 n5444 n5445 1.1875
r9514 n5339 n5446 0.013671875
r9515 n5445 n5446 1.0625
r9516 n5340 n5447 0.21875
r9517 n5446 n5447 1.0625
r9518 n5341 n5448 0.012152777777777778
r9519 n5447 n5448 1.1875
r9520 n5342 n5449 0.21875
r9521 n5448 n5449 1.1875
r9522 n5343 n5450 0.013671875
r9523 n5449 n5450 1.0625
r9524 n5344 n5451 0.21875
r9525 n5450 n5451 1.0625
r9526 n5345 n5452 0.036458333333333336
r9527 n5451 n5452 0.4375
r9528 n5346 n5453 0.050000000000000003
r9529 n5347 n5454 0.25
r9530 n5453 n5454 0.125
r9531 n5348 n5455 0.015625
r9532 n5454 n5455 0.35416666666666669
r9533 n5349 n5456 0.25
r9534 n5455 n5456 0.35416666666666669
r9535 n5350 n5457 0.013888888888888888
r9536 n5456 n5457 0.39583333333333331
r9537 n5351 n5458 0.25
r9538 n5457 n5458 0.39583333333333331
r9539 n5352 n5459 0.038461538461538464
r9540 n5458 n5459 0.15625
r9541 n5353 n5460 0.041666666666666664
r9542 n5459 n5460 0.26041666666666669
r9543 n5354 n5461 0.071428571428571425
r9544 n5460 n5461 0.19791666666666666
r9545 n5355 n5462 0.25
r9546 n5461 n5462 0.09375
r9547 n5356 n5463 0.125
r9548 n5462 n5463 0.0625
r9549 n5357 n5464 0.055555555555555552
r9550 n5463 n5464 0.13541666666666666
r9551 n5358 n5465 0.023809523809523808
r9552 n5464 n5465 0.3125
r9553 n5359 n5466 0.25
r9554 n5465 n5466 0.23958333333333334
r9555 n5360 n5467 0.25
r9556 n5466 n5467 0.041666666666666664
r9557 n5361 n5468 0.055555555555555552
r9558 n5467 n5468 0.11458333333333333
r9559 n5362 n5469 0.041666666666666664
r9560 n5468 n5469 0.21875
r9561 n5363 n5470 0.055555555555555552
r9562 n5469 n5470 0.21875
r9563 n5364 n5471 0.25
r9564 n5470 n5471 0.11458333333333333
r9565 n5365 n5472 0.25
r9566 n5471 n5472 0.041666666666666664
r9567 n5366 n5473 0.023809523809523808
r9568 n5472 n5473 0.23958333333333334
r9569 n5367 n5474 0.033333333333333333
r9570 n5473 n5474 0.375
r9571 n5368 n5475 0.25
r9572 n5474 n5475 0.17708333333333334
r9573 n5369 n5476 0.015625
r9574 n5475 n5476 0.35416666666666669
r9575 n5370 n5477 0.25
r9576 n5476 n5477 0.35416666666666669
r9577 n5371 n5478 0.041666666666666664
r9578 n5477 n5478 0.14583333333333334
r9579 n5372 n5479 0.050000000000000003
r9580 n5373 n5480 0.25
r9581 n5479 n5480 0.125
r9582 n5374 n5481 0.015625
r9583 n5480 n5481 0.35416666666666669
r9584 n5375 n5482 0.25
r9585 n5481 n5482 0.35416666666666669
r9586 n5376 n5483 0.013888888888888888
r9587 n5482 n5483 0.39583333333333331
r9588 n5377 n5484 0.25
r9589 n5483 n5484 0.39583333333333331
r9590 n5378 n5485 0.015625
r9591 n5484 n5485 0.35416666666666669
r9592 n5379 n5486 0.25
r9593 n5485 n5486 0.35416666666666669
r9594 n5380 n5487 0.013888888888888888
r9595 n5486 n5487 0.39583333333333331
r9596 n5381 n5488 0.25
r9597 n5487 n5488 0.39583333333333331
r9598 n5382 n5489 0.015625
r9599 n5488 n5489 0.35416666666666669
r9600 n5383 n5490 0.25
r9601 n5489 n5490 0.35416666666666669
r9602 n5384 n5491 0.013888888888888888
r9603 n5490 n5491 0.39583333333333331
r9604 n5385 n5492 0.25
r9605 n5491 n5492 0.39583333333333331
r9606 n5386 n5493 0.015625
r9607 n5492 n5493 0.35416666666666669
r9608 n5387 n5494 0.25
r9609 n5493 n5494 0.35416666666666669
r9610 n5388 n5495 0.013888888888888888
r9611 n5494 n5495 0.39583333333333331
r9612 n5389 n5496 0.25
r9613 n5495 n5496 0.39583333333333331
r9614 n5390 n5497 0.015625
r9615 n5496 n5497 0.35416666666666669
r9616 n5391 n5498 0.25
r9617 n5497 n5498 0.35416666666666669
r9618 n5392 n5499 0.013888888888888888
r9619 n5498 n5499 0.39583333333333331
r9620 n5393 n5500 0.25
r9621 n5499 n5500 0.39583333333333331
r9622 n5394 n5501 0.015625
r9623 n5500 n5501 0.35416666666666669
r9624 n5395 n5502 0.25
r9625 n5501 n5502 0.35416666666666669
r9626 n5396 n5503 0.013888888888888888
r9627 n5502 n5503 0.39583333333333331
r9628 n5397 n5504 0.25
r9629 n5503 n5504 0.39583333333333331
r9630 n5398 n5505 0.015625
r9631 n5504 n5505 0.35416666666666669
r9632 n5399 n5506 0.25
r9633 n5505 n5506 0.35416666666666669
r9634 n5400 n5507 0.013888888888888888
r9635 n5506 n5507 0.39583333333333331
r9636 n5401 n5508 0.25
r9637 n5507 n5508 0.39583333333333331
r9638 n5402 n5509 0.015625
r9639 n5508 n5509 0.35416666666666669
r9640 n5403 n5510 0.25
r9641 n5509 n5510 0.35416666666666669
r9642 n5404 n5511 0.033333333333333333
r9643 n5510 n5511 0.17708333333333334
r9644 n5405 n5512 0.041666666666666664
r9645 n5511 n5512 0.28125
r9646 n5406 n5513 0.055555555555555552
r9647 n5512 n5513 0.21875
r9648 n5407 n5514 0.25
r9649 n5513 n5514 0.11458333333333333
r9650 n5408 n5515 0.25
r9651 n5514 n5515 0.041666666666666664
r9652 n5409 n5516 0.0625
r9653 n5515 n5516 0.10416666666666667
r9654 n5410 n5517 0.022727272727272728
r9655 n5516 n5517 0.3125
r9656 n5411 n5518 0.5
r9657 n5517 n5518 0.23958333333333334
r9658 n5412 n5519 0.5
r9659 n5518 n5519 0.020833333333333332
r9660 n5413 n5520 0.5
r9661 n5519 n5520 0.020833333333333332
r9662 n5414 n5521 0.050000000000000003
r9663 n5520 n5521 0.11458333333333333
r9664 n5415 n5522 0.041666666666666664
r9665 n5521 n5522 0.22916666666666666
r9666 n5416 n5523 0.0625
r9667 n5522 n5523 0.20833333333333334
r9668 n5417 n5524 0.25
r9669 n5523 n5524 0.10416666666666667
r9670 n5418 n5525 0.16666666666666666
r9671 n5524 n5525 0.052083333333333336
r9672 n5419 n5526 0.25
r9673 n5525 n5526 0.052083333333333336
r9674 n5420 n5527 0.083333333333333329
r9675 n5526 n5527 0.083333333333333329
r9676 n5421 n5528 0.041666666666666664
r9677 n5527 n5528 0.1875
r9678 n5422 n5529 0.035714285714285712
r9679 n5528 n5529 0.27083333333333331
r9680 n5423 n5530 0.25
r9681 n5529 n5530 0.16666666666666666
r9682 n5424 n5531 0.013888888888888888
r9683 n5530 n5531 0.39583333333333331
r9684 n5425 n5532 0.25
r9685 n5531 n5532 0.39583333333333331
r9686 n5426 n5533 0.015625
r9687 n5532 n5533 0.35416666666666669
r9688 n5427 n5534 0.25
r9689 n5533 n5534 0.35416666666666669
r9690 n5428 n5535 0.013888888888888888
r9691 n5534 n5535 0.39583333333333331
r9692 n5429 n5536 0.25
r9693 n5535 n5536 0.39583333333333331
r9694 n5430 n5537 0.015625
r9695 n5536 n5537 0.35416666666666669
r9696 n5431 n5538 0.25
r9697 n5537 n5538 0.35416666666666669
r9698 n5432 n5539 0.013888888888888888
r9699 n5538 n5539 0.39583333333333331
r9700 n5433 n5540 0.25
r9701 n5539 n5540 0.39583333333333331
r9702 n5434 n5541 0.015625
r9703 n5540 n5541 0.35416666666666669
r9704 n5435 n5542 0.25
r9705 n5541 n5542 0.35416666666666669
r9706 n5436 n5543 0.013888888888888888
r9707 n5542 n5543 0.39583333333333331
r9708 n5437 n5544 0.25
r9709 n5543 n5544 0.39583333333333331
r9710 n5438 n5545 0.015625
r9711 n5544 n5545 0.35416666666666669
r9712 n5439 n5546 0.25
r9713 n5545 n5546 0.35416666666666669
r9714 n5440 n5547 0.013888888888888888
r9715 n5546 n5547 0.39583333333333331
r9716 n5441 n5548 0.25
r9717 n5547 n5548 0.39583333333333331
r9718 n5442 n5549 0.015625
r9719 n5548 n5549 0.35416666666666669
r9720 n5443 n5550 0.25
r9721 n5549 n5550 0.35416666666666669
r9722 n5444 n5551 0.013888888888888888
r9723 n5550 n5551 0.39583333333333331
r9724 n5445 n5552 0.25
r9725 n5551 n5552 0.39583333333333331
r9726 n5446 n5553 0.015625
r9727 n5552 n5553 0.35416666666666669
r9728 n5447 n5554 0.25
r9729 n5553 n5554 0.35416666666666669
r9730 n5448 n5555 0.013888888888888888
r9731 n5554 n5555 0.39583333333333331
r9732 n5449 n5556 0.25
r9733 n5555 n5556 0.39583333333333331
r9734 n5450 n5557 0.015625
r9735 n5556 n5557 0.35416666666666669
r9736 n5451 n5558 0.25
r9737 n5557 n5558 0.35416666666666669
r9738 n5452 n5559 0.041666666666666664
r9739 n5558 n5559 0.14583333333333334
r9740 n5460 n5560 0.067708333333333329
r9741 n5461 n5561 0.11607142857142858
r9742 n5560 n5561 0.16964285714285715
r9743 n5462 n5562 0.40625
r9744 n5561 n5562 0.080357142857142863
r9745 n5463 n5563 0.203125
r9746 n5562 n5563 0.053571428571428568
r9747 n5464 n5564 0.090277777777777776
r9748 n5563 n5564 0.11607142857142858
r9749 n5465 n5565 0.038690476190476192
r9750 n5564 n5565 0.26785714285714285
r9751 n5466 n5566 0.40625
r9752 n5565 n5566 0.20535714285714285
r9753 n5467 n5567 0.40625
r9754 n5566 n5567 0.035714285714285712
r9755 n5468 n5568 0.090277777777777776
r9756 n5567 n5568 0.098214285714285712
r9757 n5469 n5569 0.067708333333333329
r9758 n5568 n5569 0.1875
r9759 n5512 n5570 0.067708333333333329
r9760 n5513 n5571 0.090277777777777776
r9761 n5570 n5571 0.1875
r9762 n5514 n5572 0.40625
r9763 n5571 n5572 0.098214285714285712
r9764 n5515 n5573 0.40625
r9765 n5572 n5573 0.035714285714285712
r9766 n5516 n5574 0.1015625
r9767 n5573 n5574 0.089285714285714288
r9768 n5517 n5575 0.036931818181818184
r9769 n5574 n5575 0.26785714285714285
r9770 n5518 n5576 0.8125
r9771 n5575 n5576 0.20535714285714285
r9772 n5519 n5577 0.8125
r9773 n5576 n5577 0.017857142857142856
r9774 n5520 n5578 0.8125
r9775 n5577 n5578 0.017857142857142856
r9776 n5521 n5579 0.081250000000000003
r9777 n5578 n5579 0.098214285714285712
r9778 n5522 n5580 0.067708333333333329
r9779 n5579 n5580 0.19642857142857142
r9780 n5581 n5582 0.027777777777777776
r9781 n5582 n5583 0.04583333333333333
r9782 n5583 n5584 0.034722222222222224
r9783 n5584 n5585 0.044444444444444446
r9784 n5585 n5586 0.044444444444444446
r9785 n5586 n5587 0.034722222222222224
r9786 n5587 n5588 0.04583333333333333
r9787 n5588 n5589 0.027777777777777776
r9788 n5590 n5591 0.027777777777777776
r9789 n5591 n5592 0.04583333333333333
r9790 n5592 n5593 0.034722222222222224
r9791 n5593 n5594 0.044444444444444446
r9792 n5594 n5595 0.044444444444444446
r9793 n5595 n5596 0.034722222222222224
r9794 n5596 n5597 0.04583333333333333
r9795 n5597 n5598 0.027777777777777776
r9796 n5581 n5599 0.46875
r9797 n5582 n5600 0.46875
r9798 n5599 n5600 0.041666666666666664
r9799 n5583 n5601 0.20380434782608695
r9800 n5600 n5601 0.068750000000000006
r9801 n5584 n5602 2.34375
r9802 n5601 n5602 0.052083333333333336
r9803 n5585 n5603 0.15625
r9804 n5602 n5603 0.066666666666666666
r9805 n5586 n5604 2.34375
r9806 n5603 n5604 0.066666666666666666
r9807 n5587 n5605 0.20380434782608695
r9808 n5604 n5605 0.052083333333333336
r9809 n5588 n5606 0.46875
r9810 n5605 n5606 0.068750000000000006
r9811 n5589 n5607 0.46875
r9812 n5606 n5607 0.041666666666666664
r9813 n5590 n5608 0.46875
r9814 n5591 n5609 0.46875
r9815 n5608 n5609 0.041666666666666664
r9816 n5592 n5610 0.20380434782608695
r9817 n5609 n5610 0.068750000000000006
r9818 n5593 n5611 2.34375
r9819 n5610 n5611 0.052083333333333336
r9820 n5594 n5612 0.15625
r9821 n5611 n5612 0.066666666666666666
r9822 n5595 n5613 2.34375
r9823 n5612 n5613 0.066666666666666666
r9824 n5596 n5614 0.20380434782608695
r9825 n5613 n5614 0.052083333333333336
r9826 n5597 n5615 0.46875
r9827 n5614 n5615 0.068750000000000006
r9828 n5598 n5616 0.46875
r9829 n5615 n5616 0.041666666666666664
r9830 n5599 n5617 0.34375
r9831 n5600 n5618 0.34375
r9832 n5617 n5618 0.050000000000000003
r9833 n5601 n5619 0.14945652173913043
r9834 n5618 n5619 0.082500000000000004
r9835 n5602 n5620 1.71875
r9836 n5619 n5620 0.0625
r9837 n5603 n5621 0.11458333333333333
r9838 n5620 n5621 0.080000000000000002
r9839 n5604 n5622 1.71875
r9840 n5621 n5622 0.080000000000000002
r9841 n5605 n5623 0.14945652173913043
r9842 n5622 n5623 0.0625
r9843 n5606 n5624 0.34375
r9844 n5623 n5624 0.082500000000000004
r9845 n5607 n5625 0.34375
r9846 n5624 n5625 0.050000000000000003
r9847 n5608 n5626 0.34375
r9848 n5609 n5627 0.34375
r9849 n5626 n5627 0.050000000000000003
r9850 n5610 n5628 0.14945652173913043
r9851 n5627 n5628 0.082500000000000004
r9852 n5611 n5629 1.71875
r9853 n5628 n5629 0.0625
r9854 n5612 n5630 0.11458333333333333
r9855 n5629 n5630 0.080000000000000002
r9856 n5613 n5631 1.71875
r9857 n5630 n5631 0.080000000000000002
r9858 n5614 n5632 0.14945652173913043
r9859 n5631 n5632 0.0625
r9860 n5615 n5633 0.34375
r9861 n5632 n5633 0.082500000000000004
r9862 n5616 n5634 0.34375
r9863 n5633 n5634 0.050000000000000003
r9864 n5617 n5635 0.28125
r9865 n5618 n5636 0.28125
r9866 n5635 n5636 0.0625
r9867 n5619 n5637 0.12228260869565218
r9868 n5636 n5637 0.10312499999999999
r9869 n5620 n5638 1.40625
r9870 n5637 n5638 0.078125
r9871 n5621 n5639 0.09375
r9872 n5638 n5639 0.10000000000000001
r9873 n5622 n5640 1.40625
r9874 n5639 n5640 0.10000000000000001
r9875 n5623 n5641 0.12228260869565218
r9876 n5640 n5641 0.078125
r9877 n5624 n5642 0.28125
r9878 n5641 n5642 0.10312499999999999
r9879 n5625 n5643 0.28125
r9880 n5642 n5643 0.0625
r9881 n5626 n5644 0.28125
r9882 n5627 n5645 0.28125
r9883 n5644 n5645 0.0625
r9884 n5628 n5646 0.12228260869565218
r9885 n5645 n5646 0.10312499999999999
r9886 n5629 n5647 1.40625
r9887 n5646 n5647 0.078125
r9888 n5630 n5648 0.09375
r9889 n5647 n5648 0.10000000000000001
r9890 n5631 n5649 1.40625
r9891 n5648 n5649 0.10000000000000001
r9892 n5632 n5650 0.12228260869565218
r9893 n5649 n5650 0.078125
r9894 n5633 n5651 0.28125
r9895 n5650 n5651 0.10312499999999999
r9896 n5634 n5652 0.28125
r9897 n5651 n5652 0.0625
r9898 n5636 n5653 0.34375
r9899 n5637 n5654 0.14945652173913043
r9900 n5653 n5654 0.058928571428571427
r9901 n5638 n5655 1.71875
r9902 n5654 n5655 0.044642857142857144
r9903 n5639 n5656 0.11458333333333333
r9904 n5655 n5656 0.057142857142857141
r9905 n5640 n5657 1.71875
r9906 n5656 n5657 0.057142857142857141
r9907 n5641 n5658 0.14945652173913043
r9908 n5657 n5658 0.044642857142857144
r9909 n5642 n5659 0.34375
r9910 n5658 n5659 0.058928571428571427
r9911 n5645 n5660 0.34375
r9912 n5646 n5661 0.14945652173913043
r9913 n5660 n5661 0.058928571428571427
r9914 n5647 n5662 1.71875
r9915 n5661 n5662 0.044642857142857144
r9916 n5648 n5663 0.11458333333333333
r9917 n5662 n5663 0.057142857142857141
r9918 n5649 n5664 1.71875
r9919 n5663 n5664 0.057142857142857141
r9920 n5650 n5665 0.14945652173913043
r9921 n5664 n5665 0.044642857142857144
r9922 n5651 n5666 0.34375
r9923 n5665 n5666 0.058928571428571427
r9924 n5653 n5667 0.4375
r9925 n5654 n5668 0.19021739130434784
r9926 n5667 n5668 0.058928571428571427
r9927 n5655 n5669 2.1875
r9928 n5668 n5669 0.044642857142857144
r9929 n5656 n5670 0.14583333333333334
r9930 n5669 n5670 0.057142857142857141
r9931 n5657 n5671 2.1875
r9932 n5670 n5671 0.057142857142857141
r9933 n5658 n5672 0.19021739130434784
r9934 n5671 n5672 0.044642857142857144
r9935 n5659 n5673 0.4375
r9936 n5672 n5673 0.058928571428571427
r9937 n5660 n5674 0.4375
r9938 n5661 n5675 0.19021739130434784
r9939 n5674 n5675 0.058928571428571427
r9940 n5662 n5676 2.1875
r9941 n5675 n5676 0.044642857142857144
r9942 n5663 n5677 0.14583333333333334
r9943 n5676 n5677 0.057142857142857141
r9944 n5664 n5678 2.1875
r9945 n5677 n5678 0.057142857142857141
r9946 n5665 n5679 0.19021739130434784
r9947 n5678 n5679 0.044642857142857144
r9948 n5666 n5680 0.4375
r9949 n5679 n5680 0.058928571428571427
r9950 n5667 n5681 0.40625
r9951 n5668 n5682 0.1766304347826087
r9952 n5681 n5682 0.068750000000000006
r9953 n5669 n5683 2.03125
r9954 n5682 n5683 0.052083333333333336
r9955 n5670 n5684 0.13541666666666666
r9956 n5683 n5684 0.066666666666666666
r9957 n5671 n5685 2.03125
r9958 n5684 n5685 0.066666666666666666
r9959 n5672 n5686 0.1766304347826087
r9960 n5685 n5686 0.052083333333333336
r9961 n5673 n5687 0.40625
r9962 n5686 n5687 0.068750000000000006
r9963 n5674 n5688 0.40625
r9964 n5675 n5689 0.1766304347826087
r9965 n5688 n5689 0.068750000000000006
r9966 n5676 n5690 2.03125
r9967 n5689 n5690 0.052083333333333336
r9968 n5677 n5691 0.13541666666666666
r9969 n5690 n5691 0.066666666666666666
r9970 n5678 n5692 2.03125
r9971 n5691 n5692 0.066666666666666666
r9972 n5679 n5693 0.1766304347826087
r9973 n5692 n5693 0.052083333333333336
r9974 n5680 n5694 0.40625
r9975 n5693 n5694 0.068750000000000006
r9976 n5681 n5695 0.375
r9977 n5682 n5696 0.16304347826086957
r9978 n5695 n5696 0.068750000000000006
r9979 n5683 n5697 1.875
r9980 n5696 n5697 0.052083333333333336
r9981 n5684 n5698 0.125
r9982 n5697 n5698 0.066666666666666666
r9983 n5685 n5699 1.875
r9984 n5698 n5699 0.066666666666666666
r9985 n5686 n5700 0.16304347826086957
r9986 n5699 n5700 0.052083333333333336
r9987 n5687 n5701 0.375
r9988 n5700 n5701 0.068750000000000006
r9989 n5688 n5702 0.375
r9990 n5689 n5703 0.16304347826086957
r9991 n5702 n5703 0.068750000000000006
r9992 n5690 n5704 1.875
r9993 n5703 n5704 0.052083333333333336
r9994 n5691 n5705 0.125
r9995 n5704 n5705 0.066666666666666666
r9996 n5692 n5706 1.875
r9997 n5705 n5706 0.066666666666666666
r9998 n5693 n5707 0.16304347826086957
r9999 n5706 n5707 0.052083333333333336
r10000 n5694 n5708 0.375
r10001 n5707 n5708 0.068750000000000006
r10002 n5695 n5709 0.41249999999999998
r10003 n5696 n5710 0.17934782608695651
r10004 n5709 n5710 0.057291666666666664
r10005 n5697 n5711 2.0625
r10006 n5710 n5711 0.043402777777777776
r10007 n5698 n5712 0.13750000000000001
r10008 n5711 n5712 0.055555555555555552
r10009 n5699 n5713 2.0625
r10010 n5712 n5713 0.055555555555555552
r10011 n5700 n5714 0.17934782608695651
r10012 n5713 n5714 0.043402777777777776
r10013 n5701 n5715 0.41249999999999998
r10014 n5714 n5715 0.057291666666666664
r10015 n5702 n5716 0.41249999999999998
r10016 n5703 n5717 0.17934782608695651
r10017 n5716 n5717 0.057291666666666664
r10018 n5704 n5718 2.0625
r10019 n5717 n5718 0.043402777777777776
r10020 n5705 n5719 0.13750000000000001
r10021 n5718 n5719 0.055555555555555552
r10022 n5706 n5720 2.0625
r10023 n5719 n5720 0.055555555555555552
r10024 n5707 n5721 0.17934782608695651
r10025 n5720 n5721 0.043402777777777776
r10026 n5708 n5722 0.41249999999999998
r10027 n5721 n5722 0.057291666666666664
r10028 n5709 n5723 0.45000000000000001
r10029 n5710 n5724 0.19565217391304349
r10030 n5723 n5724 0.057291666666666664
r10031 n5711 n5725 2.25
r10032 n5724 n5725 0.043402777777777776
r10033 n5712 n5726 0.14999999999999999
r10034 n5725 n5726 0.055555555555555552
r10035 n5713 n5727 2.25
r10036 n5726 n5727 0.055555555555555552
r10037 n5714 n5728 0.19565217391304349
r10038 n5727 n5728 0.043402777777777776
r10039 n5715 n5729 0.45000000000000001
r10040 n5728 n5729 0.057291666666666664
r10041 n5716 n5730 0.45000000000000001
r10042 n5717 n5731 0.19565217391304349
r10043 n5730 n5731 0.057291666666666664
r10044 n5718 n5732 2.25
r10045 n5731 n5732 0.043402777777777776
r10046 n5719 n5733 0.14999999999999999
r10047 n5732 n5733 0.055555555555555552
r10048 n5720 n5734 2.25
r10049 n5733 n5734 0.055555555555555552
r10050 n5721 n5735 0.19565217391304349
r10051 n5734 n5735 0.043402777777777776
r10052 n5722 n5736 0.45000000000000001
r10053 n5735 n5736 0.057291666666666664
r10054 n5723 n5737 0.40000000000000002
r10055 n5724 n5738 0.17391304347826086
r10056 n5737 n5738 0.073660714285714288
r10057 n5725 n5739 2
r10058 n5738 n5739 0.055803571428571432
r10059 n5726 n5740 0.13333333333333333
r10060 n5739 n5740 0.071428571428571425
r10061 n5727 n5741 2
r10062 n5740 n5741 0.071428571428571425
r10063 n5728 n5742 0.17391304347826086
r10064 n5741 n5742 0.055803571428571432
r10065 n5729 n5743 0.40000000000000002
r10066 n5742 n5743 0.073660714285714288
r10067 n5744 n5745 0.024553571428571428
r10068 n5745 n5746 0.0089285714285714281
r10069 n5746 n5747 0.022321428571428572
r10070 n5747 n5748 0.066964285714285712
r10071 n5748 n5749 0.051339285714285712
r10072 n5749 n5750 0.004464285714285714
r10073 n5750 n5751 0.004464285714285714
r10074 n5751 n5752 0.024553571428571428
r10075 n5752 n5753 0.049107142857142856
r10076 n5753 n5754 0.044642857142857144
r10077 n5754 n5755 0.022321428571428572
r10078 n5755 n5756 0.011160714285714286
r10079 n5756 n5757 0.011160714285714286
r10080 n5757 n5758 0.017857142857142856
r10081 n5758 n5759 0.040178571428571432
r10082 n5759 n5760 0.058035714285714288
r10083 n5760 n5761 0.035714285714285712
r10084 n5761 n5762 0.084821428571428575
r10085 n5762 n5763 0.084821428571428575
r10086 n5763 n5764 0.075892857142857137
r10087 n5764 n5765 0.075892857142857137
r10088 n5765 n5766 0.084821428571428575
r10089 n5766 n5767 0.084821428571428575
r10090 n5767 n5768 0.075892857142857137
r10091 n5768 n5769 0.075892857142857137
r10092 n5769 n5770 0.084821428571428575
r10093 n5770 n5771 0.084821428571428575
r10094 n5771 n5772 0.075892857142857137
r10095 n5772 n5773 0.075892857142857137
r10096 n5773 n5774 0.084821428571428575
r10097 n5774 n5775 0.084821428571428575
r10098 n5775 n5776 0.075892857142857137
r10099 n5776 n5777 0.075892857142857137
r10100 n5777 n5778 0.084821428571428575
r10101 n5778 n5779 0.084821428571428575
r10102 n5779 n5780 0.075892857142857137
r10103 n5780 n5781 0.075892857142857137
r10104 n5781 n5782 0.084821428571428575
r10105 n5782 n5783 0.084821428571428575
r10106 n5783 n5784 0.075892857142857137
r10107 n5784 n5785 0.075892857142857137
r10108 n5785 n5786 0.084821428571428575
r10109 n5786 n5787 0.084821428571428575
r10110 n5787 n5788 0.075892857142857137
r10111 n5788 n5789 0.075892857142857137
r10112 n5789 n5790 0.03125
r10113 n5790 n5791 0.035714285714285712
r10114 n5791 n5792 0.053571428571428568
r10115 n5792 n5793 0.12053571428571429
r10116 n5793 n5794 0.080357142857142863
r10117 n5794 n5795 0.026785714285714284
r10118 n5795 n5796 0.037946428571428568
r10119 n5796 n5797 0.022321428571428572
r10120 n5797 n5798 0.013392857142857142
r10121 n5798 n5799 0.011160714285714286
r10122 n5799 n5800 0.029017857142857144
r10123 n5800 n5801 0.066964285714285712
r10124 n5801 n5802 0.046875
r10125 n5802 n5803 0.011160714285714286
r10126 n5803 n5804 0.013392857142857142
r10127 n5804 n5805 0.022321428571428572
r10128 n5805 n5806 0.037946428571428568
r10129 n5806 n5807 0.13169642857142858
r10130 n5807 n5808 0.18526785714285715
r10131 n5808 n5809 0.18705357142857143
r10132 n5809 n5810 0.22187499999999999
r10133 n5810 n5811 0.22187499999999999
r10134 n5811 n5812 0.22232142857142856
r10135 n5812 n5813 0.13348214285714285
r10136 n5730 n5814 0.40000000000000002
r10137 n5813 n5814 0.044642857142857144
r10138 n5731 n5815 0.17391304347826086
r10139 n5814 n5815 0.073660714285714288
r10140 n5732 n5816 2
r10141 n5815 n5816 0.055803571428571432
r10142 n5733 n5817 0.13333333333333333
r10143 n5816 n5817 0.071428571428571425
r10144 n5734 n5818 2
r10145 n5817 n5818 0.071428571428571425
r10146 n5735 n5819 0.17391304347826086
r10147 n5818 n5819 0.055803571428571432
r10148 n5736 n5820 0.40000000000000002
r10149 n5819 n5820 0.073660714285714288
r10150 n5737 n5821 0.34999999999999998
r10151 n5738 n5822 0.15217391304347827
r10152 n5821 n5822 0.073660714285714288
r10153 n5739 n5823 1.75
r10154 n5822 n5823 0.055803571428571432
r10155 n5740 n5824 0.11666666666666667
r10156 n5823 n5824 0.071428571428571425
r10157 n5741 n5825 1.75
r10158 n5824 n5825 0.071428571428571425
r10159 n5742 n5826 0.15217391304347827
r10160 n5825 n5826 0.055803571428571432
r10161 n5743 n5827 0.34999999999999998
r10162 n5826 n5827 0.073660714285714288
r10163 n5744 n5828 0.3888888888888889
r10164 n5745 n5829 1.75
r10165 n5828 n5829 0.024553571428571428
r10166 n5746 n5830 1.75
r10167 n5829 n5830 0.0089285714285714281
r10168 n5747 n5831 0.4375
r10169 n5830 n5831 0.022321428571428572
r10170 n5748 n5832 0.15909090909090909
r10171 n5831 n5832 0.066964285714285712
r10172 n5749 n5833 3.5
r10173 n5832 n5833 0.051339285714285712
r10174 n5750 n5834 3.5
r10175 n5833 n5834 0.004464285714285714
r10176 n5751 n5835 3.5
r10177 n5834 n5835 0.004464285714285714
r10178 n5752 n5836 0.34999999999999998
r10179 n5835 n5836 0.024553571428571428
r10180 n5753 n5837 0.29166666666666669
r10181 n5836 n5837 0.049107142857142856
r10182 n5754 n5838 0.4375
r10183 n5837 n5838 0.044642857142857144
r10184 n5755 n5839 1.75
r10185 n5838 n5839 0.022321428571428572
r10186 n5756 n5840 1.1666666666666667
r10187 n5839 n5840 0.011160714285714286
r10188 n5757 n5841 1.75
r10189 n5840 n5841 0.011160714285714286
r10190 n5758 n5842 0.58333333333333337
r10191 n5841 n5842 0.017857142857142856
r10192 n5759 n5843 0.29166666666666669
r10193 n5842 n5843 0.040178571428571432
r10194 n5760 n5844 0.25
r10195 n5843 n5844 0.058035714285714288
r10196 n5761 n5845 1.75
r10197 n5844 n5845 0.035714285714285712
r10198 n5762 n5846 0.097222222222222224
r10199 n5845 n5846 0.084821428571428575
r10200 n5763 n5847 1.75
r10201 n5846 n5847 0.084821428571428575
r10202 n5764 n5848 0.109375
r10203 n5847 n5848 0.075892857142857137
r10204 n5765 n5849 1.75
r10205 n5848 n5849 0.075892857142857137
r10206 n5766 n5850 0.097222222222222224
r10207 n5849 n5850 0.084821428571428575
r10208 n5767 n5851 1.75
r10209 n5850 n5851 0.084821428571428575
r10210 n5768 n5852 0.109375
r10211 n5851 n5852 0.075892857142857137
r10212 n5769 n5853 1.75
r10213 n5852 n5853 0.075892857142857137
r10214 n5770 n5854 0.097222222222222224
r10215 n5853 n5854 0.084821428571428575
r10216 n5771 n5855 1.75
r10217 n5854 n5855 0.084821428571428575
r10218 n5772 n5856 0.109375
r10219 n5855 n5856 0.075892857142857137
r10220 n5773 n5857 1.75
r10221 n5856 n5857 0.075892857142857137
r10222 n5774 n5858 0.097222222222222224
r10223 n5857 n5858 0.084821428571428575
r10224 n5775 n5859 1.75
r10225 n5858 n5859 0.084821428571428575
r10226 n5776 n5860 0.109375
r10227 n5859 n5860 0.075892857142857137
r10228 n5777 n5861 1.75
r10229 n5860 n5861 0.075892857142857137
r10230 n5778 n5862 0.097222222222222224
r10231 n5861 n5862 0.084821428571428575
r10232 n5779 n5863 1.75
r10233 n5862 n5863 0.084821428571428575
r10234 n5780 n5864 0.109375
r10235 n5863 n5864 0.075892857142857137
r10236 n5781 n5865 1.75
r10237 n5864 n5865 0.075892857142857137
r10238 n5782 n5866 0.097222222222222224
r10239 n5865 n5866 0.084821428571428575
r10240 n5783 n5867 1.75
r10241 n5866 n5867 0.084821428571428575
r10242 n5784 n5868 0.109375
r10243 n5867 n5868 0.075892857142857137
r10244 n5785 n5869 1.75
r10245 n5868 n5869 0.075892857142857137
r10246 n5786 n5870 0.097222222222222224
r10247 n5869 n5870 0.084821428571428575
r10248 n5787 n5871 1.75
r10249 n5870 n5871 0.084821428571428575
r10250 n5788 n5872 0.109375
r10251 n5871 n5872 0.075892857142857137
r10252 n5789 n5873 1.75
r10253 n5872 n5873 0.075892857142857137
r10254 n5790 n5874 0.29166666666666669
r10255 n5873 n5874 0.03125
r10256 n5791 n5875 0.875
r10257 n5874 n5875 0.035714285714285712
r10258 n5792 n5876 0.17499999999999999
r10259 n5875 n5876 0.053571428571428568
r10260 n5793 n5877 0.10294117647058823
r10261 n5876 n5877 0.12053571428571429
r10262 n5794 n5878 1.75
r10263 n5877 n5878 0.080357142857142863
r10264 n5795 n5879 0.34999999999999998
r10265 n5878 n5879 0.026785714285714284
r10266 n5796 n5880 0.5
r10267 n5879 n5880 0.037946428571428568
r10268 n5797 n5881 1.1666666666666667
r10269 n5880 n5881 0.022321428571428572
r10270 n5798 n5882 1.1666666666666667
r10271 n5881 n5882 0.013392857142857142
r10272 n5799 n5883 1.75
r10273 n5882 n5883 0.011160714285714286
r10274 n5800 n5884 0.31818181818181818
r10275 n5883 n5884 0.029017857142857144
r10276 n5801 n5885 0.18421052631578946
r10277 n5884 n5885 0.066964285714285712
r10278 n5802 n5886 1.75
r10279 n5885 n5886 0.046875
r10280 n5803 n5887 1.1666666666666667
r10281 n5886 n5887 0.011160714285714286
r10282 n5804 n5888 1.1666666666666667
r10283 n5887 n5888 0.013392857142857142
r10284 n5805 n5889 0.5
r10285 n5888 n5889 0.022321428571428572
r10286 n5806 n5890 0.34999999999999998
r10287 n5889 n5890 0.037946428571428568
r10288 n5807 n5891 0.071428571428571425
r10289 n5890 n5891 0.13169642857142858
r10290 n5808 n5892 0.10294117647058823
r10291 n5891 n5892 0.18526785714285715
r10292 n5809 n5893 0.070281124497991967
r10293 n5892 n5893 0.18705357142857143
r10294 n5810 n5894 0.070564516129032265
r10295 n5893 n5894 0.22187499999999999
r10296 n5811 n5895 0.070281124497991967
r10297 n5894 n5895 0.22187499999999999
r10298 n5812 n5896 0.070281124497991967
r10299 n5895 n5896 0.22232142857142856
r10300 n5813 n5897 0.34999999999999998
r10301 n5896 n5897 0.13348214285714285
r10302 n5814 n5898 0.34999999999999998
r10303 n5897 n5898 0.044642857142857144
r10304 n5815 n5899 0.15217391304347827
r10305 n5898 n5899 0.073660714285714288
r10306 n5816 n5900 1.75
r10307 n5899 n5900 0.055803571428571432
r10308 n5817 n5901 0.11666666666666667
r10309 n5900 n5901 0.071428571428571425
r10310 n5818 n5902 1.75
r10311 n5901 n5902 0.071428571428571425
r10312 n5819 n5903 0.15217391304347827
r10313 n5902 n5903 0.055803571428571432
r10314 n5820 n5904 0.34999999999999998
r10315 n5903 n5904 0.073660714285714288
r10316 n5821 n5905 0.46250000000000002
r10317 n5822 n5906 0.20108695652173914
r10318 n5905 n5906 0.044836956521739128
r10319 n5823 n5907 2.3125
r10320 n5906 n5907 0.033967391304347824
r10321 n5824 n5908 0.15416666666666667
r10322 n5907 n5908 0.043478260869565216
r10323 n5825 n5909 2.3125
r10324 n5908 n5909 0.043478260869565216
r10325 n5826 n5910 0.20108695652173914
r10326 n5909 n5910 0.033967391304347824
r10327 n5827 n5911 0.46250000000000002
r10328 n5910 n5911 0.044836956521739128
r10329 n5828 n5912 0.51388888888888884
r10330 n5829 n5913 2.3125
r10331 n5912 n5913 0.014945652173913044
r10332 n5830 n5914 2.3125
r10333 n5913 n5914 0.005434782608695652
r10334 n5831 n5915 0.578125
r10335 n5914 n5915 0.01358695652173913
r10336 n5832 n5916 0.21022727272727273
r10337 n5915 n5916 0.040760869565217392
r10338 n5833 n5917 4.625
r10339 n5916 n5917 0.03125
r10340 n5834 n5918 4.625
r10341 n5917 n5918 0.002717391304347826
r10342 n5835 n5919 4.625
r10343 n5918 n5919 0.002717391304347826
r10344 n5836 n5920 0.46250000000000002
r10345 n5919 n5920 0.014945652173913044
r10346 n5837 n5921 0.38541666666666669
r10347 n5920 n5921 0.029891304347826088
r10348 n5838 n5922 0.578125
r10349 n5921 n5922 0.02717391304347826
r10350 n5839 n5923 2.3125
r10351 n5922 n5923 0.01358695652173913
r10352 n5840 n5924 1.5416666666666667
r10353 n5923 n5924 0.006793478260869565
r10354 n5841 n5925 2.3125
r10355 n5924 n5925 0.006793478260869565
r10356 n5842 n5926 0.77083333333333337
r10357 n5925 n5926 0.010869565217391304
r10358 n5898 n5927 0.46250000000000002
r10359 n5899 n5928 0.20108695652173914
r10360 n5927 n5928 0.044836956521739128
r10361 n5900 n5929 2.3125
r10362 n5928 n5929 0.033967391304347824
r10363 n5901 n5930 0.15416666666666667
r10364 n5929 n5930 0.043478260869565216
r10365 n5902 n5931 2.3125
r10366 n5930 n5931 0.043478260869565216
r10367 n5903 n5932 0.20108695652173914
r10368 n5931 n5932 0.033967391304347824
r10369 n5904 n5933 0.46250000000000002
r10370 n5932 n5933 0.044836956521739128
r10371 n5905 n5934 0.29999999999999999
r10372 n5906 n5935 0.13043478260869565
r10373 n5934 n5935 1.03125
r10374 n5907 n5936 1.5
r10375 n5935 n5936 0.78125
r10376 n5908 n5937 0.10000000000000001
r10377 n5936 n5937 1
r10378 n5909 n5938 1.5
r10379 n5937 n5938 1
r10380 n5910 n5939 0.13043478260869565
r10381 n5938 n5939 0.78125
r10382 n5911 n5940 0.29999999999999999
r10383 n5939 n5940 1.03125
r10384 n5941 n5942 0.71875
r10385 n5942 n5943 0.125
r10386 n5943 n5944 0.34375
r10387 n5944 n5945 0.65625
r10388 n5945 n5946 0.65625
r10389 n5946 n5947 0.34375
r10390 n5947 n5948 0.125
r10391 n5948 n5949 0.71875
r10392 n5912 n5950 0.33333333333333331
r10393 n5913 n5951 1.5
r10394 n5950 n5951 0.34375
r10395 n5914 n5952 1.5
r10396 n5951 n5952 0.125
r10397 n5915 n5953 0.375
r10398 n5952 n5953 0.3125
r10399 n5916 n5954 0.13636363636363635
r10400 n5953 n5954 0.9375
r10401 n5917 n5955 3
r10402 n5954 n5955 0.71875
r10403 n5918 n5956 3
r10404 n5955 n5956 0.0625
r10405 n5919 n5957 3
r10406 n5956 n5957 0.0625
r10407 n5920 n5958 0.29999999999999999
r10408 n5957 n5958 0.34375
r10409 n5921 n5959 0.25
r10410 n5958 n5959 0.6875
r10411 n5922 n5960 0.375
r10412 n5959 n5960 0.625
r10413 n5923 n5961 1.5
r10414 n5960 n5961 0.3125
r10415 n5924 n5962 1
r10416 n5961 n5962 0.15625
r10417 n5925 n5963 1.5
r10418 n5962 n5963 0.15625
r10419 n5926 n5964 0.5
r10420 n5963 n5964 0.25
r10421 n5964 n5965 0.5625
r10422 n5927 n5966 0.29999999999999999
r10423 n5928 n5967 0.13043478260869565
r10424 n5966 n5967 1.03125
r10425 n5929 n5968 1.5
r10426 n5967 n5968 0.78125
r10427 n5930 n5969 0.10000000000000001
r10428 n5968 n5969 1
r10429 n5931 n5970 1.5
r10430 n5969 n5970 1
r10431 n5932 n5971 0.13043478260869565
r10432 n5970 n5971 0.78125
r10433 n5933 n5972 0.29999999999999999
r10434 n5971 n5972 1.03125
r10435 n5934 n5973 0.081250000000000003
r10436 n5935 n5974 0.035326086956521736
r10437 n5973 n5974 0.1875
r10438 n5936 n5975 0.40625
r10439 n5974 n5975 0.14204545454545456
r10440 n5937 n5976 0.027083333333333334
r10441 n5975 n5976 0.18181818181818182
r10442 n5938 n5977 0.40625
r10443 n5976 n5977 0.18181818181818182
r10444 n5939 n5978 0.035326086956521736
r10445 n5977 n5978 0.14204545454545456
r10446 n5940 n5979 0.081250000000000003
r10447 n5978 n5979 0.1875
r10448 n5979 n5980 0.11363636363636363
r10449 n5980 n5981 0.27272727272727271
r10450 n5981 n5982 0.43181818181818182
r10451 n5982 n5983 0.43181818181818182
r10452 n5983 n5984 0.43181818181818182
r10453 n5984 n5985 0.40909090909090912
r10454 n5985 n5986 0.36931818181818182
r10455 n5986 n5987 0.35227272727272729
r10456 n5987 n5988 0.36931818181818182
r10457 n5988 n5989 0.32954545454545453
r10458 n5989 n5990 0.15909090909090909
r10459 n5990 n5991 0.079545454545454544
r10460 n5991 n5992 0.068181818181818177
r10461 n5992 n5993 0.19318181818181818
r10462 n5993 n5994 0.19318181818181818
r10463 n5994 n5995 0.21590909090909091
r10464 n5995 n5996 0.21590909090909091
r10465 n5996 n5997 0.085227272727272721
r10466 n5997 n5998 0.14204545454545456
r10467 n5998 n5999 0.10795454545454546
r10468 n5999 n6000 0.05113636363636364
r10469 n6000 n6001 0.034090909090909088
r10470 n6001 n6002 0.073863636363636367
r10471 n5941 n6003 0.038690476190476192
r10472 n6002 n6003 0.17045454545454544
r10473 n5942 n6004 0.40625
r10474 n6003 n6004 0.13068181818181818
r10475 n5943 n6005 0.40625
r10476 n6004 n6005 0.022727272727272728
r10477 n5944 n6006 0.090277777777777776
r10478 n6005 n6006 0.0625
r10479 n5945 n6007 0.067708333333333329
r10480 n6006 n6007 0.11931818181818182
r10481 n5946 n6008 0.090277777777777776
r10482 n6007 n6008 0.11931818181818182
r10483 n5947 n6009 0.40625
r10484 n6008 n6009 0.0625
r10485 n5948 n6010 0.40625
r10486 n6009 n6010 0.022727272727272728
r10487 n5949 n6011 0.038690476190476192
r10488 n6010 n6011 0.13068181818181818
r10489 n5950 n6012 0.090277777777777776
r10490 n5951 n6013 0.40625
r10491 n6012 n6013 0.0625
r10492 n5952 n6014 0.40625
r10493 n6013 n6014 0.022727272727272728
r10494 n5953 n6015 0.1015625
r10495 n6014 n6015 0.056818181818181816
r10496 n5954 n6016 0.036931818181818184
r10497 n6015 n6016 0.17045454545454544
r10498 n5955 n6017 0.8125
r10499 n6016 n6017 0.13068181818181818
r10500 n5956 n6018 0.8125
r10501 n6017 n6018 0.011363636363636364
r10502 n5957 n6019 0.8125
r10503 n6018 n6019 0.011363636363636364
r10504 n5958 n6020 0.081250000000000003
r10505 n6019 n6020 0.0625
r10506 n5959 n6021 0.067708333333333329
r10507 n6020 n6021 0.125
r10508 n5960 n6022 0.1015625
r10509 n6021 n6022 0.11363636363636363
r10510 n5961 n6023 0.40625
r10511 n6022 n6023 0.056818181818181816
r10512 n5962 n6024 0.27083333333333331
r10513 n6023 n6024 0.028409090909090908
r10514 n5963 n6025 0.40625
r10515 n6024 n6025 0.028409090909090908
r10516 n5964 n6026 0.13541666666666666
r10517 n6025 n6026 0.045454545454545456
r10518 n5965 n6027 0.067708333333333329
r10519 n6026 n6027 0.10227272727272728
r10520 n5966 n6028 0.081250000000000003
r10521 n5967 n6029 0.035326086956521736
r10522 n6028 n6029 0.1875
r10523 n5968 n6030 0.40625
r10524 n6029 n6030 0.14204545454545456
r10525 n5969 n6031 0.027083333333333334
r10526 n6030 n6031 0.18181818181818182
r10527 n5970 n6032 0.40625
r10528 n6031 n6032 0.18181818181818182
r10529 n5971 n6033 0.035326086956521736
r10530 n6032 n6033 0.14204545454545456
r10531 n5972 n6034 0.081250000000000003
r10532 n6033 n6034 0.1875
r10533 n5973 n6035 0.081250000000000003
r10534 n5974 n6036 0.035326086956521736
r10535 n6035 n6036 1.03125
r10536 n5975 n6037 0.40625
r10537 n6036 n6037 0.78125
r10538 n5976 n6038 0.027083333333333334
r10539 n6037 n6038 1
r10540 n5977 n6039 0.40625
r10541 n6038 n6039 1
r10542 n5978 n6040 0.035326086956521736
r10543 n6039 n6040 0.78125
r10544 n5979 n6041 0.081250000000000003
r10545 n6040 n6041 1.03125
r10546 n5980 n6042 0.081250000000000003
r10547 n6041 n6042 0.625
r10548 n5981 n6043 0.021381578947368422
r10549 n6042 n6043 1.5
r10550 n5982 n6044 0.021381578947368422
r10551 n6043 n6044 2.375
r10552 n5983 n6045 0.021381578947368422
r10553 n6044 n6045 2.375
r10554 n5984 n6046 0.021381578947368422
r10555 n6045 n6046 2.375
r10556 n5985 n6047 0.02389705882352941
r10557 n6046 n6047 2.25
r10558 n5986 n6048 0.02620967741935484
r10559 n6047 n6048 2.03125
r10560 n5987 n6049 0.02620967741935484
r10561 n6048 n6049 1.9375
r10562 n5988 n6050 0.02389705882352941
r10563 n6049 n6050 2.03125
r10564 n5989 n6051 0.033854166666666664
r10565 n6050 n6051 1.8125
r10566 n5990 n6052 0.203125
r10567 n6051 n6052 0.875
r10568 n5991 n6053 0.081250000000000003
r10569 n6052 n6053 0.4375
r10570 n5992 n6054 0.40625
r10571 n6053 n6054 0.375
r10572 n5993 n6055 0.025390625
r10573 n6054 n6055 1.0625
r10574 n5994 n6056 0.40625
r10575 n6055 n6056 1.0625
r10576 n5995 n6057 0.022569444444444444
r10577 n6056 n6057 1.1875
r10578 n5996 n6058 0.40625
r10579 n6057 n6058 1.1875
r10580 n5997 n6059 0.0625
r10581 n6058 n6059 0.46875
r10582 n5998 n6060 0.067708333333333329
r10583 n6059 n6060 0.78125
r10584 n5999 n6061 0.11607142857142858
r10585 n6060 n6061 0.59375
r10586 n6000 n6062 0.40625
r10587 n6061 n6062 0.28125
r10588 n6001 n6063 0.203125
r10589 n6062 n6063 0.1875
r10590 n6002 n6064 0.090277777777777776
r10591 n6063 n6064 0.40625
r10592 n6003 n6065 0.038690476190476192
r10593 n6064 n6065 0.9375
r10594 n6004 n6066 0.40625
r10595 n6065 n6066 0.71875
r10596 n6005 n6067 0.40625
r10597 n6066 n6067 0.125
r10598 n6006 n6068 0.090277777777777776
r10599 n6067 n6068 0.34375
r10600 n6007 n6069 0.067708333333333329
r10601 n6068 n6069 0.65625
r10602 n6008 n6070 0.090277777777777776
r10603 n6069 n6070 0.65625
r10604 n6009 n6071 0.40625
r10605 n6070 n6071 0.34375
r10606 n6010 n6072 0.40625
r10607 n6071 n6072 0.125
r10608 n6011 n6073 0.038690476190476192
r10609 n6072 n6073 0.71875
r10610 n6012 n6074 0.090277777777777776
r10611 n6013 n6075 0.40625
r10612 n6074 n6075 0.34375
r10613 n6014 n6076 0.40625
r10614 n6075 n6076 0.125
r10615 n6015 n6077 0.1015625
r10616 n6076 n6077 0.3125
r10617 n6016 n6078 0.036931818181818184
r10618 n6077 n6078 0.9375
r10619 n6017 n6079 0.8125
r10620 n6078 n6079 0.71875
r10621 n6018 n6080 0.8125
r10622 n6079 n6080 0.0625
r10623 n6019 n6081 0.8125
r10624 n6080 n6081 0.0625
r10625 n6020 n6082 0.081250000000000003
r10626 n6081 n6082 0.34375
r10627 n6021 n6083 0.067708333333333329
r10628 n6082 n6083 0.6875
r10629 n6022 n6084 0.1015625
r10630 n6083 n6084 0.625
r10631 n6023 n6085 0.40625
r10632 n6084 n6085 0.3125
r10633 n6024 n6086 0.27083333333333331
r10634 n6085 n6086 0.15625
r10635 n6025 n6087 0.40625
r10636 n6086 n6087 0.15625
r10637 n6026 n6088 0.13541666666666666
r10638 n6087 n6088 0.25
r10639 n6027 n6089 0.067708333333333329
r10640 n6088 n6089 0.5625
r10641 n6028 n6090 0.081250000000000003
r10642 n6029 n6091 0.035326086956521736
r10643 n6090 n6091 1.03125
r10644 n6030 n6092 0.40625
r10645 n6091 n6092 0.78125
r10646 n6031 n6093 0.027083333333333334
r10647 n6092 n6093 1
r10648 n6032 n6094 0.40625
r10649 n6093 n6094 1
r10650 n6033 n6095 0.035326086956521736
r10651 n6094 n6095 0.78125
r10652 n6034 n6096 0.081250000000000003
r10653 n6095 n6096 1.03125
r10654 n6035 n6097 0.20000000000000001
r10655 n6036 n6098 0.086956521739130432
r10656 n6097 n6098 0.068750000000000006
r10657 n6037 n6099 1
r10658 n6098 n6099 0.052083333333333336
r10659 n6038 n6100 0.066666666666666666
r10660 n6099 n6100 0.066666666666666666
r10661 n6039 n6101 1
r10662 n6100 n6101 0.066666666666666666
r10663 n6040 n6102 0.086956521739130432
r10664 n6101 n6102 0.052083333333333336
r10665 n6041 n6103 0.20000000000000001
r10666 n6102 n6103 0.068750000000000006
r10667 n6042 n6104 0.20000000000000001
r10668 n6103 n6104 0.041666666666666664
r10669 n6043 n6105 0.052631578947368418
r10670 n6104 n6105 0.10000000000000001
r10671 n6044 n6106 0.052631578947368418
r10672 n6105 n6106 0.15833333333333333
r10673 n6045 n6107 0.052631578947368418
r10674 n6106 n6107 0.15833333333333333
r10675 n6046 n6108 0.052631578947368418
r10676 n6107 n6108 0.15833333333333333
r10677 n6047 n6109 0.058823529411764705
r10678 n6108 n6109 0.14999999999999999
r10679 n6048 n6110 0.064516129032258063
r10680 n6109 n6110 0.13541666666666666
r10681 n6049 n6111 0.064516129032258063
r10682 n6110 n6111 0.12916666666666668
r10683 n6050 n6112 0.058823529411764705
r10684 n6111 n6112 0.13541666666666666
r10685 n6051 n6113 0.083333333333333329
r10686 n6112 n6113 0.12083333333333333
r10687 n6052 n6114 0.5
r10688 n6113 n6114 0.058333333333333334
r10689 n6053 n6115 0.20000000000000001
r10690 n6114 n6115 0.029166666666666667
r10691 n6054 n6116 1
r10692 n6115 n6116 0.025000000000000001
r10693 n6055 n6117 0.0625
r10694 n6116 n6117 0.070833333333333331
r10695 n6056 n6118 1
r10696 n6117 n6118 0.070833333333333331
r10697 n6057 n6119 0.055555555555555552
r10698 n6118 n6119 0.079166666666666663
r10699 n6058 n6120 1
r10700 n6119 n6120 0.079166666666666663
r10701 n6059 n6121 0.15384615384615385
r10702 n6120 n6121 0.03125
r10703 n6060 n6122 0.16666666666666666
r10704 n6121 n6122 0.052083333333333336
r10705 n6061 n6123 0.2857142857142857
r10706 n6122 n6123 0.039583333333333331
r10707 n6062 n6124 1
r10708 n6123 n6124 0.018749999999999999
r10709 n6063 n6125 0.5
r10710 n6124 n6125 0.012500000000000001
r10711 n6064 n6126 0.22222222222222221
r10712 n6125 n6126 0.027083333333333334
r10713 n6065 n6127 0.095238095238095233
r10714 n6126 n6127 0.0625
r10715 n6066 n6128 1
r10716 n6127 n6128 0.04791666666666667
r10717 n6067 n6129 1
r10718 n6128 n6129 0.0083333333333333332
r10719 n6068 n6130 0.22222222222222221
r10720 n6129 n6130 0.022916666666666665
r10721 n6069 n6131 0.16666666666666666
r10722 n6130 n6131 0.043749999999999997
r10723 n6070 n6132 0.22222222222222221
r10724 n6131 n6132 0.043749999999999997
r10725 n6071 n6133 1
r10726 n6132 n6133 0.022916666666666665
r10727 n6072 n6134 1
r10728 n6133 n6134 0.0083333333333333332
r10729 n6073 n6135 0.095238095238095233
r10730 n6134 n6135 0.04791666666666667
r10731 n6074 n6136 0.22222222222222221
r10732 n6075 n6137 1
r10733 n6136 n6137 0.022916666666666665
r10734 n6076 n6138 1
r10735 n6137 n6138 0.0083333333333333332
r10736 n6077 n6139 0.25
r10737 n6138 n6139 0.020833333333333332
r10738 n6078 n6140 0.090909090909090912
r10739 n6139 n6140 0.0625
r10740 n6079 n6141 2
r10741 n6140 n6141 0.04791666666666667
r10742 n6080 n6142 2
r10743 n6141 n6142 0.0041666666666666666
r10744 n6081 n6143 2
r10745 n6142 n6143 0.0041666666666666666
r10746 n6082 n6144 0.20000000000000001
r10747 n6143 n6144 0.022916666666666665
r10748 n6083 n6145 0.16666666666666666
r10749 n6144 n6145 0.04583333333333333
r10750 n6084 n6146 0.25
r10751 n6145 n6146 0.041666666666666664
r10752 n6085 n6147 1
r10753 n6146 n6147 0.020833333333333332
r10754 n6086 n6148 0.66666666666666663
r10755 n6147 n6148 0.010416666666666666
r10756 n6087 n6149 1
r10757 n6148 n6149 0.010416666666666666
r10758 n6088 n6150 0.33333333333333331
r10759 n6149 n6150 0.016666666666666666
r10760 n6089 n6151 0.16666666666666666
r10761 n6150 n6151 0.037499999999999999
r10762 n6090 n6152 0.20000000000000001
r10763 n6091 n6153 0.086956521739130432
r10764 n6152 n6153 0.068750000000000006
r10765 n6092 n6154 1
r10766 n6153 n6154 0.052083333333333336
r10767 n6093 n6155 0.066666666666666666
r10768 n6154 n6155 0.066666666666666666
r10769 n6094 n6156 1
r10770 n6155 n6156 0.066666666666666666
r10771 n6095 n6157 0.086956521739130432
r10772 n6156 n6157 0.052083333333333336
r10773 n6096 n6158 0.20000000000000001
r10774 n6157 n6158 0.068750000000000006
r10775 n6097 n6159 0.20000000000000001
r10776 n6098 n6160 0.086956521739130432
r10777 n6159 n6160 1.03125
r10778 n6099 n6161 1
r10779 n6160 n6161 0.78125
r10780 n6100 n6162 0.066666666666666666
r10781 n6161 n6162 1
r10782 n6101 n6163 1
r10783 n6162 n6163 1
r10784 n6102 n6164 0.086956521739130432
r10785 n6163 n6164 0.78125
r10786 n6103 n6165 0.20000000000000001
r10787 n6164 n6165 1.03125
r10788 n6104 n6166 0.20000000000000001
r10789 n6165 n6166 0.625
r10790 n6105 n6167 0.052631578947368418
r10791 n6166 n6167 1.5
r10792 n6106 n6168 0.052631578947368418
r10793 n6167 n6168 2.375
r10794 n6107 n6169 0.052631578947368418
r10795 n6168 n6169 2.375
r10796 n6108 n6170 0.052631578947368418
r10797 n6169 n6170 2.375
r10798 n6109 n6171 0.058823529411764705
r10799 n6170 n6171 2.25
r10800 n6110 n6172 0.064516129032258063
r10801 n6171 n6172 2.03125
r10802 n6111 n6173 0.064516129032258063
r10803 n6172 n6173 1.9375
r10804 n6112 n6174 0.058823529411764705
r10805 n6173 n6174 2.03125
r10806 n6113 n6175 0.083333333333333329
r10807 n6174 n6175 1.8125
r10808 n6114 n6176 0.5
r10809 n6175 n6176 0.875
r10810 n6115 n6177 0.20000000000000001
r10811 n6176 n6177 0.4375
r10812 n6116 n6178 1
r10813 n6177 n6178 0.375
r10814 n6117 n6179 0.0625
r10815 n6178 n6179 1.0625
r10816 n6118 n6180 1
r10817 n6179 n6180 1.0625
r10818 n6119 n6181 0.055555555555555552
r10819 n6180 n6181 1.1875
r10820 n6120 n6182 1
r10821 n6181 n6182 1.1875
r10822 n6121 n6183 0.15384615384615385
r10823 n6182 n6183 0.46875
r10824 n6122 n6184 0.16666666666666666
r10825 n6183 n6184 0.78125
r10826 n6123 n6185 0.2857142857142857
r10827 n6184 n6185 0.59375
r10828 n6124 n6186 1
r10829 n6185 n6186 0.28125
r10830 n6125 n6187 0.5
r10831 n6186 n6187 0.1875
r10832 n6126 n6188 0.22222222222222221
r10833 n6187 n6188 0.40625
r10834 n6127 n6189 0.095238095238095233
r10835 n6188 n6189 0.9375
r10836 n6128 n6190 1
r10837 n6189 n6190 0.71875
r10838 n6129 n6191 1
r10839 n6190 n6191 0.125
r10840 n6130 n6192 0.22222222222222221
r10841 n6191 n6192 0.34375
r10842 n6131 n6193 0.16666666666666666
r10843 n6192 n6193 0.65625
r10844 n6132 n6194 0.22222222222222221
r10845 n6193 n6194 0.65625
r10846 n6133 n6195 1
r10847 n6194 n6195 0.34375
r10848 n6134 n6196 1
r10849 n6195 n6196 0.125
r10850 n6135 n6197 0.095238095238095233
r10851 n6196 n6197 0.71875
r10852 n6136 n6198 0.22222222222222221
r10853 n6137 n6199 1
r10854 n6198 n6199 0.34375
r10855 n6138 n6200 1
r10856 n6199 n6200 0.125
r10857 n6139 n6201 0.25
r10858 n6200 n6201 0.3125
r10859 n6140 n6202 0.090909090909090912
r10860 n6201 n6202 0.9375
r10861 n6141 n6203 2
r10862 n6202 n6203 0.71875
r10863 n6142 n6204 2
r10864 n6203 n6204 0.0625
r10865 n6143 n6205 2
r10866 n6204 n6205 0.0625
r10867 n6144 n6206 0.20000000000000001
r10868 n6205 n6206 0.34375
r10869 n6145 n6207 0.16666666666666666
r10870 n6206 n6207 0.6875
r10871 n6146 n6208 0.25
r10872 n6207 n6208 0.625
r10873 n6147 n6209 1
r10874 n6208 n6209 0.3125
r10875 n6148 n6210 0.66666666666666663
r10876 n6209 n6210 0.15625
r10877 n6149 n6211 1
r10878 n6210 n6211 0.15625
r10879 n6150 n6212 0.33333333333333331
r10880 n6211 n6212 0.25
r10881 n6151 n6213 0.16666666666666666
r10882 n6212 n6213 0.5625
r10883 n6152 n6214 0.20000000000000001
r10884 n6153 n6215 0.086956521739130432
r10885 n6214 n6215 1.03125
r10886 n6154 n6216 1
r10887 n6215 n6216 0.78125
r10888 n6155 n6217 0.066666666666666666
r10889 n6216 n6217 1
r10890 n6156 n6218 1
r10891 n6217 n6218 1
r10892 n6157 n6219 0.086956521739130432
r10893 n6218 n6219 0.78125
r10894 n6158 n6220 0.20000000000000001
r10895 n6219 n6220 1.03125
r10896 n6159 n6221 0.081250000000000003
r10897 n6160 n6222 0.035326086956521736
r10898 n6221 n6222 0.1875
r10899 n6161 n6223 0.40625
r10900 n6222 n6223 0.14204545454545456
r10901 n6162 n6224 0.027083333333333334
r10902 n6223 n6224 0.18181818181818182
r10903 n6163 n6225 0.40625
r10904 n6224 n6225 0.18181818181818182
r10905 n6164 n6226 0.035326086956521736
r10906 n6225 n6226 0.14204545454545456
r10907 n6165 n6227 0.081250000000000003
r10908 n6226 n6227 0.1875
r10909 n6166 n6228 0.081250000000000003
r10910 n6227 n6228 0.11363636363636363
r10911 n6167 n6229 0.021381578947368422
r10912 n6228 n6229 0.27272727272727271
r10913 n6168 n6230 0.021381578947368422
r10914 n6229 n6230 0.43181818181818182
r10915 n6169 n6231 0.021381578947368422
r10916 n6230 n6231 0.43181818181818182
r10917 n6170 n6232 0.021381578947368422
r10918 n6231 n6232 0.43181818181818182
r10919 n6171 n6233 0.02389705882352941
r10920 n6232 n6233 0.40909090909090912
r10921 n6172 n6234 0.02620967741935484
r10922 n6233 n6234 0.36931818181818182
r10923 n6173 n6235 0.02620967741935484
r10924 n6234 n6235 0.35227272727272729
r10925 n6174 n6236 0.02389705882352941
r10926 n6235 n6236 0.36931818181818182
r10927 n6175 n6237 0.033854166666666664
r10928 n6236 n6237 0.32954545454545453
r10929 n6176 n6238 0.203125
r10930 n6237 n6238 0.15909090909090909
r10931 n6177 n6239 0.081250000000000003
r10932 n6238 n6239 0.079545454545454544
r10933 n6178 n6240 0.40625
r10934 n6239 n6240 0.068181818181818177
r10935 n6179 n6241 0.025390625
r10936 n6240 n6241 0.19318181818181818
r10937 n6180 n6242 0.40625
r10938 n6241 n6242 0.19318181818181818
r10939 n6181 n6243 0.022569444444444444
r10940 n6242 n6243 0.21590909090909091
r10941 n6182 n6244 0.40625
r10942 n6243 n6244 0.21590909090909091
r10943 n6183 n6245 0.0625
r10944 n6244 n6245 0.085227272727272721
r10945 n6184 n6246 0.067708333333333329
r10946 n6245 n6246 0.14204545454545456
r10947 n6185 n6247 0.11607142857142858
r10948 n6246 n6247 0.10795454545454546
r10949 n6186 n6248 0.40625
r10950 n6247 n6248 0.05113636363636364
r10951 n6187 n6249 0.203125
r10952 n6248 n6249 0.034090909090909088
r10953 n6188 n6250 0.090277777777777776
r10954 n6249 n6250 0.073863636363636367
r10955 n6189 n6251 0.038690476190476192
r10956 n6250 n6251 0.17045454545454544
r10957 n6190 n6252 0.40625
r10958 n6251 n6252 0.13068181818181818
r10959 n6191 n6253 0.40625
r10960 n6252 n6253 0.022727272727272728
r10961 n6192 n6254 0.090277777777777776
r10962 n6253 n6254 0.0625
r10963 n6193 n6255 0.067708333333333329
r10964 n6254 n6255 0.11931818181818182
r10965 n6194 n6256 0.090277777777777776
r10966 n6255 n6256 0.11931818181818182
r10967 n6195 n6257 0.40625
r10968 n6256 n6257 0.0625
r10969 n6196 n6258 0.40625
r10970 n6257 n6258 0.022727272727272728
r10971 n6197 n6259 0.038690476190476192
r10972 n6258 n6259 0.13068181818181818
r10973 n6198 n6260 0.090277777777777776
r10974 n6199 n6261 0.40625
r10975 n6260 n6261 0.0625
r10976 n6200 n6262 0.40625
r10977 n6261 n6262 0.022727272727272728
r10978 n6201 n6263 0.1015625
r10979 n6262 n6263 0.056818181818181816
r10980 n6202 n6264 0.036931818181818184
r10981 n6263 n6264 0.17045454545454544
r10982 n6203 n6265 0.8125
r10983 n6264 n6265 0.13068181818181818
r10984 n6204 n6266 0.8125
r10985 n6265 n6266 0.011363636363636364
r10986 n6205 n6267 0.8125
r10987 n6266 n6267 0.011363636363636364
r10988 n6206 n6268 0.081250000000000003
r10989 n6267 n6268 0.0625
r10990 n6207 n6269 0.067708333333333329
r10991 n6268 n6269 0.125
r10992 n6208 n6270 0.1015625
r10993 n6269 n6270 0.11363636363636363
r10994 n6209 n6271 0.40625
r10995 n6270 n6271 0.056818181818181816
r10996 n6210 n6272 0.27083333333333331
r10997 n6271 n6272 0.028409090909090908
r10998 n6211 n6273 0.40625
r10999 n6272 n6273 0.028409090909090908
r11000 n6212 n6274 0.13541666666666666
r11001 n6273 n6274 0.045454545454545456
r11002 n6213 n6275 0.067708333333333329
r11003 n6274 n6275 0.10227272727272728
r11004 n6214 n6276 0.081250000000000003
r11005 n6215 n6277 0.035326086956521736
r11006 n6276 n6277 0.1875
r11007 n6216 n6278 0.40625
r11008 n6277 n6278 0.14204545454545456
r11009 n6217 n6279 0.027083333333333334
r11010 n6278 n6279 0.18181818181818182
r11011 n6218 n6280 0.40625
r11012 n6279 n6280 0.18181818181818182
r11013 n6219 n6281 0.035326086956521736
r11014 n6280 n6281 0.14204545454545456
r11015 n6220 n6282 0.081250000000000003
r11016 n6281 n6282 0.1875
r11017 n6221 n6283 0.081250000000000003
r11018 n6222 n6284 0.035326086956521736
r11019 n6283 n6284 1.03125
r11020 n6223 n6285 0.40625
r11021 n6284 n6285 0.78125
r11022 n6224 n6286 0.027083333333333334
r11023 n6285 n6286 1
r11024 n6225 n6287 0.40625
r11025 n6286 n6287 1
r11026 n6226 n6288 0.035326086956521736
r11027 n6287 n6288 0.78125
r11028 n6227 n6289 0.081250000000000003
r11029 n6288 n6289 1.03125
r11030 n6251 n6290 0.038690476190476192
r11031 n6252 n6291 0.40625
r11032 n6290 n6291 0.71875
r11033 n6253 n6292 0.40625
r11034 n6291 n6292 0.125
r11035 n6254 n6293 0.090277777777777776
r11036 n6292 n6293 0.34375
r11037 n6255 n6294 0.067708333333333329
r11038 n6293 n6294 0.65625
r11039 n6256 n6295 0.090277777777777776
r11040 n6294 n6295 0.65625
r11041 n6257 n6296 0.40625
r11042 n6295 n6296 0.34375
r11043 n6258 n6297 0.40625
r11044 n6296 n6297 0.125
r11045 n6259 n6298 0.038690476190476192
r11046 n6297 n6298 0.71875
r11047 n6260 n6299 0.090277777777777776
r11048 n6261 n6300 0.40625
r11049 n6299 n6300 0.34375
r11050 n6262 n6301 0.40625
r11051 n6300 n6301 0.125
r11052 n6263 n6302 0.1015625
r11053 n6301 n6302 0.3125
r11054 n6264 n6303 0.036931818181818184
r11055 n6302 n6303 0.9375
r11056 n6265 n6304 0.8125
r11057 n6303 n6304 0.71875
r11058 n6266 n6305 0.8125
r11059 n6304 n6305 0.0625
r11060 n6267 n6306 0.8125
r11061 n6305 n6306 0.0625
r11062 n6268 n6307 0.081250000000000003
r11063 n6306 n6307 0.34375
r11064 n6269 n6308 0.067708333333333329
r11065 n6307 n6308 0.6875
r11066 n6270 n6309 0.1015625
r11067 n6308 n6309 0.625
r11068 n6271 n6310 0.40625
r11069 n6309 n6310 0.3125
r11070 n6272 n6311 0.27083333333333331
r11071 n6310 n6311 0.15625
r11072 n6273 n6312 0.40625
r11073 n6311 n6312 0.15625
r11074 n6274 n6313 0.13541666666666666
r11075 n6312 n6313 0.25
r11076 n6275 n6314 0.067708333333333329
r11077 n6313 n6314 0.5625
r11078 n6276 n6315 0.081250000000000003
r11079 n6277 n6316 0.035326086956521736
r11080 n6315 n6316 1.03125
r11081 n6278 n6317 0.40625
r11082 n6316 n6317 0.78125
r11083 n6279 n6318 0.027083333333333334
r11084 n6317 n6318 1
r11085 n6280 n6319 0.40625
r11086 n6318 n6319 1
r11087 n6281 n6320 0.035326086956521736
r11088 n6319 n6320 0.78125
r11089 n6282 n6321 0.081250000000000003
r11090 n6320 n6321 1.03125
r11091 n6283 n6322 0.20624999999999999
r11092 n6284 n6323 0.089673913043478257
r11093 n6322 n6323 0.066532258064516125
r11094 n6285 n6324 1.03125
r11095 n6323 n6324 0.05040322580645161
r11096 n6286 n6325 0.068750000000000006
r11097 n6324 n6325 0.064516129032258063
r11098 n6287 n6326 1.03125
r11099 n6325 n6326 0.064516129032258063
r11100 n6288 n6327 0.089673913043478257
r11101 n6326 n6327 0.05040322580645161
r11102 n6289 n6328 0.20624999999999999
r11103 n6327 n6328 0.066532258064516125
r11104 n6299 n6329 0.22916666666666666
r11105 n6300 n6330 1.03125
r11106 n6329 n6330 0.022177419354838711
r11107 n6301 n6331 1.03125
r11108 n6330 n6331 0.0080645161290322578
r11109 n6302 n6332 0.2578125
r11110 n6331 n6332 0.020161290322580645
r11111 n6303 n6333 0.09375
r11112 n6332 n6333 0.060483870967741937
r11113 n6304 n6334 2.0625
r11114 n6333 n6334 0.046370967741935484
r11115 n6305 n6335 2.0625
r11116 n6334 n6335 0.0040322580645161289
r11117 n6306 n6336 2.0625
r11118 n6335 n6336 0.0040322580645161289
r11119 n6307 n6337 0.20624999999999999
r11120 n6336 n6337 0.022177419354838711
r11121 n6315 n6338 0.20624999999999999
r11122 n6316 n6339 0.089673913043478257
r11123 n6338 n6339 0.066532258064516125
r11124 n6317 n6340 1.03125
r11125 n6339 n6340 0.05040322580645161
r11126 n6318 n6341 0.068750000000000006
r11127 n6340 n6341 0.064516129032258063
r11128 n6319 n6342 1.03125
r11129 n6341 n6342 0.064516129032258063
r11130 n6320 n6343 0.089673913043478257
r11131 n6342 n6343 0.05040322580645161
r11132 n6321 n6344 0.20624999999999999
r11133 n6343 n6344 0.066532258064516125
r11134 n6322 n6345 0.38750000000000001
r11135 n6323 n6346 0.16847826086956522
r11136 n6345 n6346 0.066532258064516125
r11137 n6324 n6347 1.9375
r11138 n6346 n6347 0.05040322580645161
r11139 n6325 n6348 0.12916666666666668
r11140 n6347 n6348 0.064516129032258063
r11141 n6326 n6349 1.9375
r11142 n6348 n6349 0.064516129032258063
r11143 n6327 n6350 0.16847826086956522
r11144 n6349 n6350 0.05040322580645161
r11145 n6328 n6351 0.38750000000000001
r11146 n6350 n6351 0.066532258064516125
r11147 n6329 n6352 0.43055555555555558
r11148 n6330 n6353 1.9375
r11149 n6352 n6353 0.022177419354838711
r11150 n6331 n6354 1.9375
r11151 n6353 n6354 0.0080645161290322578
r11152 n6332 n6355 0.484375
r11153 n6354 n6355 0.020161290322580645
r11154 n6333 n6356 0.17613636363636365
r11155 n6355 n6356 0.060483870967741937
r11156 n6334 n6357 3.875
r11157 n6356 n6357 0.046370967741935484
r11158 n6335 n6358 3.875
r11159 n6357 n6358 0.0040322580645161289
r11160 n6336 n6359 3.875
r11161 n6358 n6359 0.0040322580645161289
r11162 n6337 n6360 0.38750000000000001
r11163 n6359 n6360 0.022177419354838711
r11164 n6338 n6361 0.38750000000000001
r11165 n6339 n6362 0.16847826086956522
r11166 n6361 n6362 0.066532258064516125
r11167 n6340 n6363 1.9375
r11168 n6362 n6363 0.05040322580645161
r11169 n6341 n6364 0.12916666666666668
r11170 n6363 n6364 0.064516129032258063
r11171 n6342 n6365 1.9375
r11172 n6364 n6365 0.064516129032258063
r11173 n6343 n6366 0.16847826086956522
r11174 n6365 n6366 0.05040322580645161
r11175 n6344 n6367 0.38750000000000001
r11176 n6366 n6367 0.066532258064516125
r11177 n6345 n6368 0.28125
r11178 n6346 n6369 0.12228260869565218
r11179 n6368 n6369 0.14732142857142858
r11180 n6347 n6370 1.40625
r11181 n6369 n6370 0.11160714285714286
r11182 n6348 n6371 0.09375
r11183 n6370 n6371 0.14285714285714285
r11184 n6349 n6372 1.40625
r11185 n6371 n6372 0.14285714285714285
r11186 n6350 n6373 0.12228260869565218
r11187 n6372 n6373 0.11160714285714286
r11188 n6351 n6374 0.28125
r11189 n6373 n6374 0.14732142857142858
r11190 n6352 n6375 0.3125
r11191 n6353 n6376 1.40625
r11192 n6375 n6376 0.049107142857142856
r11193 n6354 n6377 1.40625
r11194 n6376 n6377 0.017857142857142856
r11195 n6355 n6378 0.3515625
r11196 n6377 n6378 0.044642857142857144
r11197 n6356 n6379 0.12784090909090909
r11198 n6378 n6379 0.13392857142857142
r11199 n6357 n6380 2.8125
r11200 n6379 n6380 0.10267857142857142
r11201 n6358 n6381 2.8125
r11202 n6380 n6381 0.0089285714285714281
r11203 n6359 n6382 2.8125
r11204 n6381 n6382 0.0089285714285714281
r11205 n6360 n6383 0.28125
r11206 n6382 n6383 0.049107142857142856
r11207 n6361 n6384 0.28125
r11208 n6362 n6385 0.12228260869565218
r11209 n6384 n6385 0.14732142857142858
r11210 n6363 n6386 1.40625
r11211 n6385 n6386 0.11160714285714286
r11212 n6364 n6387 0.09375
r11213 n6386 n6387 0.14285714285714285
r11214 n6365 n6388 1.40625
r11215 n6387 n6388 0.14285714285714285
r11216 n6366 n6389 0.12228260869565218
r11217 n6388 n6389 0.11160714285714286
r11218 n6367 n6390 0.28125
r11219 n6389 n6390 0.14732142857142858
r11220 n6368 n6391 0.10000000000000001
r11221 n6369 n6392 0.043478260869565216
r11222 n6391 n6392 1.03125
r11223 n6370 n6393 0.5
r11224 n6392 n6393 0.78125
r11225 n6371 n6394 0.033333333333333333
r11226 n6393 n6394 1
r11227 n6372 n6395 0.5
r11228 n6394 n6395 1
r11229 n6373 n6396 0.043478260869565216
r11230 n6395 n6396 0.78125
r11231 n6374 n6397 0.10000000000000001
r11232 n6396 n6397 1.03125
r11233 n6398 n6399 0.59375
r11234 n6399 n6400 0.28125
r11235 n6400 n6401 0.1875
r11236 n6401 n6402 0.40625
r11237 n6402 n6403 0.9375
r11238 n6403 n6404 0.71875
r11239 n6404 n6405 0.125
r11240 n6405 n6406 0.34375
r11241 n6406 n6407 0.65625
r11242 n6375 n6409 0.1111111111111111
r11243 n6408 n6409 0.65625
r11244 n6376 n6410 0.5
r11245 n6409 n6410 0.34375
r11246 n6377 n6411 0.5
r11247 n6410 n6411 0.125
r11248 n6378 n6412 0.125
r11249 n6411 n6412 0.3125
r11250 n6379 n6413 0.045454545454545456
r11251 n6412 n6413 0.9375
r11252 n6380 n6414 1
r11253 n6413 n6414 0.71875
r11254 n6381 n6415 1
r11255 n6414 n6415 0.0625
r11256 n6382 n6416 1
r11257 n6415 n6416 0.0625
r11258 n6383 n6417 0.10000000000000001
r11259 n6416 n6417 0.34375
r11260 n6417 n6418 0.6875
r11261 n6384 n6419 0.10000000000000001
r11262 n6385 n6420 0.043478260869565216
r11263 n6419 n6420 1.03125
r11264 n6386 n6421 0.5
r11265 n6420 n6421 0.78125
r11266 n6387 n6422 0.033333333333333333
r11267 n6421 n6422 1
r11268 n6388 n6423 0.5
r11269 n6422 n6423 1
r11270 n6389 n6424 0.043478260869565216
r11271 n6423 n6424 0.78125
r11272 n6390 n6425 0.10000000000000001
r11273 n6424 n6425 1.03125
r11274 n6391 n6426 0.043749999999999997
r11275 n6392 n6427 0.019021739130434784
r11276 n6426 n6427 0.41249999999999998
r11277 n6393 n6428 0.21875
r11278 n6427 n6428 0.3125
r11279 n6394 n6429 0.014583333333333334
r11280 n6428 n6429 0.40000000000000002
r11281 n6395 n6430 0.21875
r11282 n6429 n6430 0.40000000000000002
r11283 n6396 n6431 0.019021739130434784
r11284 n6430 n6431 0.3125
r11285 n6397 n6432 0.043749999999999997
r11286 n6431 n6432 0.41249999999999998
r11287 n6432 n6433 0.25
r11288 n6433 n6434 0.59999999999999998
r11289 n6434 n6435 0.94999999999999996
r11290 n6435 n6436 0.94999999999999996
r11291 n6436 n6437 0.94999999999999996
r11292 n6437 n6438 0.90000000000000002
r11293 n6438 n6439 0.8125
r11294 n6439 n6440 0.77500000000000002
r11295 n6440 n6441 0.8125
r11296 n6441 n6442 0.72499999999999998
r11297 n6442 n6443 0.34999999999999998
r11298 n6443 n6444 0.17499999999999999
r11299 n6444 n6445 0.14999999999999999
r11300 n6445 n6446 0.42499999999999999
r11301 n6446 n6447 0.42499999999999999
r11302 n6447 n6448 0.47499999999999998
r11303 n6448 n6449 0.47499999999999998
r11304 n6449 n6450 0.1875
r11305 n6398 n6451 0.036458333333333336
r11306 n6450 n6451 0.3125
r11307 n6399 n6452 0.0625
r11308 n6451 n6452 0.23749999999999999
r11309 n6400 n6453 0.21875
r11310 n6452 n6453 0.1125
r11311 n6401 n6454 0.109375
r11312 n6453 n6454 0.074999999999999997
r11313 n6402 n6455 0.048611111111111112
r11314 n6454 n6455 0.16250000000000001
r11315 n6403 n6456 0.020833333333333332
r11316 n6455 n6456 0.375
r11317 n6404 n6457 0.21875
r11318 n6456 n6457 0.28749999999999998
r11319 n6405 n6458 0.21875
r11320 n6457 n6458 0.050000000000000003
r11321 n6406 n6459 0.048611111111111112
r11322 n6458 n6459 0.13750000000000001
r11323 n6407 n6460 0.036458333333333336
r11324 n6459 n6460 0.26250000000000001
r11325 n6408 n6461 0.036458333333333336
r11326 n6409 n6462 0.048611111111111112
r11327 n6461 n6462 0.26250000000000001
r11328 n6410 n6463 0.21875
r11329 n6462 n6463 0.13750000000000001
r11330 n6411 n6464 0.21875
r11331 n6463 n6464 0.050000000000000003
r11332 n6412 n6465 0.0546875
r11333 n6464 n6465 0.125
r11334 n6413 n6466 0.019886363636363636
r11335 n6465 n6466 0.375
r11336 n6414 n6467 0.4375
r11337 n6466 n6467 0.28749999999999998
r11338 n6415 n6468 0.4375
r11339 n6467 n6468 0.025000000000000001
r11340 n6416 n6469 0.4375
r11341 n6468 n6469 0.025000000000000001
r11342 n6417 n6470 0.043749999999999997
r11343 n6469 n6470 0.13750000000000001
r11344 n6418 n6471 0.036458333333333336
r11345 n6470 n6471 0.27500000000000002
r11346 n6419 n6472 0.043749999999999997
r11347 n6420 n6473 0.019021739130434784
r11348 n6472 n6473 0.41249999999999998
r11349 n6421 n6474 0.21875
r11350 n6473 n6474 0.3125
r11351 n6422 n6475 0.014583333333333334
r11352 n6474 n6475 0.40000000000000002
r11353 n6423 n6476 0.21875
r11354 n6475 n6476 0.40000000000000002
r11355 n6424 n6477 0.019021739130434784
r11356 n6476 n6477 0.3125
r11357 n6425 n6478 0.043749999999999997
r11358 n6477 n6478 0.41249999999999998
r11359 n6426 n6479 0.068750000000000006
r11360 n6427 n6480 0.029891304347826088
r11361 n6479 n6480 0.34375
r11362 n6428 n6481 0.34375
r11363 n6480 n6481 0.26041666666666669
r11364 n6429 n6482 0.022916666666666665
r11365 n6481 n6482 0.33333333333333331
r11366 n6430 n6483 0.34375
r11367 n6482 n6483 0.33333333333333331
r11368 n6431 n6484 0.029891304347826088
r11369 n6483 n6484 0.26041666666666669
r11370 n6432 n6485 0.068750000000000006
r11371 n6484 n6485 0.34375
r11372 n6433 n6486 0.068750000000000006
r11373 n6485 n6486 0.20833333333333334
r11374 n6434 n6487 0.018092105263157895
r11375 n6486 n6487 0.5
r11376 n6435 n6488 0.018092105263157895
r11377 n6487 n6488 0.79166666666666663
r11378 n6436 n6489 0.018092105263157895
r11379 n6488 n6489 0.79166666666666663
r11380 n6437 n6490 0.018092105263157895
r11381 n6489 n6490 0.79166666666666663
r11382 n6438 n6491 0.020220588235294119
r11383 n6490 n6491 0.75
r11384 n6439 n6492 0.022177419354838711
r11385 n6491 n6492 0.67708333333333337
r11386 n6440 n6493 0.022177419354838711
r11387 n6492 n6493 0.64583333333333337
r11388 n6441 n6494 0.020220588235294119
r11389 n6493 n6494 0.67708333333333337
r11390 n6442 n6495 0.028645833333333332
r11391 n6494 n6495 0.60416666666666663
r11392 n6443 n6496 0.171875
r11393 n6495 n6496 0.29166666666666669
r11394 n6444 n6497 0.068750000000000006
r11395 n6496 n6497 0.14583333333333334
r11396 n6445 n6498 0.34375
r11397 n6497 n6498 0.125
r11398 n6446 n6499 0.021484375
r11399 n6498 n6499 0.35416666666666669
r11400 n6447 n6500 0.34375
r11401 n6499 n6500 0.35416666666666669
r11402 n6448 n6501 0.019097222222222224
r11403 n6500 n6501 0.39583333333333331
r11404 n6449 n6502 0.34375
r11405 n6501 n6502 0.39583333333333331
r11406 n6450 n6503 0.052884615384615384
r11407 n6502 n6503 0.15625
r11408 n6451 n6504 0.057291666666666664
r11409 n6503 n6504 0.26041666666666669
r11410 n6452 n6505 0.098214285714285712
r11411 n6504 n6505 0.19791666666666666
r11412 n6453 n6506 0.34375
r11413 n6505 n6506 0.09375
r11414 n6454 n6507 0.171875
r11415 n6506 n6507 0.0625
r11416 n6455 n6508 0.076388888888888895
r11417 n6507 n6508 0.13541666666666666
r11418 n6456 n6509 0.03273809523809524
r11419 n6508 n6509 0.3125
r11420 n6457 n6510 0.34375
r11421 n6509 n6510 0.23958333333333334
r11422 n6458 n6511 0.34375
r11423 n6510 n6511 0.041666666666666664
r11424 n6459 n6512 0.076388888888888895
r11425 n6511 n6512 0.11458333333333333
r11426 n6460 n6513 0.057291666666666664
r11427 n6512 n6513 0.21875
r11428 n6461 n6514 0.057291666666666664
r11429 n6462 n6515 0.076388888888888895
r11430 n6514 n6515 0.21875
r11431 n6463 n6516 0.34375
r11432 n6515 n6516 0.11458333333333333
r11433 n6464 n6517 0.34375
r11434 n6516 n6517 0.041666666666666664
r11435 n6465 n6518 0.0859375
r11436 n6517 n6518 0.10416666666666667
r11437 n6466 n6519 0.03125
r11438 n6518 n6519 0.3125
r11439 n6467 n6520 0.6875
r11440 n6519 n6520 0.23958333333333334
r11441 n6468 n6521 0.6875
r11442 n6520 n6521 0.020833333333333332
r11443 n6469 n6522 0.6875
r11444 n6521 n6522 0.020833333333333332
r11445 n6470 n6523 0.068750000000000006
r11446 n6522 n6523 0.11458333333333333
r11447 n6471 n6524 0.057291666666666664
r11448 n6523 n6524 0.22916666666666666
r11449 n6472 n6525 0.068750000000000006
r11450 n6473 n6526 0.029891304347826088
r11451 n6525 n6526 0.34375
r11452 n6474 n6527 0.34375
r11453 n6526 n6527 0.26041666666666669
r11454 n6475 n6528 0.022916666666666665
r11455 n6527 n6528 0.33333333333333331
r11456 n6476 n6529 0.34375
r11457 n6528 n6529 0.33333333333333331
r11458 n6477 n6530 0.029891304347826088
r11459 n6529 n6530 0.26041666666666669
r11460 n6478 n6531 0.068750000000000006
r11461 n6530 n6531 0.34375
r11462 n6479 n6532 0.050000000000000003
r11463 n6480 n6533 0.021739130434782608
r11464 n6532 n6533 1.03125
r11465 n6481 n6534 0.25
r11466 n6533 n6534 0.78125
r11467 n6482 n6535 0.016666666666666666
r11468 n6534 n6535 1
r11469 n6483 n6536 0.25
r11470 n6535 n6536 1
r11471 n6484 n6537 0.021739130434782608
r11472 n6536 n6537 0.78125
r11473 n6485 n6538 0.050000000000000003
r11474 n6537 n6538 1.03125
r11475 n6486 n6539 0.050000000000000003
r11476 n6538 n6539 0.625
r11477 n6487 n6540 0.013157894736842105
r11478 n6539 n6540 1.5
r11479 n6488 n6541 0.013157894736842105
r11480 n6540 n6541 2.375
r11481 n6489 n6542 0.013157894736842105
r11482 n6541 n6542 2.375
r11483 n6490 n6543 0.013157894736842105
r11484 n6542 n6543 2.375
r11485 n6491 n6544 0.014705882352941176
r11486 n6543 n6544 2.25
r11487 n6492 n6545 0.016129032258064516
r11488 n6544 n6545 2.03125
r11489 n6493 n6546 0.016129032258064516
r11490 n6545 n6546 1.9375
r11491 n6494 n6547 0.014705882352941176
r11492 n6546 n6547 2.03125
r11493 n6495 n6548 0.020833333333333332
r11494 n6547 n6548 1.8125
r11495 n6496 n6549 0.125
r11496 n6548 n6549 0.875
r11497 n6497 n6550 0.050000000000000003
r11498 n6549 n6550 0.4375
r11499 n6498 n6551 0.25
r11500 n6550 n6551 0.375
r11501 n6499 n6552 0.015625
r11502 n6551 n6552 1.0625
r11503 n6500 n6553 0.25
r11504 n6552 n6553 1.0625
r11505 n6501 n6554 0.013888888888888888
r11506 n6553 n6554 1.1875
r11507 n6502 n6555 0.25
r11508 n6554 n6555 1.1875
r11509 n6503 n6556 0.038461538461538464
r11510 n6555 n6556 0.46875
r11511 n6504 n6557 0.041666666666666664
r11512 n6556 n6557 0.78125
r11513 n6505 n6558 0.071428571428571425
r11514 n6557 n6558 0.59375
r11515 n6506 n6559 0.25
r11516 n6558 n6559 0.28125
r11517 n6507 n6560 0.125
r11518 n6559 n6560 0.1875
r11519 n6508 n6561 0.055555555555555552
r11520 n6560 n6561 0.40625
r11521 n6509 n6562 0.023809523809523808
r11522 n6561 n6562 0.9375
r11523 n6510 n6563 0.25
r11524 n6562 n6563 0.71875
r11525 n6511 n6564 0.25
r11526 n6563 n6564 0.125
r11527 n6512 n6565 0.055555555555555552
r11528 n6564 n6565 0.34375
r11529 n6513 n6566 0.041666666666666664
r11530 n6565 n6566 0.65625
r11531 n6514 n6567 0.041666666666666664
r11532 n6515 n6568 0.055555555555555552
r11533 n6567 n6568 0.65625
r11534 n6516 n6569 0.25
r11535 n6568 n6569 0.34375
r11536 n6517 n6570 0.25
r11537 n6569 n6570 0.125
r11538 n6518 n6571 0.0625
r11539 n6570 n6571 0.3125
r11540 n6519 n6572 0.022727272727272728
r11541 n6571 n6572 0.9375
r11542 n6520 n6573 0.5
r11543 n6572 n6573 0.71875
r11544 n6521 n6574 0.5
r11545 n6573 n6574 0.0625
r11546 n6522 n6575 0.5
r11547 n6574 n6575 0.0625
r11548 n6523 n6576 0.050000000000000003
r11549 n6575 n6576 0.34375
r11550 n6524 n6577 0.041666666666666664
r11551 n6576 n6577 0.6875
r11552 n6525 n6578 0.050000000000000003
r11553 n6526 n6579 0.021739130434782608
r11554 n6578 n6579 1.03125
r11555 n6527 n6580 0.25
r11556 n6579 n6580 0.78125
r11557 n6528 n6581 0.016666666666666666
r11558 n6580 n6581 1
r11559 n6529 n6582 0.25
r11560 n6581 n6582 1
r11561 n6530 n6583 0.021739130434782608
r11562 n6582 n6583 0.78125
r11563 n6531 n6584 0.050000000000000003
r11564 n6583 n6584 1.03125
r11565 n6532 n6585 0.043749999999999997
r11566 n6533 n6586 0.019021739130434784
r11567 n6585 n6586 0.41249999999999998
r11568 n6534 n6587 0.21875
r11569 n6586 n6587 0.3125
r11570 n6535 n6588 0.014583333333333334
r11571 n6587 n6588 0.40000000000000002
r11572 n6536 n6589 0.21875
r11573 n6588 n6589 0.40000000000000002
r11574 n6537 n6590 0.019021739130434784
r11575 n6589 n6590 0.3125
r11576 n6538 n6591 0.043749999999999997
r11577 n6590 n6591 0.41249999999999998
r11578 n6539 n6592 0.043749999999999997
r11579 n6591 n6592 0.25
r11580 n6540 n6593 0.011513157894736841
r11581 n6592 n6593 0.59999999999999998
r11582 n6541 n6594 0.011513157894736841
r11583 n6593 n6594 0.94999999999999996
r11584 n6542 n6595 0.011513157894736841
r11585 n6594 n6595 0.94999999999999996
r11586 n6543 n6596 0.011513157894736841
r11587 n6595 n6596 0.94999999999999996
r11588 n6544 n6597 0.012867647058823529
r11589 n6596 n6597 0.90000000000000002
r11590 n6545 n6598 0.014112903225806451
r11591 n6597 n6598 0.8125
r11592 n6546 n6599 0.014112903225806451
r11593 n6598 n6599 0.77500000000000002
r11594 n6547 n6600 0.012867647058823529
r11595 n6599 n6600 0.8125
r11596 n6548 n6601 0.018229166666666668
r11597 n6600 n6601 0.72499999999999998
r11598 n6549 n6602 0.109375
r11599 n6601 n6602 0.34999999999999998
r11600 n6550 n6603 0.043749999999999997
r11601 n6602 n6603 0.17499999999999999
r11602 n6551 n6604 0.21875
r11603 n6603 n6604 0.14999999999999999
r11604 n6552 n6605 0.013671875
r11605 n6604 n6605 0.42499999999999999
r11606 n6553 n6606 0.21875
r11607 n6605 n6606 0.42499999999999999
r11608 n6554 n6607 0.012152777777777778
r11609 n6606 n6607 0.47499999999999998
r11610 n6555 n6608 0.21875
r11611 n6607 n6608 0.47499999999999998
r11612 n6556 n6609 0.033653846153846152
r11613 n6608 n6609 0.1875
r11614 n6557 n6610 0.036458333333333336
r11615 n6609 n6610 0.3125
r11616 n6558 n6611 0.0625
r11617 n6610 n6611 0.23749999999999999
r11618 n6559 n6612 0.21875
r11619 n6611 n6612 0.1125
r11620 n6560 n6613 0.109375
r11621 n6612 n6613 0.074999999999999997
r11622 n6561 n6614 0.048611111111111112
r11623 n6613 n6614 0.16250000000000001
r11624 n6562 n6615 0.020833333333333332
r11625 n6614 n6615 0.375
r11626 n6563 n6616 0.21875
r11627 n6615 n6616 0.28749999999999998
r11628 n6564 n6617 0.21875
r11629 n6616 n6617 0.050000000000000003
r11630 n6565 n6618 0.048611111111111112
r11631 n6617 n6618 0.13750000000000001
r11632 n6566 n6619 0.036458333333333336
r11633 n6618 n6619 0.26250000000000001
r11634 n6567 n6620 0.036458333333333336
r11635 n6568 n6621 0.048611111111111112
r11636 n6620 n6621 0.26250000000000001
r11637 n6569 n6622 0.21875
r11638 n6621 n6622 0.13750000000000001
r11639 n6570 n6623 0.21875
r11640 n6622 n6623 0.050000000000000003
r11641 n6571 n6624 0.0546875
r11642 n6623 n6624 0.125
r11643 n6572 n6625 0.019886363636363636
r11644 n6624 n6625 0.375
r11645 n6573 n6626 0.4375
r11646 n6625 n6626 0.28749999999999998
r11647 n6574 n6627 0.4375
r11648 n6626 n6627 0.025000000000000001
r11649 n6575 n6628 0.4375
r11650 n6627 n6628 0.025000000000000001
r11651 n6576 n6629 0.043749999999999997
r11652 n6628 n6629 0.13750000000000001
r11653 n6577 n6630 0.036458333333333336
r11654 n6629 n6630 0.27500000000000002
r11655 n6578 n6631 0.043749999999999997
r11656 n6579 n6632 0.019021739130434784
r11657 n6631 n6632 0.41249999999999998
r11658 n6580 n6633 0.21875
r11659 n6632 n6633 0.3125
r11660 n6581 n6634 0.014583333333333334
r11661 n6633 n6634 0.40000000000000002
r11662 n6582 n6635 0.21875
r11663 n6634 n6635 0.40000000000000002
r11664 n6583 n6636 0.019021739130434784
r11665 n6635 n6636 0.3125
r11666 n6584 n6637 0.043749999999999997
r11667 n6636 n6637 0.41249999999999998
r11668 n6585 n6638 0.125
r11669 n6586 n6639 0.05434782608695652
r11670 n6638 n6639 0.13750000000000001
r11671 n6587 n6640 0.625
r11672 n6639 n6640 0.10416666666666667
r11673 n6588 n6641 0.041666666666666664
r11674 n6640 n6641 0.13333333333333333
r11675 n6589 n6642 0.625
r11676 n6641 n6642 0.13333333333333333
r11677 n6590 n6643 0.05434782608695652
r11678 n6642 n6643 0.10416666666666667
r11679 n6591 n6644 0.125
r11680 n6643 n6644 0.13750000000000001
r11681 n6592 n6645 0.125
r11682 n6644 n6645 0.083333333333333329
r11683 n6593 n6646 0.032894736842105261
r11684 n6645 n6646 0.20000000000000001
r11685 n6594 n6647 0.032894736842105261
r11686 n6646 n6647 0.31666666666666665
r11687 n6595 n6648 0.032894736842105261
r11688 n6647 n6648 0.31666666666666665
r11689 n6596 n6649 0.032894736842105261
r11690 n6648 n6649 0.31666666666666665
r11691 n6597 n6650 0.036764705882352942
r11692 n6649 n6650 0.29999999999999999
r11693 n6598 n6651 0.040322580645161289
r11694 n6650 n6651 0.27083333333333331
r11695 n6599 n6652 0.040322580645161289
r11696 n6651 n6652 0.25833333333333336
r11697 n6600 n6653 0.036764705882352942
r11698 n6652 n6653 0.27083333333333331
r11699 n6601 n6654 0.052083333333333336
r11700 n6653 n6654 0.24166666666666667
r11701 n6602 n6655 0.3125
r11702 n6654 n6655 0.11666666666666667
r11703 n6603 n6656 0.125
r11704 n6655 n6656 0.058333333333333334
r11705 n6604 n6657 0.625
r11706 n6656 n6657 0.050000000000000003
r11707 n6605 n6658 0.0390625
r11708 n6657 n6658 0.14166666666666666
r11709 n6606 n6659 0.625
r11710 n6658 n6659 0.14166666666666666
r11711 n6607 n6660 0.034722222222222224
r11712 n6659 n6660 0.15833333333333333
r11713 n6608 n6661 0.625
r11714 n6660 n6661 0.15833333333333333
r11715 n6609 n6662 0.096153846153846159
r11716 n6661 n6662 0.0625
r11717 n6610 n6663 0.10416666666666667
r11718 n6662 n6663 0.10416666666666667
r11719 n6611 n6664 0.17857142857142858
r11720 n6663 n6664 0.079166666666666663
r11721 n6612 n6665 0.625
r11722 n6664 n6665 0.037499999999999999
r11723 n6613 n6666 0.3125
r11724 n6665 n6666 0.025000000000000001
r11725 n6614 n6667 0.1388888888888889
r11726 n6666 n6667 0.054166666666666669
r11727 n6615 n6668 0.059523809523809521
r11728 n6667 n6668 0.125
r11729 n6616 n6669 0.625
r11730 n6668 n6669 0.09583333333333334
r11731 n6617 n6670 0.625
r11732 n6669 n6670 0.016666666666666666
r11733 n6618 n6671 0.1388888888888889
r11734 n6670 n6671 0.04583333333333333
r11735 n6619 n6672 0.10416666666666667
r11736 n6671 n6672 0.087499999999999994
r11737 n6620 n6673 0.10416666666666667
r11738 n6621 n6674 0.1388888888888889
r11739 n6673 n6674 0.087499999999999994
r11740 n6622 n6675 0.625
r11741 n6674 n6675 0.04583333333333333
r11742 n6623 n6676 0.625
r11743 n6675 n6676 0.016666666666666666
r11744 n6624 n6677 0.15625
r11745 n6676 n6677 0.041666666666666664
r11746 n6625 n6678 0.056818181818181816
r11747 n6677 n6678 0.125
r11748 n6626 n6679 1.25
r11749 n6678 n6679 0.09583333333333334
r11750 n6627 n6680 1.25
r11751 n6679 n6680 0.0083333333333333332
r11752 n6628 n6681 1.25
r11753 n6680 n6681 0.0083333333333333332
r11754 n6629 n6682 0.125
r11755 n6681 n6682 0.04583333333333333
r11756 n6630 n6683 0.10416666666666667
r11757 n6682 n6683 0.09166666666666666
r11758 n6631 n6684 0.125
r11759 n6632 n6685 0.05434782608695652
r11760 n6684 n6685 0.13750000000000001
r11761 n6633 n6686 0.625
r11762 n6685 n6686 0.10416666666666667
r11763 n6634 n6687 0.041666666666666664
r11764 n6686 n6687 0.13333333333333333
r11765 n6635 n6688 0.625
r11766 n6687 n6688 0.13333333333333333
r11767 n6636 n6689 0.05434782608695652
r11768 n6688 n6689 0.10416666666666667
r11769 n6637 n6690 0.125
r11770 n6689 n6690 0.13750000000000001
r11771 n6638 n6691 0.1125
r11772 n6639 n6692 0.048913043478260872
r11773 n6691 n6692 0.6875
r11774 n6640 n6693 0.5625
r11775 n6692 n6693 0.52083333333333337
r11776 n6641 n6694 0.037499999999999999
r11777 n6693 n6694 0.66666666666666663
r11778 n6642 n6695 0.5625
r11779 n6694 n6695 0.66666666666666663
r11780 n6643 n6696 0.048913043478260872
r11781 n6695 n6696 0.52083333333333337
r11782 n6644 n6697 0.1125
r11783 n6696 n6697 0.6875
r11784 n6645 n6698 0.1125
r11785 n6697 n6698 0.41666666666666669
r11786 n6646 n6699 0.029605263157894735
r11787 n6698 n6699 1
r11788 n6647 n6700 0.029605263157894735
r11789 n6699 n6700 1.5833333333333333
r11790 n6648 n6701 0.029605263157894735
r11791 n6700 n6701 1.5833333333333333
r11792 n6649 n6702 0.029605263157894735
r11793 n6701 n6702 1.5833333333333333
r11794 n6650 n6703 0.033088235294117647
r11795 n6702 n6703 1.5
r11796 n6651 n6704 0.036290322580645164
r11797 n6703 n6704 1.3541666666666667
r11798 n6652 n6705 0.036290322580645164
r11799 n6704 n6705 1.2916666666666667
r11800 n6653 n6706 0.033088235294117647
r11801 n6705 n6706 1.3541666666666667
r11802 n6654 n6707 0.046875
r11803 n6706 n6707 1.2083333333333333
r11804 n6655 n6708 0.28125
r11805 n6707 n6708 0.58333333333333337
r11806 n6656 n6709 0.1125
r11807 n6708 n6709 0.29166666666666669
r11808 n6657 n6710 0.5625
r11809 n6709 n6710 0.25
r11810 n6658 n6711 0.03515625
r11811 n6710 n6711 0.70833333333333337
r11812 n6659 n6712 0.5625
r11813 n6711 n6712 0.70833333333333337
r11814 n6660 n6713 0.03125
r11815 n6712 n6713 0.79166666666666663
r11816 n6661 n6714 0.5625
r11817 n6713 n6714 0.79166666666666663
r11818 n6662 n6715 0.086538461538461536
r11819 n6714 n6715 0.3125
r11820 n6663 n6716 0.09375
r11821 n6715 n6716 0.52083333333333337
r11822 n6664 n6717 0.16071428571428573
r11823 n6716 n6717 0.39583333333333331
r11824 n6665 n6718 0.5625
r11825 n6717 n6718 0.1875
r11826 n6666 n6719 0.28125
r11827 n6718 n6719 0.125
r11828 n6667 n6720 0.125
r11829 n6719 n6720 0.27083333333333331
r11830 n6668 n6721 0.053571428571428568
r11831 n6720 n6721 0.625
r11832 n6669 n6722 0.5625
r11833 n6721 n6722 0.47916666666666669
r11834 n6670 n6723 0.5625
r11835 n6722 n6723 0.083333333333333329
r11836 n6671 n6724 0.125
r11837 n6723 n6724 0.22916666666666666
r11838 n6672 n6725 0.09375
r11839 n6724 n6725 0.4375
r11840 n6726 n6727 0.35416666666666669
r11841 n6727 n6728 0.20833333333333334
r11842 n6728 n6729 0.125
r11843 n6729 n6730 0.10416666666666667
r11844 n6730 n6731 0.20833333333333334
r11845 n6731 n6732 0.625
r11846 n6732 n6733 0.5
r11847 n6733 n6734 0.10416666666666667
r11848 n6734 n6735 0.125
r11849 n6735 n6736 0.14583333333333334
r11850 n6736 n6737 0.14583333333333334
r11851 n6737 n6738 0.27083333333333331
r11852 n6673 n6739 0.09375
r11853 n6674 n6740 0.125
r11854 n6739 n6740 0.4375
r11855 n6675 n6741 0.5625
r11856 n6740 n6741 0.22916666666666666
r11857 n6676 n6742 0.5625
r11858 n6741 n6742 0.083333333333333329
r11859 n6677 n6743 0.140625
r11860 n6742 n6743 0.20833333333333334
r11861 n6678 n6744 0.05113636363636364
r11862 n6743 n6744 0.625
r11863 n6679 n6745 1.125
r11864 n6744 n6745 0.47916666666666669
r11865 n6680 n6746 1.125
r11866 n6745 n6746 0.041666666666666664
r11867 n6681 n6747 1.125
r11868 n6746 n6747 0.041666666666666664
r11869 n6682 n6748 0.1125
r11870 n6747 n6748 0.22916666666666666
r11871 n6683 n6749 0.09375
r11872 n6748 n6749 0.45833333333333331
r11873 n6750 n6751 0.35416666666666669
r11874 n6751 n6752 0.20833333333333334
r11875 n6752 n6753 0.125
r11876 n6753 n6754 0.10416666666666667
r11877 n6754 n6755 0.27083333333333331
r11878 n6755 n6756 0.625
r11879 n6756 n6757 0.4375
r11880 n6757 n6758 0.10416666666666667
r11881 n6758 n6759 0.125
r11882 n6759 n6760 0.20833333333333334
r11883 n6760 n6761 0.35416666666666669
r11884 n6684 n6762 0.1125
r11885 n6685 n6763 0.048913043478260872
r11886 n6762 n6763 0.6875
r11887 n6686 n6764 0.5625
r11888 n6763 n6764 0.52083333333333337
r11889 n6687 n6765 0.037499999999999999
r11890 n6764 n6765 0.66666666666666663
r11891 n6688 n6766 0.5625
r11892 n6765 n6766 0.66666666666666663
r11893 n6689 n6767 0.048913043478260872
r11894 n6766 n6767 0.52083333333333337
r11895 n6690 n6768 0.1125
r11896 n6767 n6768 0.6875
r11897 n6691 n6769 0.043749999999999997
r11898 n6692 n6770 0.019021739130434784
r11899 n6769 n6770 0.515625
r11900 n6693 n6771 0.21875
r11901 n6770 n6771 0.390625
r11902 n6694 n6772 0.014583333333333334
r11903 n6771 n6772 0.5
r11904 n6695 n6773 0.21875
r11905 n6772 n6773 0.5
r11906 n6696 n6774 0.019021739130434784
r11907 n6773 n6774 0.390625
r11908 n6697 n6775 0.043749999999999997
r11909 n6774 n6775 0.515625
r11910 n6698 n6776 0.043749999999999997
r11911 n6775 n6776 0.3125
r11912 n6699 n6777 0.011513157894736841
r11913 n6776 n6777 0.75
r11914 n6700 n6778 0.011513157894736841
r11915 n6777 n6778 1.1875
r11916 n6701 n6779 0.011513157894736841
r11917 n6778 n6779 1.1875
r11918 n6702 n6780 0.011513157894736841
r11919 n6779 n6780 1.1875
r11920 n6703 n6781 0.012867647058823529
r11921 n6780 n6781 1.125
r11922 n6704 n6782 0.014112903225806451
r11923 n6781 n6782 1.015625
r11924 n6705 n6783 0.014112903225806451
r11925 n6782 n6783 0.96875
r11926 n6706 n6784 0.012867647058823529
r11927 n6783 n6784 1.015625
r11928 n6707 n6785 0.018229166666666668
r11929 n6784 n6785 0.90625
r11930 n6708 n6786 0.109375
r11931 n6785 n6786 0.4375
r11932 n6709 n6787 0.043749999999999997
r11933 n6786 n6787 0.21875
r11934 n6710 n6788 0.21875
r11935 n6787 n6788 0.1875
r11936 n6711 n6789 0.013671875
r11937 n6788 n6789 0.53125
r11938 n6712 n6790 0.21875
r11939 n6789 n6790 0.53125
r11940 n6713 n6791 0.012152777777777778
r11941 n6790 n6791 0.59375
r11942 n6714 n6792 0.21875
r11943 n6791 n6792 0.59375
r11944 n6715 n6793 0.033653846153846152
r11945 n6792 n6793 0.234375
r11946 n6716 n6794 0.036458333333333336
r11947 n6793 n6794 0.390625
r11948 n6717 n6795 0.0625
r11949 n6794 n6795 0.296875
r11950 n6718 n6796 0.21875
r11951 n6795 n6796 0.140625
r11952 n6719 n6797 0.109375
r11953 n6796 n6797 0.09375
r11954 n6720 n6798 0.048611111111111112
r11955 n6797 n6798 0.203125
r11956 n6721 n6799 0.020833333333333332
r11957 n6798 n6799 0.46875
r11958 n6722 n6800 0.21875
r11959 n6799 n6800 0.359375
r11960 n6723 n6801 0.21875
r11961 n6800 n6801 0.0625
r11962 n6724 n6802 0.048611111111111112
r11963 n6801 n6802 0.171875
r11964 n6725 n6803 0.036458333333333336
r11965 n6802 n6803 0.328125
r11966 n6726 n6804 0.043749999999999997
r11967 n6727 n6805 0.0625
r11968 n6804 n6805 0.265625
r11969 n6728 n6806 0.14583333333333334
r11970 n6805 n6806 0.15625
r11971 n6729 n6807 0.14583333333333334
r11972 n6806 n6807 0.09375
r11973 n6730 n6808 0.21875
r11974 n6807 n6808 0.078125
r11975 n6731 n6809 0.0546875
r11976 n6808 n6809 0.15625
r11977 n6732 n6810 0.019886363636363636
r11978 n6809 n6810 0.46875
r11979 n6733 n6811 0.21875
r11980 n6810 n6811 0.375
r11981 n6734 n6812 0.14583333333333334
r11982 n6811 n6812 0.078125
r11983 n6735 n6813 0.14583333333333334
r11984 n6812 n6813 0.09375
r11985 n6736 n6814 0.109375
r11986 n6813 n6814 0.109375
r11987 n6737 n6815 0.14583333333333334
r11988 n6814 n6815 0.109375
r11989 n6738 n6816 0.043749999999999997
r11990 n6815 n6816 0.203125
r11991 n6739 n6817 0.036458333333333336
r11992 n6740 n6818 0.048611111111111112
r11993 n6817 n6818 0.328125
r11994 n6741 n6819 0.21875
r11995 n6818 n6819 0.171875
r11996 n6742 n6820 0.21875
r11997 n6819 n6820 0.0625
r11998 n6743 n6821 0.0546875
r11999 n6820 n6821 0.15625
r12000 n6744 n6822 0.019886363636363636
r12001 n6821 n6822 0.46875
r12002 n6745 n6823 0.4375
r12003 n6822 n6823 0.359375
r12004 n6746 n6824 0.4375
r12005 n6823 n6824 0.03125
r12006 n6747 n6825 0.4375
r12007 n6824 n6825 0.03125
r12008 n6748 n6826 0.043749999999999997
r12009 n6825 n6826 0.171875
r12010 n6749 n6827 0.036458333333333336
r12011 n6826 n6827 0.34375
r12012 n6750 n6828 0.043749999999999997
r12013 n6751 n6829 0.0625
r12014 n6828 n6829 0.265625
r12015 n6752 n6830 0.14583333333333334
r12016 n6829 n6830 0.15625
r12017 n6753 n6831 0.14583333333333334
r12018 n6830 n6831 0.09375
r12019 n6754 n6832 0.21875
r12020 n6831 n6832 0.078125
r12021 n6755 n6833 0.039772727272727272
r12022 n6832 n6833 0.203125
r12023 n6756 n6834 0.023026315789473683
r12024 n6833 n6834 0.46875
r12025 n6757 n6835 0.21875
r12026 n6834 n6835 0.328125
r12027 n6758 n6836 0.14583333333333334
r12028 n6835 n6836 0.078125
r12029 n6759 n6837 0.14583333333333334
r12030 n6836 n6837 0.09375
r12031 n6760 n6838 0.0625
r12032 n6837 n6838 0.15625
r12033 n6761 n6839 0.043749999999999997
r12034 n6838 n6839 0.265625
r12035 n6762 n6840 0.043749999999999997
r12036 n6763 n6841 0.019021739130434784
r12037 n6840 n6841 0.515625
r12038 n6764 n6842 0.21875
r12039 n6841 n6842 0.390625
r12040 n6765 n6843 0.014583333333333334
r12041 n6842 n6843 0.5
r12042 n6766 n6844 0.21875
r12043 n6843 n6844 0.5
r12044 n6767 n6845 0.019021739130434784
r12045 n6844 n6845 0.390625
r12046 n6768 n6846 0.043749999999999997
r12047 n6845 n6846 0.515625
r12048 n6769 n6847 0.043749999999999997
r12049 n6770 n6848 0.019021739130434784
r12050 n6847 n6848 0.6875
r12051 n6771 n6849 0.21875
r12052 n6848 n6849 0.52083333333333337
r12053 n6772 n6850 0.014583333333333334
r12054 n6849 n6850 0.66666666666666663
r12055 n6773 n6851 0.21875
r12056 n6850 n6851 0.66666666666666663
r12057 n6774 n6852 0.019021739130434784
r12058 n6851 n6852 0.52083333333333337
r12059 n6775 n6853 0.043749999999999997
r12060 n6852 n6853 0.6875
r12061 n6776 n6854 0.043749999999999997
r12062 n6853 n6854 0.41666666666666669
r12063 n6777 n6855 0.011513157894736841
r12064 n6854 n6855 1
r12065 n6778 n6856 0.011513157894736841
r12066 n6855 n6856 1.5833333333333333
r12067 n6779 n6857 0.011513157894736841
r12068 n6856 n6857 1.5833333333333333
r12069 n6780 n6858 0.011513157894736841
r12070 n6857 n6858 1.5833333333333333
r12071 n6781 n6859 0.012867647058823529
r12072 n6858 n6859 1.5
r12073 n6782 n6860 0.014112903225806451
r12074 n6859 n6860 1.3541666666666667
r12075 n6783 n6861 0.014112903225806451
r12076 n6860 n6861 1.2916666666666667
r12077 n6784 n6862 0.012867647058823529
r12078 n6861 n6862 1.3541666666666667
r12079 n6785 n6863 0.018229166666666668
r12080 n6862 n6863 1.2083333333333333
r12081 n6786 n6864 0.109375
r12082 n6863 n6864 0.58333333333333337
r12083 n6787 n6865 0.043749999999999997
r12084 n6864 n6865 0.29166666666666669
r12085 n6788 n6866 0.21875
r12086 n6865 n6866 0.25
r12087 n6789 n6867 0.013671875
r12088 n6866 n6867 0.70833333333333337
r12089 n6790 n6868 0.21875
r12090 n6867 n6868 0.70833333333333337
r12091 n6791 n6869 0.012152777777777778
r12092 n6868 n6869 0.79166666666666663
r12093 n6792 n6870 0.21875
r12094 n6869 n6870 0.79166666666666663
r12095 n6793 n6871 0.033653846153846152
r12096 n6870 n6871 0.3125
r12097 n6794 n6872 0.036458333333333336
r12098 n6871 n6872 0.52083333333333337
r12099 n6795 n6873 0.0625
r12100 n6872 n6873 0.39583333333333331
r12101 n6796 n6874 0.21875
r12102 n6873 n6874 0.1875
r12103 n6797 n6875 0.109375
r12104 n6874 n6875 0.125
r12105 n6798 n6876 0.048611111111111112
r12106 n6875 n6876 0.27083333333333331
r12107 n6799 n6877 0.020833333333333332
r12108 n6876 n6877 0.625
r12109 n6800 n6878 0.21875
r12110 n6877 n6878 0.47916666666666669
r12111 n6801 n6879 0.21875
r12112 n6878 n6879 0.083333333333333329
r12113 n6802 n6880 0.048611111111111112
r12114 n6879 n6880 0.22916666666666666
r12115 n6803 n6881 0.036458333333333336
r12116 n6880 n6881 0.4375
r12117 n6804 n6882 0.043749999999999997
r12118 n6805 n6883 0.0625
r12119 n6882 n6883 0.35416666666666669
r12120 n6806 n6884 0.14583333333333334
r12121 n6883 n6884 0.20833333333333334
r12122 n6807 n6885 0.14583333333333334
r12123 n6884 n6885 0.125
r12124 n6808 n6886 0.21875
r12125 n6885 n6886 0.10416666666666667
r12126 n6809 n6887 0.0546875
r12127 n6886 n6887 0.20833333333333334
r12128 n6810 n6888 0.019886363636363636
r12129 n6887 n6888 0.625
r12130 n6811 n6889 0.21875
r12131 n6888 n6889 0.5
r12132 n6812 n6890 0.14583333333333334
r12133 n6889 n6890 0.10416666666666667
r12134 n6813 n6891 0.14583333333333334
r12135 n6890 n6891 0.125
r12136 n6814 n6892 0.109375
r12137 n6891 n6892 0.14583333333333334
r12138 n6815 n6893 0.14583333333333334
r12139 n6892 n6893 0.14583333333333334
r12140 n6816 n6894 0.043749999999999997
r12141 n6893 n6894 0.27083333333333331
r12142 n6817 n6895 0.036458333333333336
r12143 n6818 n6896 0.048611111111111112
r12144 n6895 n6896 0.4375
r12145 n6819 n6897 0.21875
r12146 n6896 n6897 0.22916666666666666
r12147 n6820 n6898 0.21875
r12148 n6897 n6898 0.083333333333333329
r12149 n6821 n6899 0.0546875
r12150 n6898 n6899 0.20833333333333334
r12151 n6822 n6900 0.019886363636363636
r12152 n6899 n6900 0.625
r12153 n6823 n6901 0.4375
r12154 n6900 n6901 0.47916666666666669
r12155 n6824 n6902 0.4375
r12156 n6901 n6902 0.041666666666666664
r12157 n6825 n6903 0.4375
r12158 n6902 n6903 0.041666666666666664
r12159 n6826 n6904 0.043749999999999997
r12160 n6903 n6904 0.22916666666666666
r12161 n6827 n6905 0.036458333333333336
r12162 n6904 n6905 0.45833333333333331
r12163 n6828 n6906 0.043749999999999997
r12164 n6829 n6907 0.0625
r12165 n6906 n6907 0.35416666666666669
r12166 n6830 n6908 0.14583333333333334
r12167 n6907 n6908 0.20833333333333334
r12168 n6831 n6909 0.14583333333333334
r12169 n6908 n6909 0.125
r12170 n6832 n6910 0.21875
r12171 n6909 n6910 0.10416666666666667
r12172 n6833 n6911 0.039772727272727272
r12173 n6910 n6911 0.27083333333333331
r12174 n6834 n6912 0.023026315789473683
r12175 n6911 n6912 0.625
r12176 n6835 n6913 0.21875
r12177 n6912 n6913 0.4375
r12178 n6836 n6914 0.14583333333333334
r12179 n6913 n6914 0.10416666666666667
r12180 n6837 n6915 0.14583333333333334
r12181 n6914 n6915 0.125
r12182 n6838 n6916 0.0625
r12183 n6915 n6916 0.20833333333333334
r12184 n6839 n6917 0.043749999999999997
r12185 n6916 n6917 0.35416666666666669
r12186 n6840 n6918 0.043749999999999997
r12187 n6841 n6919 0.019021739130434784
r12188 n6918 n6919 0.6875
r12189 n6842 n6920 0.21875
r12190 n6919 n6920 0.52083333333333337
r12191 n6843 n6921 0.014583333333333334
r12192 n6920 n6921 0.66666666666666663
r12193 n6844 n6922 0.21875
r12194 n6921 n6922 0.66666666666666663
r12195 n6845 n6923 0.019021739130434784
r12196 n6922 n6923 0.52083333333333337
r12197 n6846 n6924 0.043749999999999997
r12198 n6923 n6924 0.6875
r12199 n6847 n6925 0.03125
r12200 n6848 n6926 0.01358695652173913
r12201 n6925 n6926 1.03125
r12202 n6849 n6927 0.15625
r12203 n6926 n6927 0.78125
r12204 n6850 n6928 0.010416666666666666
r12205 n6927 n6928 1
r12206 n6851 n6929 0.15625
r12207 n6928 n6929 1
r12208 n6852 n6930 0.01358695652173913
r12209 n6929 n6930 0.78125
r12210 n6853 n6931 0.03125
r12211 n6930 n6931 1.03125
r12212 n6854 n6932 0.03125
r12213 n6931 n6932 0.625
r12214 n6855 n6933 0.0082236842105263153
r12215 n6932 n6933 1.5
r12216 n6856 n6934 0.0082236842105263153
r12217 n6933 n6934 2.375
r12218 n6857 n6935 0.0082236842105263153
r12219 n6934 n6935 2.375
r12220 n6858 n6936 0.0082236842105263153
r12221 n6935 n6936 2.375
r12222 n6859 n6937 0.0091911764705882356
r12223 n6936 n6937 2.25
r12224 n6860 n6938 0.010080645161290322
r12225 n6937 n6938 2.03125
r12226 n6861 n6939 0.010080645161290322
r12227 n6938 n6939 1.9375
r12228 n6862 n6940 0.0091911764705882356
r12229 n6939 n6940 2.03125
r12230 n6863 n6941 0.013020833333333334
r12231 n6940 n6941 1.8125
r12232 n6864 n6942 0.078125
r12233 n6941 n6942 0.875
r12234 n6865 n6943 0.03125
r12235 n6942 n6943 0.4375
r12236 n6866 n6944 0.15625
r12237 n6943 n6944 0.375
r12238 n6867 n6945 0.009765625
r12239 n6944 n6945 1.0625
r12240 n6868 n6946 0.15625
r12241 n6945 n6946 1.0625
r12242 n6869 n6947 0.0086805555555555559
r12243 n6946 n6947 1.1875
r12244 n6870 n6948 0.15625
r12245 n6947 n6948 1.1875
r12246 n6871 n6949 0.02403846153846154
r12247 n6948 n6949 0.46875
r12248 n6872 n6950 0.026041666666666668
r12249 n6949 n6950 0.78125
r12250 n6873 n6951 0.044642857142857144
r12251 n6950 n6951 0.59375
r12252 n6874 n6952 0.15625
r12253 n6951 n6952 0.28125
r12254 n6875 n6953 0.078125
r12255 n6952 n6953 0.1875
r12256 n6876 n6954 0.034722222222222224
r12257 n6953 n6954 0.40625
r12258 n6877 n6955 0.01488095238095238
r12259 n6954 n6955 0.9375
r12260 n6878 n6956 0.15625
r12261 n6955 n6956 0.71875
r12262 n6879 n6957 0.15625
r12263 n6956 n6957 0.125
r12264 n6880 n6958 0.034722222222222224
r12265 n6957 n6958 0.34375
r12266 n6881 n6959 0.026041666666666668
r12267 n6958 n6959 0.65625
r12268 n6882 n6960 0.03125
r12269 n6883 n6961 0.044642857142857144
r12270 n6960 n6961 0.53125
r12271 n6884 n6962 0.10416666666666667
r12272 n6961 n6962 0.3125
r12273 n6885 n6963 0.10416666666666667
r12274 n6962 n6963 0.1875
r12275 n6886 n6964 0.15625
r12276 n6963 n6964 0.15625
r12277 n6887 n6965 0.0390625
r12278 n6964 n6965 0.3125
r12279 n6888 n6966 0.014204545454545454
r12280 n6965 n6966 0.9375
r12281 n6889 n6967 0.15625
r12282 n6966 n6967 0.75
r12283 n6890 n6968 0.10416666666666667
r12284 n6967 n6968 0.15625
r12285 n6891 n6969 0.10416666666666667
r12286 n6968 n6969 0.1875
r12287 n6892 n6970 0.078125
r12288 n6969 n6970 0.21875
r12289 n6893 n6971 0.10416666666666667
r12290 n6970 n6971 0.21875
r12291 n6894 n6972 0.03125
r12292 n6971 n6972 0.40625
r12293 n6895 n6973 0.026041666666666668
r12294 n6896 n6974 0.034722222222222224
r12295 n6973 n6974 0.65625
r12296 n6897 n6975 0.15625
r12297 n6974 n6975 0.34375
r12298 n6898 n6976 0.15625
r12299 n6975 n6976 0.125
r12300 n6899 n6977 0.0390625
r12301 n6976 n6977 0.3125
r12302 n6900 n6978 0.014204545454545454
r12303 n6977 n6978 0.9375
r12304 n6901 n6979 0.3125
r12305 n6978 n6979 0.71875
r12306 n6902 n6980 0.3125
r12307 n6979 n6980 0.0625
r12308 n6903 n6981 0.3125
r12309 n6980 n6981 0.0625
r12310 n6904 n6982 0.03125
r12311 n6981 n6982 0.34375
r12312 n6905 n6983 0.026041666666666668
r12313 n6982 n6983 0.6875
r12314 n6906 n6984 0.03125
r12315 n6907 n6985 0.044642857142857144
r12316 n6984 n6985 0.53125
r12317 n6908 n6986 0.10416666666666667
r12318 n6985 n6986 0.3125
r12319 n6909 n6987 0.10416666666666667
r12320 n6986 n6987 0.1875
r12321 n6910 n6988 0.15625
r12322 n6987 n6988 0.15625
r12323 n6911 n6989 0.028409090909090908
r12324 n6988 n6989 0.40625
r12325 n6912 n6990 0.016447368421052631
r12326 n6989 n6990 0.9375
r12327 n6913 n6991 0.15625
r12328 n6990 n6991 0.65625
r12329 n6914 n6992 0.10416666666666667
r12330 n6991 n6992 0.15625
r12331 n6915 n6993 0.10416666666666667
r12332 n6992 n6993 0.1875
r12333 n6916 n6994 0.044642857142857144
r12334 n6993 n6994 0.3125
r12335 n6917 n6995 0.03125
r12336 n6994 n6995 0.53125
r12337 n6918 n6996 0.03125
r12338 n6919 n6997 0.01358695652173913
r12339 n6996 n6997 1.03125
r12340 n6920 n6998 0.15625
r12341 n6997 n6998 0.78125
r12342 n6921 n6999 0.010416666666666666
r12343 n6998 n6999 1
r12344 n6922 n7000 0.15625
r12345 n6999 n7000 1
r12346 n6923 n7001 0.01358695652173913
r12347 n7000 n7001 0.78125
r12348 n6924 n7002 0.03125
r12349 n7001 n7002 1.03125
r12350 n6925 n7003 0.050000000000000003
r12351 n6926 n7004 0.021739130434782608
r12352 n7003 n7004 0.34375
r12353 n6927 n7005 0.25
r12354 n7004 n7005 0.26041666666666669
r12355 n6928 n7006 0.016666666666666666
r12356 n7005 n7006 0.33333333333333331
r12357 n6929 n7007 0.25
r12358 n7006 n7007 0.33333333333333331
r12359 n6930 n7008 0.021739130434782608
r12360 n7007 n7008 0.26041666666666669
r12361 n6931 n7009 0.050000000000000003
r12362 n7008 n7009 0.34375
r12363 n6932 n7010 0.050000000000000003
r12364 n7009 n7010 0.20833333333333334
r12365 n6933 n7011 0.013157894736842105
r12366 n7010 n7011 0.5
r12367 n6934 n7012 0.013157894736842105
r12368 n7011 n7012 0.79166666666666663
r12369 n6935 n7013 0.013157894736842105
r12370 n7012 n7013 0.79166666666666663
r12371 n6936 n7014 0.013157894736842105
r12372 n7013 n7014 0.79166666666666663
r12373 n6937 n7015 0.014705882352941176
r12374 n7014 n7015 0.75
r12375 n6938 n7016 0.016129032258064516
r12376 n7015 n7016 0.67708333333333337
r12377 n6939 n7017 0.016129032258064516
r12378 n7016 n7017 0.64583333333333337
r12379 n6940 n7018 0.014705882352941176
r12380 n7017 n7018 0.67708333333333337
r12381 n6941 n7019 0.020833333333333332
r12382 n7018 n7019 0.60416666666666663
r12383 n6942 n7020 0.125
r12384 n7019 n7020 0.29166666666666669
r12385 n6943 n7021 0.050000000000000003
r12386 n7020 n7021 0.14583333333333334
r12387 n6944 n7022 0.25
r12388 n7021 n7022 0.125
r12389 n6945 n7023 0.015625
r12390 n7022 n7023 0.35416666666666669
r12391 n6946 n7024 0.25
r12392 n7023 n7024 0.35416666666666669
r12393 n6947 n7025 0.013888888888888888
r12394 n7024 n7025 0.39583333333333331
r12395 n6948 n7026 0.25
r12396 n7025 n7026 0.39583333333333331
r12397 n6949 n7027 0.038461538461538464
r12398 n7026 n7027 0.15625
r12399 n6950 n7028 0.041666666666666664
r12400 n7027 n7028 0.26041666666666669
r12401 n6951 n7029 0.071428571428571425
r12402 n7028 n7029 0.19791666666666666
r12403 n6952 n7030 0.25
r12404 n7029 n7030 0.09375
r12405 n6953 n7031 0.125
r12406 n7030 n7031 0.0625
r12407 n6954 n7032 0.055555555555555552
r12408 n7031 n7032 0.13541666666666666
r12409 n6955 n7033 0.023809523809523808
r12410 n7032 n7033 0.3125
r12411 n6956 n7034 0.25
r12412 n7033 n7034 0.23958333333333334
r12413 n6957 n7035 0.25
r12414 n7034 n7035 0.041666666666666664
r12415 n6958 n7036 0.055555555555555552
r12416 n7035 n7036 0.11458333333333333
r12417 n6959 n7037 0.041666666666666664
r12418 n7036 n7037 0.21875
r12419 n6960 n7038 0.050000000000000003
r12420 n6961 n7039 0.071428571428571425
r12421 n7038 n7039 0.17708333333333334
r12422 n6962 n7040 0.16666666666666666
r12423 n7039 n7040 0.10416666666666667
r12424 n6963 n7041 0.16666666666666666
r12425 n7040 n7041 0.0625
r12426 n6964 n7042 0.25
r12427 n7041 n7042 0.052083333333333336
r12428 n6965 n7043 0.0625
r12429 n7042 n7043 0.10416666666666667
r12430 n6966 n7044 0.022727272727272728
r12431 n7043 n7044 0.3125
r12432 n6967 n7045 0.25
r12433 n7044 n7045 0.25
r12434 n6968 n7046 0.16666666666666666
r12435 n7045 n7046 0.052083333333333336
r12436 n6969 n7047 0.16666666666666666
r12437 n7046 n7047 0.0625
r12438 n6970 n7048 0.125
r12439 n7047 n7048 0.072916666666666671
r12440 n6971 n7049 0.16666666666666666
r12441 n7048 n7049 0.072916666666666671
r12442 n6972 n7050 0.050000000000000003
r12443 n7049 n7050 0.13541666666666666
r12444 n6973 n7051 0.041666666666666664
r12445 n6974 n7052 0.055555555555555552
r12446 n7051 n7052 0.21875
r12447 n6975 n7053 0.25
r12448 n7052 n7053 0.11458333333333333
r12449 n6976 n7054 0.25
r12450 n7053 n7054 0.041666666666666664
r12451 n6977 n7055 0.0625
r12452 n7054 n7055 0.10416666666666667
r12453 n6978 n7056 0.022727272727272728
r12454 n7055 n7056 0.3125
r12455 n6979 n7057 0.5
r12456 n7056 n7057 0.23958333333333334
r12457 n6980 n7058 0.5
r12458 n7057 n7058 0.020833333333333332
r12459 n6981 n7059 0.5
r12460 n7058 n7059 0.020833333333333332
r12461 n6982 n7060 0.050000000000000003
r12462 n7059 n7060 0.11458333333333333
r12463 n6983 n7061 0.041666666666666664
r12464 n7060 n7061 0.22916666666666666
r12465 n6984 n7062 0.050000000000000003
r12466 n6985 n7063 0.071428571428571425
r12467 n7062 n7063 0.17708333333333334
r12468 n6986 n7064 0.16666666666666666
r12469 n7063 n7064 0.10416666666666667
r12470 n6987 n7065 0.16666666666666666
r12471 n7064 n7065 0.0625
r12472 n6988 n7066 0.25
r12473 n7065 n7066 0.052083333333333336
r12474 n6989 n7067 0.045454545454545456
r12475 n7066 n7067 0.13541666666666666
r12476 n6990 n7068 0.026315789473684209
r12477 n7067 n7068 0.3125
r12478 n6991 n7069 0.25
r12479 n7068 n7069 0.21875
r12480 n6992 n7070 0.16666666666666666
r12481 n7069 n7070 0.052083333333333336
r12482 n6993 n7071 0.16666666666666666
r12483 n7070 n7071 0.0625
r12484 n6994 n7072 0.071428571428571425
r12485 n7071 n7072 0.10416666666666667
r12486 n6995 n7073 0.050000000000000003
r12487 n7072 n7073 0.17708333333333334
r12488 n6996 n7074 0.050000000000000003
r12489 n6997 n7075 0.021739130434782608
r12490 n7074 n7075 0.34375
r12491 n6998 n7076 0.25
r12492 n7075 n7076 0.26041666666666669
r12493 n6999 n7077 0.016666666666666666
r12494 n7076 n7077 0.33333333333333331
r12495 n7000 n7078 0.25
r12496 n7077 n7078 0.33333333333333331
r12497 n7001 n7079 0.021739130434782608
r12498 n7078 n7079 0.26041666666666669
r12499 n7002 n7080 0.050000000000000003
r12500 n7079 n7080 0.34375
r12501 n7003 n7081 0.050000000000000003
r12502 n7004 n7082 0.021739130434782608
r12503 n7081 n7082 1.03125
r12504 n7005 n7083 0.25
r12505 n7082 n7083 0.78125
r12506 n7006 n7084 0.016666666666666666
r12507 n7083 n7084 1
r12508 n7007 n7085 0.25
r12509 n7084 n7085 1
r12510 n7008 n7086 0.021739130434782608
r12511 n7085 n7086 0.78125
r12512 n7009 n7087 0.050000000000000003
r12513 n7086 n7087 1.03125
r12514 n7010 n7088 0.050000000000000003
r12515 n7087 n7088 0.625
r12516 n7011 n7089 0.013157894736842105
r12517 n7088 n7089 1.5
r12518 n7012 n7090 0.013157894736842105
r12519 n7089 n7090 2.375
r12520 n7013 n7091 0.013157894736842105
r12521 n7090 n7091 2.375
r12522 n7014 n7092 0.013157894736842105
r12523 n7091 n7092 2.375
r12524 n7015 n7093 0.014705882352941176
r12525 n7092 n7093 2.25
r12526 n7016 n7094 0.016129032258064516
r12527 n7093 n7094 2.03125
r12528 n7017 n7095 0.016129032258064516
r12529 n7094 n7095 1.9375
r12530 n7018 n7096 0.014705882352941176
r12531 n7095 n7096 2.03125
r12532 n7019 n7097 0.020833333333333332
r12533 n7096 n7097 1.8125
r12534 n7020 n7098 0.125
r12535 n7097 n7098 0.875
r12536 n7021 n7099 0.050000000000000003
r12537 n7098 n7099 0.4375
r12538 n7022 n7100 0.25
r12539 n7099 n7100 0.375
r12540 n7023 n7101 0.015625
r12541 n7100 n7101 1.0625
r12542 n7024 n7102 0.25
r12543 n7101 n7102 1.0625
r12544 n7025 n7103 0.013888888888888888
r12545 n7102 n7103 1.1875
r12546 n7026 n7104 0.25
r12547 n7103 n7104 1.1875
r12548 n7027 n7105 0.038461538461538464
r12549 n7104 n7105 0.46875
r12550 n7028 n7106 0.041666666666666664
r12551 n7105 n7106 0.78125
r12552 n7029 n7107 0.071428571428571425
r12553 n7106 n7107 0.59375
r12554 n7030 n7108 0.25
r12555 n7107 n7108 0.28125
r12556 n7031 n7109 0.125
r12557 n7108 n7109 0.1875
r12558 n7032 n7110 0.055555555555555552
r12559 n7109 n7110 0.40625
r12560 n7033 n7111 0.023809523809523808
r12561 n7110 n7111 0.9375
r12562 n7034 n7112 0.25
r12563 n7111 n7112 0.71875
r12564 n7035 n7113 0.25
r12565 n7112 n7113 0.125
r12566 n7036 n7114 0.055555555555555552
r12567 n7113 n7114 0.34375
r12568 n7037 n7115 0.041666666666666664
r12569 n7114 n7115 0.65625
r12570 n7038 n7116 0.050000000000000003
r12571 n7039 n7117 0.071428571428571425
r12572 n7116 n7117 0.53125
r12573 n7040 n7118 0.16666666666666666
r12574 n7117 n7118 0.3125
r12575 n7041 n7119 0.16666666666666666
r12576 n7118 n7119 0.1875
r12577 n7042 n7120 0.25
r12578 n7119 n7120 0.15625
r12579 n7043 n7121 0.0625
r12580 n7120 n7121 0.3125
r12581 n7044 n7122 0.022727272727272728
r12582 n7121 n7122 0.9375
r12583 n7045 n7123 0.25
r12584 n7122 n7123 0.75
r12585 n7046 n7124 0.16666666666666666
r12586 n7123 n7124 0.15625
r12587 n7047 n7125 0.16666666666666666
r12588 n7124 n7125 0.1875
r12589 n7048 n7126 0.125
r12590 n7125 n7126 0.21875
r12591 n7049 n7127 0.16666666666666666
r12592 n7126 n7127 0.21875
r12593 n7050 n7128 0.050000000000000003
r12594 n7127 n7128 0.40625
r12595 n7051 n7129 0.041666666666666664
r12596 n7052 n7130 0.055555555555555552
r12597 n7129 n7130 0.65625
r12598 n7053 n7131 0.25
r12599 n7130 n7131 0.34375
r12600 n7054 n7132 0.25
r12601 n7131 n7132 0.125
r12602 n7055 n7133 0.0625
r12603 n7132 n7133 0.3125
r12604 n7056 n7134 0.022727272727272728
r12605 n7133 n7134 0.9375
r12606 n7057 n7135 0.5
r12607 n7134 n7135 0.71875
r12608 n7058 n7136 0.5
r12609 n7135 n7136 0.0625
r12610 n7059 n7137 0.5
r12611 n7136 n7137 0.0625
r12612 n7060 n7138 0.050000000000000003
r12613 n7137 n7138 0.34375
r12614 n7061 n7139 0.041666666666666664
r12615 n7138 n7139 0.6875
r12616 n7062 n7140 0.050000000000000003
r12617 n7063 n7141 0.071428571428571425
r12618 n7140 n7141 0.53125
r12619 n7064 n7142 0.16666666666666666
r12620 n7141 n7142 0.3125
r12621 n7065 n7143 0.16666666666666666
r12622 n7142 n7143 0.1875
r12623 n7066 n7144 0.25
r12624 n7143 n7144 0.15625
r12625 n7067 n7145 0.045454545454545456
r12626 n7144 n7145 0.40625
r12627 n7068 n7146 0.026315789473684209
r12628 n7145 n7146 0.9375
r12629 n7069 n7147 0.25
r12630 n7146 n7147 0.65625
r12631 n7070 n7148 0.16666666666666666
r12632 n7147 n7148 0.15625
r12633 n7071 n7149 0.16666666666666666
r12634 n7148 n7149 0.1875
r12635 n7072 n7150 0.071428571428571425
r12636 n7149 n7150 0.3125
r12637 n7073 n7151 0.050000000000000003
r12638 n7150 n7151 0.53125
r12639 n7074 n7152 0.050000000000000003
r12640 n7075 n7153 0.021739130434782608
r12641 n7152 n7153 1.03125
r12642 n7076 n7154 0.25
r12643 n7153 n7154 0.78125
r12644 n7077 n7155 0.016666666666666666
r12645 n7154 n7155 1
r12646 n7078 n7156 0.25
r12647 n7155 n7156 1
r12648 n7079 n7157 0.021739130434782608
r12649 n7156 n7157 0.78125
r12650 n7080 n7158 0.050000000000000003
r12651 n7157 n7158 1.03125
r12652 n7081 n7159 0.03125
r12653 n7082 n7160 0.01358695652173913
r12654 n7159 n7160 0.6875
r12655 n7083 n7161 0.15625
r12656 n7160 n7161 0.52083333333333337
r12657 n7084 n7162 0.010416666666666666
r12658 n7161 n7162 0.66666666666666663
r12659 n7085 n7163 0.15625
r12660 n7162 n7163 0.66666666666666663
r12661 n7086 n7164 0.01358695652173913
r12662 n7163 n7164 0.52083333333333337
r12663 n7087 n7165 0.03125
r12664 n7164 n7165 0.6875
r12665 n7088 n7166 0.03125
r12666 n7165 n7166 0.41666666666666669
r12667 n7089 n7167 0.0082236842105263153
r12668 n7166 n7167 1
r12669 n7090 n7168 0.0082236842105263153
r12670 n7167 n7168 1.5833333333333333
r12671 n7091 n7169 0.0082236842105263153
r12672 n7168 n7169 1.5833333333333333
r12673 n7092 n7170 0.0082236842105263153
r12674 n7169 n7170 1.5833333333333333
r12675 n7093 n7171 0.0091911764705882356
r12676 n7170 n7171 1.5
r12677 n7094 n7172 0.010080645161290322
r12678 n7171 n7172 1.3541666666666667
r12679 n7095 n7173 0.010080645161290322
r12680 n7172 n7173 1.2916666666666667
r12681 n7096 n7174 0.0091911764705882356
r12682 n7173 n7174 1.3541666666666667
r12683 n7097 n7175 0.013020833333333334
r12684 n7174 n7175 1.2083333333333333
r12685 n7098 n7176 0.078125
r12686 n7175 n7176 0.58333333333333337
r12687 n7099 n7177 0.03125
r12688 n7176 n7177 0.29166666666666669
r12689 n7100 n7178 0.15625
r12690 n7177 n7178 0.25
r12691 n7101 n7179 0.009765625
r12692 n7178 n7179 0.70833333333333337
r12693 n7102 n7180 0.15625
r12694 n7179 n7180 0.70833333333333337
r12695 n7103 n7181 0.0086805555555555559
r12696 n7180 n7181 0.79166666666666663
r12697 n7104 n7182 0.15625
r12698 n7181 n7182 0.79166666666666663
r12699 n7105 n7183 0.02403846153846154
r12700 n7182 n7183 0.3125
r12701 n7106 n7184 0.026041666666666668
r12702 n7183 n7184 0.52083333333333337
r12703 n7107 n7185 0.044642857142857144
r12704 n7184 n7185 0.39583333333333331
r12705 n7108 n7186 0.15625
r12706 n7185 n7186 0.1875
r12707 n7109 n7187 0.078125
r12708 n7186 n7187 0.125
r12709 n7110 n7188 0.034722222222222224
r12710 n7187 n7188 0.27083333333333331
r12711 n7111 n7189 0.01488095238095238
r12712 n7188 n7189 0.625
r12713 n7112 n7190 0.15625
r12714 n7189 n7190 0.47916666666666669
r12715 n7113 n7191 0.15625
r12716 n7190 n7191 0.083333333333333329
r12717 n7114 n7192 0.034722222222222224
r12718 n7191 n7192 0.22916666666666666
r12719 n7115 n7193 0.026041666666666668
r12720 n7192 n7193 0.4375
r12721 n7116 n7194 0.03125
r12722 n7117 n7195 0.044642857142857144
r12723 n7194 n7195 0.35416666666666669
r12724 n7118 n7196 0.10416666666666667
r12725 n7195 n7196 0.20833333333333334
r12726 n7119 n7197 0.10416666666666667
r12727 n7196 n7197 0.125
r12728 n7120 n7198 0.15625
r12729 n7197 n7198 0.10416666666666667
r12730 n7121 n7199 0.0390625
r12731 n7198 n7199 0.20833333333333334
r12732 n7122 n7200 0.014204545454545454
r12733 n7199 n7200 0.625
r12734 n7123 n7201 0.15625
r12735 n7200 n7201 0.5
r12736 n7124 n7202 0.10416666666666667
r12737 n7201 n7202 0.10416666666666667
r12738 n7125 n7203 0.10416666666666667
r12739 n7202 n7203 0.125
r12740 n7126 n7204 0.078125
r12741 n7203 n7204 0.14583333333333334
r12742 n7127 n7205 0.10416666666666667
r12743 n7204 n7205 0.14583333333333334
r12744 n7128 n7206 0.03125
r12745 n7205 n7206 0.27083333333333331
r12746 n7129 n7207 0.026041666666666668
r12747 n7130 n7208 0.034722222222222224
r12748 n7207 n7208 0.4375
r12749 n7131 n7209 0.15625
r12750 n7208 n7209 0.22916666666666666
r12751 n7132 n7210 0.15625
r12752 n7209 n7210 0.083333333333333329
r12753 n7133 n7211 0.0390625
r12754 n7210 n7211 0.20833333333333334
r12755 n7134 n7212 0.014204545454545454
r12756 n7211 n7212 0.625
r12757 n7135 n7213 0.3125
r12758 n7212 n7213 0.47916666666666669
r12759 n7136 n7214 0.3125
r12760 n7213 n7214 0.041666666666666664
r12761 n7137 n7215 0.3125
r12762 n7214 n7215 0.041666666666666664
r12763 n7138 n7216 0.03125
r12764 n7215 n7216 0.22916666666666666
r12765 n7139 n7217 0.026041666666666668
r12766 n7216 n7217 0.45833333333333331
r12767 n7140 n7218 0.03125
r12768 n7141 n7219 0.044642857142857144
r12769 n7218 n7219 0.35416666666666669
r12770 n7142 n7220 0.10416666666666667
r12771 n7219 n7220 0.20833333333333334
r12772 n7143 n7221 0.10416666666666667
r12773 n7220 n7221 0.125
r12774 n7144 n7222 0.15625
r12775 n7221 n7222 0.10416666666666667
r12776 n7145 n7223 0.028409090909090908
r12777 n7222 n7223 0.27083333333333331
r12778 n7146 n7224 0.016447368421052631
r12779 n7223 n7224 0.625
r12780 n7147 n7225 0.15625
r12781 n7224 n7225 0.4375
r12782 n7148 n7226 0.10416666666666667
r12783 n7225 n7226 0.10416666666666667
r12784 n7149 n7227 0.10416666666666667
r12785 n7226 n7227 0.125
r12786 n7150 n7228 0.044642857142857144
r12787 n7227 n7228 0.20833333333333334
r12788 n7151 n7229 0.03125
r12789 n7228 n7229 0.35416666666666669
r12790 n7152 n7230 0.03125
r12791 n7153 n7231 0.01358695652173913
r12792 n7230 n7231 0.6875
r12793 n7154 n7232 0.15625
r12794 n7231 n7232 0.52083333333333337
r12795 n7155 n7233 0.010416666666666666
r12796 n7232 n7233 0.66666666666666663
r12797 n7156 n7234 0.15625
r12798 n7233 n7234 0.66666666666666663
r12799 n7157 n7235 0.01358695652173913
r12800 n7234 n7235 0.52083333333333337
r12801 n7158 n7236 0.03125
r12802 n7235 n7236 0.6875
r12803 n7159 n7237 0.03125
r12804 n7160 n7238 0.01358695652173913
r12805 n7237 n7238 1.03125
r12806 n7161 n7239 0.15625
r12807 n7238 n7239 0.78125
r12808 n7162 n7240 0.010416666666666666
r12809 n7239 n7240 1
r12810 n7163 n7241 0.15625
r12811 n7240 n7241 1
r12812 n7164 n7242 0.01358695652173913
r12813 n7241 n7242 0.78125
r12814 n7165 n7243 0.03125
r12815 n7242 n7243 1.03125
r12816 n7184 n7244 0.026041666666666668
r12817 n7185 n7245 0.044642857142857144
r12818 n7244 n7245 0.59375
r12819 n7186 n7246 0.15625
r12820 n7245 n7246 0.28125
r12821 n7187 n7247 0.078125
r12822 n7246 n7247 0.1875
r12823 n7188 n7248 0.034722222222222224
r12824 n7247 n7248 0.40625
r12825 n7189 n7249 0.01488095238095238
r12826 n7248 n7249 0.9375
r12827 n7190 n7250 0.15625
r12828 n7249 n7250 0.71875
r12829 n7191 n7251 0.15625
r12830 n7250 n7251 0.125
r12831 n7192 n7252 0.034722222222222224
r12832 n7251 n7252 0.34375
r12833 n7193 n7253 0.026041666666666668
r12834 n7252 n7253 0.65625
r12835 n7194 n7254 0.03125
r12836 n7195 n7255 0.044642857142857144
r12837 n7254 n7255 0.53125
r12838 n7196 n7256 0.10416666666666667
r12839 n7255 n7256 0.3125
r12840 n7197 n7257 0.10416666666666667
r12841 n7256 n7257 0.1875
r12842 n7198 n7258 0.15625
r12843 n7257 n7258 0.15625
r12844 n7199 n7259 0.0390625
r12845 n7258 n7259 0.3125
r12846 n7200 n7260 0.014204545454545454
r12847 n7259 n7260 0.9375
r12848 n7201 n7261 0.15625
r12849 n7260 n7261 0.75
r12850 n7202 n7262 0.10416666666666667
r12851 n7261 n7262 0.15625
r12852 n7203 n7263 0.10416666666666667
r12853 n7262 n7263 0.1875
r12854 n7204 n7264 0.078125
r12855 n7263 n7264 0.21875
r12856 n7205 n7265 0.10416666666666667
r12857 n7264 n7265 0.21875
r12858 n7206 n7266 0.03125
r12859 n7265 n7266 0.40625
r12860 n7207 n7267 0.026041666666666668
r12861 n7208 n7268 0.034722222222222224
r12862 n7267 n7268 0.65625
r12863 n7209 n7269 0.15625
r12864 n7268 n7269 0.34375
r12865 n7210 n7270 0.15625
r12866 n7269 n7270 0.125
r12867 n7211 n7271 0.0390625
r12868 n7270 n7271 0.3125
r12869 n7212 n7272 0.014204545454545454
r12870 n7271 n7272 0.9375
r12871 n7213 n7273 0.3125
r12872 n7272 n7273 0.71875
r12873 n7214 n7274 0.3125
r12874 n7273 n7274 0.0625
r12875 n7215 n7275 0.3125
r12876 n7274 n7275 0.0625
r12877 n7216 n7276 0.03125
r12878 n7275 n7276 0.34375
r12879 n7217 n7277 0.026041666666666668
r12880 n7276 n7277 0.6875
r12881 n7218 n7278 0.03125
r12882 n7219 n7279 0.044642857142857144
r12883 n7278 n7279 0.53125
r12884 n7220 n7280 0.10416666666666667
r12885 n7279 n7280 0.3125
r12886 n7221 n7281 0.10416666666666667
r12887 n7280 n7281 0.1875
r12888 n7222 n7282 0.15625
r12889 n7281 n7282 0.15625
r12890 n7223 n7283 0.028409090909090908
r12891 n7282 n7283 0.40625
r12892 n7224 n7284 0.016447368421052631
r12893 n7283 n7284 0.9375
r12894 n7225 n7285 0.15625
r12895 n7284 n7285 0.65625
r12896 n7226 n7286 0.10416666666666667
r12897 n7285 n7286 0.15625
r12898 n7227 n7287 0.10416666666666667
r12899 n7286 n7287 0.1875
r12900 n7228 n7288 0.044642857142857144
r12901 n7287 n7288 0.3125
r12902 n7229 n7289 0.03125
r12903 n7288 n7289 0.53125
r12904 n7230 n7290 0.03125
r12905 n7231 n7291 0.01358695652173913
r12906 n7290 n7291 1.03125
r12907 n7232 n7292 0.15625
r12908 n7291 n7292 0.78125
r12909 n7233 n7293 0.010416666666666666
r12910 n7292 n7293 1
r12911 n7234 n7294 0.15625
r12912 n7293 n7294 1
r12913 n7235 n7295 0.01358695652173913
r12914 n7294 n7295 0.78125
r12915 n7236 n7296 0.03125
r12916 n7295 n7296 1.03125
r12917 n7237 n7297 0.20000000000000001
r12918 n7238 n7298 0.086956521739130432
r12919 n7297 n7298 0.068750000000000006
r12920 n7239 n7299 1
r12921 n7298 n7299 0.052083333333333336
r12922 n7240 n7300 0.066666666666666666
r12923 n7299 n7300 0.066666666666666666
r12924 n7241 n7301 1
r12925 n7300 n7301 0.066666666666666666
r12926 n7242 n7302 0.086956521739130432
r12927 n7301 n7302 0.052083333333333336
r12928 n7243 n7303 0.20000000000000001
r12929 n7302 n7303 0.068750000000000006
r12930 n7254 n7304 0.20000000000000001
r12931 n7255 n7305 0.2857142857142857
r12932 n7304 n7305 0.035416666666666666
r12933 n7256 n7306 0.66666666666666663
r12934 n7305 n7306 0.020833333333333332
r12935 n7257 n7307 0.66666666666666663
r12936 n7306 n7307 0.012500000000000001
r12937 n7258 n7308 1
r12938 n7307 n7308 0.010416666666666666
r12939 n7259 n7309 0.25
r12940 n7308 n7309 0.020833333333333332
r12941 n7260 n7310 0.090909090909090912
r12942 n7309 n7310 0.0625
r12943 n7261 n7311 1
r12944 n7310 n7311 0.050000000000000003
r12945 n7262 n7312 0.66666666666666663
r12946 n7311 n7312 0.010416666666666666
r12947 n7263 n7313 0.66666666666666663
r12948 n7312 n7313 0.012500000000000001
r12949 n7264 n7314 0.5
r12950 n7313 n7314 0.014583333333333334
r12951 n7265 n7315 0.66666666666666663
r12952 n7314 n7315 0.014583333333333334
r12953 n7266 n7316 0.20000000000000001
r12954 n7315 n7316 0.027083333333333334
r12955 n7278 n7317 0.20000000000000001
r12956 n7279 n7318 0.2857142857142857
r12957 n7317 n7318 0.035416666666666666
r12958 n7280 n7319 0.66666666666666663
r12959 n7318 n7319 0.020833333333333332
r12960 n7281 n7320 0.66666666666666663
r12961 n7319 n7320 0.012500000000000001
r12962 n7282 n7321 1
r12963 n7320 n7321 0.010416666666666666
r12964 n7283 n7322 0.18181818181818182
r12965 n7321 n7322 0.027083333333333334
r12966 n7284 n7323 0.10526315789473684
r12967 n7322 n7323 0.0625
r12968 n7285 n7324 1
r12969 n7323 n7324 0.043749999999999997
r12970 n7286 n7325 0.66666666666666663
r12971 n7324 n7325 0.010416666666666666
r12972 n7287 n7326 0.66666666666666663
r12973 n7325 n7326 0.012500000000000001
r12974 n7288 n7327 0.2857142857142857
r12975 n7326 n7327 0.020833333333333332
r12976 n7289 n7328 0.20000000000000001
r12977 n7327 n7328 0.035416666666666666
r12978 n7290 n7329 0.20000000000000001
r12979 n7291 n7330 0.086956521739130432
r12980 n7329 n7330 0.068750000000000006
r12981 n7292 n7331 1
r12982 n7330 n7331 0.052083333333333336
r12983 n7293 n7332 0.066666666666666666
r12984 n7331 n7332 0.066666666666666666
r12985 n7294 n7333 1
r12986 n7332 n7333 0.066666666666666666
r12987 n7295 n7334 0.086956521739130432
r12988 n7333 n7334 0.052083333333333336
r12989 n7296 n7335 0.20000000000000001
r12990 n7334 n7335 0.068750000000000006
r12991 n7297 n7336 0.20000000000000001
r12992 n7298 n7337 0.086956521739130432
r12993 n7336 n7337 1.03125
r12994 n7299 n7338 1
r12995 n7337 n7338 0.78125
r12996 n7300 n7339 0.066666666666666666
r12997 n7338 n7339 1
r12998 n7301 n7340 1
r12999 n7339 n7340 1
r13000 n7302 n7341 0.086956521739130432
r13001 n7340 n7341 0.78125
r13002 n7303 n7342 0.20000000000000001
r13003 n7341 n7342 1.03125
r13004 n7343 n7344 0.59375
r13005 n7344 n7345 0.28125
r13006 n7345 n7346 0.1875
r13007 n7346 n7347 0.40625
r13008 n7347 n7348 0.9375
r13009 n7348 n7349 0.71875
r13010 n7349 n7350 0.125
r13011 n7350 n7351 0.34375
r13012 n7351 n7352 0.65625
r13013 n7304 n7353 0.20000000000000001
r13014 n7305 n7354 0.2857142857142857
r13015 n7353 n7354 0.53125
r13016 n7306 n7355 0.66666666666666663
r13017 n7354 n7355 0.3125
r13018 n7307 n7356 0.66666666666666663
r13019 n7355 n7356 0.1875
r13020 n7308 n7357 1
r13021 n7356 n7357 0.15625
r13022 n7309 n7358 0.25
r13023 n7357 n7358 0.3125
r13024 n7310 n7359 0.090909090909090912
r13025 n7358 n7359 0.9375
r13026 n7311 n7360 1
r13027 n7359 n7360 0.75
r13028 n7312 n7361 0.66666666666666663
r13029 n7360 n7361 0.15625
r13030 n7313 n7362 0.66666666666666663
r13031 n7361 n7362 0.1875
r13032 n7314 n7363 0.5
r13033 n7362 n7363 0.21875
r13034 n7315 n7364 0.66666666666666663
r13035 n7363 n7364 0.21875
r13036 n7316 n7365 0.20000000000000001
r13037 n7364 n7365 0.40625
r13038 n7366 n7367 0.65625
r13039 n7367 n7368 0.34375
r13040 n7368 n7369 0.125
r13041 n7369 n7370 0.3125
r13042 n7370 n7371 0.9375
r13043 n7371 n7372 0.71875
r13044 n7372 n7373 0.0625
r13045 n7373 n7374 0.0625
r13046 n7374 n7375 0.34375
r13047 n7375 n7376 0.6875
r13048 n7317 n7377 0.20000000000000001
r13049 n7318 n7378 0.2857142857142857
r13050 n7377 n7378 0.53125
r13051 n7319 n7379 0.66666666666666663
r13052 n7378 n7379 0.3125
r13053 n7320 n7380 0.66666666666666663
r13054 n7379 n7380 0.1875
r13055 n7321 n7381 1
r13056 n7380 n7381 0.15625
r13057 n7322 n7382 0.18181818181818182
r13058 n7381 n7382 0.40625
r13059 n7323 n7383 0.10526315789473684
r13060 n7382 n7383 0.9375
r13061 n7324 n7384 1
r13062 n7383 n7384 0.65625
r13063 n7325 n7385 0.66666666666666663
r13064 n7384 n7385 0.15625
r13065 n7326 n7386 0.66666666666666663
r13066 n7385 n7386 0.1875
r13067 n7327 n7387 0.2857142857142857
r13068 n7386 n7387 0.3125
r13069 n7328 n7388 0.20000000000000001
r13070 n7387 n7388 0.53125
r13071 n7329 n7389 0.20000000000000001
r13072 n7330 n7390 0.086956521739130432
r13073 n7389 n7390 1.03125
r13074 n7331 n7391 1
r13075 n7390 n7391 0.78125
r13076 n7332 n7392 0.066666666666666666
r13077 n7391 n7392 1
r13078 n7333 n7393 1
r13079 n7392 n7393 1
r13080 n7334 n7394 0.086956521739130432
r13081 n7393 n7394 0.78125
r13082 n7335 n7395 0.20000000000000001
r13083 n7394 n7395 1.03125
r13084 n7336 n7396 0.03125
r13085 n7337 n7397 0.01358695652173913
r13086 n7396 n7397 0.6875
r13087 n7338 n7398 0.15625
r13088 n7397 n7398 0.52083333333333337
r13089 n7339 n7399 0.010416666666666666
r13090 n7398 n7399 0.66666666666666663
r13091 n7340 n7400 0.15625
r13092 n7399 n7400 0.66666666666666663
r13093 n7341 n7401 0.01358695652173913
r13094 n7400 n7401 0.52083333333333337
r13095 n7342 n7402 0.03125
r13096 n7401 n7402 0.6875
r13097 n7343 n7403 0.026041666666666668
r13098 n7344 n7404 0.044642857142857144
r13099 n7403 n7404 0.39583333333333331
r13100 n7345 n7405 0.15625
r13101 n7404 n7405 0.1875
r13102 n7346 n7406 0.078125
r13103 n7405 n7406 0.125
r13104 n7347 n7407 0.034722222222222224
r13105 n7406 n7407 0.27083333333333331
r13106 n7348 n7408 0.01488095238095238
r13107 n7407 n7408 0.625
r13108 n7349 n7409 0.15625
r13109 n7408 n7409 0.47916666666666669
r13110 n7350 n7410 0.15625
r13111 n7409 n7410 0.083333333333333329
r13112 n7351 n7411 0.034722222222222224
r13113 n7410 n7411 0.22916666666666666
r13114 n7352 n7412 0.026041666666666668
r13115 n7411 n7412 0.4375
r13116 n7353 n7413 0.03125
r13117 n7354 n7414 0.044642857142857144
r13118 n7413 n7414 0.35416666666666669
r13119 n7355 n7415 0.10416666666666667
r13120 n7414 n7415 0.20833333333333334
r13121 n7356 n7416 0.10416666666666667
r13122 n7415 n7416 0.125
r13123 n7357 n7417 0.15625
r13124 n7416 n7417 0.10416666666666667
r13125 n7358 n7418 0.0390625
r13126 n7417 n7418 0.20833333333333334
r13127 n7359 n7419 0.014204545454545454
r13128 n7418 n7419 0.625
r13129 n7360 n7420 0.15625
r13130 n7419 n7420 0.5
r13131 n7361 n7421 0.10416666666666667
r13132 n7420 n7421 0.10416666666666667
r13133 n7362 n7422 0.10416666666666667
r13134 n7421 n7422 0.125
r13135 n7363 n7423 0.078125
r13136 n7422 n7423 0.14583333333333334
r13137 n7364 n7424 0.10416666666666667
r13138 n7423 n7424 0.14583333333333334
r13139 n7365 n7425 0.03125
r13140 n7424 n7425 0.27083333333333331
r13141 n7366 n7426 0.026041666666666668
r13142 n7367 n7427 0.034722222222222224
r13143 n7426 n7427 0.4375
r13144 n7368 n7428 0.15625
r13145 n7427 n7428 0.22916666666666666
r13146 n7369 n7429 0.15625
r13147 n7428 n7429 0.083333333333333329
r13148 n7370 n7430 0.0390625
r13149 n7429 n7430 0.20833333333333334
r13150 n7371 n7431 0.014204545454545454
r13151 n7430 n7431 0.625
r13152 n7372 n7432 0.3125
r13153 n7431 n7432 0.47916666666666669
r13154 n7373 n7433 0.3125
r13155 n7432 n7433 0.041666666666666664
r13156 n7374 n7434 0.3125
r13157 n7433 n7434 0.041666666666666664
r13158 n7375 n7435 0.03125
r13159 n7434 n7435 0.22916666666666666
r13160 n7376 n7436 0.026041666666666668
r13161 n7435 n7436 0.45833333333333331
r13162 n7377 n7437 0.03125
r13163 n7378 n7438 0.044642857142857144
r13164 n7437 n7438 0.35416666666666669
r13165 n7379 n7439 0.10416666666666667
r13166 n7438 n7439 0.20833333333333334
r13167 n7380 n7440 0.10416666666666667
r13168 n7439 n7440 0.125
r13169 n7381 n7441 0.15625
r13170 n7440 n7441 0.10416666666666667
r13171 n7382 n7442 0.028409090909090908
r13172 n7441 n7442 0.27083333333333331
r13173 n7383 n7443 0.016447368421052631
r13174 n7442 n7443 0.625
r13175 n7384 n7444 0.15625
r13176 n7443 n7444 0.4375
r13177 n7385 n7445 0.10416666666666667
r13178 n7444 n7445 0.10416666666666667
r13179 n7386 n7446 0.10416666666666667
r13180 n7445 n7446 0.125
r13181 n7387 n7447 0.044642857142857144
r13182 n7446 n7447 0.20833333333333334
r13183 n7388 n7448 0.03125
r13184 n7447 n7448 0.35416666666666669
r13185 n7389 n7449 0.03125
r13186 n7390 n7450 0.01358695652173913
r13187 n7449 n7450 0.6875
r13188 n7391 n7451 0.15625
r13189 n7450 n7451 0.52083333333333337
r13190 n7392 n7452 0.010416666666666666
r13191 n7451 n7452 0.66666666666666663
r13192 n7393 n7453 0.15625
r13193 n7452 n7453 0.66666666666666663
r13194 n7394 n7454 0.01358695652173913
r13195 n7453 n7454 0.52083333333333337
r13196 n7395 n7455 0.03125
r13197 n7454 n7455 0.6875
r13198 n7396 n7456 0.03125
r13199 n7397 n7457 0.01358695652173913
r13200 n7456 n7457 1.03125
r13201 n7398 n7458 0.15625
r13202 n7457 n7458 0.78125
r13203 n7399 n7459 0.010416666666666666
r13204 n7458 n7459 1
r13205 n7400 n7460 0.15625
r13206 n7459 n7460 1
r13207 n7401 n7461 0.01358695652173913
r13208 n7460 n7461 0.78125
r13209 n7402 n7462 0.03125
r13210 n7461 n7462 1.03125
r13211 n7403 n7463 0.026041666666666668
r13212 n7404 n7464 0.044642857142857144
r13213 n7463 n7464 0.59375
r13214 n7405 n7465 0.15625
r13215 n7464 n7465 0.28125
r13216 n7406 n7466 0.078125
r13217 n7465 n7466 0.1875
r13218 n7407 n7467 0.034722222222222224
r13219 n7466 n7467 0.40625
r13220 n7408 n7468 0.01488095238095238
r13221 n7467 n7468 0.9375
r13222 n7409 n7469 0.15625
r13223 n7468 n7469 0.71875
r13224 n7410 n7470 0.15625
r13225 n7469 n7470 0.125
r13226 n7411 n7471 0.034722222222222224
r13227 n7470 n7471 0.34375
r13228 n7412 n7472 0.026041666666666668
r13229 n7471 n7472 0.65625
r13230 n7413 n7473 0.03125
r13231 n7414 n7474 0.044642857142857144
r13232 n7473 n7474 0.53125
r13233 n7415 n7475 0.10416666666666667
r13234 n7474 n7475 0.3125
r13235 n7416 n7476 0.10416666666666667
r13236 n7475 n7476 0.1875
r13237 n7417 n7477 0.15625
r13238 n7476 n7477 0.15625
r13239 n7418 n7478 0.0390625
r13240 n7477 n7478 0.3125
r13241 n7419 n7479 0.014204545454545454
r13242 n7478 n7479 0.9375
r13243 n7420 n7480 0.15625
r13244 n7479 n7480 0.75
r13245 n7421 n7481 0.10416666666666667
r13246 n7480 n7481 0.15625
r13247 n7422 n7482 0.10416666666666667
r13248 n7481 n7482 0.1875
r13249 n7423 n7483 0.078125
r13250 n7482 n7483 0.21875
r13251 n7424 n7484 0.10416666666666667
r13252 n7483 n7484 0.21875
r13253 n7425 n7485 0.03125
r13254 n7484 n7485 0.40625
r13255 n7426 n7486 0.026041666666666668
r13256 n7427 n7487 0.034722222222222224
r13257 n7486 n7487 0.65625
r13258 n7428 n7488 0.15625
r13259 n7487 n7488 0.34375
r13260 n7429 n7489 0.15625
r13261 n7488 n7489 0.125
r13262 n7430 n7490 0.0390625
r13263 n7489 n7490 0.3125
r13264 n7431 n7491 0.014204545454545454
r13265 n7490 n7491 0.9375
r13266 n7432 n7492 0.3125
r13267 n7491 n7492 0.71875
r13268 n7433 n7493 0.3125
r13269 n7492 n7493 0.0625
r13270 n7434 n7494 0.3125
r13271 n7493 n7494 0.0625
r13272 n7435 n7495 0.03125
r13273 n7494 n7495 0.34375
r13274 n7436 n7496 0.026041666666666668
r13275 n7495 n7496 0.6875
r13276 n7437 n7497 0.03125
r13277 n7438 n7498 0.044642857142857144
r13278 n7497 n7498 0.53125
r13279 n7439 n7499 0.10416666666666667
r13280 n7498 n7499 0.3125
r13281 n7440 n7500 0.10416666666666667
r13282 n7499 n7500 0.1875
r13283 n7441 n7501 0.15625
r13284 n7500 n7501 0.15625
r13285 n7442 n7502 0.028409090909090908
r13286 n7501 n7502 0.40625
r13287 n7443 n7503 0.016447368421052631
r13288 n7502 n7503 0.9375
r13289 n7444 n7504 0.15625
r13290 n7503 n7504 0.65625
r13291 n7445 n7505 0.10416666666666667
r13292 n7504 n7505 0.15625
r13293 n7446 n7506 0.10416666666666667
r13294 n7505 n7506 0.1875
r13295 n7447 n7507 0.044642857142857144
r13296 n7506 n7507 0.3125
r13297 n7448 n7508 0.03125
r13298 n7507 n7508 0.53125
r13299 n7449 n7509 0.03125
r13300 n7450 n7510 0.01358695652173913
r13301 n7509 n7510 1.03125
r13302 n7451 n7511 0.15625
r13303 n7510 n7511 0.78125
r13304 n7452 n7512 0.010416666666666666
r13305 n7511 n7512 1
r13306 n7453 n7513 0.15625
r13307 n7512 n7513 1
r13308 n7454 n7514 0.01358695652173913
r13309 n7513 n7514 0.78125
r13310 n7455 n7515 0.03125
r13311 n7514 n7515 1.03125
r13312 n7456 n7516 0.050000000000000003
r13313 n7457 n7517 0.021739130434782608
r13314 n7516 n7517 0.34375
r13315 n7458 n7518 0.25
r13316 n7517 n7518 0.26041666666666669
r13317 n7459 n7519 0.016666666666666666
r13318 n7518 n7519 0.33333333333333331
r13319 n7460 n7520 0.25
r13320 n7519 n7520 0.33333333333333331
r13321 n7461 n7521 0.021739130434782608
r13322 n7520 n7521 0.26041666666666669
r13323 n7462 n7522 0.050000000000000003
r13324 n7521 n7522 0.34375
r13325 n7463 n7523 0.041666666666666664
r13326 n7464 n7524 0.071428571428571425
r13327 n7523 n7524 0.19791666666666666
r13328 n7465 n7525 0.25
r13329 n7524 n7525 0.09375
r13330 n7466 n7526 0.125
r13331 n7525 n7526 0.0625
r13332 n7467 n7527 0.055555555555555552
r13333 n7526 n7527 0.13541666666666666
r13334 n7468 n7528 0.023809523809523808
r13335 n7527 n7528 0.3125
r13336 n7469 n7529 0.25
r13337 n7528 n7529 0.23958333333333334
r13338 n7470 n7530 0.25
r13339 n7529 n7530 0.041666666666666664
r13340 n7471 n7531 0.055555555555555552
r13341 n7530 n7531 0.11458333333333333
r13342 n7472 n7532 0.041666666666666664
r13343 n7531 n7532 0.21875
r13344 n7473 n7533 0.050000000000000003
r13345 n7474 n7534 0.071428571428571425
r13346 n7533 n7534 0.17708333333333334
r13347 n7475 n7535 0.16666666666666666
r13348 n7534 n7535 0.10416666666666667
r13349 n7476 n7536 0.16666666666666666
r13350 n7535 n7536 0.0625
r13351 n7477 n7537 0.25
r13352 n7536 n7537 0.052083333333333336
r13353 n7478 n7538 0.0625
r13354 n7537 n7538 0.10416666666666667
r13355 n7479 n7539 0.022727272727272728
r13356 n7538 n7539 0.3125
r13357 n7480 n7540 0.25
r13358 n7539 n7540 0.25
r13359 n7481 n7541 0.16666666666666666
r13360 n7540 n7541 0.052083333333333336
r13361 n7482 n7542 0.16666666666666666
r13362 n7541 n7542 0.0625
r13363 n7483 n7543 0.125
r13364 n7542 n7543 0.072916666666666671
r13365 n7484 n7544 0.16666666666666666
r13366 n7543 n7544 0.072916666666666671
r13367 n7485 n7545 0.050000000000000003
r13368 n7544 n7545 0.13541666666666666
r13369 n7486 n7546 0.041666666666666664
r13370 n7487 n7547 0.055555555555555552
r13371 n7546 n7547 0.21875
r13372 n7488 n7548 0.25
r13373 n7547 n7548 0.11458333333333333
r13374 n7489 n7549 0.25
r13375 n7548 n7549 0.041666666666666664
r13376 n7490 n7550 0.0625
r13377 n7549 n7550 0.10416666666666667
r13378 n7491 n7551 0.022727272727272728
r13379 n7550 n7551 0.3125
r13380 n7492 n7552 0.5
r13381 n7551 n7552 0.23958333333333334
r13382 n7493 n7553 0.5
r13383 n7552 n7553 0.020833333333333332
r13384 n7494 n7554 0.5
r13385 n7553 n7554 0.020833333333333332
r13386 n7495 n7555 0.050000000000000003
r13387 n7554 n7555 0.11458333333333333
r13388 n7496 n7556 0.041666666666666664
r13389 n7555 n7556 0.22916666666666666
r13390 n7497 n7557 0.050000000000000003
r13391 n7498 n7558 0.071428571428571425
r13392 n7557 n7558 0.17708333333333334
r13393 n7499 n7559 0.16666666666666666
r13394 n7558 n7559 0.10416666666666667
r13395 n7500 n7560 0.16666666666666666
r13396 n7559 n7560 0.0625
r13397 n7501 n7561 0.25
r13398 n7560 n7561 0.052083333333333336
r13399 n7502 n7562 0.045454545454545456
r13400 n7561 n7562 0.13541666666666666
r13401 n7503 n7563 0.026315789473684209
r13402 n7562 n7563 0.3125
r13403 n7504 n7564 0.25
r13404 n7563 n7564 0.21875
r13405 n7505 n7565 0.16666666666666666
r13406 n7564 n7565 0.052083333333333336
r13407 n7506 n7566 0.16666666666666666
r13408 n7565 n7566 0.0625
r13409 n7507 n7567 0.071428571428571425
r13410 n7566 n7567 0.10416666666666667
r13411 n7508 n7568 0.050000000000000003
r13412 n7567 n7568 0.17708333333333334
r13413 n7509 n7569 0.050000000000000003
r13414 n7510 n7570 0.021739130434782608
r13415 n7569 n7570 0.34375
r13416 n7511 n7571 0.25
r13417 n7570 n7571 0.26041666666666669
r13418 n7512 n7572 0.016666666666666666
r13419 n7571 n7572 0.33333333333333331
r13420 n7513 n7573 0.25
r13421 n7572 n7573 0.33333333333333331
r13422 n7514 n7574 0.021739130434782608
r13423 n7573 n7574 0.26041666666666669
r13424 n7515 n7575 0.050000000000000003
r13425 n7574 n7575 0.34375
r13426 n7516 n7576 0.050000000000000003
r13427 n7517 n7577 0.021739130434782608
r13428 n7576 n7577 1.03125
r13429 n7518 n7578 0.25
r13430 n7577 n7578 0.78125
r13431 n7519 n7579 0.016666666666666666
r13432 n7578 n7579 1
r13433 n7520 n7580 0.25
r13434 n7579 n7580 1
r13435 n7521 n7581 0.021739130434782608
r13436 n7580 n7581 0.78125
r13437 n7522 n7582 0.050000000000000003
r13438 n7581 n7582 1.03125
r13439 n7523 n7583 0.041666666666666664
r13440 n7524 n7584 0.071428571428571425
r13441 n7583 n7584 0.59375
r13442 n7525 n7585 0.25
r13443 n7584 n7585 0.28125
r13444 n7526 n7586 0.125
r13445 n7585 n7586 0.1875
r13446 n7527 n7587 0.055555555555555552
r13447 n7586 n7587 0.40625
r13448 n7528 n7588 0.023809523809523808
r13449 n7587 n7588 0.9375
r13450 n7529 n7589 0.25
r13451 n7588 n7589 0.71875
r13452 n7530 n7590 0.25
r13453 n7589 n7590 0.125
r13454 n7531 n7591 0.055555555555555552
r13455 n7590 n7591 0.34375
r13456 n7532 n7592 0.041666666666666664
r13457 n7591 n7592 0.65625
r13458 n7533 n7593 0.050000000000000003
r13459 n7534 n7594 0.071428571428571425
r13460 n7593 n7594 0.53125
r13461 n7535 n7595 0.16666666666666666
r13462 n7594 n7595 0.3125
r13463 n7536 n7596 0.16666666666666666
r13464 n7595 n7596 0.1875
r13465 n7537 n7597 0.25
r13466 n7596 n7597 0.15625
r13467 n7538 n7598 0.0625
r13468 n7597 n7598 0.3125
r13469 n7539 n7599 0.022727272727272728
r13470 n7598 n7599 0.9375
r13471 n7540 n7600 0.25
r13472 n7599 n7600 0.75
r13473 n7541 n7601 0.16666666666666666
r13474 n7600 n7601 0.15625
r13475 n7542 n7602 0.16666666666666666
r13476 n7601 n7602 0.1875
r13477 n7543 n7603 0.125
r13478 n7602 n7603 0.21875
r13479 n7544 n7604 0.16666666666666666
r13480 n7603 n7604 0.21875
r13481 n7545 n7605 0.050000000000000003
r13482 n7604 n7605 0.40625
r13483 n7546 n7606 0.041666666666666664
r13484 n7547 n7607 0.055555555555555552
r13485 n7606 n7607 0.65625
r13486 n7548 n7608 0.25
r13487 n7607 n7608 0.34375
r13488 n7549 n7609 0.25
r13489 n7608 n7609 0.125
r13490 n7550 n7610 0.0625
r13491 n7609 n7610 0.3125
r13492 n7551 n7611 0.022727272727272728
r13493 n7610 n7611 0.9375
r13494 n7552 n7612 0.5
r13495 n7611 n7612 0.71875
r13496 n7553 n7613 0.5
r13497 n7612 n7613 0.0625
r13498 n7554 n7614 0.5
r13499 n7613 n7614 0.0625
r13500 n7555 n7615 0.050000000000000003
r13501 n7614 n7615 0.34375
r13502 n7556 n7616 0.041666666666666664
r13503 n7615 n7616 0.6875
r13504 n7557 n7617 0.050000000000000003
r13505 n7558 n7618 0.071428571428571425
r13506 n7617 n7618 0.53125
r13507 n7559 n7619 0.16666666666666666
r13508 n7618 n7619 0.3125
r13509 n7560 n7620 0.16666666666666666
r13510 n7619 n7620 0.1875
r13511 n7561 n7621 0.25
r13512 n7620 n7621 0.15625
r13513 n7562 n7622 0.045454545454545456
r13514 n7621 n7622 0.40625
r13515 n7563 n7623 0.026315789473684209
r13516 n7622 n7623 0.9375
r13517 n7564 n7624 0.25
r13518 n7623 n7624 0.65625
r13519 n7565 n7625 0.16666666666666666
r13520 n7624 n7625 0.15625
r13521 n7566 n7626 0.16666666666666666
r13522 n7625 n7626 0.1875
r13523 n7567 n7627 0.071428571428571425
r13524 n7626 n7627 0.3125
r13525 n7568 n7628 0.050000000000000003
r13526 n7627 n7628 0.53125
r13527 n7569 n7629 0.050000000000000003
r13528 n7570 n7630 0.021739130434782608
r13529 n7629 n7630 1.03125
r13530 n7571 n7631 0.25
r13531 n7630 n7631 0.78125
r13532 n7572 n7632 0.016666666666666666
r13533 n7631 n7632 1
r13534 n7573 n7633 0.25
r13535 n7632 n7633 1
r13536 n7574 n7634 0.021739130434782608
r13537 n7633 n7634 0.78125
r13538 n7575 n7635 0.050000000000000003
r13539 n7634 n7635 1.03125
r13540 n7576 n7636 0.03125
r13541 n7577 n7637 0.01358695652173913
r13542 n7636 n7637 0.6875
r13543 n7578 n7638 0.15625
r13544 n7637 n7638 0.52083333333333337
r13545 n7579 n7639 0.010416666666666666
r13546 n7638 n7639 0.66666666666666663
r13547 n7580 n7640 0.15625
r13548 n7639 n7640 0.66666666666666663
r13549 n7581 n7641 0.01358695652173913
r13550 n7640 n7641 0.52083333333333337
r13551 n7582 n7642 0.03125
r13552 n7641 n7642 0.6875
r13553 n7583 n7643 0.026041666666666668
r13554 n7584 n7644 0.044642857142857144
r13555 n7643 n7644 0.39583333333333331
r13556 n7585 n7645 0.15625
r13557 n7644 n7645 0.1875
r13558 n7586 n7646 0.078125
r13559 n7645 n7646 0.125
r13560 n7587 n7647 0.034722222222222224
r13561 n7646 n7647 0.27083333333333331
r13562 n7588 n7648 0.01488095238095238
r13563 n7647 n7648 0.625
r13564 n7589 n7649 0.15625
r13565 n7648 n7649 0.47916666666666669
r13566 n7590 n7650 0.15625
r13567 n7649 n7650 0.083333333333333329
r13568 n7591 n7651 0.034722222222222224
r13569 n7650 n7651 0.22916666666666666
r13570 n7592 n7652 0.026041666666666668
r13571 n7651 n7652 0.4375
r13572 n7593 n7653 0.03125
r13573 n7594 n7654 0.044642857142857144
r13574 n7653 n7654 0.35416666666666669
r13575 n7595 n7655 0.10416666666666667
r13576 n7654 n7655 0.20833333333333334
r13577 n7596 n7656 0.10416666666666667
r13578 n7655 n7656 0.125
r13579 n7597 n7657 0.15625
r13580 n7656 n7657 0.10416666666666667
r13581 n7598 n7658 0.0390625
r13582 n7657 n7658 0.20833333333333334
r13583 n7599 n7659 0.014204545454545454
r13584 n7658 n7659 0.625
r13585 n7600 n7660 0.15625
r13586 n7659 n7660 0.5
r13587 n7601 n7661 0.10416666666666667
r13588 n7660 n7661 0.10416666666666667
r13589 n7602 n7662 0.10416666666666667
r13590 n7661 n7662 0.125
r13591 n7603 n7663 0.078125
r13592 n7662 n7663 0.14583333333333334
r13593 n7604 n7664 0.10416666666666667
r13594 n7663 n7664 0.14583333333333334
r13595 n7605 n7665 0.03125
r13596 n7664 n7665 0.27083333333333331
r13597 n7606 n7666 0.026041666666666668
r13598 n7607 n7667 0.034722222222222224
r13599 n7666 n7667 0.4375
r13600 n7608 n7668 0.15625
r13601 n7667 n7668 0.22916666666666666
r13602 n7609 n7669 0.15625
r13603 n7668 n7669 0.083333333333333329
r13604 n7610 n7670 0.0390625
r13605 n7669 n7670 0.20833333333333334
r13606 n7611 n7671 0.014204545454545454
r13607 n7670 n7671 0.625
r13608 n7612 n7672 0.3125
r13609 n7671 n7672 0.47916666666666669
r13610 n7613 n7673 0.3125
r13611 n7672 n7673 0.041666666666666664
r13612 n7614 n7674 0.3125
r13613 n7673 n7674 0.041666666666666664
r13614 n7615 n7675 0.03125
r13615 n7674 n7675 0.22916666666666666
r13616 n7616 n7676 0.026041666666666668
r13617 n7675 n7676 0.45833333333333331
r13618 n7617 n7677 0.03125
r13619 n7618 n7678 0.044642857142857144
r13620 n7677 n7678 0.35416666666666669
r13621 n7619 n7679 0.10416666666666667
r13622 n7678 n7679 0.20833333333333334
r13623 n7620 n7680 0.10416666666666667
r13624 n7679 n7680 0.125
r13625 n7621 n7681 0.15625
r13626 n7680 n7681 0.10416666666666667
r13627 n7622 n7682 0.028409090909090908
r13628 n7681 n7682 0.27083333333333331
r13629 n7623 n7683 0.016447368421052631
r13630 n7682 n7683 0.625
r13631 n7624 n7684 0.15625
r13632 n7683 n7684 0.4375
r13633 n7625 n7685 0.10416666666666667
r13634 n7684 n7685 0.10416666666666667
r13635 n7626 n7686 0.10416666666666667
r13636 n7685 n7686 0.125
r13637 n7627 n7687 0.044642857142857144
r13638 n7686 n7687 0.20833333333333334
r13639 n7628 n7688 0.03125
r13640 n7687 n7688 0.35416666666666669
r13641 n7629 n7689 0.03125
r13642 n7630 n7690 0.01358695652173913
r13643 n7689 n7690 0.6875
r13644 n7631 n7691 0.15625
r13645 n7690 n7691 0.52083333333333337
r13646 n7632 n7692 0.010416666666666666
r13647 n7691 n7692 0.66666666666666663
r13648 n7633 n7693 0.15625
r13649 n7692 n7693 0.66666666666666663
r13650 n7634 n7694 0.01358695652173913
r13651 n7693 n7694 0.52083333333333337
r13652 n7635 n7695 0.03125
r13653 n7694 n7695 0.6875
r13654 n7636 n7696 0.043749999999999997
r13655 n7637 n7697 0.019021739130434784
r13656 n7696 n7697 0.515625
r13657 n7638 n7698 0.21875
r13658 n7697 n7698 0.390625
r13659 n7639 n7699 0.014583333333333334
r13660 n7698 n7699 0.5
r13661 n7640 n7700 0.21875
r13662 n7699 n7700 0.5
r13663 n7641 n7701 0.019021739130434784
r13664 n7700 n7701 0.390625
r13665 n7642 n7702 0.043749999999999997
r13666 n7701 n7702 0.515625
r13667 n7643 n7703 0.036458333333333336
r13668 n7644 n7704 0.0625
r13669 n7703 n7704 0.296875
r13670 n7645 n7705 0.21875
r13671 n7704 n7705 0.140625
r13672 n7646 n7706 0.109375
r13673 n7705 n7706 0.09375
r13674 n7647 n7707 0.048611111111111112
r13675 n7706 n7707 0.203125
r13676 n7648 n7708 0.020833333333333332
r13677 n7707 n7708 0.46875
r13678 n7649 n7709 0.21875
r13679 n7708 n7709 0.359375
r13680 n7650 n7710 0.21875
r13681 n7709 n7710 0.0625
r13682 n7651 n7711 0.048611111111111112
r13683 n7710 n7711 0.171875
r13684 n7652 n7712 0.036458333333333336
r13685 n7711 n7712 0.328125
r13686 n7653 n7713 0.043749999999999997
r13687 n7654 n7714 0.0625
r13688 n7713 n7714 0.265625
r13689 n7655 n7715 0.14583333333333334
r13690 n7714 n7715 0.15625
r13691 n7656 n7716 0.14583333333333334
r13692 n7715 n7716 0.09375
r13693 n7657 n7717 0.21875
r13694 n7716 n7717 0.078125
r13695 n7658 n7718 0.0546875
r13696 n7717 n7718 0.15625
r13697 n7659 n7719 0.019886363636363636
r13698 n7718 n7719 0.46875
r13699 n7660 n7720 0.21875
r13700 n7719 n7720 0.375
r13701 n7661 n7721 0.14583333333333334
r13702 n7720 n7721 0.078125
r13703 n7662 n7722 0.14583333333333334
r13704 n7721 n7722 0.09375
r13705 n7663 n7723 0.109375
r13706 n7722 n7723 0.109375
r13707 n7664 n7724 0.14583333333333334
r13708 n7723 n7724 0.109375
r13709 n7665 n7725 0.043749999999999997
r13710 n7724 n7725 0.203125
r13711 n7666 n7726 0.036458333333333336
r13712 n7667 n7727 0.048611111111111112
r13713 n7726 n7727 0.328125
r13714 n7668 n7728 0.21875
r13715 n7727 n7728 0.171875
r13716 n7669 n7729 0.21875
r13717 n7728 n7729 0.0625
r13718 n7670 n7730 0.0546875
r13719 n7729 n7730 0.15625
r13720 n7671 n7731 0.019886363636363636
r13721 n7730 n7731 0.46875
r13722 n7672 n7732 0.4375
r13723 n7731 n7732 0.359375
r13724 n7673 n7733 0.4375
r13725 n7732 n7733 0.03125
r13726 n7674 n7734 0.4375
r13727 n7733 n7734 0.03125
r13728 n7675 n7735 0.043749999999999997
r13729 n7734 n7735 0.171875
r13730 n7676 n7736 0.036458333333333336
r13731 n7735 n7736 0.34375
r13732 n7677 n7737 0.043749999999999997
r13733 n7678 n7738 0.0625
r13734 n7737 n7738 0.265625
r13735 n7679 n7739 0.14583333333333334
r13736 n7738 n7739 0.15625
r13737 n7680 n7740 0.14583333333333334
r13738 n7739 n7740 0.09375
r13739 n7681 n7741 0.21875
r13740 n7740 n7741 0.078125
r13741 n7682 n7742 0.039772727272727272
r13742 n7741 n7742 0.203125
r13743 n7683 n7743 0.023026315789473683
r13744 n7742 n7743 0.46875
r13745 n7684 n7744 0.21875
r13746 n7743 n7744 0.328125
r13747 n7685 n7745 0.14583333333333334
r13748 n7744 n7745 0.078125
r13749 n7686 n7746 0.14583333333333334
r13750 n7745 n7746 0.09375
r13751 n7687 n7747 0.0625
r13752 n7746 n7747 0.15625
r13753 n7688 n7748 0.043749999999999997
r13754 n7747 n7748 0.265625
r13755 n7689 n7749 0.043749999999999997
r13756 n7690 n7750 0.019021739130434784
r13757 n7749 n7750 0.515625
r13758 n7691 n7751 0.21875
r13759 n7750 n7751 0.390625
r13760 n7692 n7752 0.014583333333333334
r13761 n7751 n7752 0.5
r13762 n7693 n7753 0.21875
r13763 n7752 n7753 0.5
r13764 n7694 n7754 0.019021739130434784
r13765 n7753 n7754 0.390625
r13766 n7695 n7755 0.043749999999999997
r13767 n7754 n7755 0.515625
r13768 n7696 n7756 0.043749999999999997
r13769 n7697 n7757 0.019021739130434784
r13770 n7756 n7757 0.6875
r13771 n7698 n7758 0.21875
r13772 n7757 n7758 0.52083333333333337
r13773 n7699 n7759 0.014583333333333334
r13774 n7758 n7759 0.66666666666666663
r13775 n7700 n7760 0.21875
r13776 n7759 n7760 0.66666666666666663
r13777 n7701 n7761 0.019021739130434784
r13778 n7760 n7761 0.52083333333333337
r13779 n7702 n7762 0.043749999999999997
r13780 n7761 n7762 0.6875
r13781 n7703 n7763 0.036458333333333336
r13782 n7704 n7764 0.0625
r13783 n7763 n7764 0.39583333333333331
r13784 n7705 n7765 0.21875
r13785 n7764 n7765 0.1875
r13786 n7706 n7766 0.109375
r13787 n7765 n7766 0.125
r13788 n7707 n7767 0.048611111111111112
r13789 n7766 n7767 0.27083333333333331
r13790 n7708 n7768 0.020833333333333332
r13791 n7767 n7768 0.625
r13792 n7709 n7769 0.21875
r13793 n7768 n7769 0.47916666666666669
r13794 n7710 n7770 0.21875
r13795 n7769 n7770 0.083333333333333329
r13796 n7711 n7771 0.048611111111111112
r13797 n7770 n7771 0.22916666666666666
r13798 n7712 n7772 0.036458333333333336
r13799 n7771 n7772 0.4375
r13800 n7713 n7773 0.043749999999999997
r13801 n7714 n7774 0.0625
r13802 n7773 n7774 0.35416666666666669
r13803 n7715 n7775 0.14583333333333334
r13804 n7774 n7775 0.20833333333333334
r13805 n7716 n7776 0.14583333333333334
r13806 n7775 n7776 0.125
r13807 n7717 n7777 0.21875
r13808 n7776 n7777 0.10416666666666667
r13809 n7718 n7778 0.0546875
r13810 n7777 n7778 0.20833333333333334
r13811 n7719 n7779 0.019886363636363636
r13812 n7778 n7779 0.625
r13813 n7720 n7780 0.21875
r13814 n7779 n7780 0.5
r13815 n7721 n7781 0.14583333333333334
r13816 n7780 n7781 0.10416666666666667
r13817 n7722 n7782 0.14583333333333334
r13818 n7781 n7782 0.125
r13819 n7723 n7783 0.109375
r13820 n7782 n7783 0.14583333333333334
r13821 n7724 n7784 0.14583333333333334
r13822 n7783 n7784 0.14583333333333334
r13823 n7725 n7785 0.043749999999999997
r13824 n7784 n7785 0.27083333333333331
r13825 n7726 n7786 0.036458333333333336
r13826 n7727 n7787 0.048611111111111112
r13827 n7786 n7787 0.4375
r13828 n7728 n7788 0.21875
r13829 n7787 n7788 0.22916666666666666
r13830 n7729 n7789 0.21875
r13831 n7788 n7789 0.083333333333333329
r13832 n7730 n7790 0.0546875
r13833 n7789 n7790 0.20833333333333334
r13834 n7731 n7791 0.019886363636363636
r13835 n7790 n7791 0.625
r13836 n7732 n7792 0.4375
r13837 n7791 n7792 0.47916666666666669
r13838 n7733 n7793 0.4375
r13839 n7792 n7793 0.041666666666666664
r13840 n7734 n7794 0.4375
r13841 n7793 n7794 0.041666666666666664
r13842 n7735 n7795 0.043749999999999997
r13843 n7794 n7795 0.22916666666666666
r13844 n7736 n7796 0.036458333333333336
r13845 n7795 n7796 0.45833333333333331
r13846 n7737 n7797 0.043749999999999997
r13847 n7738 n7798 0.0625
r13848 n7797 n7798 0.35416666666666669
r13849 n7739 n7799 0.14583333333333334
r13850 n7798 n7799 0.20833333333333334
r13851 n7740 n7800 0.14583333333333334
r13852 n7799 n7800 0.125
r13853 n7741 n7801 0.21875
r13854 n7800 n7801 0.10416666666666667
r13855 n7742 n7802 0.039772727272727272
r13856 n7801 n7802 0.27083333333333331
r13857 n7743 n7803 0.023026315789473683
r13858 n7802 n7803 0.625
r13859 n7744 n7804 0.21875
r13860 n7803 n7804 0.4375
r13861 n7745 n7805 0.14583333333333334
r13862 n7804 n7805 0.10416666666666667
r13863 n7746 n7806 0.14583333333333334
r13864 n7805 n7806 0.125
r13865 n7747 n7807 0.0625
r13866 n7806 n7807 0.20833333333333334
r13867 n7748 n7808 0.043749999999999997
r13868 n7807 n7808 0.35416666666666669
r13869 n7749 n7809 0.043749999999999997
r13870 n7750 n7810 0.019021739130434784
r13871 n7809 n7810 0.6875
r13872 n7751 n7811 0.21875
r13873 n7810 n7811 0.52083333333333337
r13874 n7752 n7812 0.014583333333333334
r13875 n7811 n7812 0.66666666666666663
r13876 n7753 n7813 0.21875
r13877 n7812 n7813 0.66666666666666663
r13878 n7754 n7814 0.019021739130434784
r13879 n7813 n7814 0.52083333333333337
r13880 n7755 n7815 0.043749999999999997
r13881 n7814 n7815 0.6875
r13882 n7756 n7816 0.1125
r13883 n7757 n7817 0.048913043478260872
r13884 n7816 n7817 0.13750000000000001
r13885 n7758 n7818 0.5625
r13886 n7817 n7818 0.10416666666666667
r13887 n7759 n7819 0.037499999999999999
r13888 n7818 n7819 0.13333333333333333
r13889 n7760 n7820 0.5625
r13890 n7819 n7820 0.13333333333333333
r13891 n7761 n7821 0.048913043478260872
r13892 n7820 n7821 0.10416666666666667
r13893 n7762 n7822 0.1125
r13894 n7821 n7822 0.13750000000000001
r13895 n7763 n7823 0.09375
r13896 n7764 n7824 0.16071428571428573
r13897 n7823 n7824 0.079166666666666663
r13898 n7765 n7825 0.5625
r13899 n7824 n7825 0.037499999999999999
r13900 n7766 n7826 0.28125
r13901 n7825 n7826 0.025000000000000001
r13902 n7767 n7827 0.125
r13903 n7826 n7827 0.054166666666666669
r13904 n7768 n7828 0.053571428571428568
r13905 n7827 n7828 0.125
r13906 n7769 n7829 0.5625
r13907 n7828 n7829 0.09583333333333334
r13908 n7770 n7830 0.5625
r13909 n7829 n7830 0.016666666666666666
r13910 n7771 n7831 0.125
r13911 n7830 n7831 0.04583333333333333
r13912 n7772 n7832 0.09375
r13913 n7831 n7832 0.087499999999999994
r13914 n7786 n7833 0.09375
r13915 n7787 n7834 0.125
r13916 n7833 n7834 0.087499999999999994
r13917 n7788 n7835 0.5625
r13918 n7834 n7835 0.04583333333333333
r13919 n7789 n7836 0.5625
r13920 n7835 n7836 0.016666666666666666
r13921 n7790 n7837 0.140625
r13922 n7836 n7837 0.041666666666666664
r13923 n7791 n7838 0.05113636363636364
r13924 n7837 n7838 0.125
r13925 n7792 n7839 1.125
r13926 n7838 n7839 0.09583333333333334
r13927 n7793 n7840 1.125
r13928 n7839 n7840 0.0083333333333333332
r13929 n7794 n7841 1.125
r13930 n7840 n7841 0.0083333333333333332
r13931 n7795 n7842 0.1125
r13932 n7841 n7842 0.04583333333333333
r13933 n7796 n7843 0.09375
r13934 n7842 n7843 0.09166666666666666
r13935 n7809 n7844 0.1125
r13936 n7810 n7845 0.048913043478260872
r13937 n7844 n7845 0.13750000000000001
r13938 n7811 n7846 0.5625
r13939 n7845 n7846 0.10416666666666667
r13940 n7812 n7847 0.037499999999999999
r13941 n7846 n7847 0.13333333333333333
r13942 n7813 n7848 0.5625
r13943 n7847 n7848 0.13333333333333333
r13944 n7814 n7849 0.048913043478260872
r13945 n7848 n7849 0.10416666666666667
r13946 n7815 n7850 0.1125
r13947 n7849 n7850 0.13750000000000001
r13948 n7816 n7851 0.125
r13949 n7817 n7852 0.05434782608695652
r13950 n7851 n7852 0.41249999999999998
r13951 n7818 n7853 0.625
r13952 n7852 n7853 0.3125
r13953 n7819 n7854 0.041666666666666664
r13954 n7853 n7854 0.40000000000000002
r13955 n7820 n7855 0.625
r13956 n7854 n7855 0.40000000000000002
r13957 n7821 n7856 0.05434782608695652
r13958 n7855 n7856 0.3125
r13959 n7822 n7857 0.125
r13960 n7856 n7857 0.41249999999999998
r13961 n7823 n7858 0.10416666666666667
r13962 n7824 n7859 0.17857142857142858
r13963 n7858 n7859 0.23749999999999999
r13964 n7825 n7860 0.625
r13965 n7859 n7860 0.1125
r13966 n7826 n7861 0.3125
r13967 n7860 n7861 0.074999999999999997
r13968 n7827 n7862 0.1388888888888889
r13969 n7861 n7862 0.16250000000000001
r13970 n7828 n7863 0.059523809523809521
r13971 n7862 n7863 0.375
r13972 n7829 n7864 0.625
r13973 n7863 n7864 0.28749999999999998
r13974 n7830 n7865 0.625
r13975 n7864 n7865 0.050000000000000003
r13976 n7831 n7866 0.1388888888888889
r13977 n7865 n7866 0.13750000000000001
r13978 n7832 n7867 0.10416666666666667
r13979 n7866 n7867 0.26250000000000001
r13980 n7833 n7868 0.10416666666666667
r13981 n7834 n7869 0.1388888888888889
r13982 n7868 n7869 0.26250000000000001
r13983 n7835 n7870 0.625
r13984 n7869 n7870 0.13750000000000001
r13985 n7836 n7871 0.625
r13986 n7870 n7871 0.050000000000000003
r13987 n7837 n7872 0.15625
r13988 n7871 n7872 0.125
r13989 n7838 n7873 0.056818181818181816
r13990 n7872 n7873 0.375
r13991 n7839 n7874 1.25
r13992 n7873 n7874 0.28749999999999998
r13993 n7840 n7875 1.25
r13994 n7874 n7875 0.025000000000000001
r13995 n7841 n7876 1.25
r13996 n7875 n7876 0.025000000000000001
r13997 n7842 n7877 0.125
r13998 n7876 n7877 0.13750000000000001
r13999 n7843 n7878 0.10416666666666667
r14000 n7877 n7878 0.27500000000000002
r14001 n7844 n7879 0.125
r14002 n7845 n7880 0.05434782608695652
r14003 n7879 n7880 0.41249999999999998
r14004 n7846 n7881 0.625
r14005 n7880 n7881 0.3125
r14006 n7847 n7882 0.041666666666666664
r14007 n7881 n7882 0.40000000000000002
r14008 n7848 n7883 0.625
r14009 n7882 n7883 0.40000000000000002
r14010 n7849 n7884 0.05434782608695652
r14011 n7883 n7884 0.3125
r14012 n7850 n7885 0.125
r14013 n7884 n7885 0.41249999999999998
r14014 n7851 n7886 0.043749999999999997
r14015 n7852 n7887 0.019021739130434784
r14016 n7886 n7887 1.03125
r14017 n7853 n7888 0.21875
r14018 n7887 n7888 0.78125
r14019 n7854 n7889 0.014583333333333334
r14020 n7888 n7889 1
r14021 n7855 n7890 0.21875
r14022 n7889 n7890 1
r14023 n7856 n7891 0.019021739130434784
r14024 n7890 n7891 0.78125
r14025 n7857 n7892 0.043749999999999997
r14026 n7891 n7892 1.03125
r14027 n7858 n7893 0.036458333333333336
r14028 n7859 n7894 0.0625
r14029 n7893 n7894 0.59375
r14030 n7860 n7895 0.21875
r14031 n7894 n7895 0.28125
r14032 n7861 n7896 0.109375
r14033 n7895 n7896 0.1875
r14034 n7862 n7897 0.048611111111111112
r14035 n7896 n7897 0.40625
r14036 n7863 n7898 0.020833333333333332
r14037 n7897 n7898 0.9375
r14038 n7864 n7899 0.21875
r14039 n7898 n7899 0.71875
r14040 n7865 n7900 0.21875
r14041 n7899 n7900 0.125
r14042 n7866 n7901 0.048611111111111112
r14043 n7900 n7901 0.34375
r14044 n7867 n7902 0.036458333333333336
r14045 n7901 n7902 0.65625
r14046 n7868 n7903 0.036458333333333336
r14047 n7869 n7904 0.048611111111111112
r14048 n7903 n7904 0.65625
r14049 n7870 n7905 0.21875
r14050 n7904 n7905 0.34375
r14051 n7871 n7906 0.21875
r14052 n7905 n7906 0.125
r14053 n7872 n7907 0.0546875
r14054 n7906 n7907 0.3125
r14055 n7873 n7908 0.019886363636363636
r14056 n7907 n7908 0.9375
r14057 n7874 n7909 0.4375
r14058 n7908 n7909 0.71875
r14059 n7875 n7910 0.4375
r14060 n7909 n7910 0.0625
r14061 n7876 n7911 0.4375
r14062 n7910 n7911 0.0625
r14063 n7877 n7912 0.043749999999999997
r14064 n7911 n7912 0.34375
r14065 n7878 n7913 0.036458333333333336
r14066 n7912 n7913 0.6875
r14067 n7879 n7914 0.043749999999999997
r14068 n7880 n7915 0.019021739130434784
r14069 n7914 n7915 1.03125
r14070 n7881 n7916 0.21875
r14071 n7915 n7916 0.78125
r14072 n7882 n7917 0.014583333333333334
r14073 n7916 n7917 1
r14074 n7883 n7918 0.21875
r14075 n7917 n7918 1
r14076 n7884 n7919 0.019021739130434784
r14077 n7918 n7919 0.78125
r14078 n7885 n7920 0.043749999999999997
r14079 n7919 n7920 1.03125
r14080 n7886 n7921 0.050000000000000003
r14081 n7887 n7922 0.021739130434782608
r14082 n7921 n7922 0.34375
r14083 n7888 n7923 0.25
r14084 n7922 n7923 0.26041666666666669
r14085 n7889 n7924 0.016666666666666666
r14086 n7923 n7924 0.33333333333333331
r14087 n7890 n7925 0.25
r14088 n7924 n7925 0.33333333333333331
r14089 n7891 n7926 0.021739130434782608
r14090 n7925 n7926 0.26041666666666669
r14091 n7892 n7927 0.050000000000000003
r14092 n7926 n7927 0.34375
r14093 n7893 n7928 0.041666666666666664
r14094 n7894 n7929 0.071428571428571425
r14095 n7928 n7929 0.19791666666666666
r14096 n7895 n7930 0.25
r14097 n7929 n7930 0.09375
r14098 n7896 n7931 0.125
r14099 n7930 n7931 0.0625
r14100 n7897 n7932 0.055555555555555552
r14101 n7931 n7932 0.13541666666666666
r14102 n7898 n7933 0.023809523809523808
r14103 n7932 n7933 0.3125
r14104 n7899 n7934 0.25
r14105 n7933 n7934 0.23958333333333334
r14106 n7900 n7935 0.25
r14107 n7934 n7935 0.041666666666666664
r14108 n7901 n7936 0.055555555555555552
r14109 n7935 n7936 0.11458333333333333
r14110 n7902 n7937 0.041666666666666664
r14111 n7936 n7937 0.21875
r14112 n7903 n7938 0.041666666666666664
r14113 n7904 n7939 0.055555555555555552
r14114 n7938 n7939 0.21875
r14115 n7905 n7940 0.25
r14116 n7939 n7940 0.11458333333333333
r14117 n7906 n7941 0.25
r14118 n7940 n7941 0.041666666666666664
r14119 n7907 n7942 0.0625
r14120 n7941 n7942 0.10416666666666667
r14121 n7908 n7943 0.022727272727272728
r14122 n7942 n7943 0.3125
r14123 n7909 n7944 0.5
r14124 n7943 n7944 0.23958333333333334
r14125 n7910 n7945 0.5
r14126 n7944 n7945 0.020833333333333332
r14127 n7911 n7946 0.5
r14128 n7945 n7946 0.020833333333333332
r14129 n7912 n7947 0.050000000000000003
r14130 n7946 n7947 0.11458333333333333
r14131 n7913 n7948 0.041666666666666664
r14132 n7947 n7948 0.22916666666666666
r14133 n7914 n7949 0.050000000000000003
r14134 n7915 n7950 0.021739130434782608
r14135 n7949 n7950 0.34375
r14136 n7916 n7951 0.25
r14137 n7950 n7951 0.26041666666666669
r14138 n7917 n7952 0.016666666666666666
r14139 n7951 n7952 0.33333333333333331
r14140 n7918 n7953 0.25
r14141 n7952 n7953 0.33333333333333331
r14142 n7919 n7954 0.021739130434782608
r14143 n7953 n7954 0.26041666666666669
r14144 n7920 n7955 0.050000000000000003
r14145 n7954 n7955 0.34375
r14146 n7921 n7956 0.081250000000000003
r14147 n7922 n7957 0.035326086956521736
r14148 n7956 n7957 0.29464285714285715
r14149 n7923 n7958 0.40625
r14150 n7957 n7958 0.22321428571428573
r14151 n7924 n7959 0.027083333333333334
r14152 n7958 n7959 0.2857142857142857
r14153 n7925 n7960 0.40625
r14154 n7959 n7960 0.2857142857142857
r14155 n7926 n7961 0.035326086956521736
r14156 n7960 n7961 0.22321428571428573
r14157 n7927 n7962 0.081250000000000003
r14158 n7961 n7962 0.29464285714285715
r14159 n7928 n7963 0.067708333333333329
r14160 n7929 n7964 0.11607142857142858
r14161 n7963 n7964 0.16964285714285715
r14162 n7930 n7965 0.40625
r14163 n7964 n7965 0.080357142857142863
r14164 n7931 n7966 0.203125
r14165 n7965 n7966 0.053571428571428568
r14166 n7932 n7967 0.090277777777777776
r14167 n7966 n7967 0.11607142857142858
r14168 n7933 n7968 0.038690476190476192
r14169 n7967 n7968 0.26785714285714285
r14170 n7934 n7969 0.40625
r14171 n7968 n7969 0.20535714285714285
r14172 n7935 n7970 0.40625
r14173 n7969 n7970 0.035714285714285712
r14174 n7936 n7971 0.090277777777777776
r14175 n7970 n7971 0.098214285714285712
r14176 n7937 n7972 0.067708333333333329
r14177 n7971 n7972 0.1875
r14178 n7938 n7973 0.067708333333333329
r14179 n7939 n7974 0.090277777777777776
r14180 n7973 n7974 0.1875
r14181 n7940 n7975 0.40625
r14182 n7974 n7975 0.098214285714285712
r14183 n7941 n7976 0.40625
r14184 n7975 n7976 0.035714285714285712
r14185 n7942 n7977 0.1015625
r14186 n7976 n7977 0.089285714285714288
r14187 n7943 n7978 0.036931818181818184
r14188 n7977 n7978 0.26785714285714285
r14189 n7944 n7979 0.8125
r14190 n7978 n7979 0.20535714285714285
r14191 n7945 n7980 0.8125
r14192 n7979 n7980 0.017857142857142856
r14193 n7946 n7981 0.8125
r14194 n7980 n7981 0.017857142857142856
r14195 n7947 n7982 0.081250000000000003
r14196 n7981 n7982 0.098214285714285712
r14197 n7948 n7983 0.067708333333333329
r14198 n7982 n7983 0.19642857142857142
r14199 n7949 n7984 0.081250000000000003
r14200 n7950 n7985 0.035326086956521736
r14201 n7984 n7985 0.29464285714285715
r14202 n7951 n7986 0.40625
r14203 n7985 n7986 0.22321428571428573
r14204 n7952 n7987 0.027083333333333334
r14205 n7986 n7987 0.2857142857142857
r14206 n7953 n7988 0.40625
r14207 n7987 n7988 0.2857142857142857
r14208 n7954 n7989 0.035326086956521736
r14209 n7988 n7989 0.22321428571428573
r14210 n7955 n7990 0.081250000000000003
r14211 n7989 n7990 0.29464285714285715
r14212 n7956 n7991 0.13125000000000001
r14213 n7957 n7992 0.057065217391304345
r14214 n7991 n7992 0.14732142857142858
r14215 n7958 n7993 0.65625
r14216 n7992 n7993 0.11160714285714286
r14217 n7959 n7994 0.043749999999999997
r14218 n7993 n7994 0.14285714285714285
r14219 n7960 n7995 0.65625
r14220 n7994 n7995 0.14285714285714285
r14221 n7961 n7996 0.057065217391304345
r14222 n7995 n7996 0.11160714285714286
r14223 n7962 n7997 0.13125000000000001
r14224 n7996 n7997 0.14732142857142858
r14225 n7964 n7998 0.1875
r14226 n7965 n7999 0.65625
r14227 n7998 n7999 0.040178571428571432
r14228 n7966 n8000 0.328125
r14229 n7999 n8000 0.026785714285714284
r14230 n7967 n8001 0.14583333333333334
r14231 n8000 n8001 0.058035714285714288
r14232 n7968 n8002 0.0625
r14233 n8001 n8002 0.13392857142857142
r14234 n7969 n8003 0.65625
r14235 n8002 n8003 0.10267857142857142
r14236 n7970 n8004 0.65625
r14237 n8003 n8004 0.017857142857142856
r14238 n7971 n8005 0.14583333333333334
r14239 n8004 n8005 0.049107142857142856
r14240 n7974 n8006 0.14583333333333334
r14241 n7975 n8007 0.65625
r14242 n8006 n8007 0.049107142857142856
r14243 n7976 n8008 0.65625
r14244 n8007 n8008 0.017857142857142856
r14245 n7977 n8009 0.1640625
r14246 n8008 n8009 0.044642857142857144
r14247 n7978 n8010 0.059659090909090912
r14248 n8009 n8010 0.13392857142857142
r14249 n7979 n8011 1.3125
r14250 n8010 n8011 0.10267857142857142
r14251 n7980 n8012 1.3125
r14252 n8011 n8012 0.0089285714285714281
r14253 n7981 n8013 1.3125
r14254 n8012 n8013 0.0089285714285714281
r14255 n7982 n8014 0.13125000000000001
r14256 n8013 n8014 0.049107142857142856
r14257 n7984 n8015 0.13125000000000001
r14258 n7985 n8016 0.057065217391304345
r14259 n8015 n8016 0.14732142857142858
r14260 n7986 n8017 0.65625
r14261 n8016 n8017 0.11160714285714286
r14262 n7987 n8018 0.043749999999999997
r14263 n8017 n8018 0.14285714285714285
r14264 n7988 n8019 0.65625
r14265 n8018 n8019 0.14285714285714285
r14266 n7989 n8020 0.057065217391304345
r14267 n8019 n8020 0.11160714285714286
r14268 n7990 n8021 0.13125000000000001
r14269 n8020 n8021 0.14732142857142858
r14270 n7991 n8022 0.32250000000000001
r14271 n7992 n8023 0.14021739130434782
r14272 n8022 n8023 0.054853723404255317
r14273 n7993 n8024 1.6125
r14274 n8023 n8024 0.041555851063829786
r14275 n7994 n8025 0.1075
r14276 n8024 n8025 0.053191489361702128
r14277 n7995 n8026 1.6125
r14278 n8025 n8026 0.053191489361702128
r14279 n7996 n8027 0.14021739130434782
r14280 n8026 n8027 0.041555851063829786
r14281 n7997 n8028 0.32250000000000001
r14282 n8027 n8028 0.054853723404255317
r14283 n7998 n8029 0.46071428571428569
r14284 n7999 n8030 1.6125
r14285 n8029 n8030 0.014960106382978724
r14286 n8000 n8031 0.80625000000000002
r14287 n8030 n8031 0.0099734042553191495
r14288 n8001 n8032 0.35833333333333334
r14289 n8031 n8032 0.021609042553191491
r14290 n8002 n8033 0.15357142857142858
r14291 n8032 n8033 0.049867021276595744
r14292 n8003 n8034 1.6125
r14293 n8033 n8034 0.038231382978723402
r14294 n8004 n8035 1.6125
r14295 n8034 n8035 0.006648936170212766
r14296 n8005 n8036 0.35833333333333334
r14297 n8035 n8036 0.018284574468085107
r14298 n8006 n8037 0.35833333333333334
r14299 n8007 n8038 1.6125
r14300 n8037 n8038 0.018284574468085107
r14301 n8008 n8039 1.6125
r14302 n8038 n8039 0.006648936170212766
r14303 n8009 n8040 0.40312500000000001
r14304 n8039 n8040 0.016622340425531915
r14305 n8010 n8041 0.14659090909090908
r14306 n8040 n8041 0.049867021276595744
r14307 n8011 n8042 3.2250000000000001
r14308 n8041 n8042 0.038231382978723402
r14309 n8012 n8043 3.2250000000000001
r14310 n8042 n8043 0.003324468085106383
r14311 n8013 n8044 3.2250000000000001
r14312 n8043 n8044 0.003324468085106383
r14313 n8014 n8045 0.32250000000000001
r14314 n8044 n8045 0.018284574468085107
r14315 n8015 n8046 0.32250000000000001
r14316 n8016 n8047 0.14021739130434782
r14317 n8046 n8047 0.054853723404255317
r14318 n8017 n8048 1.6125
r14319 n8047 n8048 0.041555851063829786
r14320 n8018 n8049 0.1075
r14321 n8048 n8049 0.053191489361702128
r14322 n8019 n8050 1.6125
r14323 n8049 n8050 0.053191489361702128
r14324 n8020 n8051 0.14021739130434782
r14325 n8050 n8051 0.041555851063829786
r14326 n8021 n8052 0.32250000000000001
r14327 n8051 n8052 0.054853723404255317
r14328 n8022 n8053 0.46875
r14329 n8023 n8054 0.20380434782608695
r14330 n8053 n8054 0.05514705882352941
r14331 n8024 n8055 2.34375
r14332 n8054 n8055 0.041778074866310161
r14333 n8025 n8056 0.15625
r14334 n8055 n8056 0.053475935828877004
r14335 n8026 n8057 2.34375
r14336 n8056 n8057 0.053475935828877004
r14337 n8027 n8058 0.20380434782608695
r14338 n8057 n8058 0.041778074866310161
r14339 n8028 n8059 0.46875
r14340 n8058 n8059 0.05514705882352941
r14341 n8029 n8060 0.6696428571428571
r14342 n8030 n8061 2.34375
r14343 n8060 n8061 0.015040106951871657
r14344 n8031 n8062 1.171875
r14345 n8061 n8062 0.010026737967914439
r14346 n8032 n8063 0.52083333333333337
r14347 n8062 n8063 0.021724598930481284
r14348 n8033 n8064 0.22321428571428573
r14349 n8063 n8064 0.050133689839572192
r14350 n8034 n8065 2.34375
r14351 n8064 n8065 0.038435828877005349
r14352 n8035 n8066 2.34375
r14353 n8065 n8066 0.0066844919786096255
r14354 n8036 n8067 0.52083333333333337
r14355 n8066 n8067 0.018382352941176471
r14356 n8037 n8068 0.52083333333333337
r14357 n8038 n8069 2.34375
r14358 n8068 n8069 0.018382352941176471
r14359 n8039 n8070 2.34375
r14360 n8069 n8070 0.0066844919786096255
r14361 n8040 n8071 0.5859375
r14362 n8070 n8071 0.016711229946524065
r14363 n8041 n8072 0.21306818181818182
r14364 n8071 n8072 0.050133689839572192
r14365 n8042 n8073 4.6875
r14366 n8072 n8073 0.038435828877005349
r14367 n8043 n8074 4.6875
r14368 n8073 n8074 0.0033422459893048127
r14369 n8044 n8075 4.6875
r14370 n8074 n8075 0.0033422459893048127
r14371 n8045 n8076 0.46875
r14372 n8075 n8076 0.018382352941176471
r14373 n8046 n8077 0.46875
r14374 n8047 n8078 0.20380434782608695
r14375 n8077 n8078 0.05514705882352941
r14376 n8048 n8079 2.34375
r14377 n8078 n8079 0.041778074866310161
r14378 n8049 n8080 0.15625
r14379 n8079 n8080 0.053475935828877004
r14380 n8050 n8081 2.34375
r14381 n8080 n8081 0.053475935828877004
r14382 n8051 n8082 0.20380434782608695
r14383 n8081 n8082 0.041778074866310161
r14384 n8052 n8083 0.46875
r14385 n8082 n8083 0.05514705882352941
r14386 n8053 n8084 0.44624999999999998
r14387 n8054 n8085 0.19402173913043477
r14388 n8084 n8085 0.060661764705882353
r14389 n8055 n8086 2.2312500000000002
r14390 n8085 n8086 0.04595588235294118
r14391 n8056 n8087 0.14874999999999999
r14392 n8086 n8087 0.058823529411764705
r14393 n8057 n8088 2.2312500000000002
r14394 n8087 n8088 0.058823529411764705
r14395 n8058 n8089 0.19402173913043477
r14396 n8088 n8089 0.04595588235294118
r14397 n8059 n8090 0.44624999999999998
r14398 n8089 n8090 0.060661764705882353
r14399 n8060 n8091 0.63749999999999996
r14400 n8061 n8092 2.2312500000000002
r14401 n8091 n8092 0.016544117647058824
r14402 n8062 n8093 1.1156250000000001
r14403 n8092 n8093 0.011029411764705883
r14404 n8063 n8094 0.49583333333333335
r14405 n8093 n8094 0.02389705882352941
r14406 n8064 n8095 0.21249999999999999
r14407 n8094 n8095 0.05514705882352941
r14408 n8065 n8096 2.2312500000000002
r14409 n8095 n8096 0.042279411764705885
r14410 n8066 n8097 2.2312500000000002
r14411 n8096 n8097 0.0073529411764705881
r14412 n8067 n8098 0.49583333333333335
r14413 n8097 n8098 0.020220588235294119
r14414 n8068 n8099 0.49583333333333335
r14415 n8069 n8100 2.2312500000000002
r14416 n8099 n8100 0.020220588235294119
r14417 n8070 n8101 2.2312500000000002
r14418 n8100 n8101 0.0073529411764705881
r14419 n8071 n8102 0.55781250000000004
r14420 n8101 n8102 0.018382352941176471
r14421 n8072 n8103 0.2028409090909091
r14422 n8102 n8103 0.05514705882352941
r14423 n8073 n8104 4.4625000000000004
r14424 n8103 n8104 0.042279411764705885
r14425 n8074 n8105 4.4625000000000004
r14426 n8104 n8105 0.0036764705882352941
r14427 n8075 n8106 4.4625000000000004
r14428 n8105 n8106 0.0036764705882352941
r14429 n8076 n8107 0.44624999999999998
r14430 n8106 n8107 0.020220588235294119
r14431 n8077 n8108 0.44624999999999998
r14432 n8078 n8109 0.19402173913043477
r14433 n8108 n8109 0.060661764705882353
r14434 n8079 n8110 2.2312500000000002
r14435 n8109 n8110 0.04595588235294118
r14436 n8080 n8111 0.14874999999999999
r14437 n8110 n8111 0.058823529411764705
r14438 n8081 n8112 2.2312500000000002
r14439 n8111 n8112 0.058823529411764705
r14440 n8082 n8113 0.19402173913043477
r14441 n8112 n8113 0.04595588235294118
r14442 n8083 n8114 0.44624999999999998
r14443 n8113 n8114 0.060661764705882353
r14444 n8084 n8115 0.46000000000000002
r14445 n8085 n8116 0.20000000000000001
r14446 n8115 n8116 0.052083333333333336
r14447 n8086 n8117 2.2999999999999998
r14448 n8116 n8117 0.039457070707070704
r14449 n8087 n8118 0.15333333333333332
r14450 n8117 n8118 0.050505050505050504
r14451 n8088 n8119 2.2999999999999998
r14452 n8118 n8119 0.050505050505050504
r14453 n8089 n8120 0.20000000000000001
r14454 n8119 n8120 0.039457070707070704
r14455 n8090 n8121 0.46000000000000002
r14456 n8120 n8121 0.052083333333333336
r14457 n8091 n8122 0.65714285714285714
r14458 n8092 n8123 2.2999999999999998
r14459 n8122 n8123 0.014204545454545454
r14460 n8093 n8124 1.1499999999999999
r14461 n8123 n8124 0.00946969696969697
r14462 n8094 n8125 0.51111111111111107
r14463 n8124 n8125 0.020517676767676768
r14464 n8095 n8126 0.21904761904761905
r14465 n8125 n8126 0.047348484848484848
r14466 n8096 n8127 2.2999999999999998
r14467 n8126 n8127 0.036300505050505048
r14468 n8097 n8128 2.2999999999999998
r14469 n8127 n8128 0.006313131313131313
r14470 n8098 n8129 0.51111111111111107
r14471 n8128 n8129 0.017361111111111112
r14472 n8099 n8130 0.51111111111111107
r14473 n8100 n8131 2.2999999999999998
r14474 n8130 n8131 0.017361111111111112
r14475 n8101 n8132 2.2999999999999998
r14476 n8131 n8132 0.006313131313131313
r14477 n8102 n8133 0.57499999999999996
r14478 n8132 n8133 0.015782828282828284
r14479 n8103 n8134 0.20909090909090908
r14480 n8133 n8134 0.047348484848484848
r14481 n8104 n8135 4.5999999999999996
r14482 n8134 n8135 0.036300505050505048
r14483 n8105 n8136 4.5999999999999996
r14484 n8135 n8136 0.0031565656565656565
r14485 n8106 n8137 4.5999999999999996
r14486 n8136 n8137 0.0031565656565656565
r14487 n8107 n8138 0.46000000000000002
r14488 n8137 n8138 0.017361111111111112
r14489 n8108 n8139 0.46000000000000002
r14490 n8109 n8140 0.20000000000000001
r14491 n8139 n8140 0.052083333333333336
r14492 n8110 n8141 2.2999999999999998
r14493 n8140 n8141 0.039457070707070704
r14494 n8111 n8142 0.15333333333333332
r14495 n8141 n8142 0.050505050505050504
r14496 n8112 n8143 2.2999999999999998
r14497 n8142 n8143 0.050505050505050504
r14498 n8113 n8144 0.20000000000000001
r14499 n8143 n8144 0.039457070707070704
r14500 n8114 n8145 0.46000000000000002
r14501 n8144 n8145 0.052083333333333336
r14502 n8115 n8146 0.49625000000000002
r14503 n8116 n8147 0.21576086956521739
r14504 n8146 n8147 0.051821608040201007
r14505 n8117 n8148 2.4812500000000002
r14506 n8147 n8148 0.03925879396984925
r14507 n8118 n8149 0.16541666666666666
r14508 n8148 n8149 0.050251256281407038
r14509 n8119 n8150 2.4812500000000002
r14510 n8149 n8150 0.050251256281407038
r14511 n8120 n8151 0.21576086956521739
r14512 n8150 n8151 0.03925879396984925
r14513 n8121 n8152 0.49625000000000002
r14514 n8151 n8152 0.051821608040201007
r14515 n8122 n8153 0.70892857142857146
r14516 n8123 n8154 2.4812500000000002
r14517 n8153 n8154 0.014133165829145729
r14518 n8124 n8155 1.2406250000000001
r14519 n8154 n8155 0.0094221105527638183
r14520 n8125 n8156 0.55138888888888893
r14521 n8155 n8156 0.02041457286432161
r14522 n8126 n8157 0.2363095238095238
r14523 n8156 n8157 0.047110552763819098
r14524 n8127 n8158 2.4812500000000002
r14525 n8157 n8158 0.036118090452261303
r14526 n8128 n8159 2.4812500000000002
r14527 n8158 n8159 0.0062814070351758797
r14528 n8129 n8160 0.55138888888888893
r14529 n8159 n8160 0.017273869346733667
r14530 n8130 n8161 0.55138888888888893
r14531 n8131 n8162 2.4812500000000002
r14532 n8161 n8162 0.017273869346733667
r14533 n8132 n8163 2.4812500000000002
r14534 n8162 n8163 0.0062814070351758797
r14535 n8133 n8164 0.62031250000000004
r14536 n8163 n8164 0.015703517587939697
r14537 n8134 n8165 0.22556818181818181
r14538 n8164 n8165 0.047110552763819098
r14539 n8135 n8166 4.9625000000000004
r14540 n8165 n8166 0.036118090452261303
r14541 n8136 n8167 4.9625000000000004
r14542 n8166 n8167 0.0031407035175879399
r14543 n8137 n8168 4.9625000000000004
r14544 n8167 n8168 0.0031407035175879399
r14545 n8138 n8169 0.49625000000000002
r14546 n8168 n8169 0.017273869346733667
r14547 n8139 n8170 0.49625000000000002
r14548 n8140 n8171 0.21576086956521739
r14549 n8170 n8171 0.051821608040201007
r14550 n8141 n8172 2.4812500000000002
r14551 n8171 n8172 0.03925879396984925
r14552 n8142 n8173 0.16541666666666666
r14553 n8172 n8173 0.050251256281407038
r14554 n8143 n8174 2.4812500000000002
r14555 n8173 n8174 0.050251256281407038
r14556 n8144 n8175 0.21576086956521739
r14557 n8174 n8175 0.03925879396984925
r14558 n8145 n8176 0.49625000000000002
r14559 n8175 n8176 0.051821608040201007
r14560 n8146 n8177 0.49625000000000002
r14561 n8147 n8178 0.21576086956521739
r14562 n8177 n8178 0.052083333333333336
r14563 n8148 n8179 2.4812500000000002
r14564 n8178 n8179 0.039457070707070704
r14565 n8149 n8180 0.16541666666666666
r14566 n8179 n8180 0.050505050505050504
r14567 n8150 n8181 2.4812500000000002
r14568 n8180 n8181 0.050505050505050504
r14569 n8151 n8182 0.21576086956521739
r14570 n8181 n8182 0.039457070707070704
r14571 n8152 n8183 0.49625000000000002
r14572 n8182 n8183 0.052083333333333336
r14573 n8153 n8184 0.70892857142857146
r14574 n8154 n8185 2.4812500000000002
r14575 n8184 n8185 0.014204545454545454
r14576 n8155 n8186 1.2406250000000001
r14577 n8185 n8186 0.00946969696969697
r14578 n8156 n8187 0.55138888888888893
r14579 n8186 n8187 0.020517676767676768
r14580 n8157 n8188 0.2363095238095238
r14581 n8187 n8188 0.047348484848484848
r14582 n8158 n8189 2.4812500000000002
r14583 n8188 n8189 0.036300505050505048
r14584 n8159 n8190 2.4812500000000002
r14585 n8189 n8190 0.006313131313131313
r14586 n8160 n8191 0.55138888888888893
r14587 n8190 n8191 0.017361111111111112
r14588 n8161 n8192 0.55138888888888893
r14589 n8162 n8193 2.4812500000000002
r14590 n8192 n8193 0.017361111111111112
r14591 n8163 n8194 2.4812500000000002
r14592 n8193 n8194 0.006313131313131313
r14593 n8164 n8195 0.62031250000000004
r14594 n8194 n8195 0.015782828282828284
r14595 n8165 n8196 0.22556818181818181
r14596 n8195 n8196 0.047348484848484848
r14597 n8166 n8197 4.9625000000000004
r14598 n8196 n8197 0.036300505050505048
r14599 n8167 n8198 4.9625000000000004
r14600 n8197 n8198 0.0031565656565656565
r14601 n8168 n8199 4.9625000000000004
r14602 n8198 n8199 0.0031565656565656565
r14603 n8169 n8200 0.49625000000000002
r14604 n8199 n8200 0.017361111111111112
r14605 n8170 n8201 0.49625000000000002
r14606 n8171 n8202 0.21576086956521739
r14607 n8201 n8202 0.052083333333333336
r14608 n8172 n8203 2.4812500000000002
r14609 n8202 n8203 0.039457070707070704
r14610 n8173 n8204 0.16541666666666666
r14611 n8203 n8204 0.050505050505050504
r14612 n8174 n8205 2.4812500000000002
r14613 n8204 n8205 0.050505050505050504
r14614 n8175 n8206 0.21576086956521739
r14615 n8205 n8206 0.039457070707070704
r14616 n8176 n8207 0.49625000000000002
r14617 n8206 n8207 0.052083333333333336
r14618 n8177 n8208 0.42249999999999999
r14619 n8178 n8209 0.18369565217391304
r14620 n8208 n8209 0.073660714285714288
r14621 n8179 n8210 2.1124999999999998
r14622 n8209 n8210 0.055803571428571432
r14623 n8180 n8211 0.14083333333333334
r14624 n8210 n8211 0.071428571428571425
r14625 n8181 n8212 2.1124999999999998
r14626 n8211 n8212 0.071428571428571425
r14627 n8182 n8213 0.18369565217391304
r14628 n8212 n8213 0.055803571428571432
r14629 n8183 n8214 0.42249999999999999
r14630 n8213 n8214 0.073660714285714288
r14631 n8184 n8215 0.60357142857142854
r14632 n8185 n8216 2.1124999999999998
r14633 n8215 n8216 0.020089285714285716
r14634 n8186 n8217 1.0562499999999999
r14635 n8216 n8217 0.013392857142857142
r14636 n8187 n8218 0.46944444444444444
r14637 n8217 n8218 0.029017857142857144
r14638 n8188 n8219 0.2011904761904762
r14639 n8218 n8219 0.066964285714285712
r14640 n8189 n8220 2.1124999999999998
r14641 n8219 n8220 0.051339285714285712
r14642 n8190 n8221 2.1124999999999998
r14643 n8220 n8221 0.0089285714285714281
r14644 n8191 n8222 0.46944444444444444
r14645 n8221 n8222 0.024553571428571428
r14646 n8222 n8223 0.046875
r14647 n8223 n8224 0.046875
r14648 n8224 n8225 0.024553571428571428
r14649 n8225 n8226 0.0089285714285714281
r14650 n8226 n8227 0.051339285714285712
r14651 n8227 n8228 0.080357142857142863
r14652 n8228 n8229 0.037946428571428568
r14653 n8229 n8230 0.075892857142857137
r14654 n8230 n8231 0.075892857142857137
r14655 n8231 n8232 0.03125
r14656 n8232 n8233 0.035714285714285712
r14657 n8233 n8234 0.053571428571428568
r14658 n8234 n8235 0.12053571428571429
r14659 n8235 n8236 0.087053571428571425
r14660 n8236 n8237 0.033482142857142856
r14661 n8237 n8238 0.037946428571428568
r14662 n8238 n8239 0.022321428571428572
r14663 n8239 n8240 0.013392857142857142
r14664 n8240 n8241 0.011160714285714286
r14665 n8241 n8242 0.022321428571428572
r14666 n8242 n8243 0.066964285714285712
r14667 n8243 n8244 0.053571428571428568
r14668 n8244 n8245 0.011160714285714286
r14669 n8245 n8246 0.013392857142857142
r14670 n8246 n8247 0.015625
r14671 n8247 n8248 0.015625
r14672 n8248 n8249 0.029017857142857144
r14673 n8249 n8250 0.13169642857142858
r14674 n8250 n8251 0.18526785714285715
r14675 n8251 n8252 0.17053571428571429
r14676 n8252 n8253 0.18973214285714285
r14677 n8253 n8254 0.19017857142857142
r14678 n8254 n8255 0.18973214285714285
r14679 n8255 n8256 0.16160714285714287
r14680 n8256 n8257 0.13392857142857142
r14681 n8257 n8258 0.13392857142857142
r14682 n8258 n8259 0.13392857142857142
r14683 n8259 n8260 0.15625
r14684 n8260 n8261 0.17857142857142858
r14685 n8261 n8262 0.16071428571428573
r14686 n8262 n8263 0.13392857142857142
r14687 n8263 n8264 0.125
r14688 n8264 n8265 0.13392857142857142
r14689 n8265 n8266 0.12946428571428573
r14690 n8266 n8267 0.11607142857142858
r14691 n8267 n8268 0.13392857142857142
r14692 n8268 n8269 0.14285714285714285
r14693 n8269 n8270 0.13392857142857142
r14694 n8270 n8271 0.14285714285714285
r14695 n8271 n8272 0.12946428571428573
r14696 n8272 n8273 0.0625
r14697 n8273 n8274 0.03125
r14698 n8274 n8275 0.026785714285714284
r14699 n8275 n8276 0.075892857142857137
r14700 n8276 n8277 0.075892857142857137
r14701 n8277 n8278 0.084821428571428575
r14702 n8278 n8279 0.084821428571428575
r14703 n8279 n8280 0.075892857142857137
r14704 n8280 n8281 0.075892857142857137
r14705 n8281 n8282 0.084821428571428575
r14706 n8282 n8283 0.084821428571428575
r14707 n8283 n8284 0.075892857142857137
r14708 n8284 n8285 0.075892857142857137
r14709 n8285 n8286 0.084821428571428575
r14710 n8286 n8287 0.084821428571428575
r14711 n8287 n8288 0.075892857142857137
r14712 n8288 n8289 0.075892857142857137
r14713 n8289 n8290 0.084821428571428575
r14714 n8290 n8291 0.084821428571428575
r14715 n8291 n8292 0.075892857142857137
r14716 n8292 n8293 0.075892857142857137
r14717 n8293 n8294 0.084821428571428575
r14718 n8294 n8295 0.084821428571428575
r14719 n8295 n8296 0.075892857142857137
r14720 n8296 n8297 0.075892857142857137
r14721 n8297 n8298 0.084821428571428575
r14722 n8298 n8299 0.084821428571428575
r14723 n8299 n8300 0.075892857142857137
r14724 n8300 n8301 0.075892857142857137
r14725 n8301 n8302 0.084821428571428575
r14726 n8302 n8303 0.084821428571428575
r14727 n8303 n8304 0.075892857142857137
r14728 n8304 n8305 0.075892857142857137
r14729 n8305 n8306 0.037946428571428568
r14730 n8306 n8307 0.060267857142857144
r14731 n8192 n8308 0.46944444444444444
r14732 n8307 n8308 0.046875
r14733 n8193 n8309 2.1124999999999998
r14734 n8308 n8309 0.024553571428571428
r14735 n8194 n8310 2.1124999999999998
r14736 n8309 n8310 0.0089285714285714281
r14737 n8195 n8311 0.52812499999999996
r14738 n8310 n8311 0.022321428571428572
r14739 n8196 n8312 0.19204545454545455
r14740 n8311 n8312 0.066964285714285712
r14741 n8197 n8313 4.2249999999999996
r14742 n8312 n8313 0.051339285714285712
r14743 n8198 n8314 4.2249999999999996
r14744 n8313 n8314 0.004464285714285714
r14745 n8199 n8315 4.2249999999999996
r14746 n8314 n8315 0.004464285714285714
r14747 n8200 n8316 0.42249999999999999
r14748 n8315 n8316 0.024553571428571428
r14749 n8201 n8317 0.42249999999999999
r14750 n8202 n8318 0.18369565217391304
r14751 n8317 n8318 0.073660714285714288
r14752 n8203 n8319 2.1124999999999998
r14753 n8318 n8319 0.055803571428571432
r14754 n8204 n8320 0.14083333333333334
r14755 n8319 n8320 0.071428571428571425
r14756 n8205 n8321 2.1124999999999998
r14757 n8320 n8321 0.071428571428571425
r14758 n8206 n8322 0.18369565217391304
r14759 n8321 n8322 0.055803571428571432
r14760 n8207 n8323 0.42249999999999999
r14761 n8322 n8323 0.073660714285714288
r14762 n8208 n8324 0.34999999999999998
r14763 n8209 n8325 0.15217391304347827
r14764 n8324 n8325 0.073660714285714288
r14765 n8210 n8326 1.75
r14766 n8325 n8326 0.055803571428571432
r14767 n8211 n8327 0.11666666666666667
r14768 n8326 n8327 0.071428571428571425
r14769 n8212 n8328 1.75
r14770 n8327 n8328 0.071428571428571425
r14771 n8213 n8329 0.15217391304347827
r14772 n8328 n8329 0.055803571428571432
r14773 n8214 n8330 0.34999999999999998
r14774 n8329 n8330 0.073660714285714288
r14775 n8215 n8331 0.5
r14776 n8216 n8332 1.75
r14777 n8331 n8332 0.020089285714285716
r14778 n8217 n8333 0.875
r14779 n8332 n8333 0.013392857142857142
r14780 n8218 n8334 0.3888888888888889
r14781 n8333 n8334 0.029017857142857144
r14782 n8219 n8335 0.16666666666666666
r14783 n8334 n8335 0.066964285714285712
r14784 n8220 n8336 1.75
r14785 n8335 n8336 0.051339285714285712
r14786 n8221 n8337 1.75
r14787 n8336 n8337 0.0089285714285714281
r14788 n8222 n8338 0.3888888888888889
r14789 n8337 n8338 0.024553571428571428
r14790 n8223 n8339 0.29166666666666669
r14791 n8338 n8339 0.046875
r14792 n8224 n8340 0.3888888888888889
r14793 n8339 n8340 0.046875
r14794 n8225 n8341 1.75
r14795 n8340 n8341 0.024553571428571428
r14796 n8226 n8342 1.75
r14797 n8341 n8342 0.0089285714285714281
r14798 n8227 n8343 0.16666666666666666
r14799 n8342 n8343 0.051339285714285712
r14800 n8228 n8344 0.23333333333333334
r14801 n8343 n8344 0.080357142857142863
r14802 n8229 n8345 1.75
r14803 n8344 n8345 0.037946428571428568
r14804 n8230 n8346 0.109375
r14805 n8345 n8346 0.075892857142857137
r14806 n8231 n8347 1.75
r14807 n8346 n8347 0.075892857142857137
r14808 n8232 n8348 0.29166666666666669
r14809 n8347 n8348 0.03125
r14810 n8233 n8349 0.875
r14811 n8348 n8349 0.035714285714285712
r14812 n8234 n8350 0.17499999999999999
r14813 n8349 n8350 0.053571428571428568
r14814 n8235 n8351 0.10294117647058823
r14815 n8350 n8351 0.12053571428571429
r14816 n8236 n8352 0.69999999999999996
r14817 n8351 n8352 0.087053571428571425
r14818 n8237 n8353 0.34999999999999998
r14819 n8352 n8353 0.033482142857142856
r14820 n8238 n8354 0.5
r14821 n8353 n8354 0.037946428571428568
r14822 n8239 n8355 1.1666666666666667
r14823 n8354 n8355 0.022321428571428572
r14824 n8240 n8356 1.1666666666666667
r14825 n8355 n8356 0.013392857142857142
r14826 n8241 n8357 1.75
r14827 n8356 n8357 0.011160714285714286
r14828 n8242 n8358 0.4375
r14829 n8357 n8358 0.022321428571428572
r14830 n8243 n8359 0.15909090909090909
r14831 n8358 n8359 0.066964285714285712
r14832 n8244 n8360 1.75
r14833 n8359 n8360 0.053571428571428568
r14834 n8245 n8361 1.1666666666666667
r14835 n8360 n8361 0.011160714285714286
r14836 n8246 n8362 1.1666666666666667
r14837 n8361 n8362 0.013392857142857142
r14838 n8247 n8363 0.875
r14839 n8362 n8363 0.015625
r14840 n8248 n8364 1.1666666666666667
r14841 n8363 n8364 0.015625
r14842 n8249 n8365 0.34999999999999998
r14843 n8364 n8365 0.029017857142857144
r14844 n8250 n8366 0.071428571428571425
r14845 n8365 n8366 0.13169642857142858
r14846 n8251 n8367 0.10294117647058823
r14847 n8366 n8367 0.18526785714285715
r14848 n8252 n8368 0.08254716981132075
r14849 n8367 n8368 0.17053571428571429
r14850 n8253 n8369 0.082159624413145546
r14851 n8368 n8369 0.18973214285714285
r14852 n8254 n8370 0.082159624413145546
r14853 n8369 n8370 0.19017857142857142
r14854 n8255 n8371 0.08254716981132075
r14855 n8370 n8371 0.18973214285714285
r14856 n8256 n8372 0.11666666666666667
r14857 n8371 n8372 0.16160714285714287
r14858 n8257 n8373 0.11666666666666667
r14859 n8372 n8373 0.13392857142857142
r14860 n8258 n8374 0.11666666666666667
r14861 n8373 n8374 0.13392857142857142
r14862 n8259 n8375 0.11666666666666667
r14863 n8374 n8375 0.13392857142857142
r14864 n8260 n8376 0.087499999999999994
r14865 n8375 n8376 0.15625
r14866 n8261 n8377 0.087499999999999994
r14867 n8376 n8377 0.17857142857142858
r14868 n8262 n8378 0.109375
r14869 n8377 n8378 0.16071428571428573
r14870 n8263 n8379 0.125
r14871 n8378 n8379 0.13392857142857142
r14872 n8264 n8380 0.125
r14873 n8379 n8380 0.125
r14874 n8265 n8381 0.109375
r14875 n8380 n8381 0.13392857142857142
r14876 n8266 n8382 0.13461538461538461
r14877 n8381 n8382 0.12946428571428573
r14878 n8267 n8383 0.13461538461538461
r14879 n8382 n8383 0.11607142857142858
r14880 n8268 n8384 0.10294117647058823
r14881 n8383 n8384 0.13392857142857142
r14882 n8269 n8385 0.11666666666666667
r14883 n8384 n8385 0.14285714285714285
r14884 n8270 n8386 0.11666666666666667
r14885 n8385 n8386 0.13392857142857142
r14886 n8271 n8387 0.10294117647058823
r14887 n8386 n8387 0.14285714285714285
r14888 n8272 n8388 0.14583333333333334
r14889 n8387 n8388 0.12946428571428573
r14890 n8273 n8389 0.875
r14891 n8388 n8389 0.0625
r14892 n8274 n8390 0.34999999999999998
r14893 n8389 n8390 0.03125
r14894 n8275 n8391 1.75
r14895 n8390 n8391 0.026785714285714284
r14896 n8276 n8392 0.109375
r14897 n8391 n8392 0.075892857142857137
r14898 n8277 n8393 1.75
r14899 n8392 n8393 0.075892857142857137
r14900 n8278 n8394 0.097222222222222224
r14901 n8393 n8394 0.084821428571428575
r14902 n8279 n8395 1.75
r14903 n8394 n8395 0.084821428571428575
r14904 n8280 n8396 0.109375
r14905 n8395 n8396 0.075892857142857137
r14906 n8281 n8397 1.75
r14907 n8396 n8397 0.075892857142857137
r14908 n8282 n8398 0.097222222222222224
r14909 n8397 n8398 0.084821428571428575
r14910 n8283 n8399 1.75
r14911 n8398 n8399 0.084821428571428575
r14912 n8284 n8400 0.109375
r14913 n8399 n8400 0.075892857142857137
r14914 n8285 n8401 1.75
r14915 n8400 n8401 0.075892857142857137
r14916 n8286 n8402 0.097222222222222224
r14917 n8401 n8402 0.084821428571428575
r14918 n8287 n8403 1.75
r14919 n8402 n8403 0.084821428571428575
r14920 n8288 n8404 0.109375
r14921 n8403 n8404 0.075892857142857137
r14922 n8289 n8405 1.75
r14923 n8404 n8405 0.075892857142857137
r14924 n8290 n8406 0.097222222222222224
r14925 n8405 n8406 0.084821428571428575
r14926 n8291 n8407 1.75
r14927 n8406 n8407 0.084821428571428575
r14928 n8292 n8408 0.109375
r14929 n8407 n8408 0.075892857142857137
r14930 n8293 n8409 1.75
r14931 n8408 n8409 0.075892857142857137
r14932 n8294 n8410 0.097222222222222224
r14933 n8409 n8410 0.084821428571428575
r14934 n8295 n8411 1.75
r14935 n8410 n8411 0.084821428571428575
r14936 n8296 n8412 0.109375
r14937 n8411 n8412 0.075892857142857137
r14938 n8297 n8413 1.75
r14939 n8412 n8413 0.075892857142857137
r14940 n8298 n8414 0.097222222222222224
r14941 n8413 n8414 0.084821428571428575
r14942 n8299 n8415 1.75
r14943 n8414 n8415 0.084821428571428575
r14944 n8300 n8416 0.109375
r14945 n8415 n8416 0.075892857142857137
r14946 n8301 n8417 1.75
r14947 n8416 n8417 0.075892857142857137
r14948 n8302 n8418 0.097222222222222224
r14949 n8417 n8418 0.084821428571428575
r14950 n8303 n8419 1.75
r14951 n8418 n8419 0.084821428571428575
r14952 n8304 n8420 0.109375
r14953 n8419 n8420 0.075892857142857137
r14954 n8305 n8421 1.75
r14955 n8420 n8421 0.075892857142857137
r14956 n8306 n8422 0.23333333333333334
r14957 n8421 n8422 0.037946428571428568
r14958 n8307 n8423 0.29166666666666669
r14959 n8422 n8423 0.060267857142857144
r14960 n8308 n8424 0.3888888888888889
r14961 n8423 n8424 0.046875
r14962 n8309 n8425 1.75
r14963 n8424 n8425 0.024553571428571428
r14964 n8310 n8426 1.75
r14965 n8425 n8426 0.0089285714285714281
r14966 n8311 n8427 0.4375
r14967 n8426 n8427 0.022321428571428572
r14968 n8312 n8428 0.15909090909090909
r14969 n8427 n8428 0.066964285714285712
r14970 n8313 n8429 3.5
r14971 n8428 n8429 0.051339285714285712
r14972 n8314 n8430 3.5
r14973 n8429 n8430 0.004464285714285714
r14974 n8315 n8431 3.5
r14975 n8430 n8431 0.004464285714285714
r14976 n8316 n8432 0.34999999999999998
r14977 n8431 n8432 0.024553571428571428
r14978 n8317 n8433 0.34999999999999998
r14979 n8318 n8434 0.15217391304347827
r14980 n8433 n8434 0.073660714285714288
r14981 n8319 n8435 1.75
r14982 n8434 n8435 0.055803571428571432
r14983 n8320 n8436 0.11666666666666667
r14984 n8435 n8436 0.071428571428571425
r14985 n8321 n8437 1.75
r14986 n8436 n8437 0.071428571428571425
r14987 n8322 n8438 0.15217391304347827
r14988 n8437 n8438 0.055803571428571432
r14989 n8323 n8439 0.34999999999999998
r14990 n8438 n8439 0.073660714285714288
r14991 n8324 n8440 0.40875
r14992 n8325 n8441 0.17771739130434783
r14993 n8440 n8441 0.05514705882352941
r14994 n8326 n8442 2.0437500000000002
r14995 n8441 n8442 0.041778074866310161
r14996 n8327 n8443 0.13625000000000001
r14997 n8442 n8443 0.053475935828877004
r14998 n8328 n8444 2.0437500000000002
r14999 n8443 n8444 0.053475935828877004
r15000 n8329 n8445 0.17771739130434783
r15001 n8444 n8445 0.041778074866310161
r15002 n8330 n8446 0.40875
r15003 n8445 n8446 0.05514705882352941
r15004 n8379 n8447 0.14598214285714287
r15005 n8380 n8448 0.14598214285714287
r15006 n8447 n8448 0.093582887700534759
r15007 n8433 n8449 0.40875
r15008 n8434 n8450 0.17771739130434783
r15009 n8449 n8450 0.05514705882352941
r15010 n8435 n8451 2.0437500000000002
r15011 n8450 n8451 0.041778074866310161
r15012 n8436 n8452 0.13625000000000001
r15013 n8451 n8452 0.053475935828877004
r15014 n8437 n8453 2.0437500000000002
r15015 n8452 n8453 0.053475935828877004
r15016 n8438 n8454 0.17771739130434783
r15017 n8453 n8454 0.041778074866310161
r15018 n8439 n8455 0.40875
r15019 n8454 n8455 0.05514705882352941
r15020 n8440 n8456 0.46625
r15021 n8441 n8457 0.20271739130434782
r15022 n8456 n8457 0.055443548387096774
r15023 n8442 n8458 2.3312499999999998
r15024 n8457 n8458 0.042002688172043008
r15025 n8443 n8459 0.15541666666666668
r15026 n8458 n8459 0.053763440860215055
r15027 n8444 n8460 2.3312499999999998
r15028 n8459 n8460 0.053763440860215055
r15029 n8445 n8461 0.20271739130434782
r15030 n8460 n8461 0.042002688172043008
r15031 n8446 n8462 0.46625
r15032 n8461 n8462 0.055443548387096774
r15033 n8447 n8463 0.16651785714285713
r15034 n8448 n8464 0.16651785714285713
r15035 n8463 n8464 0.094086021505376344
r15036 n8449 n8465 0.46625
r15037 n8450 n8466 0.20271739130434782
r15038 n8465 n8466 0.055443548387096774
r15039 n8451 n8467 2.3312499999999998
r15040 n8466 n8467 0.042002688172043008
r15041 n8452 n8468 0.15541666666666668
r15042 n8467 n8468 0.053763440860215055
r15043 n8453 n8469 2.3312499999999998
r15044 n8468 n8469 0.053763440860215055
r15045 n8454 n8470 0.20271739130434782
r15046 n8469 n8470 0.042002688172043008
r15047 n8455 n8471 0.46625
r15048 n8470 n8471 0.055443548387096774
r15049 n8456 n8472 0.46625
r15050 n8457 n8473 0.20271739130434782
r15051 n8472 n8473 0.05514705882352941
r15052 n8458 n8474 2.3312499999999998
r15053 n8473 n8474 0.041778074866310161
r15054 n8459 n8475 0.15541666666666668
r15055 n8474 n8475 0.053475935828877004
r15056 n8460 n8476 2.3312499999999998
r15057 n8475 n8476 0.053475935828877004
r15058 n8461 n8477 0.20271739130434782
r15059 n8476 n8477 0.041778074866310161
r15060 n8462 n8478 0.46625
r15061 n8477 n8478 0.05514705882352941
r15062 n8463 n8479 0.16651785714285713
r15063 n8464 n8480 0.16651785714285713
r15064 n8479 n8480 0.093582887700534759
r15065 n8465 n8481 0.46625
r15066 n8466 n8482 0.20271739130434782
r15067 n8481 n8482 0.05514705882352941
r15068 n8467 n8483 2.3312499999999998
r15069 n8482 n8483 0.041778074866310161
r15070 n8468 n8484 0.15541666666666668
r15071 n8483 n8484 0.053475935828877004
r15072 n8469 n8485 2.3312499999999998
r15073 n8484 n8485 0.053475935828877004
r15074 n8470 n8486 0.20271739130434782
r15075 n8485 n8486 0.041778074866310161
r15076 n8471 n8487 0.46625
r15077 n8486 n8487 0.05514705882352941
r15078 n8472 n8488 0.46250000000000002
r15079 n8473 n8489 0.20108695652173914
r15080 n8488 n8489 0.056352459016393443
r15081 n8474 n8490 2.3125
r15082 n8489 n8490 0.042691256830601092
r15083 n8475 n8491 0.15416666666666667
r15084 n8490 n8491 0.054644808743169397
r15085 n8476 n8492 2.3125
r15086 n8491 n8492 0.054644808743169397
r15087 n8477 n8493 0.20108695652173914
r15088 n8492 n8493 0.042691256830601092
r15089 n8478 n8494 0.46250000000000002
r15090 n8493 n8494 0.056352459016393443
r15091 n8479 out 0.16517857142857142
r15092 n8480 out 0.16517857142857142
r15093 n8481 n8499 0.46250000000000002
r15094 n8482 n8500 0.20108695652173914
r15095 n8499 n8500 0.056352459016393443
r15096 n8483 n8501 2.3125
r15097 n8500 n8501 0.042691256830601092
r15098 n8484 n8502 0.15416666666666667
r15099 n8501 n8502 0.054644808743169397
r15100 n8485 n8503 2.3125
r15101 n8502 n8503 0.054644808743169397
r15102 n8486 n8504 0.20108695652173914
r15103 n8503 n8504 0.042691256830601092
r15104 n8487 n8505 0.46250000000000002
r15105 n8504 n8505 0.056352459016393443
r15106 n8488 n8506 0.45874999999999999
r15107 n8489 n8507 0.19945652173913042
r15108 n8506 n8507 0.056046195652173912
r15109 n8490 n8508 2.2937500000000002
r15110 n8507 n8508 0.042459239130434784
r15111 n8491 n8509 0.15291666666666667
r15112 n8508 n8509 0.05434782608695652
r15113 n8492 n8510 2.2937500000000002
r15114 n8509 n8510 0.05434782608695652
r15115 n8493 n8511 0.19945652173913042
r15116 n8510 n8511 0.042459239130434784
r15117 n8494 n8512 0.45874999999999999
r15118 n8511 n8512 0.056046195652173912
r15119 n8499 n8517 0.45874999999999999
r15120 n8500 n8518 0.19945652173913042
r15121 n8517 n8518 0.056046195652173912
r15122 n8501 n8519 2.2937500000000002
r15123 n8518 n8519 0.042459239130434784
r15124 n8502 n8520 0.15291666666666667
r15125 n8519 n8520 0.05434782608695652
r15126 n8503 n8521 2.2937500000000002
r15127 n8520 n8521 0.05434782608695652
r15128 n8504 n8522 0.19945652173913042
r15129 n8521 n8522 0.042459239130434784
r15130 n8505 n8523 0.45874999999999999
r15131 n8522 n8523 0.056046195652173912
r15132 n8506 n8524 0.45874999999999999
r15133 n8507 n8525 0.19945652173913042
r15134 n8524 n8525 0.056352459016393443
r15135 n8508 n8526 2.2937500000000002
r15136 n8525 n8526 0.042691256830601092
r15137 n8509 n8527 0.15291666666666667
r15138 n8526 n8527 0.054644808743169397
r15139 n8510 n8528 2.2937500000000002
r15140 n8527 n8528 0.054644808743169397
r15141 n8511 n8529 0.19945652173913042
r15142 n8528 n8529 0.042691256830601092
r15143 n8512 n8530 0.45874999999999999
r15144 n8529 n8530 0.056352459016393443
r15145 n8517 n8535 0.45874999999999999
r15146 n8518 n8536 0.19945652173913042
r15147 n8535 n8536 0.056352459016393443
r15148 n8519 n8537 2.2937500000000002
r15149 n8536 n8537 0.042691256830601092
r15150 n8520 n8538 0.15291666666666667
r15151 n8537 n8538 0.054644808743169397
r15152 n8521 n8539 2.2937500000000002
r15153 n8538 n8539 0.054644808743169397
r15154 n8522 n8540 0.19945652173913042
r15155 n8539 n8540 0.042691256830601092
r15156 n8523 n8541 0.45874999999999999
r15157 n8540 n8541 0.056352459016393443
r15158 in n8562 0.043083333333333335
r15159 in n8563 0.043083333333333335
r15160 n8562 n8563 0.040285714285714286
r15161 n8562 n8564 0.054833333333333331
r15162 n8563 n8565 0.054833333333333331
r15163 n8564 n8565 0.040285714285714286
r15164 n8566 n8567 0.0078333333333333328
r15165 n8567 n8568 0.0046999999999999993
r15166 n8568 n8569 0.0039166666666666664
r15167 n8569 n8570 0.0078333333333333328
r15168 n8570 n8571 0.0235
r15169 n8571 n8572 0.018799999999999997
r15170 n8572 n8573 0.0039166666666666664
r15171 n8573 n8574 0.0046999999999999993
r15172 n8574 n8575 0.0054833333333333331
r15173 n8575 n8576 0.0054833333333333331
r15174 n8576 n8577 0.010183333333333334
r15175 n8577 n8578 0.04621666666666667
r15176 n8578 n8579 0.065016666666666667
r15177 n8579 n8580 0.059846666666666666
r15178 n8580 n8581 0.066583333333333342
r15179 n8581 n8582 0.066739999999999994
r15180 n8582 n8583 0.066583333333333342
r15181 n8583 n8584 0.056713333333333331
r15182 n8564 n8585 0.050916666666666666
r15183 n8584 n8585 0.047
r15184 n8565 n8586 0.050916666666666666
r15185 n8585 n8586 0.047
r15186 n8586 n8587 0.047
r15187 n8587 n8588 0.054833333333333331
r15188 n8588 n8589 0.062666666666666662
r15189 n8589 n8590 0.056400000000000006
r15190 n8590 n8591 0.047
r15191 n8591 n8592 0.043866666666666665
r15192 n8592 n8593 0.047
r15193 n8593 n8594 0.045433333333333333
r15194 n8594 n8595 0.040733333333333337
r15195 n8595 n8596 0.047
r15196 n8596 n8597 0.050133333333333328
r15197 n8597 n8598 0.047
r15198 n8598 n8599 0.050133333333333328
r15199 n8599 n8600 0.045433333333333333
r15200 n8600 n8601 0.021933333333333332
r15201 n8601 n8602 0.010966666666666666
r15202 n8602 n8603 0.0093999999999999986
r15203 n8603 n8604 0.026633333333333335
r15204 n8604 n8605 0.026633333333333335
r15205 n8605 n8606 0.029766666666666667
r15206 n8606 n8607 0.029766666666666667
r15207 n8607 n8608 0.026633333333333335
r15208 n8608 n8609 0.026633333333333335
r15209 n8609 n8610 0.029766666666666667
r15210 n8610 n8611 0.029766666666666667
r15211 n8611 n8612 0.026633333333333335
r15212 n8612 n8613 0.026633333333333335
r15213 n8613 n8614 0.029766666666666667
r15214 n8614 n8615 0.029766666666666667
r15215 n8615 n8616 0.026633333333333335
r15216 n8616 n8617 0.026633333333333335
r15217 n8617 n8618 0.029766666666666667
r15218 n8618 n8619 0.029766666666666667
r15219 n8619 n8620 0.026633333333333335
r15220 n8620 n8621 0.026633333333333335
r15221 n8621 n8622 0.029766666666666667
r15222 n8622 n8623 0.029766666666666667
r15223 n8623 n8624 0.026633333333333335
r15224 n8624 n8625 0.026633333333333335
r15225 n8625 n8626 0.029766666666666667
r15226 n8626 n8627 0.029766666666666667
r15227 n8627 n8628 0.026633333333333335
r15228 n8628 n8629 0.026633333333333335
r15229 n8629 n8630 0.029766666666666667
r15230 n8630 n8631 0.029766666666666667
r15231 n8631 n8632 0.026633333333333335
r15232 n8632 n8633 0.026633333333333335
r15233 n8633 n8634 0.013316666666666668
r15234 n8634 n8635 0.021149999999999999
r15235 n8635 n8636 0.016449999999999999
r15236 n8636 n8637 0.0086166666666666666
r15237 n8637 n8638 0.003133333333333333
r15238 n8638 n8639 0.0078333333333333328
r15239 n8639 n8640 0.0235
r15240 n8640 n8641 0.018016666666666667
r15241 n8641 n8642 0.0015666666666666665
r15242 n8642 n8643 0.0015666666666666665
r15243 n8643 n8644 0.0086166666666666666
r15244 n8644 n8645 0.017233333333333333
r15245 n8645 n8646 0.015666666666666666
r15246 n8646 n8647 0.0078333333333333328
r15247 n8647 n8648 0.0039166666666666664
r15248 n8648 n8649 0.0039166666666666664
r15249 n8649 n8650 0.006266666666666666
r15250 n8650 n8651 0.014100000000000001
r15251 n8651 n8652 0.020366666666666668
r15252 n8652 n8653 0.012533333333333332
r15253 n8653 n8654 0.029766666666666667
r15254 n8654 n8655 0.029766666666666667
r15255 n8655 n8656 0.026633333333333335
r15256 n8656 n8657 0.026633333333333335
r15257 n8657 n8658 0.029766666666666667
r15258 n8658 n8659 0.029766666666666667
r15259 n8659 n8660 0.026633333333333335
r15260 n8660 n8661 0.026633333333333335
r15261 n8661 n8662 0.029766666666666667
r15262 n8662 n8663 0.029766666666666667
r15263 n8663 n8664 0.026633333333333335
r15264 n8664 n8665 0.026633333333333335
r15265 n8665 n8666 0.029766666666666667
r15266 n8666 n8667 0.029766666666666667
r15267 n8667 n8668 0.026633333333333335
r15268 n8668 n8669 0.026633333333333335
r15269 n8669 n8670 0.029766666666666667
r15270 n8670 n8671 0.029766666666666667
r15271 n8671 n8672 0.026633333333333335
r15272 n8672 n8673 0.026633333333333335
r15273 n8673 n8674 0.029766666666666667
r15274 n8674 n8675 0.029766666666666667
r15275 n8675 n8676 0.026633333333333335
r15276 n8676 n8677 0.026633333333333335
r15277 n8677 n8678 0.029766666666666667
r15278 n8678 n8679 0.029766666666666667
r15279 n8679 n8680 0.026633333333333335
r15280 n8680 n8681 0.026633333333333335
r15281 n8681 n8682 0.010966666666666666
r15282 n8682 n8683 0.012533333333333332
r15283 n8683 n8684 0.018799999999999997
r15284 n8684 n8685 0.042299999999999997
r15285 n8685 n8686 0.028200000000000003
r15286 n8686 n8687 0.0093999999999999986
r15287 n8687 n8688 0.013316666666666668
r15288 n8688 n8689 0.0078333333333333328
r15289 n8689 n8690 0.0046999999999999993
r15290 n8690 n8691 0.0039166666666666664
r15291 n8691 n8692 0.010183333333333334
r15292 n8692 n8693 0.0235
r15293 n8693 n8694 0.016449999999999999
r15294 n8694 n8695 0.0039166666666666664
r15295 n8695 n8696 0.0046999999999999993
r15296 n8696 n8697 0.0078333333333333328
r15297 n8566 n8698 0.20142857142857143
r15298 n8567 n8699 0.46999999999999997
r15299 n8698 n8699 0.0078333333333333328
r15300 n8568 n8700 0.46999999999999997
r15301 n8699 n8700 0.0046999999999999993
r15302 n8569 n8701 0.70499999999999996
r15303 n8700 n8701 0.0039166666666666664
r15304 n8570 n8702 0.17624999999999999
r15305 n8701 n8702 0.0078333333333333328
r15306 n8571 n8703 0.064090909090909087
r15307 n8702 n8703 0.0235
r15308 n8572 n8704 0.70499999999999996
r15309 n8703 n8704 0.018799999999999997
r15310 n8573 n8705 0.46999999999999997
r15311 n8704 n8705 0.0039166666666666664
r15312 n8574 n8706 0.46999999999999997
r15313 n8705 n8706 0.0046999999999999993
r15314 n8575 n8707 0.35249999999999998
r15315 n8706 n8707 0.0054833333333333331
r15316 n8576 n8708 0.46999999999999997
r15317 n8707 n8708 0.0054833333333333331
r15318 n8577 n8709 0.14099999999999999
r15319 n8708 n8709 0.010183333333333334
r15320 n8578 n8710 0.028775510204081631
r15321 n8709 n8710 0.04621666666666667
r15322 n8579 n8711 0.041470588235294113
r15323 n8710 n8711 0.065016666666666667
r15324 n8580 n8712 0.033254716981132075
r15325 n8711 n8712 0.059846666666666666
r15326 n8581 n8713 0.033098591549295772
r15327 n8712 n8713 0.066583333333333342
r15328 n8582 n8714 0.033098591549295772
r15329 n8713 n8714 0.066739999999999994
r15330 n8583 n8715 0.033254716981132075
r15331 n8714 n8715 0.066583333333333342
r15332 n8584 n8716 0.047
r15333 n8715 n8716 0.056713333333333331
r15334 n8585 n8717 0.047
r15335 n8716 n8717 0.047
r15336 n8586 n8718 0.047
r15337 n8717 n8718 0.047
r15338 n8587 n8719 0.047
r15339 n8718 n8719 0.047
r15340 n8588 n8720 0.035249999999999997
r15341 n8719 n8720 0.054833333333333331
r15342 n8589 n8721 0.035249999999999997
r15343 n8720 n8721 0.062666666666666662
r15344 n8590 n8722 0.044062499999999998
r15345 n8721 n8722 0.056400000000000006
r15346 n8591 n8723 0.050357142857142857
r15347 n8722 n8723 0.047
r15348 n8592 n8724 0.050357142857142857
r15349 n8723 n8724 0.043866666666666665
r15350 n8593 n8725 0.044062499999999998
r15351 n8724 n8725 0.047
r15352 n8594 n8726 0.054230769230769228
r15353 n8725 n8726 0.045433333333333333
r15354 n8595 n8727 0.054230769230769228
r15355 n8726 n8727 0.040733333333333337
r15356 n8596 n8728 0.041470588235294113
r15357 n8727 n8728 0.047
r15358 n8597 n8729 0.047
r15359 n8728 n8729 0.050133333333333328
r15360 n8598 n8730 0.047
r15361 n8729 n8730 0.047
r15362 n8599 n8731 0.041470588235294113
r15363 n8730 n8731 0.050133333333333328
r15364 n8600 n8732 0.058749999999999997
r15365 n8731 n8732 0.045433333333333333
r15366 n8601 n8733 0.35249999999999998
r15367 n8732 n8733 0.021933333333333332
r15368 n8602 n8734 0.14099999999999999
r15369 n8733 n8734 0.010966666666666666
r15370 n8603 n8735 0.70499999999999996
r15371 n8734 n8735 0.0093999999999999986
r15372 n8604 n8736 0.044062499999999998
r15373 n8735 n8736 0.026633333333333335
r15374 n8605 n8737 0.70499999999999996
r15375 n8736 n8737 0.026633333333333335
r15376 n8606 n8738 0.039166666666666669
r15377 n8737 n8738 0.029766666666666667
r15378 n8607 n8739 0.70499999999999996
r15379 n8738 n8739 0.029766666666666667
r15380 n8608 n8740 0.044062499999999998
r15381 n8739 n8740 0.026633333333333335
r15382 n8609 n8741 0.70499999999999996
r15383 n8740 n8741 0.026633333333333335
r15384 n8610 n8742 0.039166666666666669
r15385 n8741 n8742 0.029766666666666667
r15386 n8611 n8743 0.70499999999999996
r15387 n8742 n8743 0.029766666666666667
r15388 n8612 n8744 0.044062499999999998
r15389 n8743 n8744 0.026633333333333335
r15390 n8613 n8745 0.70499999999999996
r15391 n8744 n8745 0.026633333333333335
r15392 n8614 n8746 0.039166666666666669
r15393 n8745 n8746 0.029766666666666667
r15394 n8615 n8747 0.70499999999999996
r15395 n8746 n8747 0.029766666666666667
r15396 n8616 n8748 0.044062499999999998
r15397 n8747 n8748 0.026633333333333335
r15398 n8617 n8749 0.70499999999999996
r15399 n8748 n8749 0.026633333333333335
r15400 n8618 n8750 0.039166666666666669
r15401 n8749 n8750 0.029766666666666667
r15402 n8619 n8751 0.70499999999999996
r15403 n8750 n8751 0.029766666666666667
r15404 n8620 n8752 0.044062499999999998
r15405 n8751 n8752 0.026633333333333335
r15406 n8621 n8753 0.70499999999999996
r15407 n8752 n8753 0.026633333333333335
r15408 n8622 n8754 0.039166666666666669
r15409 n8753 n8754 0.029766666666666667
r15410 n8623 n8755 0.70499999999999996
r15411 n8754 n8755 0.029766666666666667
r15412 n8624 n8756 0.044062499999999998
r15413 n8755 n8756 0.026633333333333335
r15414 n8625 n8757 0.70499999999999996
r15415 n8756 n8757 0.026633333333333335
r15416 n8626 n8758 0.039166666666666669
r15417 n8757 n8758 0.029766666666666667
r15418 n8627 n8759 0.70499999999999996
r15419 n8758 n8759 0.029766666666666667
r15420 n8628 n8760 0.044062499999999998
r15421 n8759 n8760 0.026633333333333335
r15422 n8629 n8761 0.70499999999999996
r15423 n8760 n8761 0.026633333333333335
r15424 n8630 n8762 0.039166666666666669
r15425 n8761 n8762 0.029766666666666667
r15426 n8631 n8763 0.70499999999999996
r15427 n8762 n8763 0.029766666666666667
r15428 n8632 n8764 0.044062499999999998
r15429 n8763 n8764 0.026633333333333335
r15430 n8633 n8765 0.70499999999999996
r15431 n8764 n8765 0.026633333333333335
r15432 n8634 n8766 0.094
r15433 n8765 n8766 0.013316666666666668
r15434 n8635 n8767 0.11749999999999999
r15435 n8766 n8767 0.021149999999999999
r15436 n8636 n8768 0.15666666666666668
r15437 n8767 n8768 0.016449999999999999
r15438 n8637 n8769 0.70499999999999996
r15439 n8768 n8769 0.0086166666666666666
r15440 n8638 n8770 0.70499999999999996
r15441 n8769 n8770 0.003133333333333333
r15442 n8639 n8771 0.17624999999999999
r15443 n8770 n8771 0.0078333333333333328
r15444 n8640 n8772 0.064090909090909087
r15445 n8771 n8772 0.0235
r15446 n8641 n8773 1.4099999999999999
r15447 n8772 n8773 0.018016666666666667
r15448 n8642 n8774 1.4099999999999999
r15449 n8773 n8774 0.0015666666666666665
r15450 n8643 n8775 1.4099999999999999
r15451 n8774 n8775 0.0015666666666666665
r15452 n8644 n8776 0.14099999999999999
r15453 n8775 n8776 0.0086166666666666666
r15454 n8645 n8777 0.11749999999999999
r15455 n8776 n8777 0.017233333333333333
r15456 n8646 n8778 0.17624999999999999
r15457 n8777 n8778 0.015666666666666666
r15458 n8647 n8779 0.70499999999999996
r15459 n8778 n8779 0.0078333333333333328
r15460 n8648 n8780 0.46999999999999997
r15461 n8779 n8780 0.0039166666666666664
r15462 n8649 n8781 0.70499999999999996
r15463 n8780 n8781 0.0039166666666666664
r15464 n8650 n8782 0.23499999999999999
r15465 n8781 n8782 0.006266666666666666
r15466 n8651 n8783 0.11749999999999999
r15467 n8782 n8783 0.014100000000000001
r15468 n8652 n8784 0.10071428571428571
r15469 n8783 n8784 0.020366666666666668
r15470 n8653 n8785 0.70499999999999996
r15471 n8784 n8785 0.012533333333333332
r15472 n8654 n8786 0.039166666666666669
r15473 n8785 n8786 0.029766666666666667
r15474 n8655 n8787 0.70499999999999996
r15475 n8786 n8787 0.029766666666666667
r15476 n8656 n8788 0.044062499999999998
r15477 n8787 n8788 0.026633333333333335
r15478 n8657 n8789 0.70499999999999996
r15479 n8788 n8789 0.026633333333333335
r15480 n8658 n8790 0.039166666666666669
r15481 n8789 n8790 0.029766666666666667
r15482 n8659 n8791 0.70499999999999996
r15483 n8790 n8791 0.029766666666666667
r15484 n8660 n8792 0.044062499999999998
r15485 n8791 n8792 0.026633333333333335
r15486 n8661 n8793 0.70499999999999996
r15487 n8792 n8793 0.026633333333333335
r15488 n8662 n8794 0.039166666666666669
r15489 n8793 n8794 0.029766666666666667
r15490 n8663 n8795 0.70499999999999996
r15491 n8794 n8795 0.029766666666666667
r15492 n8664 n8796 0.044062499999999998
r15493 n8795 n8796 0.026633333333333335
r15494 n8665 n8797 0.70499999999999996
r15495 n8796 n8797 0.026633333333333335
r15496 n8666 n8798 0.039166666666666669
r15497 n8797 n8798 0.029766666666666667
r15498 n8667 n8799 0.70499999999999996
r15499 n8798 n8799 0.029766666666666667
r15500 n8668 n8800 0.044062499999999998
r15501 n8799 n8800 0.026633333333333335
r15502 n8669 n8801 0.70499999999999996
r15503 n8800 n8801 0.026633333333333335
r15504 n8670 n8802 0.039166666666666669
r15505 n8801 n8802 0.029766666666666667
r15506 n8671 n8803 0.70499999999999996
r15507 n8802 n8803 0.029766666666666667
r15508 n8672 n8804 0.044062499999999998
r15509 n8803 n8804 0.026633333333333335
r15510 n8673 n8805 0.70499999999999996
r15511 n8804 n8805 0.026633333333333335
r15512 n8674 n8806 0.039166666666666669
r15513 n8805 n8806 0.029766666666666667
r15514 n8675 n8807 0.70499999999999996
r15515 n8806 n8807 0.029766666666666667
r15516 n8676 n8808 0.044062499999999998
r15517 n8807 n8808 0.026633333333333335
r15518 n8677 n8809 0.70499999999999996
r15519 n8808 n8809 0.026633333333333335
r15520 n8678 n8810 0.039166666666666669
r15521 n8809 n8810 0.029766666666666667
r15522 n8679 n8811 0.70499999999999996
r15523 n8810 n8811 0.029766666666666667
r15524 n8680 n8812 0.044062499999999998
r15525 n8811 n8812 0.026633333333333335
r15526 n8681 n8813 0.70499999999999996
r15527 n8812 n8813 0.026633333333333335
r15528 n8682 n8814 0.11749999999999999
r15529 n8813 n8814 0.010966666666666666
r15530 n8683 n8815 0.35249999999999998
r15531 n8814 n8815 0.012533333333333332
r15532 n8684 n8816 0.070499999999999993
r15533 n8815 n8816 0.018799999999999997
r15534 n8685 n8817 0.041470588235294113
r15535 n8816 n8817 0.042299999999999997
r15536 n8686 n8818 0.70499999999999996
r15537 n8817 n8818 0.028200000000000003
r15538 n8687 n8819 0.14099999999999999
r15539 n8818 n8819 0.0093999999999999986
r15540 n8688 n8820 0.20142857142857143
r15541 n8819 n8820 0.013316666666666668
r15542 n8689 n8821 0.46999999999999997
r15543 n8820 n8821 0.0078333333333333328
r15544 n8690 n8822 0.46999999999999997
r15545 n8821 n8822 0.0046999999999999993
r15546 n8691 n8823 0.70499999999999996
r15547 n8822 n8823 0.0039166666666666664
r15548 n8692 n8824 0.12818181818181817
r15549 n8823 n8824 0.010183333333333334
r15550 n8693 n8825 0.074210526315789477
r15551 n8824 n8825 0.0235
r15552 n8694 n8826 0.70499999999999996
r15553 n8825 n8826 0.016449999999999999
r15554 n8695 n8827 0.46999999999999997
r15555 n8826 n8827 0.0039166666666666664
r15556 n8696 n8828 0.46999999999999997
r15557 n8827 n8828 0.0046999999999999993
r15558 n8697 n8829 0.20142857142857143
r15559 n8828 n8829 0.0078333333333333328
r15560 n8698 n8830 0.22157142857142856
r15561 n8699 n8831 0.51700000000000002
r15562 n8830 n8831 0.0065277777777777782
r15563 n8700 n8832 0.51700000000000002
r15564 n8831 n8832 0.0039166666666666664
r15565 n8701 n8833 0.77549999999999997
r15566 n8832 n8833 0.0032638888888888891
r15567 n8702 n8834 0.19387499999999999
r15568 n8833 n8834 0.0065277777777777782
r15569 n8703 n8835 0.070499999999999993
r15570 n8834 n8835 0.019583333333333335
r15571 n8704 n8836 0.77549999999999997
r15572 n8835 n8836 0.015666666666666666
r15573 n8705 n8837 0.51700000000000002
r15574 n8836 n8837 0.0032638888888888891
r15575 n8706 n8838 0.51700000000000002
r15576 n8837 n8838 0.0039166666666666664
r15577 n8707 n8839 0.38774999999999998
r15578 n8838 n8839 0.0045694444444444446
r15579 n8708 n8840 0.51700000000000002
r15580 n8839 n8840 0.0045694444444444446
r15581 n8820 n8841 0.22157142857142856
r15582 n8821 n8842 0.51700000000000002
r15583 n8841 n8842 0.0065277777777777782
r15584 n8822 n8843 0.51700000000000002
r15585 n8842 n8843 0.0039166666666666664
r15586 n8823 n8844 0.77549999999999997
r15587 n8843 n8844 0.0032638888888888891
r15588 n8824 n8845 0.14099999999999999
r15589 n8844 n8845 0.0084861111111111109
r15590 n8825 n8846 0.081631578947368416
r15591 n8845 n8846 0.019583333333333335
r15592 n8826 n8847 0.77549999999999997
r15593 n8846 n8847 0.013708333333333333
r15594 n8827 n8848 0.51700000000000002
r15595 n8847 n8848 0.0032638888888888891
r15596 n8828 n8849 0.51700000000000002
r15597 n8848 n8849 0.0039166666666666664
r15598 n8829 n8850 0.22157142857142856
r15599 n8849 n8850 0.0065277777777777782
r15600 n8830 n8851 0.24171428571428574
r15601 n8831 n8852 0.56400000000000006
r15602 n8851 n8852 0.0065277777777777782
r15603 n8832 n8853 0.56400000000000006
r15604 n8852 n8853 0.0039166666666666664
r15605 n8833 n8854 0.84600000000000009
r15606 n8853 n8854 0.0032638888888888891
r15607 n8834 n8855 0.21150000000000002
r15608 n8854 n8855 0.0065277777777777782
r15609 n8835 n8856 0.076909090909090913
r15610 n8855 n8856 0.019583333333333335
r15611 n8836 n8857 0.84600000000000009
r15612 n8856 n8857 0.015666666666666666
r15613 n8837 n8858 0.56400000000000006
r15614 n8857 n8858 0.0032638888888888891
r15615 n8838 n8859 0.56400000000000006
r15616 n8858 n8859 0.0039166666666666664
r15617 n8839 n8860 0.42300000000000004
r15618 n8859 n8860 0.0045694444444444446
r15619 n8840 n8861 0.56400000000000006
r15620 n8860 n8861 0.0045694444444444446
r15621 n8841 n8862 0.24171428571428574
r15622 n8842 n8863 0.56400000000000006
r15623 n8862 n8863 0.0065277777777777782
r15624 n8843 n8864 0.56400000000000006
r15625 n8863 n8864 0.0039166666666666664
r15626 n8844 n8865 0.84600000000000009
r15627 n8864 n8865 0.0032638888888888891
r15628 n8845 n8866 0.15381818181818183
r15629 n8865 n8866 0.0084861111111111109
r15630 n8846 n8867 0.089052631578947383
r15631 n8866 n8867 0.019583333333333335
r15632 n8847 n8868 0.84600000000000009
r15633 n8867 n8868 0.013708333333333333
r15634 n8848 n8869 0.56400000000000006
r15635 n8868 n8869 0.0032638888888888891
r15636 n8849 n8870 0.56400000000000006
r15637 n8869 n8870 0.0039166666666666664
r15638 n8850 n8871 0.24171428571428574
r15639 n8870 n8871 0.0065277777777777782
r15640 n8851 n8872 0.21485714285714286
r15641 n8852 n8873 0.5013333333333333
r15642 n8872 n8873 0.0083928571428571429
r15643 n8853 n8874 0.5013333333333333
r15644 n8873 n8874 0.0050357142857142857
r15645 n8854 n8875 0.752
r15646 n8874 n8875 0.0041964285714285714
r15647 n8855 n8876 0.188
r15648 n8875 n8876 0.0083928571428571429
r15649 n8856 n8877 0.068363636363636363
r15650 n8876 n8877 0.025178571428571429
r15651 n8857 n8878 0.752
r15652 n8877 n8878 0.020142857142857143
r15653 n8858 n8879 0.5013333333333333
r15654 n8878 n8879 0.0041964285714285714
r15655 n8859 n8880 0.5013333333333333
r15656 n8879 n8880 0.0050357142857142857
r15657 n8860 n8881 0.376
r15658 n8880 n8881 0.005875
r15659 n8861 n8882 0.5013333333333333
r15660 n8881 n8882 0.005875
r15661 n8862 n8883 0.21485714285714286
r15662 n8863 n8884 0.5013333333333333
r15663 n8883 n8884 0.0083928571428571429
r15664 n8864 n8885 0.5013333333333333
r15665 n8884 n8885 0.0050357142857142857
r15666 n8865 n8886 0.752
r15667 n8885 n8886 0.0041964285714285714
r15668 n8866 n8887 0.13672727272727273
r15669 n8886 n8887 0.010910714285714286
r15670 n8867 n8888 0.079157894736842108
r15671 n8887 n8888 0.025178571428571429
r15672 n8868 n8889 0.752
r15673 n8888 n8889 0.017624999999999998
r15674 n8869 n8890 0.5013333333333333
r15675 n8889 n8890 0.0041964285714285714
r15676 n8870 n8891 0.5013333333333333
r15677 n8890 n8891 0.0050357142857142857
r15678 n8871 n8892 0.21485714285714286
r15679 n8891 n8892 0.0083928571428571429
r15680 n8872 n8893 0.188
r15681 n8873 n8894 0.43866666666666665
r15682 n8893 n8894 0.0083928571428571429
r15683 n8874 n8895 0.43866666666666665
r15684 n8894 n8895 0.0050357142857142857
r15685 n8875 n8896 0.65800000000000003
r15686 n8895 n8896 0.0041964285714285714
r15687 n8876 n8897 0.16450000000000001
r15688 n8896 n8897 0.0083928571428571429
r15689 n8877 n8898 0.059818181818181819
r15690 n8897 n8898 0.025178571428571429
r15691 n8878 n8899 0.65800000000000003
r15692 n8898 n8899 0.020142857142857143
r15693 n8879 n8900 0.43866666666666665
r15694 n8899 n8900 0.0041964285714285714
r15695 n8880 n8901 0.43866666666666665
r15696 n8900 n8901 0.0050357142857142857
r15697 n8881 n8902 0.32900000000000001
r15698 n8901 n8902 0.005875
r15699 n8882 n8903 0.43866666666666665
r15700 n8902 n8903 0.005875
r15701 n8883 n8904 0.188
r15702 n8884 n8905 0.43866666666666665
r15703 n8904 n8905 0.0083928571428571429
r15704 n8885 n8906 0.43866666666666665
r15705 n8905 n8906 0.0050357142857142857
r15706 n8886 n8907 0.65800000000000003
r15707 n8906 n8907 0.0041964285714285714
r15708 n8887 n8908 0.11963636363636364
r15709 n8907 n8908 0.010910714285714286
r15710 n8888 n8909 0.069263157894736846
r15711 n8908 n8909 0.025178571428571429
r15712 n8889 n8910 0.65800000000000003
r15713 n8909 n8910 0.017624999999999998
r15714 n8890 n8911 0.43866666666666665
r15715 n8910 n8911 0.0041964285714285714
r15716 n8891 n8912 0.43866666666666665
r15717 n8911 n8912 0.0050357142857142857
r15718 n8892 n8913 0.188
r15719 n8912 n8913 0.0083928571428571429
r15720 n8893 n8914 0.24842857142857144
r15721 n8894 n8915 0.57966666666666666
r15722 n8914 n8915 0.0051086956521739129
r15723 n8895 n8916 0.57966666666666666
r15724 n8915 n8916 0.0030652173913043477
r15725 n8896 n8917 0.86950000000000005
r15726 n8916 n8917 0.0025543478260869564
r15727 n8897 n8918 0.21737500000000001
r15728 n8917 n8918 0.0051086956521739129
r15729 n8898 n8919 0.079045454545454544
r15730 n8918 n8919 0.015326086956521739
r15731 n8899 n8920 0.86950000000000005
r15732 n8919 n8920 0.012260869565217391
r15733 n8900 n8921 0.57966666666666666
r15734 n8920 n8921 0.0025543478260869564
r15735 n8901 n8922 0.57966666666666666
r15736 n8921 n8922 0.0030652173913043477
r15737 n8902 n8923 0.43475000000000003
r15738 n8922 n8923 0.003576086956521739
r15739 n8903 n8924 0.57966666666666666
r15740 n8923 n8924 0.003576086956521739
r15741 n8904 n8925 0.24842857142857144
r15742 n8905 n8926 0.57966666666666666
r15743 n8925 n8926 0.0051086956521739129
r15744 n8906 n8927 0.57966666666666666
r15745 n8926 n8927 0.0030652173913043477
r15746 n8907 n8928 0.86950000000000005
r15747 n8927 n8928 0.0025543478260869564
r15748 n8908 n8929 0.15809090909090909
r15749 n8928 n8929 0.0066413043478260872
r15750 n8909 n8930 0.091526315789473692
r15751 n8929 n8930 0.015326086956521739
r15752 n8910 n8931 0.86950000000000005
r15753 n8930 n8931 0.010728260869565217
r15754 n8911 n8932 0.57966666666666666
r15755 n8931 n8932 0.0025543478260869564
r15756 n8912 n8933 0.57966666666666666
r15757 n8932 n8933 0.0030652173913043477
r15758 n8913 n8934 0.24842857142857144
r15759 n8933 n8934 0.0051086956521739129
r15760 n8914 n8935 0.16114285714285714
r15761 n8915 n8936 0.376
r15762 n8935 n8936 0.11750000000000001
r15763 n8916 n8937 0.376
r15764 n8936 n8937 0.070499999999999993
r15765 n8917 n8938 0.56399999999999995
r15766 n8937 n8938 0.058750000000000004
r15767 n8918 n8939 0.14099999999999999
r15768 n8938 n8939 0.11750000000000001
r15769 n8919 n8940 0.051272727272727268
r15770 n8939 n8940 0.35249999999999998
r15771 n8920 n8941 0.56399999999999995
r15772 n8940 n8941 0.28199999999999997
r15773 n8921 n8942 0.376
r15774 n8941 n8942 0.058750000000000004
r15775 n8922 n8943 0.376
r15776 n8942 n8943 0.070499999999999993
r15777 n8923 n8944 0.28199999999999997
r15778 n8943 n8944 0.082250000000000004
r15779 n8924 n8945 0.376
r15780 n8944 n8945 0.082250000000000004
r15781 n8925 n8946 0.16114285714285714
r15782 n8926 n8947 0.376
r15783 n8946 n8947 0.11750000000000001
r15784 n8927 n8948 0.376
r15785 n8947 n8948 0.070499999999999993
r15786 n8928 n8949 0.56399999999999995
r15787 n8948 n8949 0.058750000000000004
r15788 n8929 n8950 0.10254545454545454
r15789 n8949 n8950 0.15275
r15790 n8930 n8951 0.059368421052631577
r15791 n8950 n8951 0.35249999999999998
r15792 n8931 n8952 0.56399999999999995
r15793 n8951 n8952 0.24674999999999997
r15794 n8932 n8953 0.376
r15795 n8952 n8953 0.058750000000000004
r15796 n8933 n8954 0.376
r15797 n8953 n8954 0.070499999999999993
r15798 n8934 n8955 0.16114285714285714
r15799 n8954 n8955 0.11750000000000001
r15800 n8935 n8956 0.043642857142857143
r15801 n8936 n8957 0.10183333333333335
r15802 n8956 n8957 0.021363636363636366
r15803 n8937 n8958 0.10183333333333335
r15804 n8957 n8958 0.012818181818181817
r15805 n8938 n8959 0.15275
r15806 n8958 n8959 0.010681818181818183
r15807 n8939 n8960 0.038187499999999999
r15808 n8959 n8960 0.021363636363636366
r15809 n8940 n8961 0.013886363636363638
r15810 n8960 n8961 0.064090909090909087
r15811 n8941 n8962 0.15275
r15812 n8961 n8962 0.051272727272727268
r15813 n8942 n8963 0.10183333333333335
r15814 n8962 n8963 0.010681818181818183
r15815 n8943 n8964 0.10183333333333335
r15816 n8963 n8964 0.012818181818181817
r15817 n8944 n8965 0.076374999999999998
r15818 n8964 n8965 0.014954545454545455
r15819 n8945 n8966 0.10183333333333335
r15820 n8965 n8966 0.014954545454545455
r15821 n8946 n8967 0.043642857142857143
r15822 n8947 n8968 0.10183333333333335
r15823 n8967 n8968 0.021363636363636366
r15824 n8948 n8969 0.10183333333333335
r15825 n8968 n8969 0.012818181818181817
r15826 n8949 n8970 0.15275
r15827 n8969 n8970 0.010681818181818183
r15828 n8950 n8971 0.027772727272727275
r15829 n8970 n8971 0.027772727272727275
r15830 n8951 n8972 0.016078947368421054
r15831 n8971 n8972 0.064090909090909087
r15832 n8952 n8973 0.15275
r15833 n8972 n8973 0.044863636363636362
r15834 n8953 n8974 0.10183333333333335
r15835 n8973 n8974 0.010681818181818183
r15836 n8954 n8975 0.10183333333333335
r15837 n8974 n8975 0.012818181818181817
r15838 n8955 n8976 0.043642857142857143
r15839 n8975 n8976 0.021363636363636366
r15840 n8956 n8977 0.043642857142857143
r15841 n8957 n8978 0.10183333333333335
r15842 n8977 n8978 0.11750000000000001
r15843 n8958 n8979 0.10183333333333335
r15844 n8978 n8979 0.070499999999999993
r15845 n8959 n8980 0.15275
r15846 n8979 n8980 0.058750000000000004
r15847 n8960 n8981 0.038187499999999999
r15848 n8980 n8981 0.11750000000000001
r15849 n8961 n8982 0.013886363636363638
r15850 n8981 n8982 0.35249999999999998
r15851 n8962 n8983 0.15275
r15852 n8982 n8983 0.28199999999999997
r15853 n8963 n8984 0.10183333333333335
r15854 n8983 n8984 0.058750000000000004
r15855 n8964 n8985 0.10183333333333335
r15856 n8984 n8985 0.070499999999999993
r15857 n8965 n8986 0.076374999999999998
r15858 n8985 n8986 0.082250000000000004
r15859 n8966 n8987 0.10183333333333335
r15860 n8986 n8987 0.082250000000000004
r15861 n8967 n8988 0.043642857142857143
r15862 n8968 n8989 0.10183333333333335
r15863 n8988 n8989 0.11750000000000001
r15864 n8969 n8990 0.10183333333333335
r15865 n8989 n8990 0.070499999999999993
r15866 n8970 n8991 0.15275
r15867 n8990 n8991 0.058750000000000004
r15868 n8971 n8992 0.027772727272727275
r15869 n8991 n8992 0.15275
r15870 n8972 n8993 0.016078947368421054
r15871 n8992 n8993 0.35249999999999998
r15872 n8973 n8994 0.15275
r15873 n8993 n8994 0.24674999999999997
r15874 n8974 n8995 0.10183333333333335
r15875 n8994 n8995 0.058750000000000004
r15876 n8975 n8996 0.10183333333333335
r15877 n8995 n8996 0.070499999999999993
r15878 n8976 n8997 0.043642857142857143
r15879 n8996 n8997 0.11750000000000001
r15880 n8977 n8998 0.10742857142857143
r15881 n8978 n8999 0.25066666666666665
r15882 n8998 n8999 0.0078333333333333328
r15883 n8979 n9000 0.25066666666666665
r15884 n8999 n9000 0.0046999999999999993
r15885 n8980 n9001 0.376
r15886 n9000 n9001 0.0039166666666666664
r15887 n8981 n9002 0.094
r15888 n9001 n9002 0.0078333333333333328
r15889 n8982 n9003 0.034181818181818181
r15890 n9002 n9003 0.0235
r15891 n8983 n9004 0.376
r15892 n9003 n9004 0.018799999999999997
r15893 n8984 n9005 0.25066666666666665
r15894 n9004 n9005 0.0039166666666666664
r15895 n8985 n9006 0.25066666666666665
r15896 n9005 n9006 0.0046999999999999993
r15897 n8986 n9007 0.188
r15898 n9006 n9007 0.0054833333333333331
r15899 n8987 n9008 0.25066666666666665
r15900 n9007 n9008 0.0054833333333333331
r15901 n8988 n9009 0.10742857142857143
r15902 n8989 n9010 0.25066666666666665
r15903 n9009 n9010 0.0078333333333333328
r15904 n8990 n9011 0.25066666666666665
r15905 n9010 n9011 0.0046999999999999993
r15906 n8991 n9012 0.376
r15907 n9011 n9012 0.0039166666666666664
r15908 n8992 n9013 0.068363636363636363
r15909 n9012 n9013 0.010183333333333334
r15910 n8993 n9014 0.039578947368421054
r15911 n9013 n9014 0.0235
r15912 n8994 n9015 0.376
r15913 n9014 n9015 0.016449999999999999
r15914 n8995 n9016 0.25066666666666665
r15915 n9015 n9016 0.0039166666666666664
r15916 n8996 n9017 0.25066666666666665
r15917 n9016 n9017 0.0046999999999999993
r15918 n8997 n9018 0.10742857142857143
r15919 n9017 n9018 0.0078333333333333328
r15920 n8998 n9019 0.10742857142857143
r15921 n8999 n9020 0.25066666666666665
r15922 n9019 n9020 0.11750000000000001
r15923 n9000 n9021 0.25066666666666665
r15924 n9020 n9021 0.070499999999999993
r15925 n9001 n9022 0.376
r15926 n9021 n9022 0.058750000000000004
r15927 n9002 n9023 0.094
r15928 n9022 n9023 0.11750000000000001
r15929 n9003 n9024 0.034181818181818181
r15930 n9023 n9024 0.35249999999999998
r15931 n9004 n9025 0.376
r15932 n9024 n9025 0.28199999999999997
r15933 n9005 n9026 0.25066666666666665
r15934 n9025 n9026 0.058750000000000004
r15935 n9006 n9027 0.25066666666666665
r15936 n9026 n9027 0.070499999999999993
r15937 n9007 n9028 0.188
r15938 n9027 n9028 0.082250000000000004
r15939 n9008 n9029 0.25066666666666665
r15940 n9028 n9029 0.082250000000000004
r15941 n9009 n9030 0.10742857142857143
r15942 n9010 n9031 0.25066666666666665
r15943 n9030 n9031 0.11750000000000001
r15944 n9011 n9032 0.25066666666666665
r15945 n9031 n9032 0.070499999999999993
r15946 n9012 n9033 0.376
r15947 n9032 n9033 0.058750000000000004
r15948 n9013 n9034 0.068363636363636363
r15949 n9033 n9034 0.15275
r15950 n9014 n9035 0.039578947368421054
r15951 n9034 n9035 0.35249999999999998
r15952 n9015 n9036 0.376
r15953 n9035 n9036 0.24674999999999997
r15954 n9016 n9037 0.25066666666666665
r15955 n9036 n9037 0.058750000000000004
r15956 n9017 n9038 0.25066666666666665
r15957 n9037 n9038 0.070499999999999993
r15958 n9018 n9039 0.10742857142857143
r15959 n9038 n9039 0.11750000000000001
r15960 n9019 n9040 0.043642857142857143
r15961 n9020 n9041 0.10183333333333335
r15962 n9040 n9041 0.021363636363636366
r15963 n9021 n9042 0.10183333333333335
r15964 n9041 n9042 0.012818181818181817
r15965 n9022 n9043 0.15275
r15966 n9042 n9043 0.010681818181818183
r15967 n9023 n9044 0.038187499999999999
r15968 n9043 n9044 0.021363636363636366
r15969 n9024 n9045 0.013886363636363638
r15970 n9044 n9045 0.064090909090909087
r15971 n9025 n9046 0.15275
r15972 n9045 n9046 0.051272727272727268
r15973 n9026 n9047 0.10183333333333335
r15974 n9046 n9047 0.010681818181818183
r15975 n9027 n9048 0.10183333333333335
r15976 n9047 n9048 0.012818181818181817
r15977 n9028 n9049 0.076374999999999998
r15978 n9048 n9049 0.014954545454545455
r15979 n9029 n9050 0.10183333333333335
r15980 n9049 n9050 0.014954545454545455
r15981 n9030 n9051 0.043642857142857143
r15982 n9031 n9052 0.10183333333333335
r15983 n9051 n9052 0.021363636363636366
r15984 n9032 n9053 0.10183333333333335
r15985 n9052 n9053 0.012818181818181817
r15986 n9033 n9054 0.15275
r15987 n9053 n9054 0.010681818181818183
r15988 n9034 n9055 0.027772727272727275
r15989 n9054 n9055 0.027772727272727275
r15990 n9035 n9056 0.016078947368421054
r15991 n9055 n9056 0.064090909090909087
r15992 n9036 n9057 0.15275
r15993 n9056 n9057 0.044863636363636362
r15994 n9037 n9058 0.10183333333333335
r15995 n9057 n9058 0.010681818181818183
r15996 n9038 n9059 0.10183333333333335
r15997 n9058 n9059 0.012818181818181817
r15998 n9039 n9060 0.043642857142857143
r15999 n9059 n9060 0.021363636363636366
r16000 n9040 n9061 0.043642857142857143
r16001 n9041 n9062 0.10183333333333335
r16002 n9061 n9062 0.11750000000000001
r16003 n9042 n9063 0.10183333333333335
r16004 n9062 n9063 0.070499999999999993
r16005 n9043 n9064 0.15275
r16006 n9063 n9064 0.058750000000000004
r16007 n9044 n9065 0.038187499999999999
r16008 n9064 n9065 0.11750000000000001
r16009 n9045 n9066 0.013886363636363638
r16010 n9065 n9066 0.35249999999999998
r16011 n9046 n9067 0.15275
r16012 n9066 n9067 0.28199999999999997
r16013 n9047 n9068 0.10183333333333335
r16014 n9067 n9068 0.058750000000000004
r16015 n9048 n9069 0.10183333333333335
r16016 n9068 n9069 0.070499999999999993
r16017 n9049 n9070 0.076374999999999998
r16018 n9069 n9070 0.082250000000000004
r16019 n9050 n9071 0.10183333333333335
r16020 n9070 n9071 0.082250000000000004
r16021 n9051 n9072 0.043642857142857143
r16022 n9052 n9073 0.10183333333333335
r16023 n9072 n9073 0.11750000000000001
r16024 n9053 n9074 0.10183333333333335
r16025 n9073 n9074 0.070499999999999993
r16026 n9054 n9075 0.15275
r16027 n9074 n9075 0.058750000000000004
r16028 n9055 n9076 0.027772727272727275
r16029 n9075 n9076 0.15275
r16030 n9056 n9077 0.016078947368421054
r16031 n9076 n9077 0.35249999999999998
r16032 n9057 n9078 0.15275
r16033 n9077 n9078 0.24674999999999997
r16034 n9058 n9079 0.10183333333333335
r16035 n9078 n9079 0.058750000000000004
r16036 n9059 n9080 0.10183333333333335
r16037 n9079 n9080 0.070499999999999993
r16038 n9060 n9081 0.043642857142857143
r16039 n9080 n9081 0.11750000000000001
r16040 n9061 n9082 0.11078571428571428
r16041 n9062 n9083 0.25850000000000001
r16042 n9082 n9083 0.0075806451612903227
r16043 n9063 n9084 0.25850000000000001
r16044 n9083 n9084 0.0045483870967741929
r16045 n9064 n9085 0.38774999999999998
r16046 n9084 n9085 0.0037903225806451613
r16047 n9065 n9086 0.096937499999999996
r16048 n9085 n9086 0.0075806451612903227
r16049 n9066 n9087 0.035249999999999997
r16050 n9086 n9087 0.022741935483870965
r16051 n9067 n9088 0.38774999999999998
r16052 n9087 n9088 0.018193548387096772
r16053 n9068 n9089 0.25850000000000001
r16054 n9088 n9089 0.0037903225806451613
r16055 n9069 n9090 0.25850000000000001
r16056 n9089 n9090 0.0045483870967741929
r16057 n9070 n9091 0.19387499999999999
r16058 n9090 n9091 0.0053064516129032258
r16059 n9071 n9092 0.25850000000000001
r16060 n9091 n9092 0.0053064516129032258
r16061 n9072 n9093 0.11078571428571428
r16062 n9073 n9094 0.25850000000000001
r16063 n9093 n9094 0.0075806451612903227
r16064 n9074 n9095 0.25850000000000001
r16065 n9094 n9095 0.0045483870967741929
r16066 n9075 n9096 0.38774999999999998
r16067 n9095 n9096 0.0037903225806451613
r16068 n9076 n9097 0.070499999999999993
r16069 n9096 n9097 0.0098548387096774204
r16070 n9077 n9098 0.040815789473684208
r16071 n9097 n9098 0.022741935483870965
r16072 n9078 n9099 0.38774999999999998
r16073 n9098 n9099 0.015919354838709675
r16074 n9079 n9100 0.25850000000000001
r16075 n9099 n9100 0.0037903225806451613
r16076 n9080 n9101 0.25850000000000001
r16077 n9100 n9101 0.0045483870967741929
r16078 n9081 n9102 0.11078571428571428
r16079 n9101 n9102 0.0075806451612903227
r16080 n9082 n9103 0.20814285714285716
r16081 n9083 n9104 0.48566666666666669
r16082 n9103 n9104 0.0075806451612903227
r16083 n9084 n9105 0.48566666666666669
r16084 n9104 n9105 0.0045483870967741929
r16085 n9085 n9106 0.72850000000000004
r16086 n9105 n9106 0.0037903225806451613
r16087 n9086 n9107 0.18212500000000001
r16088 n9106 n9107 0.0075806451612903227
r16089 n9087 n9108 0.066227272727272732
r16090 n9107 n9108 0.022741935483870965
r16091 n9088 n9109 0.72850000000000004
r16092 n9108 n9109 0.018193548387096772
r16093 n9089 n9110 0.48566666666666669
r16094 n9109 n9110 0.0037903225806451613
r16095 n9090 n9111 0.48566666666666669
r16096 n9110 n9111 0.0045483870967741929
r16097 n9091 n9112 0.36425000000000002
r16098 n9111 n9112 0.0053064516129032258
r16099 n9092 n9113 0.48566666666666669
r16100 n9112 n9113 0.0053064516129032258
r16101 n9093 n9114 0.20814285714285716
r16102 n9094 n9115 0.48566666666666669
r16103 n9114 n9115 0.0075806451612903227
r16104 n9095 n9116 0.48566666666666669
r16105 n9115 n9116 0.0045483870967741929
r16106 n9096 n9117 0.72850000000000004
r16107 n9116 n9117 0.0037903225806451613
r16108 n9097 n9118 0.13245454545454546
r16109 n9117 n9118 0.0098548387096774204
r16110 n9098 n9119 0.076684210526315785
r16111 n9118 n9119 0.022741935483870965
r16112 n9099 n9120 0.72850000000000004
r16113 n9119 n9120 0.015919354838709675
r16114 n9100 n9121 0.48566666666666669
r16115 n9120 n9121 0.0037903225806451613
r16116 n9101 n9122 0.48566666666666669
r16117 n9121 n9122 0.0045483870967741929
r16118 n9102 n9123 0.20814285714285716
r16119 n9122 n9123 0.0075806451612903227
r16120 n9103 n9124 0.15107142857142855
r16121 n9104 n9125 0.35249999999999998
r16122 n9124 n9125 0.016785714285714286
r16123 n9105 n9126 0.35249999999999998
r16124 n9125 n9126 0.010071428571428571
r16125 n9106 n9127 0.52874999999999994
r16126 n9126 n9127 0.0083928571428571429
r16127 n9107 n9128 0.13218749999999999
r16128 n9127 n9128 0.016785714285714286
r16129 n9108 n9129 0.048068181818181815
r16130 n9128 n9129 0.050357142857142857
r16131 n9109 n9130 0.52874999999999994
r16132 n9129 n9130 0.040285714285714286
r16133 n9110 n9131 0.35249999999999998
r16134 n9130 n9131 0.0083928571428571429
r16135 n9111 n9132 0.35249999999999998
r16136 n9131 n9132 0.010071428571428571
r16137 n9112 n9133 0.26437499999999997
r16138 n9132 n9133 0.01175
r16139 n9113 n9134 0.35249999999999998
r16140 n9133 n9134 0.01175
r16141 n9114 n9135 0.15107142857142855
r16142 n9115 n9136 0.35249999999999998
r16143 n9135 n9136 0.016785714285714286
r16144 n9116 n9137 0.35249999999999998
r16145 n9136 n9137 0.010071428571428571
r16146 n9117 n9138 0.52874999999999994
r16147 n9137 n9138 0.0083928571428571429
r16148 n9118 n9139 0.096136363636363631
r16149 n9138 n9139 0.021821428571428571
r16150 n9119 n9140 0.055657894736842101
r16151 n9139 n9140 0.050357142857142857
r16152 n9120 n9141 0.52874999999999994
r16153 n9140 n9141 0.035249999999999997
r16154 n9121 n9142 0.35249999999999998
r16155 n9141 n9142 0.0083928571428571429
r16156 n9122 n9143 0.35249999999999998
r16157 n9142 n9143 0.010071428571428571
r16158 n9123 n9144 0.15107142857142855
r16159 n9143 n9144 0.016785714285714286
r16160 n9124 n9145 0.053714285714285714
r16161 n9125 n9146 0.12533333333333332
r16162 n9145 n9146 0.11750000000000001
r16163 n9126 n9147 0.12533333333333332
r16164 n9146 n9147 0.070499999999999993
r16165 n9127 n9148 0.188
r16166 n9147 n9148 0.058750000000000004
r16167 n9128 n9149 0.047
r16168 n9148 n9149 0.11750000000000001
r16169 n9129 n9150 0.017090909090909091
r16170 n9149 n9150 0.35249999999999998
r16171 n9130 n9151 0.188
r16172 n9150 n9151 0.28199999999999997
r16173 n9131 n9152 0.12533333333333332
r16174 n9151 n9152 0.058750000000000004
r16175 n9132 n9153 0.12533333333333332
r16176 n9152 n9153 0.070499999999999993
r16177 n9133 n9154 0.094
r16178 n9153 n9154 0.082250000000000004
r16179 n9134 n9155 0.12533333333333332
r16180 n9154 n9155 0.082250000000000004
r16181 n9135 n9156 0.053714285714285714
r16182 n9136 n9157 0.12533333333333332
r16183 n9156 n9157 0.11750000000000001
r16184 n9137 n9158 0.12533333333333332
r16185 n9157 n9158 0.070499999999999993
r16186 n9138 n9159 0.188
r16187 n9158 n9159 0.058750000000000004
r16188 n9139 n9160 0.034181818181818181
r16189 n9159 n9160 0.15275
r16190 n9140 n9161 0.019789473684210527
r16191 n9160 n9161 0.35249999999999998
r16192 n9141 n9162 0.188
r16193 n9161 n9162 0.24674999999999997
r16194 n9142 n9163 0.12533333333333332
r16195 n9162 n9163 0.058750000000000004
r16196 n9143 n9164 0.12533333333333332
r16197 n9163 n9164 0.070499999999999993
r16198 n9144 n9165 0.053714285714285714
r16199 n9164 n9165 0.11750000000000001
r16200 n9145 n9166 0.0235
r16201 n9146 n9167 0.054833333333333331
r16202 n9166 n9167 0.047
r16203 n9147 n9168 0.054833333333333331
r16204 n9167 n9168 0.028199999999999999
r16205 n9148 n9169 0.082250000000000004
r16206 n9168 n9169 0.0235
r16207 n9149 n9170 0.020562500000000001
r16208 n9169 n9170 0.047
r16209 n9150 n9171 0.0074772727272727274
r16210 n9170 n9171 0.14099999999999999
r16211 n9151 n9172 0.082250000000000004
r16212 n9171 n9172 0.1128
r16213 n9152 n9173 0.054833333333333331
r16214 n9172 n9173 0.0235
r16215 n9153 n9174 0.054833333333333331
r16216 n9173 n9174 0.028199999999999999
r16217 n9154 n9175 0.041125000000000002
r16218 n9174 n9175 0.032899999999999999
r16219 n9155 n9176 0.054833333333333331
r16220 n9175 n9176 0.032899999999999999
r16221 n9156 n9177 0.0235
r16222 n9157 n9178 0.054833333333333331
r16223 n9177 n9178 0.047
r16224 n9158 n9179 0.054833333333333331
r16225 n9178 n9179 0.028199999999999999
r16226 n9159 n9180 0.082250000000000004
r16227 n9179 n9180 0.0235
r16228 n9160 n9181 0.014954545454545455
r16229 n9180 n9181 0.061100000000000002
r16230 n9161 n9182 0.0086578947368421057
r16231 n9181 n9182 0.14099999999999999
r16232 n9162 n9183 0.082250000000000004
r16233 n9182 n9183 0.098699999999999996
r16234 n9163 n9184 0.054833333333333331
r16235 n9183 n9184 0.0235
r16236 n9164 n9185 0.054833333333333331
r16237 n9184 n9185 0.028199999999999999
r16238 n9165 n9186 0.0235
r16239 n9185 n9186 0.047
r16240 n9166 n9187 0.036928571428571429
r16241 n9167 n9188 0.086166666666666669
r16242 n9187 n9188 0.039166666666666669
r16243 n9168 n9189 0.086166666666666669
r16244 n9188 n9189 0.0235
r16245 n9169 n9190 0.12925
r16246 n9189 n9190 0.019583333333333335
r16247 n9170 n9191 0.032312500000000001
r16248 n9190 n9191 0.039166666666666669
r16249 n9171 n9192 0.01175
r16250 n9191 n9192 0.11749999999999999
r16251 n9172 n9193 0.12925
r16252 n9192 n9193 0.094
r16253 n9173 n9194 0.086166666666666669
r16254 n9193 n9194 0.019583333333333335
r16255 n9174 n9195 0.086166666666666669
r16256 n9194 n9195 0.0235
r16257 n9175 n9196 0.064625000000000002
r16258 n9195 n9196 0.027416666666666666
r16259 n9176 n9197 0.086166666666666669
r16260 n9196 n9197 0.027416666666666666
r16261 n9177 n9198 0.036928571428571429
r16262 n9178 n9199 0.086166666666666669
r16263 n9198 n9199 0.039166666666666669
r16264 n9179 n9200 0.086166666666666669
r16265 n9199 n9200 0.0235
r16266 n9180 n9201 0.12925
r16267 n9200 n9201 0.019583333333333335
r16268 n9181 n9202 0.0235
r16269 n9201 n9202 0.050916666666666673
r16270 n9182 n9203 0.013605263157894737
r16271 n9202 n9203 0.11749999999999999
r16272 n9183 n9204 0.12925
r16273 n9203 n9204 0.08224999999999999
r16274 n9184 n9205 0.086166666666666669
r16275 n9204 n9205 0.019583333333333335
r16276 n9185 n9206 0.086166666666666669
r16277 n9205 n9206 0.0235
r16278 n9186 n9207 0.036928571428571429
r16279 n9206 n9207 0.039166666666666669
r16280 n9187 n9208 0.026857142857142857
r16281 n9188 n9209 0.062666666666666662
r16282 n9208 n9209 0.11750000000000001
r16283 n9189 n9210 0.062666666666666662
r16284 n9209 n9210 0.070499999999999993
r16285 n9190 n9211 0.094
r16286 n9210 n9211 0.058750000000000004
r16287 n9191 n9212 0.0235
r16288 n9211 n9212 0.11750000000000001
r16289 n9192 n9213 0.0085454545454545453
r16290 n9212 n9213 0.35249999999999998
r16291 n9193 n9214 0.094
r16292 n9213 n9214 0.28199999999999997
r16293 n9194 n9215 0.062666666666666662
r16294 n9214 n9215 0.058750000000000004
r16295 n9195 n9216 0.062666666666666662
r16296 n9215 n9216 0.070499999999999993
r16297 n9196 n9217 0.047
r16298 n9216 n9217 0.082250000000000004
r16299 n9197 n9218 0.062666666666666662
r16300 n9217 n9218 0.082250000000000004
r16301 n9198 n9219 0.026857142857142857
r16302 n9199 n9220 0.062666666666666662
r16303 n9219 n9220 0.11750000000000001
r16304 n9200 n9221 0.062666666666666662
r16305 n9220 n9221 0.070499999999999993
r16306 n9201 n9222 0.094
r16307 n9221 n9222 0.058750000000000004
r16308 n9202 n9223 0.017090909090909091
r16309 n9222 n9223 0.15275
r16310 n9203 n9224 0.0098947368421052635
r16311 n9223 n9224 0.35249999999999998
r16312 n9204 n9225 0.094
r16313 n9224 n9225 0.24674999999999997
r16314 n9205 n9226 0.062666666666666662
r16315 n9225 n9226 0.058750000000000004
r16316 n9206 n9227 0.062666666666666662
r16317 n9226 n9227 0.070499999999999993
r16318 n9207 n9228 0.026857142857142857
r16319 n9227 n9228 0.11750000000000001
r16320 n9208 n9229 0.0235
r16321 n9209 n9230 0.054833333333333331
r16322 n9229 n9230 0.047
r16323 n9210 n9231 0.054833333333333331
r16324 n9230 n9231 0.028199999999999999
r16325 n9211 n9232 0.082250000000000004
r16326 n9231 n9232 0.0235
r16327 n9212 n9233 0.020562500000000001
r16328 n9232 n9233 0.047
r16329 n9213 n9234 0.0074772727272727274
r16330 n9233 n9234 0.14099999999999999
r16331 n9214 n9235 0.082250000000000004
r16332 n9234 n9235 0.1128
r16333 n9215 n9236 0.054833333333333331
r16334 n9235 n9236 0.0235
r16335 n9216 n9237 0.054833333333333331
r16336 n9236 n9237 0.028199999999999999
r16337 n9217 n9238 0.041125000000000002
r16338 n9237 n9238 0.032899999999999999
r16339 n9218 n9239 0.054833333333333331
r16340 n9238 n9239 0.032899999999999999
r16341 n9219 n9240 0.0235
r16342 n9220 n9241 0.054833333333333331
r16343 n9240 n9241 0.047
r16344 n9221 n9242 0.054833333333333331
r16345 n9241 n9242 0.028199999999999999
r16346 n9222 n9243 0.082250000000000004
r16347 n9242 n9243 0.0235
r16348 n9223 n9244 0.014954545454545455
r16349 n9243 n9244 0.061100000000000002
r16350 n9224 n9245 0.0086578947368421057
r16351 n9244 n9245 0.14099999999999999
r16352 n9225 n9246 0.082250000000000004
r16353 n9245 n9246 0.098699999999999996
r16354 n9226 n9247 0.054833333333333331
r16355 n9246 n9247 0.0235
r16356 n9227 n9248 0.054833333333333331
r16357 n9247 n9248 0.028199999999999999
r16358 n9228 n9249 0.0235
r16359 n9248 n9249 0.047
r16360 n9229 n9250 0.067142857142857143
r16361 n9230 n9251 0.15666666666666668
r16362 n9250 n9251 0.015666666666666666
r16363 n9231 n9252 0.15666666666666668
r16364 n9251 n9252 0.0093999999999999986
r16365 n9232 n9253 0.23500000000000001
r16366 n9252 n9253 0.0078333333333333328
r16367 n9233 n9254 0.058750000000000004
r16368 n9253 n9254 0.015666666666666666
r16369 n9234 n9255 0.021363636363636366
r16370 n9254 n9255 0.047
r16371 n9235 n9256 0.23500000000000001
r16372 n9255 n9256 0.037599999999999995
r16373 n9236 n9257 0.15666666666666668
r16374 n9256 n9257 0.0078333333333333328
r16375 n9237 n9258 0.15666666666666668
r16376 n9257 n9258 0.0093999999999999986
r16377 n9238 n9259 0.11750000000000001
r16378 n9258 n9259 0.010966666666666666
r16379 n9239 n9260 0.15666666666666668
r16380 n9259 n9260 0.010966666666666666
r16381 n9240 n9261 0.067142857142857143
r16382 n9241 n9262 0.15666666666666668
r16383 n9261 n9262 0.015666666666666666
r16384 n9242 n9263 0.15666666666666668
r16385 n9262 n9263 0.0093999999999999986
r16386 n9243 n9264 0.23500000000000001
r16387 n9263 n9264 0.0078333333333333328
r16388 n9244 n9265 0.042727272727272732
r16389 n9264 n9265 0.020366666666666668
r16390 n9245 n9266 0.024736842105263158
r16391 n9265 n9266 0.047
r16392 n9246 n9267 0.23500000000000001
r16393 n9266 n9267 0.032899999999999999
r16394 n9247 n9268 0.15666666666666668
r16395 n9267 n9268 0.0078333333333333328
r16396 n9248 n9269 0.15666666666666668
r16397 n9268 n9269 0.0093999999999999986
r16398 n9249 n9270 0.067142857142857143
r16399 n9269 n9270 0.015666666666666666
r16400 n9250 n9272 0.060428571428571436
r16401 n9271 n9272 0.13316666666666668
r16402 n9251 n9273 0.14100000000000001
r16403 n9272 n9273 0.078333333333333338
r16404 n9252 n9274 0.14100000000000001
r16405 n9273 n9274 0.047
r16406 n9253 n9275 0.21150000000000002
r16407 n9274 n9275 0.039166666666666669
r16408 n9254 n9276 0.052875000000000005
r16409 n9275 n9276 0.078333333333333338
r16410 n9255 n9277 0.019227272727272728
r16411 n9276 n9277 0.23499999999999999
r16412 n9256 n9278 0.21150000000000002
r16413 n9277 n9278 0.188
r16414 n9257 n9279 0.14100000000000001
r16415 n9278 n9279 0.039166666666666669
r16416 n9258 n9280 0.14100000000000001
r16417 n9279 n9280 0.047
r16418 n9259 n9281 0.10575000000000001
r16419 n9280 n9281 0.054833333333333331
r16420 n9260 n9282 0.14100000000000001
r16421 n9281 n9282 0.054833333333333331
r16422 n9282 n9283 0.10183333333333335
r16423 n9261 n9285 0.060428571428571436
r16424 n9284 n9285 0.13316666666666668
r16425 n9262 n9286 0.14100000000000001
r16426 n9285 n9286 0.078333333333333338
r16427 n9263 n9287 0.14100000000000001
r16428 n9286 n9287 0.047
r16429 n9264 n9288 0.21150000000000002
r16430 n9287 n9288 0.039166666666666669
r16431 n9265 n9289 0.038454545454545457
r16432 n9288 n9289 0.10183333333333335
r16433 n9266 n9290 0.022263157894736846
r16434 n9289 n9290 0.23499999999999999
r16435 n9267 n9291 0.21150000000000002
r16436 n9290 n9291 0.16449999999999998
r16437 n9268 n9292 0.14100000000000001
r16438 n9291 n9292 0.039166666666666669
r16439 n9269 n9293 0.14100000000000001
r16440 n9292 n9293 0.047
r16441 n9270 n9294 0.060428571428571436
r16442 n9293 n9294 0.078333333333333338
r16443 n9294 n9295 0.13316666666666668
r16444 n9271 n9296 0.016449999999999999
r16445 n9272 n9297 0.0235
r16446 n9296 n9297 0.099875000000000005
r16447 n9273 n9298 0.054833333333333331
r16448 n9297 n9298 0.058750000000000004
r16449 n9274 n9299 0.054833333333333331
r16450 n9298 n9299 0.035249999999999997
r16451 n9275 n9300 0.082250000000000004
r16452 n9299 n9300 0.029375000000000002
r16453 n9276 n9301 0.020562500000000001
r16454 n9300 n9301 0.058750000000000004
r16455 n9277 n9302 0.0074772727272727274
r16456 n9301 n9302 0.17624999999999999
r16457 n9278 n9303 0.082250000000000004
r16458 n9302 n9303 0.14099999999999999
r16459 n9279 n9304 0.054833333333333331
r16460 n9303 n9304 0.029375000000000002
r16461 n9280 n9305 0.054833333333333331
r16462 n9304 n9305 0.035249999999999997
r16463 n9281 n9306 0.041125000000000002
r16464 n9305 n9306 0.041125000000000002
r16465 n9282 n9307 0.054833333333333331
r16466 n9306 n9307 0.041125000000000002
r16467 n9283 n9308 0.016449999999999999
r16468 n9307 n9308 0.076374999999999998
r16469 n9284 n9309 0.016449999999999999
r16470 n9285 n9310 0.0235
r16471 n9309 n9310 0.099875000000000005
r16472 n9286 n9311 0.054833333333333331
r16473 n9310 n9311 0.058750000000000004
r16474 n9287 n9312 0.054833333333333331
r16475 n9311 n9312 0.035249999999999997
r16476 n9288 n9313 0.082250000000000004
r16477 n9312 n9313 0.029375000000000002
r16478 n9289 n9314 0.014954545454545455
r16479 n9313 n9314 0.076374999999999998
r16480 n9290 n9315 0.0086578947368421057
r16481 n9314 n9315 0.17624999999999999
r16482 n9291 n9316 0.082250000000000004
r16483 n9315 n9316 0.12337499999999998
r16484 n9292 n9317 0.054833333333333331
r16485 n9316 n9317 0.029375000000000002
r16486 n9293 n9318 0.054833333333333331
r16487 n9317 n9318 0.035249999999999997
r16488 n9294 n9319 0.0235
r16489 n9318 n9319 0.058750000000000004
r16490 n9295 n9320 0.016449999999999999
r16491 n9319 n9320 0.099875000000000005
r16492 n9296 n9321 0.016449999999999999
r16493 n9297 n9322 0.0235
r16494 n9321 n9322 0.13316666666666668
r16495 n9298 n9323 0.054833333333333331
r16496 n9322 n9323 0.078333333333333338
r16497 n9299 n9324 0.054833333333333331
r16498 n9323 n9324 0.047
r16499 n9300 n9325 0.082250000000000004
r16500 n9324 n9325 0.039166666666666669
r16501 n9301 n9326 0.020562500000000001
r16502 n9325 n9326 0.078333333333333338
r16503 n9302 n9327 0.0074772727272727274
r16504 n9326 n9327 0.23499999999999999
r16505 n9303 n9328 0.082250000000000004
r16506 n9327 n9328 0.188
r16507 n9304 n9329 0.054833333333333331
r16508 n9328 n9329 0.039166666666666669
r16509 n9305 n9330 0.054833333333333331
r16510 n9329 n9330 0.047
r16511 n9306 n9331 0.041125000000000002
r16512 n9330 n9331 0.054833333333333331
r16513 n9307 n9332 0.054833333333333331
r16514 n9331 n9332 0.054833333333333331
r16515 n9308 n9333 0.016449999999999999
r16516 n9332 n9333 0.10183333333333335
r16517 n9309 n9334 0.016449999999999999
r16518 n9310 n9335 0.0235
r16519 n9334 n9335 0.13316666666666668
r16520 n9311 n9336 0.054833333333333331
r16521 n9335 n9336 0.078333333333333338
r16522 n9312 n9337 0.054833333333333331
r16523 n9336 n9337 0.047
r16524 n9313 n9338 0.082250000000000004
r16525 n9337 n9338 0.039166666666666669
r16526 n9314 n9339 0.014954545454545455
r16527 n9338 n9339 0.10183333333333335
r16528 n9315 n9340 0.0086578947368421057
r16529 n9339 n9340 0.23499999999999999
r16530 n9316 n9341 0.082250000000000004
r16531 n9340 n9341 0.16449999999999998
r16532 n9317 n9342 0.054833333333333331
r16533 n9341 n9342 0.039166666666666669
r16534 n9318 n9343 0.054833333333333331
r16535 n9342 n9343 0.047
r16536 n9319 n9344 0.0235
r16537 n9343 n9344 0.078333333333333338
r16538 n9320 n9345 0.016449999999999999
r16539 n9344 n9345 0.13316666666666668
r16540 n9321 n9346 0.01175
r16541 n9322 n9347 0.016785714285714286
r16542 n9346 n9347 0.19975000000000001
r16543 n9323 n9348 0.039166666666666669
r16544 n9347 n9348 0.11750000000000001
r16545 n9324 n9349 0.039166666666666669
r16546 n9348 n9349 0.070499999999999993
r16547 n9325 n9350 0.058750000000000004
r16548 n9349 n9350 0.058750000000000004
r16549 n9326 n9351 0.014687500000000001
r16550 n9350 n9351 0.11750000000000001
r16551 n9327 n9352 0.0053409090909090915
r16552 n9351 n9352 0.35249999999999998
r16553 n9328 n9353 0.058750000000000004
r16554 n9352 n9353 0.28199999999999997
r16555 n9329 n9354 0.039166666666666669
r16556 n9353 n9354 0.058750000000000004
r16557 n9330 n9355 0.039166666666666669
r16558 n9354 n9355 0.070499999999999993
r16559 n9331 n9356 0.029375000000000002
r16560 n9355 n9356 0.082250000000000004
r16561 n9332 n9357 0.039166666666666669
r16562 n9356 n9357 0.082250000000000004
r16563 n9333 n9358 0.01175
r16564 n9357 n9358 0.15275
r16565 n9334 n9359 0.01175
r16566 n9335 n9360 0.016785714285714286
r16567 n9359 n9360 0.19975000000000001
r16568 n9336 n9361 0.039166666666666669
r16569 n9360 n9361 0.11750000000000001
r16570 n9337 n9362 0.039166666666666669
r16571 n9361 n9362 0.070499999999999993
r16572 n9338 n9363 0.058750000000000004
r16573 n9362 n9363 0.058750000000000004
r16574 n9339 n9364 0.010681818181818183
r16575 n9363 n9364 0.15275
r16576 n9340 n9365 0.0061842105263157894
r16577 n9364 n9365 0.35249999999999998
r16578 n9341 n9366 0.058750000000000004
r16579 n9365 n9366 0.24674999999999997
r16580 n9342 n9367 0.039166666666666669
r16581 n9366 n9367 0.058750000000000004
r16582 n9343 n9368 0.039166666666666669
r16583 n9367 n9368 0.070499999999999993
r16584 n9344 n9369 0.016785714285714286
r16585 n9368 n9369 0.11750000000000001
r16586 n9345 n9370 0.01175
r16587 n9369 n9370 0.19975000000000001
r16588 n9346 n9371 0.018799999999999997
r16589 n9347 n9372 0.026857142857142857
r16590 n9371 n9372 0.066583333333333342
r16591 n9348 n9373 0.062666666666666662
r16592 n9372 n9373 0.039166666666666669
r16593 n9349 n9374 0.062666666666666662
r16594 n9373 n9374 0.0235
r16595 n9350 n9375 0.094
r16596 n9374 n9375 0.019583333333333335
r16597 n9351 n9376 0.0235
r16598 n9375 n9376 0.039166666666666669
r16599 n9352 n9377 0.0085454545454545453
r16600 n9376 n9377 0.11749999999999999
r16601 n9353 n9378 0.094
r16602 n9377 n9378 0.094
r16603 n9354 n9379 0.062666666666666662
r16604 n9378 n9379 0.019583333333333335
r16605 n9355 n9380 0.062666666666666662
r16606 n9379 n9380 0.0235
r16607 n9356 n9381 0.047
r16608 n9380 n9381 0.027416666666666666
r16609 n9357 n9382 0.062666666666666662
r16610 n9381 n9382 0.027416666666666666
r16611 n9358 n9383 0.018799999999999997
r16612 n9382 n9383 0.050916666666666673
r16613 n9359 n9384 0.018799999999999997
r16614 n9360 n9385 0.026857142857142857
r16615 n9384 n9385 0.066583333333333342
r16616 n9361 n9386 0.062666666666666662
r16617 n9385 n9386 0.039166666666666669
r16618 n9362 n9387 0.062666666666666662
r16619 n9386 n9387 0.0235
r16620 n9363 n9388 0.094
r16621 n9387 n9388 0.019583333333333335
r16622 n9364 n9389 0.017090909090909091
r16623 n9388 n9389 0.050916666666666673
r16624 n9365 n9390 0.0098947368421052635
r16625 n9389 n9390 0.11749999999999999
r16626 n9366 n9391 0.094
r16627 n9390 n9391 0.08224999999999999
r16628 n9367 n9392 0.062666666666666662
r16629 n9391 n9392 0.019583333333333335
r16630 n9368 n9393 0.062666666666666662
r16631 n9392 n9393 0.0235
r16632 n9369 n9394 0.026857142857142857
r16633 n9393 n9394 0.039166666666666669
r16634 n9370 n9395 0.018799999999999997
r16635 n9394 n9395 0.066583333333333342
r16636 n9371 n9396 0.018799999999999997
r16637 n9372 n9397 0.026857142857142857
r16638 n9396 n9397 0.19975000000000001
r16639 n9373 n9398 0.062666666666666662
r16640 n9397 n9398 0.11750000000000001
r16641 n9374 n9399 0.062666666666666662
r16642 n9398 n9399 0.070499999999999993
r16643 n9375 n9400 0.094
r16644 n9399 n9400 0.058750000000000004
r16645 n9376 n9401 0.0235
r16646 n9400 n9401 0.11750000000000001
r16647 n9377 n9402 0.0085454545454545453
r16648 n9401 n9402 0.35249999999999998
r16649 n9378 n9403 0.094
r16650 n9402 n9403 0.28199999999999997
r16651 n9379 n9404 0.062666666666666662
r16652 n9403 n9404 0.058750000000000004
r16653 n9380 n9405 0.062666666666666662
r16654 n9404 n9405 0.070499999999999993
r16655 n9381 n9406 0.047
r16656 n9405 n9406 0.082250000000000004
r16657 n9382 n9407 0.062666666666666662
r16658 n9406 n9407 0.082250000000000004
r16659 n9383 n9408 0.018799999999999997
r16660 n9407 n9408 0.15275
r16661 n9384 n9409 0.018799999999999997
r16662 n9385 n9410 0.026857142857142857
r16663 n9409 n9410 0.19975000000000001
r16664 n9386 n9411 0.062666666666666662
r16665 n9410 n9411 0.11750000000000001
r16666 n9387 n9412 0.062666666666666662
r16667 n9411 n9412 0.070499999999999993
r16668 n9388 n9413 0.094
r16669 n9412 n9413 0.058750000000000004
r16670 n9389 n9414 0.017090909090909091
r16671 n9413 n9414 0.15275
r16672 n9390 n9415 0.0098947368421052635
r16673 n9414 n9415 0.35249999999999998
r16674 n9391 n9416 0.094
r16675 n9415 n9416 0.24674999999999997
r16676 n9392 n9417 0.062666666666666662
r16677 n9416 n9417 0.058750000000000004
r16678 n9393 n9418 0.062666666666666662
r16679 n9417 n9418 0.070499999999999993
r16680 n9394 n9419 0.026857142857142857
r16681 n9418 n9419 0.11750000000000001
r16682 n9395 n9420 0.018799999999999997
r16683 n9419 n9420 0.19975000000000001
r16684 n9396 n9421 0.01175
r16685 n9397 n9422 0.016785714285714286
r16686 n9421 n9422 0.13316666666666668
r16687 n9398 n9423 0.039166666666666669
r16688 n9422 n9423 0.078333333333333338
r16689 n9399 n9424 0.039166666666666669
r16690 n9423 n9424 0.047
r16691 n9400 n9425 0.058750000000000004
r16692 n9424 n9425 0.039166666666666669
r16693 n9401 n9426 0.014687500000000001
r16694 n9425 n9426 0.078333333333333338
r16695 n9402 n9427 0.0053409090909090915
r16696 n9426 n9427 0.23499999999999999
r16697 n9403 n9428 0.058750000000000004
r16698 n9427 n9428 0.188
r16699 n9404 n9429 0.039166666666666669
r16700 n9428 n9429 0.039166666666666669
r16701 n9405 n9430 0.039166666666666669
r16702 n9429 n9430 0.047
r16703 n9406 n9431 0.029375000000000002
r16704 n9430 n9431 0.054833333333333331
r16705 n9407 n9432 0.039166666666666669
r16706 n9431 n9432 0.054833333333333331
r16707 n9408 n9433 0.01175
r16708 n9432 n9433 0.10183333333333335
r16709 n9409 n9434 0.01175
r16710 n9410 n9435 0.016785714285714286
r16711 n9434 n9435 0.13316666666666668
r16712 n9411 n9436 0.039166666666666669
r16713 n9435 n9436 0.078333333333333338
r16714 n9412 n9437 0.039166666666666669
r16715 n9436 n9437 0.047
r16716 n9413 n9438 0.058750000000000004
r16717 n9437 n9438 0.039166666666666669
r16718 n9414 n9439 0.010681818181818183
r16719 n9438 n9439 0.10183333333333335
r16720 n9415 n9440 0.0061842105263157894
r16721 n9439 n9440 0.23499999999999999
r16722 n9416 n9441 0.058750000000000004
r16723 n9440 n9441 0.16449999999999998
r16724 n9417 n9442 0.039166666666666669
r16725 n9441 n9442 0.039166666666666669
r16726 n9418 n9443 0.039166666666666669
r16727 n9442 n9443 0.047
r16728 n9419 n9444 0.016785714285714286
r16729 n9443 n9444 0.078333333333333338
r16730 n9420 n9445 0.01175
r16731 n9444 n9445 0.13316666666666668
r16732 n9421 n9446 0.01175
r16733 n9422 n9447 0.016785714285714286
r16734 n9446 n9447 0.19975000000000001
r16735 n9423 n9448 0.039166666666666669
r16736 n9447 n9448 0.11750000000000001
r16737 n9424 n9449 0.039166666666666669
r16738 n9448 n9449 0.070499999999999993
r16739 n9425 n9450 0.058750000000000004
r16740 n9449 n9450 0.058750000000000004
r16741 n9426 n9451 0.014687500000000001
r16742 n9450 n9451 0.11750000000000001
r16743 n9427 n9452 0.0053409090909090915
r16744 n9451 n9452 0.35249999999999998
r16745 n9428 n9453 0.058750000000000004
r16746 n9452 n9453 0.28199999999999997
r16747 n9429 n9454 0.039166666666666669
r16748 n9453 n9454 0.058750000000000004
r16749 n9430 n9455 0.039166666666666669
r16750 n9454 n9455 0.070499999999999993
r16751 n9431 n9456 0.029375000000000002
r16752 n9455 n9456 0.082250000000000004
r16753 n9432 n9457 0.039166666666666669
r16754 n9456 n9457 0.082250000000000004
r16755 n9433 n9458 0.01175
r16756 n9457 n9458 0.15275
r16757 n9434 n9459 0.01175
r16758 n9435 n9460 0.016785714285714286
r16759 n9459 n9460 0.19975000000000001
r16760 n9436 n9461 0.039166666666666669
r16761 n9460 n9461 0.11750000000000001
r16762 n9437 n9462 0.039166666666666669
r16763 n9461 n9462 0.070499999999999993
r16764 n9438 n9463 0.058750000000000004
r16765 n9462 n9463 0.058750000000000004
r16766 n9439 n9464 0.010681818181818183
r16767 n9463 n9464 0.15275
r16768 n9440 n9465 0.0061842105263157894
r16769 n9464 n9465 0.35249999999999998
r16770 n9441 n9466 0.058750000000000004
r16771 n9465 n9466 0.24674999999999997
r16772 n9442 n9467 0.039166666666666669
r16773 n9466 n9467 0.058750000000000004
r16774 n9443 n9468 0.039166666666666669
r16775 n9467 n9468 0.070499999999999993
r16776 n9444 n9469 0.016785714285714286
r16777 n9468 n9469 0.11750000000000001
r16778 n9445 n9470 0.01175
r16779 n9469 n9470 0.19975000000000001
r16780 n9446 n9471 0.075199999999999989
r16781 n9447 n9472 0.10742857142857143
r16782 n9471 n9472 0.013316666666666668
r16783 n9448 n9473 0.25066666666666665
r16784 n9472 n9473 0.0078333333333333328
r16785 n9449 n9474 0.25066666666666665
r16786 n9473 n9474 0.0046999999999999993
r16787 n9450 n9475 0.376
r16788 n9474 n9475 0.0039166666666666664
r16789 n9451 n9476 0.094
r16790 n9475 n9476 0.0078333333333333328
r16791 n9452 n9477 0.034181818181818181
r16792 n9476 n9477 0.0235
r16793 n9453 n9478 0.376
r16794 n9477 n9478 0.018799999999999997
r16795 n9454 n9479 0.25066666666666665
r16796 n9478 n9479 0.0039166666666666664
r16797 n9455 n9480 0.25066666666666665
r16798 n9479 n9480 0.0046999999999999993
r16799 n9456 n9481 0.188
r16800 n9480 n9481 0.0054833333333333331
r16801 n9457 n9482 0.25066666666666665
r16802 n9481 n9482 0.0054833333333333331
r16803 n9458 n9483 0.075199999999999989
r16804 n9482 n9483 0.010183333333333334
r16805 n9459 n9484 0.075199999999999989
r16806 n9460 n9485 0.10742857142857143
r16807 n9484 n9485 0.013316666666666668
r16808 n9461 n9486 0.25066666666666665
r16809 n9485 n9486 0.0078333333333333328
r16810 n9462 n9487 0.25066666666666665
r16811 n9486 n9487 0.0046999999999999993
r16812 n9463 n9488 0.376
r16813 n9487 n9488 0.0039166666666666664
r16814 n9464 n9489 0.068363636363636363
r16815 n9488 n9489 0.010183333333333334
r16816 n9465 n9490 0.039578947368421054
r16817 n9489 n9490 0.0235
r16818 n9466 n9491 0.376
r16819 n9490 n9491 0.016449999999999999
r16820 n9467 n9492 0.25066666666666665
r16821 n9491 n9492 0.0039166666666666664
r16822 n9468 n9493 0.25066666666666665
r16823 n9492 n9493 0.0046999999999999993
r16824 n9469 n9494 0.10742857142857143
r16825 n9493 n9494 0.0078333333333333328
r16826 n9470 n9495 0.075199999999999989
r16827 n9494 n9495 0.013316666666666668
r16828 n9471 n9496 0.075199999999999989
r16829 n9472 n9497 0.10742857142857143
r16830 n9496 n9497 0.19975000000000001
r16831 n9473 n9498 0.25066666666666665
r16832 n9497 n9498 0.11750000000000001
r16833 n9474 n9499 0.25066666666666665
r16834 n9498 n9499 0.070499999999999993
r16835 n9475 n9500 0.376
r16836 n9499 n9500 0.058750000000000004
r16837 n9476 n9501 0.094
r16838 n9500 n9501 0.11750000000000001
r16839 n9477 n9502 0.034181818181818181
r16840 n9501 n9502 0.35249999999999998
r16841 n9478 n9503 0.376
r16842 n9502 n9503 0.28199999999999997
r16843 n9479 n9504 0.25066666666666665
r16844 n9503 n9504 0.058750000000000004
r16845 n9480 n9505 0.25066666666666665
r16846 n9504 n9505 0.070499999999999993
r16847 n9481 n9506 0.188
r16848 n9505 n9506 0.082250000000000004
r16849 n9482 n9507 0.25066666666666665
r16850 n9506 n9507 0.082250000000000004
r16851 n9483 n9508 0.075199999999999989
r16852 n9507 n9508 0.15275
r16853 n9484 n9509 0.075199999999999989
r16854 n9485 n9510 0.10742857142857143
r16855 n9509 n9510 0.19975000000000001
r16856 n9486 n9511 0.25066666666666665
r16857 n9510 n9511 0.11750000000000001
r16858 n9487 n9512 0.25066666666666665
r16859 n9511 n9512 0.070499999999999993
r16860 n9488 n9513 0.376
r16861 n9512 n9513 0.058750000000000004
r16862 n9489 n9514 0.068363636363636363
r16863 n9513 n9514 0.15275
r16864 n9490 n9515 0.039578947368421054
r16865 n9514 n9515 0.35249999999999998
r16866 n9491 n9516 0.376
r16867 n9515 n9516 0.24674999999999997
r16868 n9492 n9517 0.25066666666666665
r16869 n9516 n9517 0.058750000000000004
r16870 n9493 n9518 0.25066666666666665
r16871 n9517 n9518 0.070499999999999993
r16872 n9494 n9519 0.10742857142857143
r16873 n9518 n9519 0.11750000000000001
r16874 n9495 n9520 0.075199999999999989
r16875 n9519 n9520 0.19975000000000001
r16876 n9496 n9521 0.01175
r16877 n9497 n9522 0.016785714285714286
r16878 n9521 n9522 0.13316666666666668
r16879 n9498 n9523 0.039166666666666669
r16880 n9522 n9523 0.078333333333333338
r16881 n9499 n9524 0.039166666666666669
r16882 n9523 n9524 0.047
r16883 n9500 n9525 0.058750000000000004
r16884 n9524 n9525 0.039166666666666669
r16885 n9501 n9526 0.014687500000000001
r16886 n9525 n9526 0.078333333333333338
r16887 n9502 n9527 0.0053409090909090915
r16888 n9526 n9527 0.23499999999999999
r16889 n9503 n9528 0.058750000000000004
r16890 n9527 n9528 0.188
r16891 n9504 n9529 0.039166666666666669
r16892 n9528 n9529 0.039166666666666669
r16893 n9505 n9530 0.039166666666666669
r16894 n9529 n9530 0.047
r16895 n9506 n9531 0.029375000000000002
r16896 n9530 n9531 0.054833333333333331
r16897 n9507 n9532 0.039166666666666669
r16898 n9531 n9532 0.054833333333333331
r16899 n9508 n9533 0.01175
r16900 n9532 n9533 0.10183333333333335
r16901 n9509 n9534 0.01175
r16902 n9510 n9535 0.016785714285714286
r16903 n9534 n9535 0.13316666666666668
r16904 n9511 n9536 0.039166666666666669
r16905 n9535 n9536 0.078333333333333338
r16906 n9512 n9537 0.039166666666666669
r16907 n9536 n9537 0.047
r16908 n9513 n9538 0.058750000000000004
r16909 n9537 n9538 0.039166666666666669
r16910 n9514 n9539 0.010681818181818183
r16911 n9538 n9539 0.10183333333333335
r16912 n9515 n9540 0.0061842105263157894
r16913 n9539 n9540 0.23499999999999999
r16914 n9516 n9541 0.058750000000000004
r16915 n9540 n9541 0.16449999999999998
r16916 n9517 n9542 0.039166666666666669
r16917 n9541 n9542 0.039166666666666669
r16918 n9518 n9543 0.039166666666666669
r16919 n9542 n9543 0.047
r16920 n9519 n9544 0.016785714285714286
r16921 n9543 n9544 0.078333333333333338
r16922 n9520 n9545 0.01175
r16923 n9544 n9545 0.13316666666666668
r16924 n9521 n9546 0.01175
r16925 n9522 n9547 0.016785714285714286
r16926 n9546 n9547 0.19975000000000001
r16927 n9523 n9548 0.039166666666666669
r16928 n9547 n9548 0.11750000000000001
r16929 n9524 n9549 0.039166666666666669
r16930 n9548 n9549 0.070499999999999993
r16931 n9525 n9550 0.058750000000000004
r16932 n9549 n9550 0.058750000000000004
r16933 n9526 n9551 0.014687500000000001
r16934 n9550 n9551 0.11750000000000001
r16935 n9527 n9552 0.0053409090909090915
r16936 n9551 n9552 0.35249999999999998
r16937 n9528 n9553 0.058750000000000004
r16938 n9552 n9553 0.28199999999999997
r16939 n9529 n9554 0.039166666666666669
r16940 n9553 n9554 0.058750000000000004
r16941 n9530 n9555 0.039166666666666669
r16942 n9554 n9555 0.070499999999999993
r16943 n9531 n9556 0.029375000000000002
r16944 n9555 n9556 0.082250000000000004
r16945 n9532 n9557 0.039166666666666669
r16946 n9556 n9557 0.082250000000000004
r16947 n9533 n9558 0.01175
r16948 n9557 n9558 0.15275
r16949 n9534 n9559 0.01175
r16950 n9535 n9560 0.016785714285714286
r16951 n9559 n9560 0.19975000000000001
r16952 n9536 n9561 0.039166666666666669
r16953 n9560 n9561 0.11750000000000001
r16954 n9537 n9562 0.039166666666666669
r16955 n9561 n9562 0.070499999999999993
r16956 n9538 n9563 0.058750000000000004
r16957 n9562 n9563 0.058750000000000004
r16958 n9539 n9564 0.010681818181818183
r16959 n9563 n9564 0.15275
r16960 n9540 n9565 0.0061842105263157894
r16961 n9564 n9565 0.35249999999999998
r16962 n9541 n9566 0.058750000000000004
r16963 n9565 n9566 0.24674999999999997
r16964 n9542 n9567 0.039166666666666669
r16965 n9566 n9567 0.058750000000000004
r16966 n9543 n9568 0.039166666666666669
r16967 n9567 n9568 0.070499999999999993
r16968 n9544 n9569 0.016785714285714286
r16969 n9568 n9569 0.11750000000000001
r16970 n9545 n9570 0.01175
r16971 n9569 n9570 0.19975000000000001
r16972 n9546 n9571 0.018799999999999997
r16973 n9547 n9572 0.026857142857142857
r16974 n9571 n9572 0.066583333333333342
r16975 n9548 n9573 0.062666666666666662
r16976 n9572 n9573 0.039166666666666669
r16977 n9549 n9574 0.062666666666666662
r16978 n9573 n9574 0.0235
r16979 n9550 n9575 0.094
r16980 n9574 n9575 0.019583333333333335
r16981 n9551 n9576 0.0235
r16982 n9575 n9576 0.039166666666666669
r16983 n9552 n9577 0.0085454545454545453
r16984 n9576 n9577 0.11749999999999999
r16985 n9553 n9578 0.094
r16986 n9577 n9578 0.094
r16987 n9554 n9579 0.062666666666666662
r16988 n9578 n9579 0.019583333333333335
r16989 n9555 n9580 0.062666666666666662
r16990 n9579 n9580 0.0235
r16991 n9556 n9581 0.047
r16992 n9580 n9581 0.027416666666666666
r16993 n9557 n9582 0.062666666666666662
r16994 n9581 n9582 0.027416666666666666
r16995 n9558 n9583 0.018799999999999997
r16996 n9582 n9583 0.050916666666666673
r16997 n9559 n9584 0.018799999999999997
r16998 n9560 n9585 0.026857142857142857
r16999 n9584 n9585 0.066583333333333342
r17000 n9561 n9586 0.062666666666666662
r17001 n9585 n9586 0.039166666666666669
r17002 n9562 n9587 0.062666666666666662
r17003 n9586 n9587 0.0235
r17004 n9563 n9588 0.094
r17005 n9587 n9588 0.019583333333333335
r17006 n9564 n9589 0.017090909090909091
r17007 n9588 n9589 0.050916666666666673
r17008 n9565 n9590 0.0098947368421052635
r17009 n9589 n9590 0.11749999999999999
r17010 n9566 n9591 0.094
r17011 n9590 n9591 0.08224999999999999
r17012 n9567 n9592 0.062666666666666662
r17013 n9591 n9592 0.019583333333333335
r17014 n9568 n9593 0.062666666666666662
r17015 n9592 n9593 0.0235
r17016 n9569 n9594 0.026857142857142857
r17017 n9593 n9594 0.039166666666666669
r17018 n9570 n9595 0.018799999999999997
r17019 n9594 n9595 0.066583333333333342
r17020 n9571 n9596 0.018799999999999997
r17021 n9572 n9597 0.026857142857142857
r17022 n9596 n9597 0.19975000000000001
r17023 n9573 n9598 0.062666666666666662
r17024 n9597 n9598 0.11750000000000001
r17025 n9574 n9599 0.062666666666666662
r17026 n9598 n9599 0.070499999999999993
r17027 n9575 n9600 0.094
r17028 n9599 n9600 0.058750000000000004
r17029 n9576 n9601 0.0235
r17030 n9600 n9601 0.11750000000000001
r17031 n9577 n9602 0.0085454545454545453
r17032 n9601 n9602 0.35249999999999998
r17033 n9578 n9603 0.094
r17034 n9602 n9603 0.28199999999999997
r17035 n9579 n9604 0.062666666666666662
r17036 n9603 n9604 0.058750000000000004
r17037 n9580 n9605 0.062666666666666662
r17038 n9604 n9605 0.070499999999999993
r17039 n9581 n9606 0.047
r17040 n9605 n9606 0.082250000000000004
r17041 n9582 n9607 0.062666666666666662
r17042 n9606 n9607 0.082250000000000004
r17043 n9583 n9608 0.018799999999999997
r17044 n9607 n9608 0.15275
r17045 n9584 n9609 0.018799999999999997
r17046 n9585 n9610 0.026857142857142857
r17047 n9609 n9610 0.19975000000000001
r17048 n9586 n9611 0.062666666666666662
r17049 n9610 n9611 0.11750000000000001
r17050 n9587 n9612 0.062666666666666662
r17051 n9611 n9612 0.070499999999999993
r17052 n9588 n9613 0.094
r17053 n9612 n9613 0.058750000000000004
r17054 n9589 n9614 0.017090909090909091
r17055 n9613 n9614 0.15275
r17056 n9590 n9615 0.0098947368421052635
r17057 n9614 n9615 0.35249999999999998
r17058 n9591 n9616 0.094
r17059 n9615 n9616 0.24674999999999997
r17060 n9592 n9617 0.062666666666666662
r17061 n9616 n9617 0.058750000000000004
r17062 n9593 n9618 0.062666666666666662
r17063 n9617 n9618 0.070499999999999993
r17064 n9594 n9619 0.026857142857142857
r17065 n9618 n9619 0.11750000000000001
r17066 n9595 n9620 0.018799999999999997
r17067 n9619 n9620 0.19975000000000001
r17068 n9596 n9621 0.01175
r17069 n9597 n9622 0.016785714285714286
r17070 n9621 n9622 0.13316666666666668
r17071 n9598 n9623 0.039166666666666669
r17072 n9622 n9623 0.078333333333333338
r17073 n9599 n9624 0.039166666666666669
r17074 n9623 n9624 0.047
r17075 n9600 n9625 0.058750000000000004
r17076 n9624 n9625 0.039166666666666669
r17077 n9601 n9626 0.014687500000000001
r17078 n9625 n9626 0.078333333333333338
r17079 n9602 n9627 0.0053409090909090915
r17080 n9626 n9627 0.23499999999999999
r17081 n9603 n9628 0.058750000000000004
r17082 n9627 n9628 0.188
r17083 n9604 n9629 0.039166666666666669
r17084 n9628 n9629 0.039166666666666669
r17085 n9605 n9630 0.039166666666666669
r17086 n9629 n9630 0.047
r17087 n9606 n9631 0.029375000000000002
r17088 n9630 n9631 0.054833333333333331
r17089 n9607 n9632 0.039166666666666669
r17090 n9631 n9632 0.054833333333333331
r17091 n9608 n9633 0.01175
r17092 n9632 n9633 0.10183333333333335
r17093 n9609 n9634 0.01175
r17094 n9610 n9635 0.016785714285714286
r17095 n9634 n9635 0.13316666666666668
r17096 n9611 n9636 0.039166666666666669
r17097 n9635 n9636 0.078333333333333338
r17098 n9612 n9637 0.039166666666666669
r17099 n9636 n9637 0.047
r17100 n9613 n9638 0.058750000000000004
r17101 n9637 n9638 0.039166666666666669
r17102 n9614 n9639 0.010681818181818183
r17103 n9638 n9639 0.10183333333333335
r17104 n9615 n9640 0.0061842105263157894
r17105 n9639 n9640 0.23499999999999999
r17106 n9616 n9641 0.058750000000000004
r17107 n9640 n9641 0.16449999999999998
r17108 n9617 n9642 0.039166666666666669
r17109 n9641 n9642 0.039166666666666669
r17110 n9618 n9643 0.039166666666666669
r17111 n9642 n9643 0.047
r17112 n9619 n9644 0.016785714285714286
r17113 n9643 n9644 0.078333333333333338
r17114 n9620 n9645 0.01175
r17115 n9644 n9645 0.13316666666666668
r17116 n9621 n9646 0.016449999999999999
r17117 n9622 n9647 0.0235
r17118 n9646 n9647 0.099875000000000005
r17119 n9623 n9648 0.054833333333333331
r17120 n9647 n9648 0.058750000000000004
r17121 n9624 n9649 0.054833333333333331
r17122 n9648 n9649 0.035249999999999997
r17123 n9625 n9650 0.082250000000000004
r17124 n9649 n9650 0.029375000000000002
r17125 n9626 n9651 0.020562500000000001
r17126 n9650 n9651 0.058750000000000004
r17127 n9627 n9652 0.0074772727272727274
r17128 n9651 n9652 0.17624999999999999
r17129 n9628 n9653 0.082250000000000004
r17130 n9652 n9653 0.14099999999999999
r17131 n9629 n9654 0.054833333333333331
r17132 n9653 n9654 0.029375000000000002
r17133 n9630 n9655 0.054833333333333331
r17134 n9654 n9655 0.035249999999999997
r17135 n9631 n9656 0.041125000000000002
r17136 n9655 n9656 0.041125000000000002
r17137 n9632 n9657 0.054833333333333331
r17138 n9656 n9657 0.041125000000000002
r17139 n9633 n9658 0.016449999999999999
r17140 n9657 n9658 0.076374999999999998
r17141 n9634 n9659 0.016449999999999999
r17142 n9635 n9660 0.0235
r17143 n9659 n9660 0.099875000000000005
r17144 n9636 n9661 0.054833333333333331
r17145 n9660 n9661 0.058750000000000004
r17146 n9637 n9662 0.054833333333333331
r17147 n9661 n9662 0.035249999999999997
r17148 n9638 n9663 0.082250000000000004
r17149 n9662 n9663 0.029375000000000002
r17150 n9639 n9664 0.014954545454545455
r17151 n9663 n9664 0.076374999999999998
r17152 n9640 n9665 0.0086578947368421057
r17153 n9664 n9665 0.17624999999999999
r17154 n9641 n9666 0.082250000000000004
r17155 n9665 n9666 0.12337499999999998
r17156 n9642 n9667 0.054833333333333331
r17157 n9666 n9667 0.029375000000000002
r17158 n9643 n9668 0.054833333333333331
r17159 n9667 n9668 0.035249999999999997
r17160 n9644 n9669 0.0235
r17161 n9668 n9669 0.058750000000000004
r17162 n9645 n9670 0.016449999999999999
r17163 n9669 n9670 0.099875000000000005
r17164 n9646 n9671 0.016449999999999999
r17165 n9647 n9672 0.0235
r17166 n9671 n9672 0.13316666666666668
r17167 n9648 n9673 0.054833333333333331
r17168 n9672 n9673 0.078333333333333338
r17169 n9649 n9674 0.054833333333333331
r17170 n9673 n9674 0.047
r17171 n9650 n9675 0.082250000000000004
r17172 n9674 n9675 0.039166666666666669
r17173 n9651 n9676 0.020562500000000001
r17174 n9675 n9676 0.078333333333333338
r17175 n9652 n9677 0.0074772727272727274
r17176 n9676 n9677 0.23499999999999999
r17177 n9653 n9678 0.082250000000000004
r17178 n9677 n9678 0.188
r17179 n9654 n9679 0.054833333333333331
r17180 n9678 n9679 0.039166666666666669
r17181 n9655 n9680 0.054833333333333331
r17182 n9679 n9680 0.047
r17183 n9656 n9681 0.041125000000000002
r17184 n9680 n9681 0.054833333333333331
r17185 n9657 n9682 0.054833333333333331
r17186 n9681 n9682 0.054833333333333331
r17187 n9658 n9683 0.016449999999999999
r17188 n9682 n9683 0.10183333333333335
r17189 n9659 n9684 0.016449999999999999
r17190 n9660 n9685 0.0235
r17191 n9684 n9685 0.13316666666666668
r17192 n9661 n9686 0.054833333333333331
r17193 n9685 n9686 0.078333333333333338
r17194 n9662 n9687 0.054833333333333331
r17195 n9686 n9687 0.047
r17196 n9663 n9688 0.082250000000000004
r17197 n9687 n9688 0.039166666666666669
r17198 n9664 n9689 0.014954545454545455
r17199 n9688 n9689 0.10183333333333335
r17200 n9665 n9690 0.0086578947368421057
r17201 n9689 n9690 0.23499999999999999
r17202 n9666 n9691 0.082250000000000004
r17203 n9690 n9691 0.16449999999999998
r17204 n9667 n9692 0.054833333333333331
r17205 n9691 n9692 0.039166666666666669
r17206 n9668 n9693 0.054833333333333331
r17207 n9692 n9693 0.047
r17208 n9669 n9694 0.0235
r17209 n9693 n9694 0.078333333333333338
r17210 n9670 n9695 0.016449999999999999
r17211 n9694 n9695 0.13316666666666668
r17212 n21 0 158.10000000000002
r17213 n22 0 10.540000000000001
r17214 n23 0 158.10000000000002
r17215 n363 n2897 158.10000000000002
r17216 n364 n2898 10.540000000000001
r17217 n365 n2899 158.10000000000002
r17218 n900 n3278 167.98125000000002
r17219 n901 n3279 2687.7000000000003
r17220 n1015 n3385 67.192499999999995
r17221 n1016 n3386 1075.0799999999999
r17222 n1130 n3492 22.397500000000004
r17223 n1131 n3493 358.36000000000007
r17224 n1245 n3599 111.98750000000001
r17225 n1246 n3600 1791.8000000000002
r17226 n1360 n3706 83.990625000000009
r17227 n1361 n3707 1343.8500000000001
r17228 n1475 n3829 111.98750000000001
r17229 n1476 n3830 1791.8000000000002
r17230 n1598 n3952 167.98125000000002
r17231 n1599 n3953 2687.7000000000003
r17232 n1829 n4649 167.98125000000002
r17233 n1830 n4650 2687.7000000000003
r17234 n1952 n4781 111.98750000000001
r17235 n1953 n4782 1791.8000000000002
r17236 n2075 n4904 83.990625000000009
r17237 n2076 n4905 1343.8500000000001
r17238 n2190 n5027 111.98750000000001
r17239 n2191 n5028 1791.8000000000002
r17240 n2305 n5134 22.397500000000004
r17241 n2306 n5135 358.36000000000007
r17242 n2420 n5241 67.192499999999995
r17243 n2421 n5242 1075.0799999999999
r17244 n2535 n5348 167.98125000000002
r17245 n2536 n5349 2687.7000000000003
r17246 n904 n3282 413.49230769230769
r17247 n905 n3283 447.95000000000005
r17248 n906 n3284 767.91428571428582
r17249 n907 n3285 2687.7000000000003
r17250 n1019 n3389 165.39692307692309
r17251 n1020 n3390 179.18000000000004
r17252 n1021 n3391 307.16571428571433
r17253 n1022 n3392 1075.0799999999999
r17254 n1134 n3496 55.132307692307698
r17255 n1135 n3497 59.726666666666674
r17256 n1136 n3498 102.38857142857144
r17257 n1137 n3499 358.36000000000007
r17258 n1249 n3603 275.66153846153844
r17259 n1250 n3604 298.63333333333338
r17260 n1251 n3605 511.94285714285718
r17261 n1252 n3606 1791.8000000000002
r17262 n1364 n3710 206.74615384615385
r17263 n1365 n3711 223.97500000000002
r17264 n1366 n3712 383.95714285714291
r17265 n1367 n3713 1343.8500000000001
r17266 n1479 n3833 275.66153846153844
r17267 n1480 n3834 298.63333333333338
r17268 n1481 n3835 511.94285714285718
r17269 n1482 n3836 1791.8000000000002
r17270 n1602 n3956 413.49230769230769
r17271 n1603 n3957 447.95000000000005
r17272 n1604 n3958 767.91428571428582
r17273 n1605 n3959 2687.7000000000003
r17274 n1833 n4653 413.49230769230769
r17275 n1834 n4654 447.95000000000005
r17276 n1835 n4655 767.91428571428582
r17277 n1836 n4656 2687.7000000000003
r17278 n1956 n4785 275.66153846153844
r17279 n1957 n4786 298.63333333333338
r17280 n1958 n4787 511.94285714285718
r17281 n1959 n4788 1791.8000000000002
r17282 n2079 n4908 206.74615384615385
r17283 n2080 n4909 223.97500000000002
r17284 n2081 n4910 383.95714285714291
r17285 n2082 n4911 1343.8500000000001
r17286 n2194 n5031 275.66153846153844
r17287 n2195 n5032 298.63333333333338
r17288 n2196 n5033 511.94285714285718
r17289 n2197 n5034 1791.8000000000002
r17290 n2309 n5138 55.132307692307698
r17291 n2310 n5139 59.726666666666674
r17292 n2311 n5140 102.38857142857144
r17293 n2312 n5141 358.36000000000007
r17294 n2424 n5245 165.39692307692309
r17295 n2425 n5246 179.18000000000004
r17296 n2426 n5247 307.16571428571433
r17297 n2427 n5248 1075.0799999999999
r17298 n2539 n5352 413.49230769230769
r17299 n2540 n5353 447.95000000000005
r17300 n2541 n5354 767.91428571428582
r17301 n2542 n5355 2687.7000000000003
r17302 n416 n3024 2687.7000000000003
r17303 n417 n3025 597.26666666666677
r17304 n418 n3026 447.95000000000005
r17305 n419 n3027 597.26666666666677
r17306 n420 n3028 2687.7000000000003
r17307 n572 n3045 179.18000000000004
r17308 n573 n3046 39.817777777777778
r17309 n574 n3047 29.863333333333337
r17310 n575 n3048 39.817777777777778
r17311 n576 n3049 179.18000000000004
r17312 n728 n3066 2687.7000000000003
r17313 n729 n3067 597.26666666666677
r17314 n730 n3068 447.95000000000005
r17315 n731 n3069 597.26666666666677
r17316 n732 n3070 2687.7000000000003
r17317 n913 n3291 597.26666666666677
r17318 n914 n3292 447.95000000000005
r17319 n915 n3293 597.26666666666677
r17320 n916 n3294 2687.7000000000003
r17321 n917 n3295 2687.7000000000003
r17322 n1028 n3398 238.90666666666669
r17323 n1029 n3399 179.18000000000004
r17324 n1030 n3400 238.90666666666669
r17325 n1031 n3401 1075.0799999999999
r17326 n1032 n3402 1075.0799999999999
r17327 n1143 n3505 79.635555555555555
r17328 n1144 n3506 59.726666666666674
r17329 n1145 n3507 79.635555555555555
r17330 n1146 n3508 358.36000000000007
r17331 n1147 n3509 358.36000000000007
r17332 n1258 n3612 398.17777777777781
r17333 n1259 n3613 298.63333333333338
r17334 n1260 n3614 398.17777777777781
r17335 n1261 n3615 1791.8000000000002
r17336 n1262 n3616 1791.8000000000002
r17337 n1373 n3719 298.63333333333338
r17338 n1374 n3720 223.97500000000002
r17339 n1375 n3721 298.63333333333338
r17340 n1376 n3722 1343.8500000000001
r17341 n1377 n3723 1343.8500000000001
r17342 n1488 n3842 398.17777777777781
r17343 n1489 n3843 298.63333333333338
r17344 n1490 n3844 398.17777777777781
r17345 n1491 n3845 1791.8000000000002
r17346 n1492 n3846 1791.8000000000002
r17347 n1611 n3965 597.26666666666677
r17348 n1612 n3966 447.95000000000005
r17349 n1613 n3967 597.26666666666677
r17350 n1614 n3968 2687.7000000000003
r17351 n1615 n3969 2687.7000000000003
r17352 n1842 n4662 597.26666666666677
r17353 n1843 n4663 447.95000000000005
r17354 n1844 n4664 597.26666666666677
r17355 n1845 n4665 2687.7000000000003
r17356 n1846 n4666 2687.7000000000003
r17357 n1965 n4794 398.17777777777781
r17358 n1966 n4795 298.63333333333338
r17359 n1967 n4796 398.17777777777781
r17360 n1968 n4797 1791.8000000000002
r17361 n1969 n4798 1791.8000000000002
r17362 n2088 n4917 298.63333333333338
r17363 n2089 n4918 223.97500000000002
r17364 n2090 n4919 298.63333333333338
r17365 n2091 n4920 1343.8500000000001
r17366 n2092 n4921 1343.8500000000001
r17367 n2203 n5040 398.17777777777781
r17368 n2204 n5041 298.63333333333338
r17369 n2205 n5042 398.17777777777781
r17370 n2206 n5043 1791.8000000000002
r17371 n2207 n5044 1791.8000000000002
r17372 n2318 n5147 79.635555555555555
r17373 n2319 n5148 59.726666666666674
r17374 n2320 n5149 79.635555555555555
r17375 n2321 n5150 358.36000000000007
r17376 n2322 n5151 358.36000000000007
r17377 n2433 n5254 238.90666666666669
r17378 n2434 n5255 179.18000000000004
r17379 n2435 n5256 238.90666666666669
r17380 n2436 n5257 1075.0799999999999
r17381 n2437 n5258 1075.0799999999999
r17382 n2548 n5361 597.26666666666677
r17383 n2549 n5362 447.95000000000005
r17384 n2550 n5363 597.26666666666677
r17385 n2551 n5364 2687.7000000000003
r17386 n2552 n5365 2687.7000000000003
r17387 n921 n3299 167.98125000000002
r17388 n922 n3300 2687.7000000000003
r17389 n1036 n3406 67.192499999999995
r17390 n1037 n3407 1075.0799999999999
r17391 n1151 n3513 22.397500000000004
r17392 n1152 n3514 358.36000000000007
r17393 n1266 n3620 111.98750000000001
r17394 n1267 n3621 1791.8000000000002
r17395 n1381 n3727 83.990625000000009
r17396 n1382 n3728 1343.8500000000001
r17397 n1496 n3850 111.98750000000001
r17398 n1497 n3851 1791.8000000000002
r17399 n1619 n3973 167.98125000000002
r17400 n1620 n3974 2687.7000000000003
r17401 n1850 n4670 167.98125000000002
r17402 n1851 n4671 2687.7000000000003
r17403 n1973 n4802 111.98750000000001
r17404 n1974 n4803 1791.8000000000002
r17405 n2096 n4925 83.990625000000009
r17406 n2097 n4926 1343.8500000000001
r17407 n2211 n5048 111.98750000000001
r17408 n2212 n5049 1791.8000000000002
r17409 n2326 n5155 22.397500000000004
r17410 n2327 n5156 358.36000000000007
r17411 n2441 n5262 67.192499999999995
r17412 n2442 n5263 1075.0799999999999
r17413 n2556 n5369 167.98125000000002
r17414 n2557 n5370 2687.7000000000003
r17415 n1754 n4320 2687.7000000000003
r17416 n1755 n4321 671.92500000000007
r17417 n1756 n4322 244.33636363636364
r17418 n1757 n4323 2687.7000000000003
r17419 n1766 n4356 179.18000000000004
r17420 n1767 n4357 44.795000000000009
r17421 n1768 n4358 16.289090909090913
r17422 n1769 n4359 179.18000000000004
r17423 n1778 n4391 2687.7000000000003
r17424 n1779 n4392 671.92500000000007
r17425 n1780 n4393 244.33636363636364
r17426 n1781 n4394 2687.7000000000003
r17427 n930 n3304 167.98125000000002
r17428 n931 n3305 2687.7000000000003
r17429 n1045 n3411 67.192499999999995
r17430 n1046 n3412 1075.0799999999999
r17431 n1160 n3518 22.397500000000004
r17432 n1161 n3519 358.36000000000007
r17433 n1275 n3625 111.98750000000001
r17434 n1276 n3626 1791.8000000000002
r17435 n1390 n3740 83.990625000000009
r17436 n1391 n3741 1343.8500000000001
r17437 n1509 n3863 111.98750000000001
r17438 n1510 n3864 1791.8000000000002
r17439 n1632 n3991 167.98125000000002
r17440 n1633 n3992 2687.7000000000003
r17441 n1863 n4688 167.98125000000002
r17442 n1864 n4689 2687.7000000000003
r17443 n1986 n4815 111.98750000000001
r17444 n1987 n4816 1791.8000000000002
r17445 n2105 n4938 83.990625000000009
r17446 n2106 n4939 1343.8500000000001
r17447 n2220 n5053 111.98750000000001
r17448 n2221 n5054 1791.8000000000002
r17449 n2335 n5160 22.397500000000004
r17450 n2336 n5161 358.36000000000007
r17451 n2450 n5267 67.192499999999995
r17452 n2451 n5268 1075.0799999999999
r17453 n2565 n5374 167.98125000000002
r17454 n2566 n5375 2687.7000000000003
r17455 n934 n3308 167.98125000000002
r17456 n935 n3309 2687.7000000000003
r17457 n1049 n3415 67.192499999999995
r17458 n1050 n3416 1075.0799999999999
r17459 n1164 n3522 22.397500000000004
r17460 n1165 n3523 358.36000000000007
r17461 n1279 n3629 111.98750000000001
r17462 n1280 n3630 1791.8000000000002
r17463 n1394 n3744 83.990625000000009
r17464 n1395 n3745 1343.8500000000001
r17465 n1513 n3867 111.98750000000001
r17466 n1514 n3868 1791.8000000000002
r17467 n1636 n3995 167.98125000000002
r17468 n1637 n3996 2687.7000000000003
r17469 n1867 n4692 167.98125000000002
r17470 n1868 n4693 2687.7000000000003
r17471 n1990 n4819 111.98750000000001
r17472 n1991 n4820 1791.8000000000002
r17473 n2109 n4942 83.990625000000009
r17474 n2110 n4943 1343.8500000000001
r17475 n2224 n5057 111.98750000000001
r17476 n2225 n5058 1791.8000000000002
r17477 n2339 n5164 22.397500000000004
r17478 n2340 n5165 358.36000000000007
r17479 n2454 n5271 67.192499999999995
r17480 n2455 n5272 1075.0799999999999
r17481 n2569 n5378 167.98125000000002
r17482 n2570 n5379 2687.7000000000003
r17483 n938 n3312 167.98125000000002
r17484 n939 n3313 2687.7000000000003
r17485 n1053 n3419 67.192499999999995
r17486 n1054 n3420 1075.0799999999999
r17487 n1168 n3526 22.397500000000004
r17488 n1169 n3527 358.36000000000007
r17489 n1283 n3633 111.98750000000001
r17490 n1284 n3634 1791.8000000000002
r17491 n1398 n3748 83.990625000000009
r17492 n1399 n3749 1343.8500000000001
r17493 n1517 n3871 111.98750000000001
r17494 n1518 n3872 1791.8000000000002
r17495 n1640 n3999 167.98125000000002
r17496 n1641 n4000 2687.7000000000003
r17497 n1871 n4696 167.98125000000002
r17498 n1872 n4697 2687.7000000000003
r17499 n1994 n4823 111.98750000000001
r17500 n1995 n4824 1791.8000000000002
r17501 n2113 n4946 83.990625000000009
r17502 n2114 n4947 1343.8500000000001
r17503 n2228 n5061 111.98750000000001
r17504 n2229 n5062 1791.8000000000002
r17505 n2343 n5168 22.397500000000004
r17506 n2344 n5169 358.36000000000007
r17507 n2458 n5275 67.192499999999995
r17508 n2459 n5276 1075.0799999999999
r17509 n2573 n5382 167.98125000000002
r17510 n2574 n5383 2687.7000000000003
r17511 n942 n3316 167.98125000000002
r17512 n943 n3317 2687.7000000000003
r17513 n1057 n3423 67.192499999999995
r17514 n1058 n3424 1075.0799999999999
r17515 n1172 n3530 22.397500000000004
r17516 n1173 n3531 358.36000000000007
r17517 n1287 n3637 111.98750000000001
r17518 n1288 n3638 1791.8000000000002
r17519 n1402 n3752 83.990625000000009
r17520 n1403 n3753 1343.8500000000001
r17521 n1521 n3875 111.98750000000001
r17522 n1522 n3876 1791.8000000000002
r17523 n1644 n4003 167.98125000000002
r17524 n1645 n4004 2687.7000000000003
r17525 n1875 n4700 167.98125000000002
r17526 n1876 n4701 2687.7000000000003
r17527 n1998 n4827 111.98750000000001
r17528 n1999 n4828 1791.8000000000002
r17529 n2117 n4950 83.990625000000009
r17530 n2118 n4951 1343.8500000000001
r17531 n2232 n5065 111.98750000000001
r17532 n2233 n5066 1791.8000000000002
r17533 n2347 n5172 22.397500000000004
r17534 n2348 n5173 358.36000000000007
r17535 n2462 n5279 67.192499999999995
r17536 n2463 n5280 1075.0799999999999
r17537 n2577 n5386 167.98125000000002
r17538 n2578 n5387 2687.7000000000003
r17539 n946 n3320 167.98125000000002
r17540 n947 n3321 2687.7000000000003
r17541 n1061 n3427 67.192499999999995
r17542 n1062 n3428 1075.0799999999999
r17543 n1176 n3534 22.397500000000004
r17544 n1177 n3535 358.36000000000007
r17545 n1291 n3641 111.98750000000001
r17546 n1292 n3642 1791.8000000000002
r17547 n1406 n3756 83.990625000000009
r17548 n1407 n3757 1343.8500000000001
r17549 n1525 n3879 111.98750000000001
r17550 n1526 n3880 1791.8000000000002
r17551 n1648 n4007 167.98125000000002
r17552 n1649 n4008 2687.7000000000003
r17553 n1879 n4704 167.98125000000002
r17554 n1880 n4705 2687.7000000000003
r17555 n2002 n4831 111.98750000000001
r17556 n2003 n4832 1791.8000000000002
r17557 n2121 n4954 83.990625000000009
r17558 n2122 n4955 1343.8500000000001
r17559 n2236 n5069 111.98750000000001
r17560 n2237 n5070 1791.8000000000002
r17561 n2351 n5176 22.397500000000004
r17562 n2352 n5177 358.36000000000007
r17563 n2466 n5283 67.192499999999995
r17564 n2467 n5284 1075.0799999999999
r17565 n2581 n5390 167.98125000000002
r17566 n2582 n5391 2687.7000000000003
r17567 n950 n3324 167.98125000000002
r17568 n951 n3325 2687.7000000000003
r17569 n1065 n3431 67.192499999999995
r17570 n1066 n3432 1075.0799999999999
r17571 n1180 n3538 22.397500000000004
r17572 n1181 n3539 358.36000000000007
r17573 n1295 n3645 111.98750000000001
r17574 n1296 n3646 1791.8000000000002
r17575 n1410 n3760 83.990625000000009
r17576 n1411 n3761 1343.8500000000001
r17577 n1529 n3883 111.98750000000001
r17578 n1530 n3884 1791.8000000000002
r17579 n1652 n4011 167.98125000000002
r17580 n1653 n4012 2687.7000000000003
r17581 n1883 n4708 167.98125000000002
r17582 n1884 n4709 2687.7000000000003
r17583 n2006 n4835 111.98750000000001
r17584 n2007 n4836 1791.8000000000002
r17585 n2125 n4958 83.990625000000009
r17586 n2126 n4959 1343.8500000000001
r17587 n2240 n5073 111.98750000000001
r17588 n2241 n5074 1791.8000000000002
r17589 n2355 n5180 22.397500000000004
r17590 n2356 n5181 358.36000000000007
r17591 n2470 n5287 67.192499999999995
r17592 n2471 n5288 1075.0799999999999
r17593 n2585 n5394 167.98125000000002
r17594 n2586 n5395 2687.7000000000003
r17595 n954 n3328 167.98125000000002
r17596 n955 n3329 2687.7000000000003
r17597 n1069 n3435 67.192499999999995
r17598 n1070 n3436 1075.0799999999999
r17599 n1184 n3542 22.397500000000004
r17600 n1185 n3543 358.36000000000007
r17601 n1299 n3649 111.98750000000001
r17602 n1300 n3650 1791.8000000000002
r17603 n1414 n3764 83.990625000000009
r17604 n1415 n3765 1343.8500000000001
r17605 n1533 n3887 111.98750000000001
r17606 n1534 n3888 1791.8000000000002
r17607 n1656 n4015 167.98125000000002
r17608 n1657 n4016 2687.7000000000003
r17609 n1887 n4712 167.98125000000002
r17610 n1888 n4713 2687.7000000000003
r17611 n2010 n4839 111.98750000000001
r17612 n2011 n4840 1791.8000000000002
r17613 n2129 n4962 83.990625000000009
r17614 n2130 n4963 1343.8500000000001
r17615 n2244 n5077 111.98750000000001
r17616 n2245 n5078 1791.8000000000002
r17617 n2359 n5184 22.397500000000004
r17618 n2360 n5185 358.36000000000007
r17619 n2474 n5291 67.192499999999995
r17620 n2475 n5292 1075.0799999999999
r17621 n2589 n5398 167.98125000000002
r17622 n2590 n5399 2687.7000000000003
r17623 n958 n3332 167.98125000000002
r17624 n959 n3333 2687.7000000000003
r17625 n1073 n3439 67.192499999999995
r17626 n1074 n3440 1075.0799999999999
r17627 n1188 n3546 22.397500000000004
r17628 n1189 n3547 358.36000000000007
r17629 n1303 n3653 111.98750000000001
r17630 n1304 n3654 1791.8000000000002
r17631 n1418 n3768 83.990625000000009
r17632 n1419 n3769 1343.8500000000001
r17633 n1537 n3891 111.98750000000001
r17634 n1538 n3892 1791.8000000000002
r17635 n1660 n4019 167.98125000000002
r17636 n1661 n4020 2687.7000000000003
r17637 n1891 n4716 167.98125000000002
r17638 n1892 n4717 2687.7000000000003
r17639 n2014 n4843 111.98750000000001
r17640 n2015 n4844 1791.8000000000002
r17641 n2133 n4966 83.990625000000009
r17642 n2134 n4967 1343.8500000000001
r17643 n2248 n5081 111.98750000000001
r17644 n2249 n5082 1791.8000000000002
r17645 n2363 n5188 22.397500000000004
r17646 n2364 n5189 358.36000000000007
r17647 n2478 n5295 67.192499999999995
r17648 n2479 n5296 1075.0799999999999
r17649 n2593 n5402 167.98125000000002
r17650 n2594 n5403 2687.7000000000003
r17651 n964 n3338 2687.7000000000003
r17652 n965 n3339 671.92500000000007
r17653 n966 n3340 244.33636363636364
r17654 n967 n3341 5375.4000000000005
r17655 n968 n3342 5375.4000000000005
r17656 n1079 n3445 1075.0799999999999
r17657 n1080 n3446 268.76999999999998
r17658 n1081 n3447 97.734545454545454
r17659 n1082 n3448 2150.1599999999999
r17660 n1083 n3449 2150.1599999999999
r17661 n1194 n3552 358.36000000000007
r17662 n1195 n3553 89.590000000000018
r17663 n1196 n3554 32.578181818181825
r17664 n1197 n3555 716.72000000000014
r17665 n1198 n3556 716.72000000000014
r17666 n1309 n3659 1791.8000000000002
r17667 n1310 n3660 447.95000000000005
r17668 n1311 n3661 162.8909090909091
r17669 n1312 n3662 3583.6000000000004
r17670 n1313 n3663 3583.6000000000004
r17671 n1424 n3774 1343.8500000000001
r17672 n1425 n3775 335.96250000000003
r17673 n1426 n3776 122.16818181818182
r17674 n1427 n3777 2687.7000000000003
r17675 n1428 n3778 2687.7000000000003
r17676 n1543 n3897 1791.8000000000002
r17677 n1544 n3898 447.95000000000005
r17678 n1545 n3899 162.8909090909091
r17679 n1546 n3900 3583.6000000000004
r17680 n1547 n3901 3583.6000000000004
r17681 n1666 n4025 2687.7000000000003
r17682 n1667 n4026 671.92500000000007
r17683 n1668 n4027 244.33636363636364
r17684 n1669 n4028 5375.4000000000005
r17685 n1670 n4029 5375.4000000000005
r17686 n1897 n4722 2687.7000000000003
r17687 n1898 n4723 671.92500000000007
r17688 n1899 n4724 244.33636363636364
r17689 n1900 n4725 5375.4000000000005
r17690 n1901 n4726 5375.4000000000005
r17691 n2020 n4849 1791.8000000000002
r17692 n2021 n4850 447.95000000000005
r17693 n2022 n4851 162.8909090909091
r17694 n2023 n4852 3583.6000000000004
r17695 n2024 n4853 3583.6000000000004
r17696 n2139 n4972 1343.8500000000001
r17697 n2140 n4973 335.96250000000003
r17698 n2141 n4974 122.16818181818182
r17699 n2142 n4975 2687.7000000000003
r17700 n2143 n4976 2687.7000000000003
r17701 n2254 n5087 1791.8000000000002
r17702 n2255 n5088 447.95000000000005
r17703 n2256 n5089 162.8909090909091
r17704 n2257 n5090 3583.6000000000004
r17705 n2258 n5091 3583.6000000000004
r17706 n2369 n5194 358.36000000000007
r17707 n2370 n5195 89.590000000000018
r17708 n2371 n5196 32.578181818181825
r17709 n2372 n5197 716.72000000000014
r17710 n2373 n5198 716.72000000000014
r17711 n2484 n5301 1075.0799999999999
r17712 n2485 n5302 268.76999999999998
r17713 n2486 n5303 97.734545454545454
r17714 n2487 n5304 2150.1599999999999
r17715 n2488 n5305 2150.1599999999999
r17716 n2599 n5408 2687.7000000000003
r17717 n2600 n5409 671.92500000000007
r17718 n2601 n5410 244.33636363636364
r17719 n2602 n5411 5375.4000000000005
r17720 n2603 n5412 5375.4000000000005
r17721 n493 n3033 5375.4000000000005
r17722 n494 n3034 5375.4000000000005
r17723 n495 n3035 537.53999999999996
r17724 n496 n3036 447.95000000000005
r17725 n497 n3037 671.92500000000007
r17726 n498 n3038 2687.7000000000003
r17727 n649 n3054 358.36000000000007
r17728 n650 n3055 358.36000000000007
r17729 n651 n3056 35.836000000000006
r17730 n652 n3057 29.863333333333337
r17731 n653 n3058 44.795000000000009
r17732 n654 n3059 179.18000000000004
r17733 n805 n3075 5375.4000000000005
r17734 n806 n3076 5375.4000000000005
r17735 n807 n3077 537.53999999999996
r17736 n808 n3078 447.95000000000005
r17737 n809 n3079 671.92500000000007
r17738 n810 n3080 2687.7000000000003
r17739 n976 n3350 895.90000000000009
r17740 n977 n3351 447.95000000000005
r17741 n978 n3352 383.95714285714291
r17742 n979 n3353 2687.7000000000003
r17743 n1091 n3457 358.36000000000007
r17744 n1092 n3458 179.18000000000004
r17745 n1093 n3459 153.58285714285716
r17746 n1094 n3460 1075.0799999999999
r17747 n1206 n3564 119.45333333333335
r17748 n1207 n3565 59.726666666666674
r17749 n1208 n3566 51.194285714285719
r17750 n1209 n3567 358.36000000000007
r17751 n1321 n3671 597.26666666666677
r17752 n1322 n3672 298.63333333333338
r17753 n1323 n3673 255.97142857142859
r17754 n1324 n3674 1791.8000000000002
r17755 n1436 n3786 447.95000000000005
r17756 n1437 n3787 223.97500000000002
r17757 n1438 n3788 191.97857142857146
r17758 n1439 n3789 1343.8500000000001
r17759 n1555 n3909 597.26666666666677
r17760 n1556 n3910 298.63333333333338
r17761 n1557 n3911 255.97142857142859
r17762 n1558 n3912 1791.8000000000002
r17763 n1678 n4037 895.90000000000009
r17764 n1679 n4038 447.95000000000005
r17765 n1680 n4039 383.95714285714291
r17766 n1681 n4040 2687.7000000000003
r17767 n1909 n4734 895.90000000000009
r17768 n1910 n4735 447.95000000000005
r17769 n1911 n4736 383.95714285714291
r17770 n1912 n4737 2687.7000000000003
r17771 n2032 n4861 597.26666666666677
r17772 n2033 n4862 298.63333333333338
r17773 n2034 n4863 255.97142857142859
r17774 n2035 n4864 1791.8000000000002
r17775 n2151 n4984 447.95000000000005
r17776 n2152 n4985 223.97500000000002
r17777 n2153 n4986 191.97857142857146
r17778 n2154 n4987 1343.8500000000001
r17779 n2266 n5099 597.26666666666677
r17780 n2267 n5100 298.63333333333338
r17781 n2268 n5101 255.97142857142859
r17782 n2269 n5102 1791.8000000000002
r17783 n2381 n5206 119.45333333333335
r17784 n2382 n5207 59.726666666666674
r17785 n2383 n5208 51.194285714285719
r17786 n2384 n5209 358.36000000000007
r17787 n2496 n5313 358.36000000000007
r17788 n2497 n5314 179.18000000000004
r17789 n2498 n5315 153.58285714285716
r17790 n2499 n5316 1075.0799999999999
r17791 n2611 n5420 895.90000000000009
r17792 n2612 n5421 447.95000000000005
r17793 n2613 n5422 383.95714285714291
r17794 n2614 n5423 2687.7000000000003
r17795 n982 n3356 167.98125000000002
r17796 n983 n3357 2687.7000000000003
r17797 n1097 n3463 67.192499999999995
r17798 n1098 n3464 1075.0799999999999
r17799 n1212 n3570 22.397500000000004
r17800 n1213 n3571 358.36000000000007
r17801 n1327 n3677 111.98750000000001
r17802 n1328 n3678 1791.8000000000002
r17803 n1442 n3792 83.990625000000009
r17804 n1443 n3793 1343.8500000000001
r17805 n1561 n3915 111.98750000000001
r17806 n1562 n3916 1791.8000000000002
r17807 n1684 n4043 167.98125000000002
r17808 n1685 n4044 2687.7000000000003
r17809 n1915 n4740 167.98125000000002
r17810 n1916 n4741 2687.7000000000003
r17811 n2038 n4867 111.98750000000001
r17812 n2039 n4868 1791.8000000000002
r17813 n2157 n4990 83.990625000000009
r17814 n2158 n4991 1343.8500000000001
r17815 n2272 n5105 111.98750000000001
r17816 n2273 n5106 1791.8000000000002
r17817 n2387 n5212 22.397500000000004
r17818 n2388 n5213 358.36000000000007
r17819 n2502 n5319 67.192499999999995
r17820 n2503 n5320 1075.0799999999999
r17821 n2617 n5426 167.98125000000002
r17822 n2618 n5427 2687.7000000000003
r17823 n986 n3360 167.98125000000002
r17824 n987 n3361 2687.7000000000003
r17825 n1101 n3467 67.192499999999995
r17826 n1102 n3468 1075.0799999999999
r17827 n1216 n3574 22.397500000000004
r17828 n1217 n3575 358.36000000000007
r17829 n1331 n3681 111.98750000000001
r17830 n1332 n3682 1791.8000000000002
r17831 n1446 n3796 83.990625000000009
r17832 n1447 n3797 1343.8500000000001
r17833 n1565 n3919 111.98750000000001
r17834 n1566 n3920 1791.8000000000002
r17835 n1688 n4047 167.98125000000002
r17836 n1689 n4048 2687.7000000000003
r17837 n1919 n4744 167.98125000000002
r17838 n1920 n4745 2687.7000000000003
r17839 n2042 n4871 111.98750000000001
r17840 n2043 n4872 1791.8000000000002
r17841 n2161 n4994 83.990625000000009
r17842 n2162 n4995 1343.8500000000001
r17843 n2276 n5109 111.98750000000001
r17844 n2277 n5110 1791.8000000000002
r17845 n2391 n5216 22.397500000000004
r17846 n2392 n5217 358.36000000000007
r17847 n2506 n5323 67.192499999999995
r17848 n2507 n5324 1075.0799999999999
r17849 n2621 n5430 167.98125000000002
r17850 n2622 n5431 2687.7000000000003
r17851 n990 n3364 167.98125000000002
r17852 n991 n3365 2687.7000000000003
r17853 n1105 n3471 67.192499999999995
r17854 n1106 n3472 1075.0799999999999
r17855 n1220 n3578 22.397500000000004
r17856 n1221 n3579 358.36000000000007
r17857 n1335 n3685 111.98750000000001
r17858 n1336 n3686 1791.8000000000002
r17859 n1450 n3800 83.990625000000009
r17860 n1451 n3801 1343.8500000000001
r17861 n1569 n3923 111.98750000000001
r17862 n1570 n3924 1791.8000000000002
r17863 n1692 n4051 167.98125000000002
r17864 n1693 n4052 2687.7000000000003
r17865 n1923 n4748 167.98125000000002
r17866 n1924 n4749 2687.7000000000003
r17867 n2046 n4875 111.98750000000001
r17868 n2047 n4876 1791.8000000000002
r17869 n2165 n4998 83.990625000000009
r17870 n2166 n4999 1343.8500000000001
r17871 n2280 n5113 111.98750000000001
r17872 n2281 n5114 1791.8000000000002
r17873 n2395 n5220 22.397500000000004
r17874 n2396 n5221 358.36000000000007
r17875 n2510 n5327 67.192499999999995
r17876 n2511 n5328 1075.0799999999999
r17877 n2625 n5434 167.98125000000002
r17878 n2626 n5435 2687.7000000000003
r17879 n994 n3368 167.98125000000002
r17880 n995 n3369 2687.7000000000003
r17881 n1109 n3475 67.192499999999995
r17882 n1110 n3476 1075.0799999999999
r17883 n1224 n3582 22.397500000000004
r17884 n1225 n3583 358.36000000000007
r17885 n1339 n3689 111.98750000000001
r17886 n1340 n3690 1791.8000000000002
r17887 n1454 n3804 83.990625000000009
r17888 n1455 n3805 1343.8500000000001
r17889 n1573 n3927 111.98750000000001
r17890 n1574 n3928 1791.8000000000002
r17891 n1696 n4055 167.98125000000002
r17892 n1697 n4056 2687.7000000000003
r17893 n1927 n4752 167.98125000000002
r17894 n1928 n4753 2687.7000000000003
r17895 n2050 n4879 111.98750000000001
r17896 n2051 n4880 1791.8000000000002
r17897 n2169 n5002 83.990625000000009
r17898 n2170 n5003 1343.8500000000001
r17899 n2284 n5117 111.98750000000001
r17900 n2285 n5118 1791.8000000000002
r17901 n2399 n5224 22.397500000000004
r17902 n2400 n5225 358.36000000000007
r17903 n2514 n5331 67.192499999999995
r17904 n2515 n5332 1075.0799999999999
r17905 n2629 n5438 167.98125000000002
r17906 n2630 n5439 2687.7000000000003
r17907 n998 n3372 167.98125000000002
r17908 n999 n3373 2687.7000000000003
r17909 n1113 n3479 67.192499999999995
r17910 n1114 n3480 1075.0799999999999
r17911 n1228 n3586 22.397500000000004
r17912 n1229 n3587 358.36000000000007
r17913 n1343 n3693 111.98750000000001
r17914 n1344 n3694 1791.8000000000002
r17915 n1458 n3808 83.990625000000009
r17916 n1459 n3809 1343.8500000000001
r17917 n1577 n3931 111.98750000000001
r17918 n1578 n3932 1791.8000000000002
r17919 n1700 n4059 167.98125000000002
r17920 n1701 n4060 2687.7000000000003
r17921 n1931 n4756 167.98125000000002
r17922 n1932 n4757 2687.7000000000003
r17923 n2054 n4883 111.98750000000001
r17924 n2055 n4884 1791.8000000000002
r17925 n2173 n5006 83.990625000000009
r17926 n2174 n5007 1343.8500000000001
r17927 n2288 n5121 111.98750000000001
r17928 n2289 n5122 1791.8000000000002
r17929 n2403 n5228 22.397500000000004
r17930 n2404 n5229 358.36000000000007
r17931 n2518 n5335 67.192499999999995
r17932 n2519 n5336 1075.0799999999999
r17933 n2633 n5442 167.98125000000002
r17934 n2634 n5443 2687.7000000000003
r17935 n1002 n3376 167.98125000000002
r17936 n1003 n3377 2687.7000000000003
r17937 n1117 n3483 67.192499999999995
r17938 n1118 n3484 1075.0799999999999
r17939 n1232 n3590 22.397500000000004
r17940 n1233 n3591 358.36000000000007
r17941 n1347 n3697 111.98750000000001
r17942 n1348 n3698 1791.8000000000002
r17943 n1462 n3812 83.990625000000009
r17944 n1463 n3813 1343.8500000000001
r17945 n1581 n3935 111.98750000000001
r17946 n1582 n3936 1791.8000000000002
r17947 n1704 n4063 167.98125000000002
r17948 n1705 n4064 2687.7000000000003
r17949 n1935 n4760 167.98125000000002
r17950 n1936 n4761 2687.7000000000003
r17951 n2058 n4887 111.98750000000001
r17952 n2059 n4888 1791.8000000000002
r17953 n2177 n5010 83.990625000000009
r17954 n2178 n5011 1343.8500000000001
r17955 n2292 n5125 111.98750000000001
r17956 n2293 n5126 1791.8000000000002
r17957 n2407 n5232 22.397500000000004
r17958 n2408 n5233 358.36000000000007
r17959 n2522 n5339 67.192499999999995
r17960 n2523 n5340 1075.0799999999999
r17961 n2637 n5446 167.98125000000002
r17962 n2638 n5447 2687.7000000000003
r17963 n1006 n3380 167.98125000000002
r17964 n1007 n3381 2687.7000000000003
r17965 n1121 n3487 67.192499999999995
r17966 n1122 n3488 1075.0799999999999
r17967 n1236 n3594 22.397500000000004
r17968 n1237 n3595 358.36000000000007
r17969 n1351 n3701 111.98750000000001
r17970 n1352 n3702 1791.8000000000002
r17971 n1466 n3816 83.990625000000009
r17972 n1467 n3817 1343.8500000000001
r17973 n1585 n3939 111.98750000000001
r17974 n1586 n3940 1791.8000000000002
r17975 n1708 n4067 167.98125000000002
r17976 n1709 n4068 2687.7000000000003
r17977 n1939 n4764 167.98125000000002
r17978 n1940 n4765 2687.7000000000003
r17979 n2062 n4891 111.98750000000001
r17980 n2063 n4892 1791.8000000000002
r17981 n2181 n5014 83.990625000000009
r17982 n2182 n5015 1343.8500000000001
r17983 n2296 n5129 111.98750000000001
r17984 n2297 n5130 1791.8000000000002
r17985 n2411 n5236 22.397500000000004
r17986 n2412 n5237 358.36000000000007
r17987 n2526 n5343 67.192499999999995
r17988 n2527 n5344 1075.0799999999999
r17989 n2641 n5450 167.98125000000002
r17990 n2642 n5451 2687.7000000000003
r17991 n1760 n4344 2687.7000000000003
r17992 n1761 n4345 488.67272727272729
r17993 n1762 n4346 282.91578947368424
r17994 n1763 n4347 2687.7000000000003
r17995 n1772 n4369 179.18000000000004
r17996 n1773 n4370 32.578181818181825
r17997 n1774 n4371 18.86105263157895
r17998 n1775 n4372 179.18000000000004
r17999 n1784 n4415 2687.7000000000003
r18000 n1785 n4416 488.67272727272729
r18001 n1786 n4417 282.91578947368424
r18002 n1787 n4418 2687.7000000000003
r18003 n30 vdd 158.10000000000002
r18004 n31 vdd 10.540000000000001
r18005 n32 vdd 158.10000000000002
r18006 n372 n2906 158.10000000000002
r18007 n373 n2907 10.540000000000001
r18008 n374 n2908 158.10000000000002
r18009 n2962 n5603 4.5
r18010 n3394 n6614 90
r18011 n3395 n6615 38.571428571428569
r18012 n3501 n6667 30
r18013 n3502 n6668 12.857142857142858
r18014 n3608 n6720 150
r18015 n3609 n6721 64.285714285714278
r18016 n3715 n6798 112.5
r18017 n3716 n6799 48.214285714285715
r18018 n3838 n6876 150
r18019 n3839 n6877 64.285714285714278
r18020 n4790 n7647 150
r18021 n4791 n7648 64.285714285714278
r18022 n4913 n7707 112.5
r18023 n4914 n7708 48.214285714285715
r18024 n5036 n7767 150
r18025 n5037 n7768 64.285714285714278
r18026 n5143 n7827 30
r18027 n5144 n7828 12.857142857142858
r18028 n5250 n7862 90
r18029 n5251 n7863 38.571428571428569
r18030 n3046 n6130 15
r18031 n3047 n6131 11.25
r18032 n3048 n6132 15
r18033 n4357 n7309 16.875
r18034 n4358 n7310 6.1363636363636367
r18035 n3446 n6624 101.25
r18036 n3447 n6625 36.81818181818182
r18037 n3553 n6677 33.75
r18038 n3554 n6678 12.272727272727273
r18039 n3660 n6743 168.75
r18040 n3661 n6744 61.363636363636367
r18041 n3775 n6821 126.5625
r18042 n3776 n6822 46.022727272727273
r18043 n3898 n6899 168.75
r18044 n3899 n6900 61.363636363636367
r18045 n4850 n7670 168.75
r18046 n4851 n7671 61.363636363636367
r18047 n4973 n7730 126.5625
r18048 n4974 n7731 46.022727272727273
r18049 n5088 n7790 168.75
r18050 n5089 n7791 61.363636363636367
r18051 n5195 n7837 33.75
r18052 n5196 n7838 12.272727272727273
r18053 n5302 n7872 101.25
r18054 n5303 n7873 36.81818181818182
r18055 n3056 n6144 13.5
r18056 n3057 n6145 11.25
r18057 n3058 n6146 16.875
r18058 n4370 n7322 12.272727272727273
r18059 n4371 n7323 7.1052631578947372
r18060 n2967 n5612 4.5
r18061 n7197 n9424 606.22222222222229
r18062 n7198 n9425 909.33333333333337
r18063 n7199 n9426 227.33333333333334
r18064 n7200 n9427 82.666666666666671
r18065 n7201 n9428 909.33333333333337
r18066 n7202 n9429 606.22222222222229
r18067 n7257 n9449 909.33333333333337
r18068 n7258 n9450 1364
r18069 n7259 n9451 341
r18070 n7260 n9452 124
r18071 n7261 n9453 1364
r18072 n7262 n9454 909.33333333333337
r18073 n7307 n9474 60.62222222222222
r18074 n7308 n9475 90.933333333333337
r18075 n7309 n9476 22.733333333333334
r18076 n7310 n9477 8.2666666666666675
r18077 n7311 n9478 90.933333333333337
r18078 n7312 n9479 60.62222222222222
r18079 n7356 n9499 909.33333333333337
r18080 n7357 n9500 1364
r18081 n7358 n9501 341
r18082 n7359 n9502 124
r18083 n7360 n9503 1364
r18084 n7361 n9504 909.33333333333337
r18085 n7416 n9524 606.22222222222229
r18086 n7417 n9525 909.33333333333337
r18087 n7418 n9526 227.33333333333334
r18088 n7419 n9527 82.666666666666671
r18089 n7420 n9528 909.33333333333337
r18090 n7421 n9529 606.22222222222229
r18091 n7221 n9437 606.22222222222229
r18092 n7222 n9438 909.33333333333337
r18093 n7223 n9439 165.33333333333334
r18094 n7224 n9440 95.719298245614041
r18095 n7225 n9441 909.33333333333337
r18096 n7226 n9442 606.22222222222229
r18097 n7281 n9462 909.33333333333337
r18098 n7282 n9463 1364
r18099 n7283 n9464 248
r18100 n7284 n9465 143.57894736842107
r18101 n7285 n9466 1364
r18102 n7286 n9467 909.33333333333337
r18103 n7320 n9487 60.62222222222222
r18104 n7321 n9488 90.933333333333337
r18105 n7322 n9489 16.533333333333335
r18106 n7323 n9490 9.5719298245614031
r18107 n7324 n9491 90.933333333333337
r18108 n7325 n9492 60.62222222222222
r18109 n7380 n9512 909.33333333333337
r18110 n7381 n9513 1364
r18111 n7382 n9514 248
r18112 n7383 n9515 143.57894736842107
r18113 n7384 n9516 1364
r18114 n7385 n9517 909.33333333333337
r18115 n7440 n9537 606.22222222222229
r18116 n7441 n9538 909.33333333333337
r18117 n7442 n9539 165.33333333333334
r18118 n7443 n9540 95.719298245614041
r18119 n7444 n9541 909.33333333333337
r18120 n7445 n9542 606.22222222222229
r18121 n880 t_m2_b 1420.7142857142858
r18122 n884 t_m2_b 9945
r18123 n888 t_m2_b 3978
r18124 n892 t_m2_b 3315
r18125 n896 t_m2_b 9945
r18126 n1011 t_m2_b 3978
r18127 n1753 t_m2_b 9945
r18128 n1765 t_m2_b 663
r18129 n1777 t_m2_b 9945
r18130 n2416 t_m2_b 3978
r18131 n2531 t_m2_b 9945
r18132 n2646 t_m2_b 3315
r18133 n2650 t_m2_b 2841.4285714285716
r18134 n2654 t_m2_b 1420.7142857142858
r18135 n399 t_m2_b 9945
r18136 n555 t_m2_b 663
r18137 n711 t_m2_b 9945
r18138 n2669 t_m2_b 585
r18139 n403 t_m2_b 169065
r18140 n404 t_m2_b 10566.5625
r18141 n559 t_m2_b 11271
r18142 n560 t_m2_b 704.4375
r18143 n715 t_m2_b 169065
r18144 n716 t_m2_b 10566.5625
r18145 n2673 t_m2_b 9945
r18146 n2674 t_m2_b 621.5625
r18147 n900 t_m2_s 3341.5625
r18148 n901 t_m2_s 53465
r18149 n1015 t_m2_s 1336.625
r18150 n1016 t_m2_s 21386
r18151 n1130 t_m2_s 445.54166666666669
r18152 n1131 t_m2_s 7128.666666666667
r18153 n1245 t_m2_s 2227.7083333333335
r18154 n1246 t_m2_s 35643.333333333336
r18155 n1360 t_m2_s 1670.78125
r18156 n1361 t_m2_s 26732.5
r18157 n1475 t_m2_s 2227.7083333333335
r18158 n1476 t_m2_s 35643.333333333336
r18159 n1598 t_m2_s 3341.5625
r18160 n1599 t_m2_s 53465
r18161 n1829 t_m2_d 3341.5625
r18162 n1830 t_m2_d 53465
r18163 n1952 t_m2_d 2227.7083333333335
r18164 n1953 t_m2_d 35643.333333333336
r18165 n2075 t_m2_d 1670.78125
r18166 n2076 t_m2_d 26732.5
r18167 n2190 t_m2_d 2227.7083333333335
r18168 n2191 t_m2_d 35643.333333333336
r18169 n2305 t_m2_d 445.54166666666669
r18170 n2306 t_m2_d 7128.666666666667
r18171 n2420 t_m2_d 1336.625
r18172 n2421 t_m2_d 21386
r18173 n2535 t_m2_d 3341.5625
r18174 n2536 t_m2_d 53465
r18175 n407 t_m2_b 169065
r18176 n408 t_m2_b 26010
r18177 n409 t_m2_b 28177.5
r18178 n410 t_m2_b 48304.285714285717
r18179 n563 t_m2_b 11271
r18180 n564 t_m2_b 1734
r18181 n565 t_m2_b 1878.5
r18182 n566 t_m2_b 3220.2857142857142
r18183 n719 t_m2_b 169065
r18184 n720 t_m2_b 26010
r18185 n721 t_m2_b 28177.5
r18186 n722 t_m2_b 48304.285714285717
r18187 n2677 t_m2_b 9945
r18188 n2678 t_m2_b 1530
r18189 n2679 t_m2_b 1657.5
r18190 n2680 t_m2_b 2841.4285714285716
r18191 n904 t_m2_s 8225.3846153846152
r18192 n905 t_m2_s 8910.8333333333339
r18193 n906 t_m2_s 15275.714285714286
r18194 n907 t_m2_s 53465
r18195 n1019 t_m2_s 3290.1538461538462
r18196 n1020 t_m2_s 3564.3333333333335
r18197 n1021 t_m2_s 6110.2857142857147
r18198 n1022 t_m2_s 21386
r18199 n1134 t_m2_s 1096.7179487179487
r18200 n1135 t_m2_s 1188.1111111111111
r18201 n1136 t_m2_s 2036.7619047619046
r18202 n1137 t_m2_s 7128.666666666667
r18203 n1249 t_m2_s 5483.5897435897432
r18204 n1250 t_m2_s 5940.5555555555557
r18205 n1251 t_m2_s 10183.809523809523
r18206 n1252 t_m2_s 35643.333333333336
r18207 n1364 t_m2_s 4112.6923076923076
r18208 n1365 t_m2_s 4455.416666666667
r18209 n1366 t_m2_s 7637.8571428571431
r18210 n1367 t_m2_s 26732.5
r18211 n1479 t_m2_s 5483.5897435897432
r18212 n1480 t_m2_s 5940.5555555555557
r18213 n1481 t_m2_s 10183.809523809523
r18214 n1482 t_m2_s 35643.333333333336
r18215 n1602 t_m2_s 8225.3846153846152
r18216 n1603 t_m2_s 8910.8333333333339
r18217 n1604 t_m2_s 15275.714285714286
r18218 n1605 t_m2_s 53465
r18219 n1833 t_m2_d 8225.3846153846152
r18220 n1834 t_m2_d 8910.8333333333339
r18221 n1835 t_m2_d 15275.714285714286
r18222 n1836 t_m2_d 53465
r18223 n1956 t_m2_d 5483.5897435897432
r18224 n1957 t_m2_d 5940.5555555555557
r18225 n1958 t_m2_d 10183.809523809523
r18226 n1959 t_m2_d 35643.333333333336
r18227 n2079 t_m2_d 4112.6923076923076
r18228 n2080 t_m2_d 4455.416666666667
r18229 n2081 t_m2_d 7637.8571428571431
r18230 n2082 t_m2_d 26732.5
r18231 n2194 t_m2_d 5483.5897435897432
r18232 n2195 t_m2_d 5940.5555555555557
r18233 n2196 t_m2_d 10183.809523809523
r18234 n2197 t_m2_d 35643.333333333336
r18235 n2309 t_m2_d 1096.7179487179487
r18236 n2310 t_m2_d 1188.1111111111111
r18237 n2311 t_m2_d 2036.7619047619046
r18238 n2312 t_m2_d 7128.666666666667
r18239 n2424 t_m2_d 3290.1538461538462
r18240 n2425 t_m2_d 3564.3333333333335
r18241 n2426 t_m2_d 6110.2857142857147
r18242 n2427 t_m2_d 21386
r18243 n2539 t_m2_d 8225.3846153846152
r18244 n2540 t_m2_d 8910.8333333333339
r18245 n2541 t_m2_d 15275.714285714286
r18246 n2542 t_m2_d 53465
r18247 n416 t_m2_b 169065
r18248 n417 t_m2_b 37570
r18249 n418 t_m2_b 28177.5
r18250 n419 t_m2_b 37570
r18251 n420 t_m2_b 169065
r18252 n572 t_m2_b 11271
r18253 n573 t_m2_b 2504.6666666666665
r18254 n574 t_m2_b 1878.5
r18255 n575 t_m2_b 2504.6666666666665
r18256 n576 t_m2_b 11271
r18257 n728 t_m2_b 169065
r18258 n729 t_m2_b 37570
r18259 n730 t_m2_b 28177.5
r18260 n731 t_m2_b 37570
r18261 n732 t_m2_b 169065
r18262 n2686 t_m2_b 9945
r18263 n2687 t_m2_b 2210
r18264 n2688 t_m2_b 1657.5
r18265 n2689 t_m2_b 2210
r18266 n2690 t_m2_b 9945
r18267 n913 t_m2_s 11881.111111111111
r18268 n914 t_m2_s 8910.8333333333339
r18269 n915 t_m2_s 11881.111111111111
r18270 n916 t_m2_s 53465
r18271 n917 t_m2_s 53465
r18272 n1028 t_m2_s 4752.4444444444443
r18273 n1029 t_m2_s 3564.3333333333335
r18274 n1030 t_m2_s 4752.4444444444443
r18275 n1031 t_m2_s 21386
r18276 n1032 t_m2_s 21386
r18277 n1143 t_m2_s 1584.1481481481483
r18278 n1144 t_m2_s 1188.1111111111111
r18279 n1145 t_m2_s 1584.1481481481483
r18280 n1146 t_m2_s 7128.666666666667
r18281 n1147 t_m2_s 7128.666666666667
r18282 n1258 t_m2_s 7920.7407407407409
r18283 n1259 t_m2_s 5940.5555555555557
r18284 n1260 t_m2_s 7920.7407407407409
r18285 n1261 t_m2_s 35643.333333333336
r18286 n1262 t_m2_s 35643.333333333336
r18287 n1373 t_m2_s 5940.5555555555557
r18288 n1374 t_m2_s 4455.416666666667
r18289 n1375 t_m2_s 5940.5555555555557
r18290 n1376 t_m2_s 26732.5
r18291 n1377 t_m2_s 26732.5
r18292 n1488 t_m2_s 7920.7407407407409
r18293 n1489 t_m2_s 5940.5555555555557
r18294 n1490 t_m2_s 7920.7407407407409
r18295 n1491 t_m2_s 35643.333333333336
r18296 n1492 t_m2_s 35643.333333333336
r18297 n1611 t_m2_s 11881.111111111111
r18298 n1612 t_m2_s 8910.8333333333339
r18299 n1613 t_m2_s 11881.111111111111
r18300 n1614 t_m2_s 53465
r18301 n1615 t_m2_s 53465
r18302 n1842 t_m2_d 11881.111111111111
r18303 n1843 t_m2_d 8910.8333333333339
r18304 n1844 t_m2_d 11881.111111111111
r18305 n1845 t_m2_d 53465
r18306 n1846 t_m2_d 53465
r18307 n1965 t_m2_d 7920.7407407407409
r18308 n1966 t_m2_d 5940.5555555555557
r18309 n1967 t_m2_d 7920.7407407407409
r18310 n1968 t_m2_d 35643.333333333336
r18311 n1969 t_m2_d 35643.333333333336
r18312 n2088 t_m2_d 5940.5555555555557
r18313 n2089 t_m2_d 4455.416666666667
r18314 n2090 t_m2_d 5940.5555555555557
r18315 n2091 t_m2_d 26732.5
r18316 n2092 t_m2_d 26732.5
r18317 n2203 t_m2_d 7920.7407407407409
r18318 n2204 t_m2_d 5940.5555555555557
r18319 n2205 t_m2_d 7920.7407407407409
r18320 n2206 t_m2_d 35643.333333333336
r18321 n2207 t_m2_d 35643.333333333336
r18322 n2318 t_m2_d 1584.1481481481483
r18323 n2319 t_m2_d 1188.1111111111111
r18324 n2320 t_m2_d 1584.1481481481483
r18325 n2321 t_m2_d 7128.666666666667
r18326 n2322 t_m2_d 7128.666666666667
r18327 n2433 t_m2_d 4752.4444444444443
r18328 n2434 t_m2_d 3564.3333333333335
r18329 n2435 t_m2_d 4752.4444444444443
r18330 n2436 t_m2_d 21386
r18331 n2437 t_m2_d 21386
r18332 n2548 t_m2_d 11881.111111111111
r18333 n2549 t_m2_d 8910.8333333333339
r18334 n2550 t_m2_d 11881.111111111111
r18335 n2551 t_m2_d 53465
r18336 n2552 t_m2_d 53465
r18337 n424 t_m2_b 169065
r18338 n425 t_m2_b 10566.5625
r18339 n580 t_m2_b 11271
r18340 n581 t_m2_b 704.4375
r18341 n736 t_m2_b 169065
r18342 n737 t_m2_b 10566.5625
r18343 n2694 t_m2_b 9945
r18344 n2695 t_m2_b 621.5625
r18345 n921 t_m2_s 3341.5625
r18346 n922 t_m2_s 53465
r18347 n1036 t_m2_s 1336.625
r18348 n1037 t_m2_s 21386
r18349 n1151 t_m2_s 445.54166666666669
r18350 n1152 t_m2_s 7128.666666666667
r18351 n1266 t_m2_s 2227.7083333333335
r18352 n1267 t_m2_s 35643.333333333336
r18353 n1381 t_m2_s 1670.78125
r18354 n1382 t_m2_s 26732.5
r18355 n1496 t_m2_s 2227.7083333333335
r18356 n1497 t_m2_s 35643.333333333336
r18357 n1619 t_m2_s 3341.5625
r18358 n1620 t_m2_s 53465
r18359 n1850 t_m2_d 3341.5625
r18360 n1851 t_m2_d 53465
r18361 n1973 t_m2_d 2227.7083333333335
r18362 n1974 t_m2_d 35643.333333333336
r18363 n2096 t_m2_d 1670.78125
r18364 n2097 t_m2_d 26732.5
r18365 n2211 t_m2_d 2227.7083333333335
r18366 n2212 t_m2_d 35643.333333333336
r18367 n2326 t_m2_d 445.54166666666669
r18368 n2327 t_m2_d 7128.666666666667
r18369 n2441 t_m2_d 1336.625
r18370 n2442 t_m2_d 21386
r18371 n2556 t_m2_d 3341.5625
r18372 n2557 t_m2_d 53465
r18373 n430 t_m2_b 9945
r18374 n586 t_m2_b 663
r18375 n742 t_m2_b 9945
r18376 n2700 t_m2_b 585
r18377 n1754 t_m2_g 43928
r18378 n1755 t_m2_g 10982
r18379 n1756 t_m2_g 3993.4545454545455
r18380 n1757 t_m2_g 43928
r18381 n1766 t_m2_g 2928.5333333333333
r18382 n1767 t_m2_g 732.13333333333333
r18383 n1768 t_m2_g 266.23030303030305
r18384 n1769 t_m2_g 2928.5333333333333
r18385 n1778 t_m2_g 43928
r18386 n1779 t_m2_g 10982
r18387 n1780 t_m2_g 3993.4545454545455
r18388 n1781 t_m2_g 43928
r18389 n438 t_m2_b 15369.545454545454
r18390 n439 t_m2_b 169065
r18391 n440 t_m2_b 112710
r18392 n441 t_m2_b 112710
r18393 n442 t_m2_b 84532.5
r18394 n594 t_m2_b 1024.6363636363637
r18395 n595 t_m2_b 11271
r18396 n596 t_m2_b 7514
r18397 n597 t_m2_b 7514
r18398 n598 t_m2_b 5635.5
r18399 n750 t_m2_b 15369.545454545454
r18400 n751 t_m2_b 169065
r18401 n752 t_m2_b 112710
r18402 n753 t_m2_b 112710
r18403 n754 t_m2_b 84532.5
r18404 n2708 t_m2_b 904.09090909090901
r18405 n2709 t_m2_b 9945
r18406 n2710 t_m2_b 6630
r18407 n2711 t_m2_b 6630
r18408 n2712 t_m2_b 4972.5
r18409 n881 t_m2_b 1420.7142857142858
r18410 n885 t_m2_b 9945
r18411 n889 t_m2_b 3978
r18412 n893 t_m2_b 3315
r18413 n925 t_m2_b 9945
r18414 n1040 t_m2_b 3978
r18415 n1758 t_m2_b 9945
r18416 n1770 t_m2_b 663
r18417 n1782 t_m2_b 9945
r18418 n2445 t_m2_b 3978
r18419 n2560 t_m2_b 9945
r18420 n2647 t_m2_b 3315
r18421 n2651 t_m2_b 2841.4285714285716
r18422 n2655 t_m2_b 1420.7142857142858
r18423 n882 t_m1_b 449.28571428571433
r18424 n886 t_m1_b 3145
r18425 n890 t_m1_b 1258
r18426 n894 t_m1_b 1048.3333333333333
r18427 n926 t_m1_b 3145
r18428 n1041 t_m1_b 1258
r18429 n1759 t_m1_b 3145
r18430 n1771 t_m1_b 209.66666666666669
r18431 n1783 t_m1_b 3145
r18432 n2446 t_m1_b 1258
r18433 n2561 t_m1_b 3145
r18434 n2648 t_m1_b 1048.3333333333333
r18435 n2652 t_m1_b 898.57142857142867
r18436 n2656 t_m1_b 449.28571428571433
r18437 n450 t_m1_b 3145
r18438 n606 t_m1_b 209.66666666666669
r18439 n762 t_m1_b 3145
r18440 n2720 t_m1_b 185
r18441 n454 t_m1_b 53465
r18442 n455 t_m1_b 3341.5625
r18443 n610 t_m1_b 3564.3333333333335
r18444 n611 t_m1_b 222.77083333333334
r18445 n766 t_m1_b 53465
r18446 n767 t_m1_b 3341.5625
r18447 n2724 t_m1_b 3145
r18448 n2725 t_m1_b 196.5625
r18449 n930 t_m1_s 10566.5625
r18450 n931 t_m1_s 169065
r18451 n1045 t_m1_s 4226.625
r18452 n1046 t_m1_s 67626
r18453 n1160 t_m1_s 1408.875
r18454 n1161 t_m1_s 22542
r18455 n1275 t_m1_s 7044.375
r18456 n1276 t_m1_s 112710
r18457 n1390 t_m1_s 5283.28125
r18458 n1391 t_m1_s 84532.5
r18459 n1509 t_m1_s 7044.375
r18460 n1510 t_m1_s 112710
r18461 n1632 t_m1_s 10566.5625
r18462 n1633 t_m1_s 169065
r18463 n1863 t_m1_d 10566.5625
r18464 n1864 t_m1_d 169065
r18465 n1986 t_m1_d 7044.375
r18466 n1987 t_m1_d 112710
r18467 n2105 t_m1_d 5283.28125
r18468 n2106 t_m1_d 84532.5
r18469 n2220 t_m1_d 7044.375
r18470 n2221 t_m1_d 112710
r18471 n2335 t_m1_d 1408.875
r18472 n2336 t_m1_d 22542
r18473 n2450 t_m1_d 4226.625
r18474 n2451 t_m1_d 67626
r18475 n2565 t_m1_d 10566.5625
r18476 n2566 t_m1_d 169065
r18477 n458 t_m1_b 53465
r18478 n459 t_m1_b 3341.5625
r18479 n614 t_m1_b 3564.3333333333335
r18480 n615 t_m1_b 222.77083333333334
r18481 n770 t_m1_b 53465
r18482 n771 t_m1_b 3341.5625
r18483 n2728 t_m1_b 3145
r18484 n2729 t_m1_b 196.5625
r18485 n934 t_m1_s 10566.5625
r18486 n935 t_m1_s 169065
r18487 n1049 t_m1_s 4226.625
r18488 n1050 t_m1_s 67626
r18489 n1164 t_m1_s 1408.875
r18490 n1165 t_m1_s 22542
r18491 n1279 t_m1_s 7044.375
r18492 n1280 t_m1_s 112710
r18493 n1394 t_m1_s 5283.28125
r18494 n1395 t_m1_s 84532.5
r18495 n1513 t_m1_s 7044.375
r18496 n1514 t_m1_s 112710
r18497 n1636 t_m1_s 10566.5625
r18498 n1637 t_m1_s 169065
r18499 n1867 t_m1_d 10566.5625
r18500 n1868 t_m1_d 169065
r18501 n1990 t_m1_d 7044.375
r18502 n1991 t_m1_d 112710
r18503 n2109 t_m1_d 5283.28125
r18504 n2110 t_m1_d 84532.5
r18505 n2224 t_m1_d 7044.375
r18506 n2225 t_m1_d 112710
r18507 n2339 t_m1_d 1408.875
r18508 n2340 t_m1_d 22542
r18509 n2454 t_m1_d 4226.625
r18510 n2455 t_m1_d 67626
r18511 n2569 t_m1_d 10566.5625
r18512 n2570 t_m1_d 169065
r18513 n462 t_m1_b 53465
r18514 n463 t_m1_b 3341.5625
r18515 n618 t_m1_b 3564.3333333333335
r18516 n619 t_m1_b 222.77083333333334
r18517 n774 t_m1_b 53465
r18518 n775 t_m1_b 3341.5625
r18519 n2732 t_m1_b 3145
r18520 n2733 t_m1_b 196.5625
r18521 n938 t_m1_s 10566.5625
r18522 n939 t_m1_s 169065
r18523 n1053 t_m1_s 4226.625
r18524 n1054 t_m1_s 67626
r18525 n1168 t_m1_s 1408.875
r18526 n1169 t_m1_s 22542
r18527 n1283 t_m1_s 7044.375
r18528 n1284 t_m1_s 112710
r18529 n1398 t_m1_s 5283.28125
r18530 n1399 t_m1_s 84532.5
r18531 n1517 t_m1_s 7044.375
r18532 n1518 t_m1_s 112710
r18533 n1640 t_m1_s 10566.5625
r18534 n1641 t_m1_s 169065
r18535 n1871 t_m1_d 10566.5625
r18536 n1872 t_m1_d 169065
r18537 n1994 t_m1_d 7044.375
r18538 n1995 t_m1_d 112710
r18539 n2113 t_m1_d 5283.28125
r18540 n2114 t_m1_d 84532.5
r18541 n2228 t_m1_d 7044.375
r18542 n2229 t_m1_d 112710
r18543 n2343 t_m1_d 1408.875
r18544 n2344 t_m1_d 22542
r18545 n2458 t_m1_d 4226.625
r18546 n2459 t_m1_d 67626
r18547 n2573 t_m1_d 10566.5625
r18548 n2574 t_m1_d 169065
r18549 n466 t_m1_b 53465
r18550 n467 t_m1_b 3341.5625
r18551 n622 t_m1_b 3564.3333333333335
r18552 n623 t_m1_b 222.77083333333334
r18553 n778 t_m1_b 53465
r18554 n779 t_m1_b 3341.5625
r18555 n2736 t_m1_b 3145
r18556 n2737 t_m1_b 196.5625
r18557 n942 t_m1_s 10566.5625
r18558 n943 t_m1_s 169065
r18559 n1057 t_m1_s 4226.625
r18560 n1058 t_m1_s 67626
r18561 n1172 t_m1_s 1408.875
r18562 n1173 t_m1_s 22542
r18563 n1287 t_m1_s 7044.375
r18564 n1288 t_m1_s 112710
r18565 n1402 t_m1_s 5283.28125
r18566 n1403 t_m1_s 84532.5
r18567 n1521 t_m1_s 7044.375
r18568 n1522 t_m1_s 112710
r18569 n1644 t_m1_s 10566.5625
r18570 n1645 t_m1_s 169065
r18571 n1875 t_m1_d 10566.5625
r18572 n1876 t_m1_d 169065
r18573 n1998 t_m1_d 7044.375
r18574 n1999 t_m1_d 112710
r18575 n2117 t_m1_d 5283.28125
r18576 n2118 t_m1_d 84532.5
r18577 n2232 t_m1_d 7044.375
r18578 n2233 t_m1_d 112710
r18579 n2347 t_m1_d 1408.875
r18580 n2348 t_m1_d 22542
r18581 n2462 t_m1_d 4226.625
r18582 n2463 t_m1_d 67626
r18583 n2577 t_m1_d 10566.5625
r18584 n2578 t_m1_d 169065
r18585 n470 t_m1_b 53465
r18586 n471 t_m1_b 3341.5625
r18587 n626 t_m1_b 3564.3333333333335
r18588 n627 t_m1_b 222.77083333333334
r18589 n782 t_m1_b 53465
r18590 n783 t_m1_b 3341.5625
r18591 n2740 t_m1_b 3145
r18592 n2741 t_m1_b 196.5625
r18593 n946 t_m1_s 10566.5625
r18594 n947 t_m1_s 169065
r18595 n1061 t_m1_s 4226.625
r18596 n1062 t_m1_s 67626
r18597 n1176 t_m1_s 1408.875
r18598 n1177 t_m1_s 22542
r18599 n1291 t_m1_s 7044.375
r18600 n1292 t_m1_s 112710
r18601 n1406 t_m1_s 5283.28125
r18602 n1407 t_m1_s 84532.5
r18603 n1525 t_m1_s 7044.375
r18604 n1526 t_m1_s 112710
r18605 n1648 t_m1_s 10566.5625
r18606 n1649 t_m1_s 169065
r18607 n1879 t_m1_d 10566.5625
r18608 n1880 t_m1_d 169065
r18609 n2002 t_m1_d 7044.375
r18610 n2003 t_m1_d 112710
r18611 n2121 t_m1_d 5283.28125
r18612 n2122 t_m1_d 84532.5
r18613 n2236 t_m1_d 7044.375
r18614 n2237 t_m1_d 112710
r18615 n2351 t_m1_d 1408.875
r18616 n2352 t_m1_d 22542
r18617 n2466 t_m1_d 4226.625
r18618 n2467 t_m1_d 67626
r18619 n2581 t_m1_d 10566.5625
r18620 n2582 t_m1_d 169065
r18621 n474 t_m1_b 53465
r18622 n475 t_m1_b 3341.5625
r18623 n630 t_m1_b 3564.3333333333335
r18624 n631 t_m1_b 222.77083333333334
r18625 n786 t_m1_b 53465
r18626 n787 t_m1_b 3341.5625
r18627 n2744 t_m1_b 3145
r18628 n2745 t_m1_b 196.5625
r18629 n950 t_m1_s 10566.5625
r18630 n951 t_m1_s 169065
r18631 n1065 t_m1_s 4226.625
r18632 n1066 t_m1_s 67626
r18633 n1180 t_m1_s 1408.875
r18634 n1181 t_m1_s 22542
r18635 n1295 t_m1_s 7044.375
r18636 n1296 t_m1_s 112710
r18637 n1410 t_m1_s 5283.28125
r18638 n1411 t_m1_s 84532.5
r18639 n1529 t_m1_s 7044.375
r18640 n1530 t_m1_s 112710
r18641 n1652 t_m1_s 10566.5625
r18642 n1653 t_m1_s 169065
r18643 n1883 t_m1_d 10566.5625
r18644 n1884 t_m1_d 169065
r18645 n2006 t_m1_d 7044.375
r18646 n2007 t_m1_d 112710
r18647 n2125 t_m1_d 5283.28125
r18648 n2126 t_m1_d 84532.5
r18649 n2240 t_m1_d 7044.375
r18650 n2241 t_m1_d 112710
r18651 n2355 t_m1_d 1408.875
r18652 n2356 t_m1_d 22542
r18653 n2470 t_m1_d 4226.625
r18654 n2471 t_m1_d 67626
r18655 n2585 t_m1_d 10566.5625
r18656 n2586 t_m1_d 169065
r18657 n478 t_m1_b 53465
r18658 n479 t_m1_b 3341.5625
r18659 n634 t_m1_b 3564.3333333333335
r18660 n635 t_m1_b 222.77083333333334
r18661 n790 t_m1_b 53465
r18662 n791 t_m1_b 3341.5625
r18663 n2748 t_m1_b 3145
r18664 n2749 t_m1_b 196.5625
r18665 n954 t_m1_s 10566.5625
r18666 n955 t_m1_s 169065
r18667 n1069 t_m1_s 4226.625
r18668 n1070 t_m1_s 67626
r18669 n1184 t_m1_s 1408.875
r18670 n1185 t_m1_s 22542
r18671 n1299 t_m1_s 7044.375
r18672 n1300 t_m1_s 112710
r18673 n1414 t_m1_s 5283.28125
r18674 n1415 t_m1_s 84532.5
r18675 n1533 t_m1_s 7044.375
r18676 n1534 t_m1_s 112710
r18677 n1656 t_m1_s 10566.5625
r18678 n1657 t_m1_s 169065
r18679 n1887 t_m1_d 10566.5625
r18680 n1888 t_m1_d 169065
r18681 n2010 t_m1_d 7044.375
r18682 n2011 t_m1_d 112710
r18683 n2129 t_m1_d 5283.28125
r18684 n2130 t_m1_d 84532.5
r18685 n2244 t_m1_d 7044.375
r18686 n2245 t_m1_d 112710
r18687 n2359 t_m1_d 1408.875
r18688 n2360 t_m1_d 22542
r18689 n2474 t_m1_d 4226.625
r18690 n2475 t_m1_d 67626
r18691 n2589 t_m1_d 10566.5625
r18692 n2590 t_m1_d 169065
r18693 n482 t_m1_b 53465
r18694 n483 t_m1_b 3341.5625
r18695 n638 t_m1_b 3564.3333333333335
r18696 n639 t_m1_b 222.77083333333334
r18697 n794 t_m1_b 53465
r18698 n795 t_m1_b 3341.5625
r18699 n2752 t_m1_b 3145
r18700 n2753 t_m1_b 196.5625
r18701 n958 t_m1_s 10566.5625
r18702 n959 t_m1_s 169065
r18703 n1073 t_m1_s 4226.625
r18704 n1074 t_m1_s 67626
r18705 n1188 t_m1_s 1408.875
r18706 n1189 t_m1_s 22542
r18707 n1303 t_m1_s 7044.375
r18708 n1304 t_m1_s 112710
r18709 n1418 t_m1_s 5283.28125
r18710 n1419 t_m1_s 84532.5
r18711 n1537 t_m1_s 7044.375
r18712 n1538 t_m1_s 112710
r18713 n1660 t_m1_s 10566.5625
r18714 n1661 t_m1_s 169065
r18715 n1891 t_m1_d 10566.5625
r18716 n1892 t_m1_d 169065
r18717 n2014 t_m1_d 7044.375
r18718 n2015 t_m1_d 112710
r18719 n2133 t_m1_d 5283.28125
r18720 n2134 t_m1_d 84532.5
r18721 n2248 t_m1_d 7044.375
r18722 n2249 t_m1_d 112710
r18723 n2363 t_m1_d 1408.875
r18724 n2364 t_m1_d 22542
r18725 n2478 t_m1_d 4226.625
r18726 n2479 t_m1_d 67626
r18727 n2593 t_m1_d 10566.5625
r18728 n2594 t_m1_d 169065
r18729 n488 t_m1_b 53465
r18730 n489 t_m1_b 53465
r18731 n490 t_m1_b 13366.25
r18732 n491 t_m1_b 4860.454545454545
r18733 n644 t_m1_b 3564.3333333333335
r18734 n645 t_m1_b 3564.3333333333335
r18735 n646 t_m1_b 891.08333333333337
r18736 n647 t_m1_b 324.03030303030306
r18737 n800 t_m1_b 53465
r18738 n801 t_m1_b 53465
r18739 n802 t_m1_b 13366.25
r18740 n803 t_m1_b 4860.454545454545
r18741 n2758 t_m1_b 3145
r18742 n2759 t_m1_b 3145
r18743 n2760 t_m1_b 786.25
r18744 n2761 t_m1_b 285.90909090909088
r18745 n964 t_m1_s 169065
r18746 n965 t_m1_s 42266.25
r18747 n966 t_m1_s 15369.545454545454
r18748 n967 t_m1_s 338130
r18749 n968 t_m1_s 338130
r18750 n1079 t_m1_s 67626
r18751 n1080 t_m1_s 16906.5
r18752 n1081 t_m1_s 6147.818181818182
r18753 n1082 t_m1_s 135252
r18754 n1083 t_m1_s 135252
r18755 n1194 t_m1_s 22542
r18756 n1195 t_m1_s 5635.5
r18757 n1196 t_m1_s 2049.2727272727275
r18758 n1197 t_m1_s 45084
r18759 n1198 t_m1_s 45084
r18760 n1309 t_m1_s 112710
r18761 n1310 t_m1_s 28177.5
r18762 n1311 t_m1_s 10246.363636363636
r18763 n1312 t_m1_s 225420
r18764 n1313 t_m1_s 225420
r18765 n1424 t_m1_s 84532.5
r18766 n1425 t_m1_s 21133.125
r18767 n1426 t_m1_s 7684.772727272727
r18768 n1427 t_m1_s 169065
r18769 n1428 t_m1_s 169065
r18770 n1543 t_m1_s 112710
r18771 n1544 t_m1_s 28177.5
r18772 n1545 t_m1_s 10246.363636363636
r18773 n1546 t_m1_s 225420
r18774 n1547 t_m1_s 225420
r18775 n1666 t_m1_s 169065
r18776 n1667 t_m1_s 42266.25
r18777 n1668 t_m1_s 15369.545454545454
r18778 n1669 t_m1_s 338130
r18779 n1670 t_m1_s 338130
r18780 n1897 t_m1_d 169065
r18781 n1898 t_m1_d 42266.25
r18782 n1899 t_m1_d 15369.545454545454
r18783 n1900 t_m1_d 338130
r18784 n1901 t_m1_d 338130
r18785 n2020 t_m1_d 112710
r18786 n2021 t_m1_d 28177.5
r18787 n2022 t_m1_d 10246.363636363636
r18788 n2023 t_m1_d 225420
r18789 n2024 t_m1_d 225420
r18790 n2139 t_m1_d 84532.5
r18791 n2140 t_m1_d 21133.125
r18792 n2141 t_m1_d 7684.772727272727
r18793 n2142 t_m1_d 169065
r18794 n2143 t_m1_d 169065
r18795 n2254 t_m1_d 112710
r18796 n2255 t_m1_d 28177.5
r18797 n2256 t_m1_d 10246.363636363636
r18798 n2257 t_m1_d 225420
r18799 n2258 t_m1_d 225420
r18800 n2369 t_m1_d 22542
r18801 n2370 t_m1_d 5635.5
r18802 n2371 t_m1_d 2049.2727272727275
r18803 n2372 t_m1_d 45084
r18804 n2373 t_m1_d 45084
r18805 n2484 t_m1_d 67626
r18806 n2485 t_m1_d 16906.5
r18807 n2486 t_m1_d 6147.818181818182
r18808 n2487 t_m1_d 135252
r18809 n2488 t_m1_d 135252
r18810 n2599 t_m1_d 169065
r18811 n2600 t_m1_d 42266.25
r18812 n2601 t_m1_d 15369.545454545454
r18813 n2602 t_m1_d 338130
r18814 n2603 t_m1_d 338130
r18815 n500 t_m1_b 53465
r18816 n501 t_m1_b 17821.666666666668
r18817 n502 t_m1_b 8910.8333333333339
r18818 n503 t_m1_b 7637.8571428571431
r18819 n656 t_m1_b 3564.3333333333335
r18820 n657 t_m1_b 1188.1111111111111
r18821 n658 t_m1_b 594.05555555555554
r18822 n659 t_m1_b 509.19047619047615
r18823 n812 t_m1_b 53465
r18824 n813 t_m1_b 17821.666666666668
r18825 n814 t_m1_b 8910.8333333333339
r18826 n815 t_m1_b 7637.8571428571431
r18827 n2770 t_m1_b 3145
r18828 n2771 t_m1_b 1048.3333333333333
r18829 n2772 t_m1_b 524.16666666666663
r18830 n2773 t_m1_b 449.28571428571433
r18831 n976 t_m1_s 56355
r18832 n977 t_m1_s 28177.5
r18833 n978 t_m1_s 24152.142857142859
r18834 n979 t_m1_s 169065
r18835 n1091 t_m1_s 22542
r18836 n1092 t_m1_s 11271
r18837 n1093 t_m1_s 9660.8571428571431
r18838 n1094 t_m1_s 67626
r18839 n1206 t_m1_s 7514
r18840 n1207 t_m1_s 3757
r18841 n1208 t_m1_s 3220.2857142857142
r18842 n1209 t_m1_s 22542
r18843 n1321 t_m1_s 37570
r18844 n1322 t_m1_s 18785
r18845 n1323 t_m1_s 16101.428571428571
r18846 n1324 t_m1_s 112710
r18847 n1436 t_m1_s 28177.5
r18848 n1437 t_m1_s 14088.75
r18849 n1438 t_m1_s 12076.071428571429
r18850 n1439 t_m1_s 84532.5
r18851 n1555 t_m1_s 37570
r18852 n1556 t_m1_s 18785
r18853 n1557 t_m1_s 16101.428571428571
r18854 n1558 t_m1_s 112710
r18855 n1678 t_m1_s 56355
r18856 n1679 t_m1_s 28177.5
r18857 n1680 t_m1_s 24152.142857142859
r18858 n1681 t_m1_s 169065
r18859 n1909 t_m1_d 56355
r18860 n1910 t_m1_d 28177.5
r18861 n1911 t_m1_d 24152.142857142859
r18862 n1912 t_m1_d 169065
r18863 n2032 t_m1_d 37570
r18864 n2033 t_m1_d 18785
r18865 n2034 t_m1_d 16101.428571428571
r18866 n2035 t_m1_d 112710
r18867 n2151 t_m1_d 28177.5
r18868 n2152 t_m1_d 14088.75
r18869 n2153 t_m1_d 12076.071428571429
r18870 n2154 t_m1_d 84532.5
r18871 n2266 t_m1_d 37570
r18872 n2267 t_m1_d 18785
r18873 n2268 t_m1_d 16101.428571428571
r18874 n2269 t_m1_d 112710
r18875 n2381 t_m1_d 7514
r18876 n2382 t_m1_d 3757
r18877 n2383 t_m1_d 3220.2857142857142
r18878 n2384 t_m1_d 22542
r18879 n2496 t_m1_d 22542
r18880 n2497 t_m1_d 11271
r18881 n2498 t_m1_d 9660.8571428571431
r18882 n2499 t_m1_d 67626
r18883 n2611 t_m1_d 56355
r18884 n2612 t_m1_d 28177.5
r18885 n2613 t_m1_d 24152.142857142859
r18886 n2614 t_m1_d 169065
r18887 n506 t_m1_b 53465
r18888 n507 t_m1_b 3341.5625
r18889 n662 t_m1_b 3564.3333333333335
r18890 n663 t_m1_b 222.77083333333334
r18891 n818 t_m1_b 53465
r18892 n819 t_m1_b 3341.5625
r18893 n2776 t_m1_b 3145
r18894 n2777 t_m1_b 196.5625
r18895 n982 t_m1_s 10566.5625
r18896 n983 t_m1_s 169065
r18897 n1097 t_m1_s 4226.625
r18898 n1098 t_m1_s 67626
r18899 n1212 t_m1_s 1408.875
r18900 n1213 t_m1_s 22542
r18901 n1327 t_m1_s 7044.375
r18902 n1328 t_m1_s 112710
r18903 n1442 t_m1_s 5283.28125
r18904 n1443 t_m1_s 84532.5
r18905 n1561 t_m1_s 7044.375
r18906 n1562 t_m1_s 112710
r18907 n1684 t_m1_s 10566.5625
r18908 n1685 t_m1_s 169065
r18909 n1915 t_m1_d 10566.5625
r18910 n1916 t_m1_d 169065
r18911 n2038 t_m1_d 7044.375
r18912 n2039 t_m1_d 112710
r18913 n2157 t_m1_d 5283.28125
r18914 n2158 t_m1_d 84532.5
r18915 n2272 t_m1_d 7044.375
r18916 n2273 t_m1_d 112710
r18917 n2387 t_m1_d 1408.875
r18918 n2388 t_m1_d 22542
r18919 n2502 t_m1_d 4226.625
r18920 n2503 t_m1_d 67626
r18921 n2617 t_m1_d 10566.5625
r18922 n2618 t_m1_d 169065
r18923 n510 t_m1_b 53465
r18924 n511 t_m1_b 3341.5625
r18925 n666 t_m1_b 3564.3333333333335
r18926 n667 t_m1_b 222.77083333333334
r18927 n822 t_m1_b 53465
r18928 n823 t_m1_b 3341.5625
r18929 n2780 t_m1_b 3145
r18930 n2781 t_m1_b 196.5625
r18931 n986 t_m1_s 10566.5625
r18932 n987 t_m1_s 169065
r18933 n1101 t_m1_s 4226.625
r18934 n1102 t_m1_s 67626
r18935 n1216 t_m1_s 1408.875
r18936 n1217 t_m1_s 22542
r18937 n1331 t_m1_s 7044.375
r18938 n1332 t_m1_s 112710
r18939 n1446 t_m1_s 5283.28125
r18940 n1447 t_m1_s 84532.5
r18941 n1565 t_m1_s 7044.375
r18942 n1566 t_m1_s 112710
r18943 n1688 t_m1_s 10566.5625
r18944 n1689 t_m1_s 169065
r18945 n1919 t_m1_d 10566.5625
r18946 n1920 t_m1_d 169065
r18947 n2042 t_m1_d 7044.375
r18948 n2043 t_m1_d 112710
r18949 n2161 t_m1_d 5283.28125
r18950 n2162 t_m1_d 84532.5
r18951 n2276 t_m1_d 7044.375
r18952 n2277 t_m1_d 112710
r18953 n2391 t_m1_d 1408.875
r18954 n2392 t_m1_d 22542
r18955 n2506 t_m1_d 4226.625
r18956 n2507 t_m1_d 67626
r18957 n2621 t_m1_d 10566.5625
r18958 n2622 t_m1_d 169065
r18959 n514 t_m1_b 53465
r18960 n515 t_m1_b 3341.5625
r18961 n670 t_m1_b 3564.3333333333335
r18962 n671 t_m1_b 222.77083333333334
r18963 n826 t_m1_b 53465
r18964 n827 t_m1_b 3341.5625
r18965 n2784 t_m1_b 3145
r18966 n2785 t_m1_b 196.5625
r18967 n990 t_m1_s 10566.5625
r18968 n991 t_m1_s 169065
r18969 n1105 t_m1_s 4226.625
r18970 n1106 t_m1_s 67626
r18971 n1220 t_m1_s 1408.875
r18972 n1221 t_m1_s 22542
r18973 n1335 t_m1_s 7044.375
r18974 n1336 t_m1_s 112710
r18975 n1450 t_m1_s 5283.28125
r18976 n1451 t_m1_s 84532.5
r18977 n1569 t_m1_s 7044.375
r18978 n1570 t_m1_s 112710
r18979 n1692 t_m1_s 10566.5625
r18980 n1693 t_m1_s 169065
r18981 n1923 t_m1_d 10566.5625
r18982 n1924 t_m1_d 169065
r18983 n2046 t_m1_d 7044.375
r18984 n2047 t_m1_d 112710
r18985 n2165 t_m1_d 5283.28125
r18986 n2166 t_m1_d 84532.5
r18987 n2280 t_m1_d 7044.375
r18988 n2281 t_m1_d 112710
r18989 n2395 t_m1_d 1408.875
r18990 n2396 t_m1_d 22542
r18991 n2510 t_m1_d 4226.625
r18992 n2511 t_m1_d 67626
r18993 n2625 t_m1_d 10566.5625
r18994 n2626 t_m1_d 169065
r18995 n518 t_m1_b 53465
r18996 n519 t_m1_b 3341.5625
r18997 n674 t_m1_b 3564.3333333333335
r18998 n675 t_m1_b 222.77083333333334
r18999 n830 t_m1_b 53465
r19000 n831 t_m1_b 3341.5625
r19001 n2788 t_m1_b 3145
r19002 n2789 t_m1_b 196.5625
r19003 n994 t_m1_s 10566.5625
r19004 n995 t_m1_s 169065
r19005 n1109 t_m1_s 4226.625
r19006 n1110 t_m1_s 67626
r19007 n1224 t_m1_s 1408.875
r19008 n1225 t_m1_s 22542
r19009 n1339 t_m1_s 7044.375
r19010 n1340 t_m1_s 112710
r19011 n1454 t_m1_s 5283.28125
r19012 n1455 t_m1_s 84532.5
r19013 n1573 t_m1_s 7044.375
r19014 n1574 t_m1_s 112710
r19015 n1696 t_m1_s 10566.5625
r19016 n1697 t_m1_s 169065
r19017 n1927 t_m1_d 10566.5625
r19018 n1928 t_m1_d 169065
r19019 n2050 t_m1_d 7044.375
r19020 n2051 t_m1_d 112710
r19021 n2169 t_m1_d 5283.28125
r19022 n2170 t_m1_d 84532.5
r19023 n2284 t_m1_d 7044.375
r19024 n2285 t_m1_d 112710
r19025 n2399 t_m1_d 1408.875
r19026 n2400 t_m1_d 22542
r19027 n2514 t_m1_d 4226.625
r19028 n2515 t_m1_d 67626
r19029 n2629 t_m1_d 10566.5625
r19030 n2630 t_m1_d 169065
r19031 n522 t_m1_b 53465
r19032 n523 t_m1_b 3341.5625
r19033 n678 t_m1_b 3564.3333333333335
r19034 n679 t_m1_b 222.77083333333334
r19035 n834 t_m1_b 53465
r19036 n835 t_m1_b 3341.5625
r19037 n2792 t_m1_b 3145
r19038 n2793 t_m1_b 196.5625
r19039 n998 t_m1_s 10566.5625
r19040 n999 t_m1_s 169065
r19041 n1113 t_m1_s 4226.625
r19042 n1114 t_m1_s 67626
r19043 n1228 t_m1_s 1408.875
r19044 n1229 t_m1_s 22542
r19045 n1343 t_m1_s 7044.375
r19046 n1344 t_m1_s 112710
r19047 n1458 t_m1_s 5283.28125
r19048 n1459 t_m1_s 84532.5
r19049 n1577 t_m1_s 7044.375
r19050 n1578 t_m1_s 112710
r19051 n1700 t_m1_s 10566.5625
r19052 n1701 t_m1_s 169065
r19053 n1931 t_m1_d 10566.5625
r19054 n1932 t_m1_d 169065
r19055 n2054 t_m1_d 7044.375
r19056 n2055 t_m1_d 112710
r19057 n2173 t_m1_d 5283.28125
r19058 n2174 t_m1_d 84532.5
r19059 n2288 t_m1_d 7044.375
r19060 n2289 t_m1_d 112710
r19061 n2403 t_m1_d 1408.875
r19062 n2404 t_m1_d 22542
r19063 n2518 t_m1_d 4226.625
r19064 n2519 t_m1_d 67626
r19065 n2633 t_m1_d 10566.5625
r19066 n2634 t_m1_d 169065
r19067 n526 t_m1_b 53465
r19068 n527 t_m1_b 3341.5625
r19069 n682 t_m1_b 3564.3333333333335
r19070 n683 t_m1_b 222.77083333333334
r19071 n838 t_m1_b 53465
r19072 n839 t_m1_b 3341.5625
r19073 n2796 t_m1_b 3145
r19074 n2797 t_m1_b 196.5625
r19075 n1002 t_m1_s 10566.5625
r19076 n1003 t_m1_s 169065
r19077 n1117 t_m1_s 4226.625
r19078 n1118 t_m1_s 67626
r19079 n1232 t_m1_s 1408.875
r19080 n1233 t_m1_s 22542
r19081 n1347 t_m1_s 7044.375
r19082 n1348 t_m1_s 112710
r19083 n1462 t_m1_s 5283.28125
r19084 n1463 t_m1_s 84532.5
r19085 n1581 t_m1_s 7044.375
r19086 n1582 t_m1_s 112710
r19087 n1704 t_m1_s 10566.5625
r19088 n1705 t_m1_s 169065
r19089 n1935 t_m1_d 10566.5625
r19090 n1936 t_m1_d 169065
r19091 n2058 t_m1_d 7044.375
r19092 n2059 t_m1_d 112710
r19093 n2177 t_m1_d 5283.28125
r19094 n2178 t_m1_d 84532.5
r19095 n2292 t_m1_d 7044.375
r19096 n2293 t_m1_d 112710
r19097 n2407 t_m1_d 1408.875
r19098 n2408 t_m1_d 22542
r19099 n2522 t_m1_d 4226.625
r19100 n2523 t_m1_d 67626
r19101 n2637 t_m1_d 10566.5625
r19102 n2638 t_m1_d 169065
r19103 n530 t_m1_b 53465
r19104 n531 t_m1_b 3341.5625
r19105 n686 t_m1_b 3564.3333333333335
r19106 n687 t_m1_b 222.77083333333334
r19107 n842 t_m1_b 53465
r19108 n843 t_m1_b 3341.5625
r19109 n2800 t_m1_b 3145
r19110 n2801 t_m1_b 196.5625
r19111 n1006 t_m1_s 10566.5625
r19112 n1007 t_m1_s 169065
r19113 n1121 t_m1_s 4226.625
r19114 n1122 t_m1_s 67626
r19115 n1236 t_m1_s 1408.875
r19116 n1237 t_m1_s 22542
r19117 n1351 t_m1_s 7044.375
r19118 n1352 t_m1_s 112710
r19119 n1466 t_m1_s 5283.28125
r19120 n1467 t_m1_s 84532.5
r19121 n1585 t_m1_s 7044.375
r19122 n1586 t_m1_s 112710
r19123 n1708 t_m1_s 10566.5625
r19124 n1709 t_m1_s 169065
r19125 n1939 t_m1_d 10566.5625
r19126 n1940 t_m1_d 169065
r19127 n2062 t_m1_d 7044.375
r19128 n2063 t_m1_d 112710
r19129 n2181 t_m1_d 5283.28125
r19130 n2182 t_m1_d 84532.5
r19131 n2296 t_m1_d 7044.375
r19132 n2297 t_m1_d 112710
r19133 n2411 t_m1_d 1408.875
r19134 n2412 t_m1_d 22542
r19135 n2526 t_m1_d 4226.625
r19136 n2527 t_m1_d 67626
r19137 n2641 t_m1_d 10566.5625
r19138 n2642 t_m1_d 169065
r19139 n536 t_m1_b 3145
r19140 n692 t_m1_b 209.66666666666669
r19141 n848 t_m1_b 3145
r19142 n2806 t_m1_b 185
r19143 n1760 t_m1_g 43928
r19144 n1761 t_m1_g 7986.909090909091
r19145 n1762 t_m1_g 4624
r19146 n1763 t_m1_g 43928
r19147 n1772 t_m1_g 2928.5333333333333
r19148 n1773 t_m1_g 532.4606060606061
r19149 n1774 t_m1_g 308.26666666666665
r19150 n1775 t_m1_g 2928.5333333333333
r19151 n1784 t_m1_g 43928
r19152 n1785 t_m1_g 7986.909090909091
r19153 n1786 t_m1_g 4624
r19154 n1787 t_m1_g 43928
r19155 n544 t_m1_b 5627.8947368421059
r19156 n545 t_m1_b 53465
r19157 n546 t_m1_b 35643.333333333336
r19158 n547 t_m1_b 35643.333333333336
r19159 n548 t_m1_b 15275.714285714286
r19160 n700 t_m1_b 375.19298245614033
r19161 n701 t_m1_b 3564.3333333333335
r19162 n702 t_m1_b 2376.2222222222222
r19163 n703 t_m1_b 2376.2222222222222
r19164 n704 t_m1_b 1018.3809523809523
r19165 n856 t_m1_b 5627.8947368421059
r19166 n857 t_m1_b 53465
r19167 n858 t_m1_b 35643.333333333336
r19168 n859 t_m1_b 35643.333333333336
r19169 n860 t_m1_b 15275.714285714286
r19170 n2814 t_m1_b 331.05263157894734
r19171 n2815 t_m1_b 3145
r19172 n2816 t_m1_b 2096.6666666666665
r19173 n2817 t_m1_b 2096.6666666666665
r19174 n2818 t_m1_b 898.57142857142867
r19175 n883 t_m1_b 449.28571428571433
r19176 n887 t_m1_b 3145
r19177 n891 t_m1_b 1258
r19178 n895 t_m1_b 1048.3333333333333
r19179 n1010 t_m1_b 3145
r19180 n1125 t_m1_b 1258
r19181 n1764 t_m1_b 3145
r19182 n1776 t_m1_b 209.66666666666669
r19183 n1788 t_m1_b 3145
r19184 n2530 t_m1_b 1258
r19185 n2645 t_m1_b 3145
r19186 n2649 t_m1_b 1048.3333333333333
r19187 n2653 t_m1_b 898.57142857142867
r19188 n2657 t_m1_b 449.28571428571433
.save all
.control
set filetype=ascii
ac lin 1 842727134.33616936 842727134.33616936
write ac_0.raw all
ac lin 1 843570282.97456229 843570282.97456229
write ac_1.raw all
ac lin 1 844414275.1833086 844414275.1833086
write ac_2.raw all
quit
.endc
.end
