Device terminal AC matrices at the complete circuit operating point
.lib /home/gokalp/.local/share/perfpdn/pdks/sky130A/libs.tech/ngspice/sky130.lib.spice tt
.option scale=1e-6
.temp 27
XM1 m1_d m1_g m1_s m1_b sky130_fd_pr__pfet_01v8 L=0.15 W=6.325 nf=1 ad='int(( 1 + 1 ) / 2 ) * 6.325 / 1 * 0.29' as='int(( 1 + 2 ) / 2 ) * 6.325 / 1 * 0.29' pd='2 * int(( 1 + 1 ) / 2 ) * ( 6.325 / 1 + 0.29 )' ps='2 * int(( 1 + 2 ) / 2 ) * ( 6.325 / 1 + 0.29 )' nrd='0.29 / 6.325 ' nrs='0.29 / 6.325 ' sa=0 sb=0 sd=0 mult=1 m=1
XM2 m2_d m2_g m2_s m2_b sky130_fd_pr__nfet_01v8 L=0.15 W=1.67 nf=1 ad='int(( 1 + 1 ) / 2 ) * 1.67 / 1 * 0.29' as='int(( 1 + 2 ) / 2 ) * 1.67 / 1 * 0.29' pd='2 * int(( 1 + 1 ) / 2 ) * ( 1.67 / 1 + 0.29 )' ps='2 * int(( 1 + 2 ) / 2 ) * ( 1.67 / 1 + 0.29 )' nrd='0.29 / 1.67 ' nrs='0.29 / 1.67 ' sa=0 sb=0 sd=0 mult=1 m=1
vc_m1_d m1_d 0 DC 0.93261620957067182 AC 0
vc_m1_g m1_g 0 DC 0.89000000000000001 AC 0
vc_m1_s m1_s 0 DC 1.758792243824552 AC 0
vc_m1_b m1_b 0 DC 1.760453357681472 AC 0
vc_m2_d m2_d 0 DC 0.92855644025144624 AC 0
vc_m2_g m2_g 0 DC 0.89000000000000001 AC 0
vc_m2_s m2_s 0 DC 0.041708332789885033 AC 0
vc_m2_b m2_b 0 DC 0.039452035325774931 AC 0
.save all
.control
set filetype=ascii
op
write clamped.raw all
alter vc_m1_d acmag = 1
ac lin 1 1000 1000
write base_0_0.raw all
ac lin 1 843572840.16407275 843572840.16407275
write base_0_1.raw all
alter vc_m1_d acmag = 0
alter vc_m1_g acmag = 1
ac lin 1 1000 1000
write base_1_0.raw all
ac lin 1 843572840.16407275 843572840.16407275
write base_1_1.raw all
alter vc_m1_g acmag = 0
alter vc_m1_s acmag = 1
ac lin 1 1000 1000
write base_2_0.raw all
ac lin 1 843572840.16407275 843572840.16407275
write base_2_1.raw all
alter vc_m1_s acmag = 0
alter vc_m1_b acmag = 1
ac lin 1 1000 1000
write base_3_0.raw all
ac lin 1 843572840.16407275 843572840.16407275
write base_3_1.raw all
alter vc_m1_b acmag = 0
alter vc_m2_d acmag = 1
ac lin 1 1000 1000
write base_4_0.raw all
ac lin 1 843572840.16407275 843572840.16407275
write base_4_1.raw all
alter vc_m2_d acmag = 0
alter vc_m2_g acmag = 1
ac lin 1 1000 1000
write base_5_0.raw all
ac lin 1 843572840.16407275 843572840.16407275
write base_5_1.raw all
alter vc_m2_g acmag = 0
alter vc_m2_s acmag = 1
ac lin 1 1000 1000
write base_6_0.raw all
ac lin 1 843572840.16407275 843572840.16407275
write base_6_1.raw all
alter vc_m2_s acmag = 0
alter vc_m2_b acmag = 1
ac lin 1 1000 1000
write base_7_0.raw all
ac lin 1 843572840.16407275 843572840.16407275
write base_7_1.raw all
alter vc_m2_b acmag = 0
alter vc_m1_d dc = 0.93271620957067181
alter vc_m1_d acmag = 1
ac lin 1 1000 1000
write plus_0_0_0.raw all
ac lin 1 843572840.16407275 843572840.16407275
write plus_0_0_1.raw all
alter vc_m1_d acmag = 0
alter vc_m1_g acmag = 1
ac lin 1 1000 1000
write plus_0_1_0.raw all
ac lin 1 843572840.16407275 843572840.16407275
write plus_0_1_1.raw all
alter vc_m1_g acmag = 0
alter vc_m1_s acmag = 1
ac lin 1 1000 1000
write plus_0_2_0.raw all
ac lin 1 843572840.16407275 843572840.16407275
write plus_0_2_1.raw all
alter vc_m1_s acmag = 0
alter vc_m1_b acmag = 1
ac lin 1 1000 1000
write plus_0_3_0.raw all
ac lin 1 843572840.16407275 843572840.16407275
write plus_0_3_1.raw all
alter vc_m1_b acmag = 0
alter vc_m2_d acmag = 1
ac lin 1 1000 1000
write plus_0_4_0.raw all
ac lin 1 843572840.16407275 843572840.16407275
write plus_0_4_1.raw all
alter vc_m2_d acmag = 0
alter vc_m2_g acmag = 1
ac lin 1 1000 1000
write plus_0_5_0.raw all
ac lin 1 843572840.16407275 843572840.16407275
write plus_0_5_1.raw all
alter vc_m2_g acmag = 0
alter vc_m2_s acmag = 1
ac lin 1 1000 1000
write plus_0_6_0.raw all
ac lin 1 843572840.16407275 843572840.16407275
write plus_0_6_1.raw all
alter vc_m2_s acmag = 0
alter vc_m2_b acmag = 1
ac lin 1 1000 1000
write plus_0_7_0.raw all
ac lin 1 843572840.16407275 843572840.16407275
write plus_0_7_1.raw all
alter vc_m2_b acmag = 0
alter vc_m1_d dc = 0.93261620957067182
alter vc_m1_d dc = 0.93251620957067183
alter vc_m1_d acmag = 1
ac lin 1 1000 1000
write minus_0_0_0.raw all
ac lin 1 843572840.16407275 843572840.16407275
write minus_0_0_1.raw all
alter vc_m1_d acmag = 0
alter vc_m1_g acmag = 1
ac lin 1 1000 1000
write minus_0_1_0.raw all
ac lin 1 843572840.16407275 843572840.16407275
write minus_0_1_1.raw all
alter vc_m1_g acmag = 0
alter vc_m1_s acmag = 1
ac lin 1 1000 1000
write minus_0_2_0.raw all
ac lin 1 843572840.16407275 843572840.16407275
write minus_0_2_1.raw all
alter vc_m1_s acmag = 0
alter vc_m1_b acmag = 1
ac lin 1 1000 1000
write minus_0_3_0.raw all
ac lin 1 843572840.16407275 843572840.16407275
write minus_0_3_1.raw all
alter vc_m1_b acmag = 0
alter vc_m2_d acmag = 1
ac lin 1 1000 1000
write minus_0_4_0.raw all
ac lin 1 843572840.16407275 843572840.16407275
write minus_0_4_1.raw all
alter vc_m2_d acmag = 0
alter vc_m2_g acmag = 1
ac lin 1 1000 1000
write minus_0_5_0.raw all
ac lin 1 843572840.16407275 843572840.16407275
write minus_0_5_1.raw all
alter vc_m2_g acmag = 0
alter vc_m2_s acmag = 1
ac lin 1 1000 1000
write minus_0_6_0.raw all
ac lin 1 843572840.16407275 843572840.16407275
write minus_0_6_1.raw all
alter vc_m2_s acmag = 0
alter vc_m2_b acmag = 1
ac lin 1 1000 1000
write minus_0_7_0.raw all
ac lin 1 843572840.16407275 843572840.16407275
write minus_0_7_1.raw all
alter vc_m2_b acmag = 0
alter vc_m1_d dc = 0.93261620957067182
alter vc_m1_g dc = 0.8901
alter vc_m1_d acmag = 1
ac lin 1 1000 1000
write plus_1_0_0.raw all
ac lin 1 843572840.16407275 843572840.16407275
write plus_1_0_1.raw all
alter vc_m1_d acmag = 0
alter vc_m1_g acmag = 1
ac lin 1 1000 1000
write plus_1_1_0.raw all
ac lin 1 843572840.16407275 843572840.16407275
write plus_1_1_1.raw all
alter vc_m1_g acmag = 0
alter vc_m1_s acmag = 1
ac lin 1 1000 1000
write plus_1_2_0.raw all
ac lin 1 843572840.16407275 843572840.16407275
write plus_1_2_1.raw all
alter vc_m1_s acmag = 0
alter vc_m1_b acmag = 1
ac lin 1 1000 1000
write plus_1_3_0.raw all
ac lin 1 843572840.16407275 843572840.16407275
write plus_1_3_1.raw all
alter vc_m1_b acmag = 0
alter vc_m2_d acmag = 1
ac lin 1 1000 1000
write plus_1_4_0.raw all
ac lin 1 843572840.16407275 843572840.16407275
write plus_1_4_1.raw all
alter vc_m2_d acmag = 0
alter vc_m2_g acmag = 1
ac lin 1 1000 1000
write plus_1_5_0.raw all
ac lin 1 843572840.16407275 843572840.16407275
write plus_1_5_1.raw all
alter vc_m2_g acmag = 0
alter vc_m2_s acmag = 1
ac lin 1 1000 1000
write plus_1_6_0.raw all
ac lin 1 843572840.16407275 843572840.16407275
write plus_1_6_1.raw all
alter vc_m2_s acmag = 0
alter vc_m2_b acmag = 1
ac lin 1 1000 1000
write plus_1_7_0.raw all
ac lin 1 843572840.16407275 843572840.16407275
write plus_1_7_1.raw all
alter vc_m2_b acmag = 0
alter vc_m1_g dc = 0.89000000000000001
alter vc_m1_g dc = 0.88990000000000002
alter vc_m1_d acmag = 1
ac lin 1 1000 1000
write minus_1_0_0.raw all
ac lin 1 843572840.16407275 843572840.16407275
write minus_1_0_1.raw all
alter vc_m1_d acmag = 0
alter vc_m1_g acmag = 1
ac lin 1 1000 1000
write minus_1_1_0.raw all
ac lin 1 843572840.16407275 843572840.16407275
write minus_1_1_1.raw all
alter vc_m1_g acmag = 0
alter vc_m1_s acmag = 1
ac lin 1 1000 1000
write minus_1_2_0.raw all
ac lin 1 843572840.16407275 843572840.16407275
write minus_1_2_1.raw all
alter vc_m1_s acmag = 0
alter vc_m1_b acmag = 1
ac lin 1 1000 1000
write minus_1_3_0.raw all
ac lin 1 843572840.16407275 843572840.16407275
write minus_1_3_1.raw all
alter vc_m1_b acmag = 0
alter vc_m2_d acmag = 1
ac lin 1 1000 1000
write minus_1_4_0.raw all
ac lin 1 843572840.16407275 843572840.16407275
write minus_1_4_1.raw all
alter vc_m2_d acmag = 0
alter vc_m2_g acmag = 1
ac lin 1 1000 1000
write minus_1_5_0.raw all
ac lin 1 843572840.16407275 843572840.16407275
write minus_1_5_1.raw all
alter vc_m2_g acmag = 0
alter vc_m2_s acmag = 1
ac lin 1 1000 1000
write minus_1_6_0.raw all
ac lin 1 843572840.16407275 843572840.16407275
write minus_1_6_1.raw all
alter vc_m2_s acmag = 0
alter vc_m2_b acmag = 1
ac lin 1 1000 1000
write minus_1_7_0.raw all
ac lin 1 843572840.16407275 843572840.16407275
write minus_1_7_1.raw all
alter vc_m2_b acmag = 0
alter vc_m1_g dc = 0.89000000000000001
alter vc_m1_s dc = 1.758892243824552
alter vc_m1_d acmag = 1
ac lin 1 1000 1000
write plus_2_0_0.raw all
ac lin 1 843572840.16407275 843572840.16407275
write plus_2_0_1.raw all
alter vc_m1_d acmag = 0
alter vc_m1_g acmag = 1
ac lin 1 1000 1000
write plus_2_1_0.raw all
ac lin 1 843572840.16407275 843572840.16407275
write plus_2_1_1.raw all
alter vc_m1_g acmag = 0
alter vc_m1_s acmag = 1
ac lin 1 1000 1000
write plus_2_2_0.raw all
ac lin 1 843572840.16407275 843572840.16407275
write plus_2_2_1.raw all
alter vc_m1_s acmag = 0
alter vc_m1_b acmag = 1
ac lin 1 1000 1000
write plus_2_3_0.raw all
ac lin 1 843572840.16407275 843572840.16407275
write plus_2_3_1.raw all
alter vc_m1_b acmag = 0
alter vc_m2_d acmag = 1
ac lin 1 1000 1000
write plus_2_4_0.raw all
ac lin 1 843572840.16407275 843572840.16407275
write plus_2_4_1.raw all
alter vc_m2_d acmag = 0
alter vc_m2_g acmag = 1
ac lin 1 1000 1000
write plus_2_5_0.raw all
ac lin 1 843572840.16407275 843572840.16407275
write plus_2_5_1.raw all
alter vc_m2_g acmag = 0
alter vc_m2_s acmag = 1
ac lin 1 1000 1000
write plus_2_6_0.raw all
ac lin 1 843572840.16407275 843572840.16407275
write plus_2_6_1.raw all
alter vc_m2_s acmag = 0
alter vc_m2_b acmag = 1
ac lin 1 1000 1000
write plus_2_7_0.raw all
ac lin 1 843572840.16407275 843572840.16407275
write plus_2_7_1.raw all
alter vc_m2_b acmag = 0
alter vc_m1_s dc = 1.758792243824552
alter vc_m1_s dc = 1.758692243824552
alter vc_m1_d acmag = 1
ac lin 1 1000 1000
write minus_2_0_0.raw all
ac lin 1 843572840.16407275 843572840.16407275
write minus_2_0_1.raw all
alter vc_m1_d acmag = 0
alter vc_m1_g acmag = 1
ac lin 1 1000 1000
write minus_2_1_0.raw all
ac lin 1 843572840.16407275 843572840.16407275
write minus_2_1_1.raw all
alter vc_m1_g acmag = 0
alter vc_m1_s acmag = 1
ac lin 1 1000 1000
write minus_2_2_0.raw all
ac lin 1 843572840.16407275 843572840.16407275
write minus_2_2_1.raw all
alter vc_m1_s acmag = 0
alter vc_m1_b acmag = 1
ac lin 1 1000 1000
write minus_2_3_0.raw all
ac lin 1 843572840.16407275 843572840.16407275
write minus_2_3_1.raw all
alter vc_m1_b acmag = 0
alter vc_m2_d acmag = 1
ac lin 1 1000 1000
write minus_2_4_0.raw all
ac lin 1 843572840.16407275 843572840.16407275
write minus_2_4_1.raw all
alter vc_m2_d acmag = 0
alter vc_m2_g acmag = 1
ac lin 1 1000 1000
write minus_2_5_0.raw all
ac lin 1 843572840.16407275 843572840.16407275
write minus_2_5_1.raw all
alter vc_m2_g acmag = 0
alter vc_m2_s acmag = 1
ac lin 1 1000 1000
write minus_2_6_0.raw all
ac lin 1 843572840.16407275 843572840.16407275
write minus_2_6_1.raw all
alter vc_m2_s acmag = 0
alter vc_m2_b acmag = 1
ac lin 1 1000 1000
write minus_2_7_0.raw all
ac lin 1 843572840.16407275 843572840.16407275
write minus_2_7_1.raw all
alter vc_m2_b acmag = 0
alter vc_m1_s dc = 1.758792243824552
alter vc_m1_b dc = 1.760553357681472
alter vc_m1_d acmag = 1
ac lin 1 1000 1000
write plus_3_0_0.raw all
ac lin 1 843572840.16407275 843572840.16407275
write plus_3_0_1.raw all
alter vc_m1_d acmag = 0
alter vc_m1_g acmag = 1
ac lin 1 1000 1000
write plus_3_1_0.raw all
ac lin 1 843572840.16407275 843572840.16407275
write plus_3_1_1.raw all
alter vc_m1_g acmag = 0
alter vc_m1_s acmag = 1
ac lin 1 1000 1000
write plus_3_2_0.raw all
ac lin 1 843572840.16407275 843572840.16407275
write plus_3_2_1.raw all
alter vc_m1_s acmag = 0
alter vc_m1_b acmag = 1
ac lin 1 1000 1000
write plus_3_3_0.raw all
ac lin 1 843572840.16407275 843572840.16407275
write plus_3_3_1.raw all
alter vc_m1_b acmag = 0
alter vc_m2_d acmag = 1
ac lin 1 1000 1000
write plus_3_4_0.raw all
ac lin 1 843572840.16407275 843572840.16407275
write plus_3_4_1.raw all
alter vc_m2_d acmag = 0
alter vc_m2_g acmag = 1
ac lin 1 1000 1000
write plus_3_5_0.raw all
ac lin 1 843572840.16407275 843572840.16407275
write plus_3_5_1.raw all
alter vc_m2_g acmag = 0
alter vc_m2_s acmag = 1
ac lin 1 1000 1000
write plus_3_6_0.raw all
ac lin 1 843572840.16407275 843572840.16407275
write plus_3_6_1.raw all
alter vc_m2_s acmag = 0
alter vc_m2_b acmag = 1
ac lin 1 1000 1000
write plus_3_7_0.raw all
ac lin 1 843572840.16407275 843572840.16407275
write plus_3_7_1.raw all
alter vc_m2_b acmag = 0
alter vc_m1_b dc = 1.760453357681472
alter vc_m1_b dc = 1.7603533576814721
alter vc_m1_d acmag = 1
ac lin 1 1000 1000
write minus_3_0_0.raw all
ac lin 1 843572840.16407275 843572840.16407275
write minus_3_0_1.raw all
alter vc_m1_d acmag = 0
alter vc_m1_g acmag = 1
ac lin 1 1000 1000
write minus_3_1_0.raw all
ac lin 1 843572840.16407275 843572840.16407275
write minus_3_1_1.raw all
alter vc_m1_g acmag = 0
alter vc_m1_s acmag = 1
ac lin 1 1000 1000
write minus_3_2_0.raw all
ac lin 1 843572840.16407275 843572840.16407275
write minus_3_2_1.raw all
alter vc_m1_s acmag = 0
alter vc_m1_b acmag = 1
ac lin 1 1000 1000
write minus_3_3_0.raw all
ac lin 1 843572840.16407275 843572840.16407275
write minus_3_3_1.raw all
alter vc_m1_b acmag = 0
alter vc_m2_d acmag = 1
ac lin 1 1000 1000
write minus_3_4_0.raw all
ac lin 1 843572840.16407275 843572840.16407275
write minus_3_4_1.raw all
alter vc_m2_d acmag = 0
alter vc_m2_g acmag = 1
ac lin 1 1000 1000
write minus_3_5_0.raw all
ac lin 1 843572840.16407275 843572840.16407275
write minus_3_5_1.raw all
alter vc_m2_g acmag = 0
alter vc_m2_s acmag = 1
ac lin 1 1000 1000
write minus_3_6_0.raw all
ac lin 1 843572840.16407275 843572840.16407275
write minus_3_6_1.raw all
alter vc_m2_s acmag = 0
alter vc_m2_b acmag = 1
ac lin 1 1000 1000
write minus_3_7_0.raw all
ac lin 1 843572840.16407275 843572840.16407275
write minus_3_7_1.raw all
alter vc_m2_b acmag = 0
alter vc_m1_b dc = 1.760453357681472
alter vc_m2_d dc = 0.92865644025144622
alter vc_m1_d acmag = 1
ac lin 1 1000 1000
write plus_4_0_0.raw all
ac lin 1 843572840.16407275 843572840.16407275
write plus_4_0_1.raw all
alter vc_m1_d acmag = 0
alter vc_m1_g acmag = 1
ac lin 1 1000 1000
write plus_4_1_0.raw all
ac lin 1 843572840.16407275 843572840.16407275
write plus_4_1_1.raw all
alter vc_m1_g acmag = 0
alter vc_m1_s acmag = 1
ac lin 1 1000 1000
write plus_4_2_0.raw all
ac lin 1 843572840.16407275 843572840.16407275
write plus_4_2_1.raw all
alter vc_m1_s acmag = 0
alter vc_m1_b acmag = 1
ac lin 1 1000 1000
write plus_4_3_0.raw all
ac lin 1 843572840.16407275 843572840.16407275
write plus_4_3_1.raw all
alter vc_m1_b acmag = 0
alter vc_m2_d acmag = 1
ac lin 1 1000 1000
write plus_4_4_0.raw all
ac lin 1 843572840.16407275 843572840.16407275
write plus_4_4_1.raw all
alter vc_m2_d acmag = 0
alter vc_m2_g acmag = 1
ac lin 1 1000 1000
write plus_4_5_0.raw all
ac lin 1 843572840.16407275 843572840.16407275
write plus_4_5_1.raw all
alter vc_m2_g acmag = 0
alter vc_m2_s acmag = 1
ac lin 1 1000 1000
write plus_4_6_0.raw all
ac lin 1 843572840.16407275 843572840.16407275
write plus_4_6_1.raw all
alter vc_m2_s acmag = 0
alter vc_m2_b acmag = 1
ac lin 1 1000 1000
write plus_4_7_0.raw all
ac lin 1 843572840.16407275 843572840.16407275
write plus_4_7_1.raw all
alter vc_m2_b acmag = 0
alter vc_m2_d dc = 0.92855644025144624
alter vc_m2_d dc = 0.92845644025144625
alter vc_m1_d acmag = 1
ac lin 1 1000 1000
write minus_4_0_0.raw all
ac lin 1 843572840.16407275 843572840.16407275
write minus_4_0_1.raw all
alter vc_m1_d acmag = 0
alter vc_m1_g acmag = 1
ac lin 1 1000 1000
write minus_4_1_0.raw all
ac lin 1 843572840.16407275 843572840.16407275
write minus_4_1_1.raw all
alter vc_m1_g acmag = 0
alter vc_m1_s acmag = 1
ac lin 1 1000 1000
write minus_4_2_0.raw all
ac lin 1 843572840.16407275 843572840.16407275
write minus_4_2_1.raw all
alter vc_m1_s acmag = 0
alter vc_m1_b acmag = 1
ac lin 1 1000 1000
write minus_4_3_0.raw all
ac lin 1 843572840.16407275 843572840.16407275
write minus_4_3_1.raw all
alter vc_m1_b acmag = 0
alter vc_m2_d acmag = 1
ac lin 1 1000 1000
write minus_4_4_0.raw all
ac lin 1 843572840.16407275 843572840.16407275
write minus_4_4_1.raw all
alter vc_m2_d acmag = 0
alter vc_m2_g acmag = 1
ac lin 1 1000 1000
write minus_4_5_0.raw all
ac lin 1 843572840.16407275 843572840.16407275
write minus_4_5_1.raw all
alter vc_m2_g acmag = 0
alter vc_m2_s acmag = 1
ac lin 1 1000 1000
write minus_4_6_0.raw all
ac lin 1 843572840.16407275 843572840.16407275
write minus_4_6_1.raw all
alter vc_m2_s acmag = 0
alter vc_m2_b acmag = 1
ac lin 1 1000 1000
write minus_4_7_0.raw all
ac lin 1 843572840.16407275 843572840.16407275
write minus_4_7_1.raw all
alter vc_m2_b acmag = 0
alter vc_m2_d dc = 0.92855644025144624
alter vc_m2_g dc = 0.8901
alter vc_m1_d acmag = 1
ac lin 1 1000 1000
write plus_5_0_0.raw all
ac lin 1 843572840.16407275 843572840.16407275
write plus_5_0_1.raw all
alter vc_m1_d acmag = 0
alter vc_m1_g acmag = 1
ac lin 1 1000 1000
write plus_5_1_0.raw all
ac lin 1 843572840.16407275 843572840.16407275
write plus_5_1_1.raw all
alter vc_m1_g acmag = 0
alter vc_m1_s acmag = 1
ac lin 1 1000 1000
write plus_5_2_0.raw all
ac lin 1 843572840.16407275 843572840.16407275
write plus_5_2_1.raw all
alter vc_m1_s acmag = 0
alter vc_m1_b acmag = 1
ac lin 1 1000 1000
write plus_5_3_0.raw all
ac lin 1 843572840.16407275 843572840.16407275
write plus_5_3_1.raw all
alter vc_m1_b acmag = 0
alter vc_m2_d acmag = 1
ac lin 1 1000 1000
write plus_5_4_0.raw all
ac lin 1 843572840.16407275 843572840.16407275
write plus_5_4_1.raw all
alter vc_m2_d acmag = 0
alter vc_m2_g acmag = 1
ac lin 1 1000 1000
write plus_5_5_0.raw all
ac lin 1 843572840.16407275 843572840.16407275
write plus_5_5_1.raw all
alter vc_m2_g acmag = 0
alter vc_m2_s acmag = 1
ac lin 1 1000 1000
write plus_5_6_0.raw all
ac lin 1 843572840.16407275 843572840.16407275
write plus_5_6_1.raw all
alter vc_m2_s acmag = 0
alter vc_m2_b acmag = 1
ac lin 1 1000 1000
write plus_5_7_0.raw all
ac lin 1 843572840.16407275 843572840.16407275
write plus_5_7_1.raw all
alter vc_m2_b acmag = 0
alter vc_m2_g dc = 0.89000000000000001
alter vc_m2_g dc = 0.88990000000000002
alter vc_m1_d acmag = 1
ac lin 1 1000 1000
write minus_5_0_0.raw all
ac lin 1 843572840.16407275 843572840.16407275
write minus_5_0_1.raw all
alter vc_m1_d acmag = 0
alter vc_m1_g acmag = 1
ac lin 1 1000 1000
write minus_5_1_0.raw all
ac lin 1 843572840.16407275 843572840.16407275
write minus_5_1_1.raw all
alter vc_m1_g acmag = 0
alter vc_m1_s acmag = 1
ac lin 1 1000 1000
write minus_5_2_0.raw all
ac lin 1 843572840.16407275 843572840.16407275
write minus_5_2_1.raw all
alter vc_m1_s acmag = 0
alter vc_m1_b acmag = 1
ac lin 1 1000 1000
write minus_5_3_0.raw all
ac lin 1 843572840.16407275 843572840.16407275
write minus_5_3_1.raw all
alter vc_m1_b acmag = 0
alter vc_m2_d acmag = 1
ac lin 1 1000 1000
write minus_5_4_0.raw all
ac lin 1 843572840.16407275 843572840.16407275
write minus_5_4_1.raw all
alter vc_m2_d acmag = 0
alter vc_m2_g acmag = 1
ac lin 1 1000 1000
write minus_5_5_0.raw all
ac lin 1 843572840.16407275 843572840.16407275
write minus_5_5_1.raw all
alter vc_m2_g acmag = 0
alter vc_m2_s acmag = 1
ac lin 1 1000 1000
write minus_5_6_0.raw all
ac lin 1 843572840.16407275 843572840.16407275
write minus_5_6_1.raw all
alter vc_m2_s acmag = 0
alter vc_m2_b acmag = 1
ac lin 1 1000 1000
write minus_5_7_0.raw all
ac lin 1 843572840.16407275 843572840.16407275
write minus_5_7_1.raw all
alter vc_m2_b acmag = 0
alter vc_m2_g dc = 0.89000000000000001
alter vc_m2_s dc = 0.041808332789885036
alter vc_m1_d acmag = 1
ac lin 1 1000 1000
write plus_6_0_0.raw all
ac lin 1 843572840.16407275 843572840.16407275
write plus_6_0_1.raw all
alter vc_m1_d acmag = 0
alter vc_m1_g acmag = 1
ac lin 1 1000 1000
write plus_6_1_0.raw all
ac lin 1 843572840.16407275 843572840.16407275
write plus_6_1_1.raw all
alter vc_m1_g acmag = 0
alter vc_m1_s acmag = 1
ac lin 1 1000 1000
write plus_6_2_0.raw all
ac lin 1 843572840.16407275 843572840.16407275
write plus_6_2_1.raw all
alter vc_m1_s acmag = 0
alter vc_m1_b acmag = 1
ac lin 1 1000 1000
write plus_6_3_0.raw all
ac lin 1 843572840.16407275 843572840.16407275
write plus_6_3_1.raw all
alter vc_m1_b acmag = 0
alter vc_m2_d acmag = 1
ac lin 1 1000 1000
write plus_6_4_0.raw all
ac lin 1 843572840.16407275 843572840.16407275
write plus_6_4_1.raw all
alter vc_m2_d acmag = 0
alter vc_m2_g acmag = 1
ac lin 1 1000 1000
write plus_6_5_0.raw all
ac lin 1 843572840.16407275 843572840.16407275
write plus_6_5_1.raw all
alter vc_m2_g acmag = 0
alter vc_m2_s acmag = 1
ac lin 1 1000 1000
write plus_6_6_0.raw all
ac lin 1 843572840.16407275 843572840.16407275
write plus_6_6_1.raw all
alter vc_m2_s acmag = 0
alter vc_m2_b acmag = 1
ac lin 1 1000 1000
write plus_6_7_0.raw all
ac lin 1 843572840.16407275 843572840.16407275
write plus_6_7_1.raw all
alter vc_m2_b acmag = 0
alter vc_m2_s dc = 0.041708332789885033
alter vc_m2_s dc = 0.04160833278988503
alter vc_m1_d acmag = 1
ac lin 1 1000 1000
write minus_6_0_0.raw all
ac lin 1 843572840.16407275 843572840.16407275
write minus_6_0_1.raw all
alter vc_m1_d acmag = 0
alter vc_m1_g acmag = 1
ac lin 1 1000 1000
write minus_6_1_0.raw all
ac lin 1 843572840.16407275 843572840.16407275
write minus_6_1_1.raw all
alter vc_m1_g acmag = 0
alter vc_m1_s acmag = 1
ac lin 1 1000 1000
write minus_6_2_0.raw all
ac lin 1 843572840.16407275 843572840.16407275
write minus_6_2_1.raw all
alter vc_m1_s acmag = 0
alter vc_m1_b acmag = 1
ac lin 1 1000 1000
write minus_6_3_0.raw all
ac lin 1 843572840.16407275 843572840.16407275
write minus_6_3_1.raw all
alter vc_m1_b acmag = 0
alter vc_m2_d acmag = 1
ac lin 1 1000 1000
write minus_6_4_0.raw all
ac lin 1 843572840.16407275 843572840.16407275
write minus_6_4_1.raw all
alter vc_m2_d acmag = 0
alter vc_m2_g acmag = 1
ac lin 1 1000 1000
write minus_6_5_0.raw all
ac lin 1 843572840.16407275 843572840.16407275
write minus_6_5_1.raw all
alter vc_m2_g acmag = 0
alter vc_m2_s acmag = 1
ac lin 1 1000 1000
write minus_6_6_0.raw all
ac lin 1 843572840.16407275 843572840.16407275
write minus_6_6_1.raw all
alter vc_m2_s acmag = 0
alter vc_m2_b acmag = 1
ac lin 1 1000 1000
write minus_6_7_0.raw all
ac lin 1 843572840.16407275 843572840.16407275
write minus_6_7_1.raw all
alter vc_m2_b acmag = 0
alter vc_m2_s dc = 0.041708332789885033
alter vc_m2_b dc = 0.039552035325774934
alter vc_m1_d acmag = 1
ac lin 1 1000 1000
write plus_7_0_0.raw all
ac lin 1 843572840.16407275 843572840.16407275
write plus_7_0_1.raw all
alter vc_m1_d acmag = 0
alter vc_m1_g acmag = 1
ac lin 1 1000 1000
write plus_7_1_0.raw all
ac lin 1 843572840.16407275 843572840.16407275
write plus_7_1_1.raw all
alter vc_m1_g acmag = 0
alter vc_m1_s acmag = 1
ac lin 1 1000 1000
write plus_7_2_0.raw all
ac lin 1 843572840.16407275 843572840.16407275
write plus_7_2_1.raw all
alter vc_m1_s acmag = 0
alter vc_m1_b acmag = 1
ac lin 1 1000 1000
write plus_7_3_0.raw all
ac lin 1 843572840.16407275 843572840.16407275
write plus_7_3_1.raw all
alter vc_m1_b acmag = 0
alter vc_m2_d acmag = 1
ac lin 1 1000 1000
write plus_7_4_0.raw all
ac lin 1 843572840.16407275 843572840.16407275
write plus_7_4_1.raw all
alter vc_m2_d acmag = 0
alter vc_m2_g acmag = 1
ac lin 1 1000 1000
write plus_7_5_0.raw all
ac lin 1 843572840.16407275 843572840.16407275
write plus_7_5_1.raw all
alter vc_m2_g acmag = 0
alter vc_m2_s acmag = 1
ac lin 1 1000 1000
write plus_7_6_0.raw all
ac lin 1 843572840.16407275 843572840.16407275
write plus_7_6_1.raw all
alter vc_m2_s acmag = 0
alter vc_m2_b acmag = 1
ac lin 1 1000 1000
write plus_7_7_0.raw all
ac lin 1 843572840.16407275 843572840.16407275
write plus_7_7_1.raw all
alter vc_m2_b acmag = 0
alter vc_m2_b dc = 0.039452035325774931
alter vc_m2_b dc = 0.039352035325774928
alter vc_m1_d acmag = 1
ac lin 1 1000 1000
write minus_7_0_0.raw all
ac lin 1 843572840.16407275 843572840.16407275
write minus_7_0_1.raw all
alter vc_m1_d acmag = 0
alter vc_m1_g acmag = 1
ac lin 1 1000 1000
write minus_7_1_0.raw all
ac lin 1 843572840.16407275 843572840.16407275
write minus_7_1_1.raw all
alter vc_m1_g acmag = 0
alter vc_m1_s acmag = 1
ac lin 1 1000 1000
write minus_7_2_0.raw all
ac lin 1 843572840.16407275 843572840.16407275
write minus_7_2_1.raw all
alter vc_m1_s acmag = 0
alter vc_m1_b acmag = 1
ac lin 1 1000 1000
write minus_7_3_0.raw all
ac lin 1 843572840.16407275 843572840.16407275
write minus_7_3_1.raw all
alter vc_m1_b acmag = 0
alter vc_m2_d acmag = 1
ac lin 1 1000 1000
write minus_7_4_0.raw all
ac lin 1 843572840.16407275 843572840.16407275
write minus_7_4_1.raw all
alter vc_m2_d acmag = 0
alter vc_m2_g acmag = 1
ac lin 1 1000 1000
write minus_7_5_0.raw all
ac lin 1 843572840.16407275 843572840.16407275
write minus_7_5_1.raw all
alter vc_m2_g acmag = 0
alter vc_m2_s acmag = 1
ac lin 1 1000 1000
write minus_7_6_0.raw all
ac lin 1 843572840.16407275 843572840.16407275
write minus_7_6_1.raw all
alter vc_m2_s acmag = 0
alter vc_m2_b acmag = 1
ac lin 1 1000 1000
write minus_7_7_0.raw all
ac lin 1 843572840.16407275 843572840.16407275
write minus_7_7_1.raw all
alter vc_m2_b acmag = 0
alter vc_m2_b dc = 0.039452035325774931
quit
.endc
.end
