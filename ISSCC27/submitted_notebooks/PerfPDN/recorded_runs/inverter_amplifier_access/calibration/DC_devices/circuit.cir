MOS terminal derivatives at the complete circuit's solved operating point
.lib /home/gokalp/.local/share/perfpdn/pdks/sky130A/libs.tech/ngspice/sky130.lib.spice tt
.option scale=1e-6
.temp 27
XM1 m1_d m1_g m1_s m1_b sky130_fd_pr__pfet_01v8 L=0.15 W=6.325 nf=1 ad='int(( 1 + 1 ) / 2 ) * 6.325 / 1 * 0.29' as='int(( 1 + 2 ) / 2 ) * 6.325 / 1 * 0.29' pd='2 * int(( 1 + 1 ) / 2 ) * ( 6.325 / 1 + 0.29 )' ps='2 * int(( 1 + 2 ) / 2 ) * ( 6.325 / 1 + 0.29 )' nrd='0.29 / 6.325 ' nrs='0.29 / 6.325 ' sa=0 sb=0 sd=0 mult=1 m=1
XM2 m2_d m2_g m2_s m2_b sky130_fd_pr__nfet_01v8 L=0.15 W=1.67 nf=1 ad='int(( 1 + 1 ) / 2 ) * 1.67 / 1 * 0.29' as='int(( 1 + 2 ) / 2 ) * 1.67 / 1 * 0.29' pd='2 * int(( 1 + 1 ) / 2 ) * ( 1.67 / 1 + 0.29 )' ps='2 * int(( 1 + 2 ) / 2 ) * ( 1.67 / 1 + 0.29 )' nrd='0.29 / 1.67 ' nrs='0.29 / 1.67 ' sa=0 sb=0 sd=0 mult=1 m=1
vc_m1_d m1_d 0 0.93261620957067182
vc_m1_g m1_g 0 0.89000000000000001
vc_m1_s m1_s 0 1.758792243824552
vc_m1_b m1_b 0 1.760453357681472
vc_m2_d m2_d 0 0.92855644025144624
vc_m2_g m2_g 0 0.89000000000000001
vc_m2_s m2_s 0 0.041708332789885033
vc_m2_b m2_b 0 0.039452035325774931
.control
set filetype=ascii
op
write clamped.raw all
tf i(vc_m1_d) vc_m1_d
write tf_0_0.raw all
tf i(vc_m1_d) vc_m1_g
write tf_0_1.raw all
tf i(vc_m1_d) vc_m1_s
write tf_0_2.raw all
tf i(vc_m1_d) vc_m1_b
write tf_0_3.raw all
tf i(vc_m1_d) vc_m2_d
write tf_0_4.raw all
tf i(vc_m1_d) vc_m2_g
write tf_0_5.raw all
tf i(vc_m1_d) vc_m2_s
write tf_0_6.raw all
tf i(vc_m1_d) vc_m2_b
write tf_0_7.raw all
tf i(vc_m1_g) vc_m1_d
write tf_1_0.raw all
tf i(vc_m1_g) vc_m1_g
write tf_1_1.raw all
tf i(vc_m1_g) vc_m1_s
write tf_1_2.raw all
tf i(vc_m1_g) vc_m1_b
write tf_1_3.raw all
tf i(vc_m1_g) vc_m2_d
write tf_1_4.raw all
tf i(vc_m1_g) vc_m2_g
write tf_1_5.raw all
tf i(vc_m1_g) vc_m2_s
write tf_1_6.raw all
tf i(vc_m1_g) vc_m2_b
write tf_1_7.raw all
tf i(vc_m1_s) vc_m1_d
write tf_2_0.raw all
tf i(vc_m1_s) vc_m1_g
write tf_2_1.raw all
tf i(vc_m1_s) vc_m1_s
write tf_2_2.raw all
tf i(vc_m1_s) vc_m1_b
write tf_2_3.raw all
tf i(vc_m1_s) vc_m2_d
write tf_2_4.raw all
tf i(vc_m1_s) vc_m2_g
write tf_2_5.raw all
tf i(vc_m1_s) vc_m2_s
write tf_2_6.raw all
tf i(vc_m1_s) vc_m2_b
write tf_2_7.raw all
tf i(vc_m1_b) vc_m1_d
write tf_3_0.raw all
tf i(vc_m1_b) vc_m1_g
write tf_3_1.raw all
tf i(vc_m1_b) vc_m1_s
write tf_3_2.raw all
tf i(vc_m1_b) vc_m1_b
write tf_3_3.raw all
tf i(vc_m1_b) vc_m2_d
write tf_3_4.raw all
tf i(vc_m1_b) vc_m2_g
write tf_3_5.raw all
tf i(vc_m1_b) vc_m2_s
write tf_3_6.raw all
tf i(vc_m1_b) vc_m2_b
write tf_3_7.raw all
tf i(vc_m2_d) vc_m1_d
write tf_4_0.raw all
tf i(vc_m2_d) vc_m1_g
write tf_4_1.raw all
tf i(vc_m2_d) vc_m1_s
write tf_4_2.raw all
tf i(vc_m2_d) vc_m1_b
write tf_4_3.raw all
tf i(vc_m2_d) vc_m2_d
write tf_4_4.raw all
tf i(vc_m2_d) vc_m2_g
write tf_4_5.raw all
tf i(vc_m2_d) vc_m2_s
write tf_4_6.raw all
tf i(vc_m2_d) vc_m2_b
write tf_4_7.raw all
tf i(vc_m2_g) vc_m1_d
write tf_5_0.raw all
tf i(vc_m2_g) vc_m1_g
write tf_5_1.raw all
tf i(vc_m2_g) vc_m1_s
write tf_5_2.raw all
tf i(vc_m2_g) vc_m1_b
write tf_5_3.raw all
tf i(vc_m2_g) vc_m2_d
write tf_5_4.raw all
tf i(vc_m2_g) vc_m2_g
write tf_5_5.raw all
tf i(vc_m2_g) vc_m2_s
write tf_5_6.raw all
tf i(vc_m2_g) vc_m2_b
write tf_5_7.raw all
tf i(vc_m2_s) vc_m1_d
write tf_6_0.raw all
tf i(vc_m2_s) vc_m1_g
write tf_6_1.raw all
tf i(vc_m2_s) vc_m1_s
write tf_6_2.raw all
tf i(vc_m2_s) vc_m1_b
write tf_6_3.raw all
tf i(vc_m2_s) vc_m2_d
write tf_6_4.raw all
tf i(vc_m2_s) vc_m2_g
write tf_6_5.raw all
tf i(vc_m2_s) vc_m2_s
write tf_6_6.raw all
tf i(vc_m2_s) vc_m2_b
write tf_6_7.raw all
tf i(vc_m2_b) vc_m1_d
write tf_7_0.raw all
tf i(vc_m2_b) vc_m1_g
write tf_7_1.raw all
tf i(vc_m2_b) vc_m1_s
write tf_7_2.raw all
tf i(vc_m2_b) vc_m1_b
write tf_7_3.raw all
tf i(vc_m2_b) vc_m2_d
write tf_7_4.raw all
tf i(vc_m2_b) vc_m2_g
write tf_7_5.raw all
tf i(vc_m2_b) vc_m2_s
write tf_7_6.raw all
tf i(vc_m2_b) vc_m2_b
write tf_7_7.raw all
.endc
.end
