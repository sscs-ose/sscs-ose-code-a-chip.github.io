PerfPDN frequency sweep
.lib /home/gokalp/.local/share/perfpdn/pdks/sky130A/libs.tech/ngspice/sky130.lib.spice tt
.option scale=1e-6
.temp 27
.option klu reltol=1e-8 abstol=1e-14 vntol=1e-10
vdd vdd 0 DC 0 AC 0 0
vin in 0 DC 0 AC 1 0
C1 out 0 1e-13
v_m1_d t_m1_d m1_d 0
v_m1_g t_m1_g m1_g -0.89000000000000001
v_m1_s t_m1_s m1_s -1.8
v_m1_b t_m1_b m1_b -1.8
XM1 m1_d m1_g m1_s m1_b sky130_fd_pr__pfet_01v8 L=0.15 W=6.325 nf=1 ad='int(( 1 + 1 ) / 2 ) * 6.325 / 1 * 0.29' as='int(( 1 + 2 ) / 2 ) * 6.325 / 1 * 0.29' pd='2 * int(( 1 + 1 ) / 2 ) * ( 6.325 / 1 + 0.29 )' ps='2 * int(( 1 + 2 ) / 2 ) * ( 6.325 / 1 + 0.29 )' nrd='0.29 / 6.325 ' nrs='0.29 / 6.325 ' sa=0 sb=0 sd=0 mult=1 m=1
v_m2_d t_m2_d m2_d 0
v_m2_g t_m2_g m2_g -0.89000000000000001
v_m2_s t_m2_s m2_s -0
v_m2_b t_m2_b m2_b -0
XM2 m2_d m2_g m2_s m2_b sky130_fd_pr__nfet_01v8 L=0.15 W=1.67 nf=1 ad='int(( 1 + 1 ) / 2 ) * 1.67 / 1 * 0.29' as='int(( 1 + 2 ) / 2 ) * 1.67 / 1 * 0.29' pd='2 * int(( 1 + 1 ) / 2 ) * ( 1.67 / 1 + 0.29 )' ps='2 * int(( 1 + 2 ) / 2 ) * ( 1.67 / 1 + 0.29 )' nrd='0.29 / 1.67 ' nrs='0.29 / 1.67 ' sa=0 sb=0 sd=0 mult=1 m=1
r0 n0 n1 1.6372093023255814
r1 n1 n2 1.4883720930232558
r2 n2 n3 4.7627906976744185
r3 n3 n4 3.7209302325581395
r4 n4 n5 4.7627906976744185
r5 n5 n6 4.7627906976744185
r6 n6 n7 3.7209302325581395
r7 n7 n8 4.7627906976744185
r8 n8 n9 1.4883720930232558
r9 n9 n10 1.6372093023255814
r10 n11 n12 2.9767441860465116
r11 n12 n13 4.9116279069767446
r12 n13 n14 3.7209302325581395
r13 n14 n15 4.7627906976744185
r14 n15 n16 4.7627906976744185
r15 n16 n17 3.7209302325581395
r16 n17 n18 4.9116279069767446
r17 n18 n19 2.9767441860465116
r18 n0 n20 49.280000000000001
r19 n1 n21 492.80000000000001
r20 n20 n21 2.0705882352941178
r21 n2 n22 54.755555555555553
r22 n21 n22 1.8823529411764706
r23 n3 n23 21.42608695652174
r24 n22 n23 6.0235294117647058
r25 n4 n24 246.40000000000001
r26 n23 n24 4.7058823529411766
r27 n5 n25 16.426666666666666
r28 n24 n25 6.0235294117647058
r29 n6 n26 246.40000000000001
r30 n25 n26 6.0235294117647058
r31 n7 n27 21.42608695652174
r32 n26 n27 4.7058823529411766
r33 n8 n28 54.755555555555553
r34 n27 n28 6.0235294117647058
r35 n9 n29 492.80000000000001
r36 n28 n29 1.8823529411764706
r37 n10 n30 49.280000000000001
r38 n29 n30 2.0705882352941178
r39 n11 n31 49.280000000000001
r40 n12 n32 49.280000000000001
r41 n31 n32 3.7647058823529411
r42 n13 n33 21.42608695652174
r43 n32 n33 6.2117647058823531
r44 n14 n34 246.40000000000001
r45 n33 n34 4.7058823529411766
r46 n15 n35 16.426666666666666
r47 n34 n35 6.0235294117647058
r48 n16 n36 246.40000000000001
r49 n35 n36 6.0235294117647058
r50 n17 n37 21.42608695652174
r51 n36 n37 4.7058823529411766
r52 n18 n38 49.280000000000001
r53 n37 n38 6.2117647058823531
r54 n19 n39 49.280000000000001
r55 n38 n39 3.7647058823529411
r56 n20 n40 49.280000000000001
r57 n21 n41 492.80000000000001
r58 n40 n41 1.6372093023255814
r59 n22 n42 54.755555555555553
r60 n41 n42 1.4883720930232558
r61 n23 n43 21.42608695652174
r62 n42 n43 4.7627906976744185
r63 n24 n44 246.40000000000001
r64 n43 n44 3.7209302325581395
r65 n25 n45 16.426666666666666
r66 n44 n45 4.7627906976744185
r67 n26 n46 246.40000000000001
r68 n45 n46 4.7627906976744185
r69 n27 n47 21.42608695652174
r70 n46 n47 3.7209302325581395
r71 n28 n48 54.755555555555553
r72 n47 n48 4.7627906976744185
r73 n29 n49 492.80000000000001
r74 n48 n49 1.4883720930232558
r75 n30 n50 49.280000000000001
r76 n49 n50 1.6372093023255814
r77 n31 n51 49.280000000000001
r78 n32 n52 49.280000000000001
r79 n51 n52 2.9767441860465116
r80 n33 n53 21.42608695652174
r81 n52 n53 4.9116279069767446
r82 n34 n54 246.40000000000001
r83 n53 n54 3.7209302325581395
r84 n35 n55 16.426666666666666
r85 n54 n55 4.7627906976744185
r86 n36 n56 246.40000000000001
r87 n55 n56 4.7627906976744185
r88 n37 n57 21.42608695652174
r89 n56 n57 3.7209302325581395
r90 n38 n58 49.280000000000001
r91 n57 n58 4.9116279069767446
r92 n39 n59 49.280000000000001
r93 n58 n59 2.9767441860465116
r94 n44 n60 265.60000000000002
r95 n45 n61 17.706666666666667
r96 n60 n61 5.1200000000000001
r97 n46 n62 265.60000000000002
r98 n61 n62 5.1200000000000001
r99 n54 n63 265.60000000000002
r100 n55 n64 17.706666666666667
r101 n63 n64 5.1200000000000001
r102 n56 n65 265.60000000000002
r103 n64 n65 5.1200000000000001
r104 n66 n67 4.0960000000000001
r105 n60 n68 288
r106 n67 n68 3.2000000000000002
r107 n61 n69 19.199999999999999
r108 n68 n69 4.0960000000000001
r109 n62 n70 288
r110 n69 n70 4.0960000000000001
r111 n70 n71 3.2000000000000002
r112 n71 n72 4.0960000000000001
r113 n63 n73 288
r114 n64 n74 19.199999999999999
r115 n73 n74 4.0960000000000001
r116 n65 n75 288
r117 n74 n75 4.0960000000000001
r118 n66 n76 71.111111111111114
r119 n67 n77 27.826086956521738
r120 n76 n77 4.0960000000000001
r121 n68 n78 320
r122 n77 n78 3.2000000000000002
r123 n69 n79 21.333333333333332
r124 n78 n79 4.0960000000000001
r125 n70 n80 320
r126 n79 n80 4.0960000000000001
r127 n71 n81 27.826086956521738
r128 n80 n81 3.2000000000000002
r129 n72 n82 71.111111111111114
r130 n81 n82 4.0960000000000001
r131 n73 n83 320
r132 n74 n84 21.333333333333332
r133 n83 n84 4.0960000000000001
r134 n75 n85 320
r135 n84 n85 4.0960000000000001
r136 n76 n86 71.111111111111114
r137 n77 n87 27.826086956521738
r138 n86 n87 4.0960000000000001
r139 n78 n88 320
r140 n87 n88 3.2000000000000002
r141 n79 n89 21.333333333333332
r142 n88 n89 4.0960000000000001
r143 n80 n90 320
r144 n89 n90 4.0960000000000001
r145 n81 n91 27.826086956521738
r146 n90 n91 3.2000000000000002
r147 n82 n92 71.111111111111114
r148 n91 n92 4.0960000000000001
r149 n83 n93 320
r150 n84 n94 21.333333333333332
r151 n93 n94 4.0960000000000001
r152 n85 n95 320
r153 n94 n95 4.0960000000000001
r154 n86 n96 71.111111111111114
r155 n87 n97 27.826086956521738
r156 n96 n97 4.0960000000000001
r157 n88 n98 320
r158 n97 n98 3.2000000000000002
r159 n89 n99 21.333333333333332
r160 n98 n99 4.0960000000000001
r161 n90 n100 320
r162 n99 n100 4.0960000000000001
r163 n91 n101 27.826086956521738
r164 n100 n101 3.2000000000000002
r165 n92 n102 71.111111111111114
r166 n101 n102 4.0960000000000001
r167 n93 n103 320
r168 n94 n104 21.333333333333332
r169 n103 n104 4.0960000000000001
r170 n95 n105 320
r171 n104 n105 4.0960000000000001
r172 n96 n106 71.111111111111114
r173 n97 n107 27.826086956521738
r174 n106 n107 4.0960000000000001
r175 n98 n108 320
r176 n107 n108 3.2000000000000002
r177 n99 n109 21.333333333333332
r178 n108 n109 4.0960000000000001
r179 n100 n110 320
r180 n109 n110 4.0960000000000001
r181 n101 n111 27.826086956521738
r182 n110 n111 3.2000000000000002
r183 n102 n112 71.111111111111114
r184 n111 n112 4.0960000000000001
r185 n103 n113 320
r186 n104 n114 21.333333333333332
r187 n113 n114 4.0960000000000001
r188 n105 n115 320
r189 n114 n115 4.0960000000000001
r190 n106 n116 71.111111111111114
r191 n107 n117 27.826086956521738
r192 n116 n117 4.0960000000000001
r193 n108 n118 320
r194 n117 n118 3.2000000000000002
r195 n109 n119 21.333333333333332
r196 n118 n119 4.0960000000000001
r197 n110 n120 320
r198 n119 n120 4.0960000000000001
r199 n111 n121 27.826086956521738
r200 n120 n121 3.2000000000000002
r201 n112 n122 71.111111111111114
r202 n121 n122 4.0960000000000001
r203 n113 n123 320
r204 n114 n124 21.333333333333332
r205 n123 n124 4.0960000000000001
r206 n115 n125 320
r207 n124 n125 4.0960000000000001
r208 n116 n126 71.111111111111114
r209 n117 n127 27.826086956521738
r210 n126 n127 4.0960000000000001
r211 n118 n128 320
r212 n127 n128 3.2000000000000002
r213 n119 n129 21.333333333333332
r214 n128 n129 4.0960000000000001
r215 n120 n130 320
r216 n129 n130 4.0960000000000001
r217 n121 n131 27.826086956521738
r218 n130 n131 3.2000000000000002
r219 n122 n132 71.111111111111114
r220 n131 n132 4.0960000000000001
r221 n123 n133 320
r222 n124 n134 21.333333333333332
r223 n133 n134 4.0960000000000001
r224 n125 n135 320
r225 n134 n135 4.0960000000000001
r226 n126 n136 71.111111111111114
r227 n127 n137 27.826086956521738
r228 n136 n137 4.0960000000000001
r229 n128 n138 320
r230 n137 n138 3.2000000000000002
r231 n129 n139 21.333333333333332
r232 n138 n139 4.0960000000000001
r233 n130 n140 320
r234 n139 n140 4.0960000000000001
r235 n131 n141 27.826086956521738
r236 n140 n141 3.2000000000000002
r237 n132 n142 71.111111111111114
r238 n141 n142 4.0960000000000001
r239 n133 n143 320
r240 n134 n144 21.333333333333332
r241 n143 n144 4.0960000000000001
r242 n135 n145 320
r243 n144 n145 4.0960000000000001
r244 n136 n146 71.111111111111114
r245 n137 n147 27.826086956521738
r246 n146 n147 4.0960000000000001
r247 n138 n148 320
r248 n147 n148 3.2000000000000002
r249 n139 n149 21.333333333333332
r250 n148 n149 4.0960000000000001
r251 n140 n150 320
r252 n149 n150 4.0960000000000001
r253 n141 n151 27.826086956521738
r254 n150 n151 3.2000000000000002
r255 n142 n152 71.111111111111114
r256 n151 n152 4.0960000000000001
r257 n143 n153 320
r258 n144 n154 21.333333333333332
r259 n153 n154 4.0960000000000001
r260 n145 n155 320
r261 n154 n155 4.0960000000000001
r262 n146 n156 71.111111111111114
r263 n147 n157 27.826086956521738
r264 n156 n157 4.0960000000000001
r265 n148 n158 320
r266 n157 n158 3.2000000000000002
r267 n149 n159 21.333333333333332
r268 n158 n159 4.0960000000000001
r269 n150 n160 320
r270 n159 n160 4.0960000000000001
r271 n151 n161 27.826086956521738
r272 n160 n161 3.2000000000000002
r273 n152 n162 71.111111111111114
r274 n161 n162 4.0960000000000001
r275 n153 n163 320
r276 n154 n164 21.333333333333332
r277 n163 n164 4.0960000000000001
r278 n155 n165 320
r279 n164 n165 4.0960000000000001
r280 n156 n166 71.111111111111114
r281 n157 n167 27.826086956521738
r282 n166 n167 4.0960000000000001
r283 n158 n168 320
r284 n167 n168 3.2000000000000002
r285 n159 n169 21.333333333333332
r286 n168 n169 4.0960000000000001
r287 n160 n170 320
r288 n169 n170 4.0960000000000001
r289 n161 n171 27.826086956521738
r290 n170 n171 3.2000000000000002
r291 n162 n172 71.111111111111114
r292 n171 n172 4.0960000000000001
r293 n163 n173 320
r294 n164 n174 21.333333333333332
r295 n173 n174 4.0960000000000001
r296 n165 n175 320
r297 n174 n175 4.0960000000000001
r298 n166 n176 71.111111111111114
r299 n167 n177 27.826086956521738
r300 n176 n177 4.0960000000000001
r301 n168 n178 320
r302 n177 n178 3.2000000000000002
r303 n169 n179 21.333333333333332
r304 n178 n179 4.0960000000000001
r305 n170 n180 320
r306 n179 n180 4.0960000000000001
r307 n171 n181 27.826086956521738
r308 n180 n181 3.2000000000000002
r309 n172 n182 71.111111111111114
r310 n181 n182 4.0960000000000001
r311 n173 n183 320
r312 n174 n184 21.333333333333332
r313 n183 n184 4.0960000000000001
r314 n175 n185 320
r315 n184 n185 4.0960000000000001
r316 n176 n186 71.111111111111114
r317 n177 n187 27.826086956521738
r318 n186 n187 4.0960000000000001
r319 n178 n188 320
r320 n187 n188 3.2000000000000002
r321 n179 n189 21.333333333333332
r322 n188 n189 4.0960000000000001
r323 n180 n190 320
r324 n189 n190 4.0960000000000001
r325 n181 n191 27.826086956521738
r326 n190 n191 3.2000000000000002
r327 n182 n192 71.111111111111114
r328 n191 n192 4.0960000000000001
r329 n183 n193 320
r330 n184 n194 21.333333333333332
r331 n193 n194 4.0960000000000001
r332 n185 n195 320
r333 n194 n195 4.0960000000000001
r334 n186 n196 71.111111111111114
r335 n187 n197 27.826086956521738
r336 n196 n197 4.0960000000000001
r337 n188 n198 320
r338 n197 n198 3.2000000000000002
r339 n189 n199 21.333333333333332
r340 n198 n199 4.0960000000000001
r341 n190 n200 320
r342 n199 n200 4.0960000000000001
r343 n191 n201 27.826086956521738
r344 n200 n201 3.2000000000000002
r345 n192 n202 71.111111111111114
r346 n201 n202 4.0960000000000001
r347 n193 n203 320
r348 n194 n204 21.333333333333332
r349 n203 n204 4.0960000000000001
r350 n195 n205 320
r351 n204 n205 4.0960000000000001
r352 n196 n206 71.111111111111114
r353 n197 n207 27.826086956521738
r354 n206 n207 4.0960000000000001
r355 n198 n208 320
r356 n207 n208 3.2000000000000002
r357 n199 n209 21.333333333333332
r358 n208 n209 4.0960000000000001
r359 n200 n210 320
r360 n209 n210 4.0960000000000001
r361 n201 n211 27.826086956521738
r362 n210 n211 3.2000000000000002
r363 n202 n212 71.111111111111114
r364 n211 n212 4.0960000000000001
r365 n203 n213 320
r366 n204 n214 21.333333333333332
r367 n213 n214 4.0960000000000001
r368 n205 n215 320
r369 n214 n215 4.0960000000000001
r370 n206 n216 71.111111111111114
r371 n207 n217 27.826086956521738
r372 n216 n217 4.0960000000000001
r373 n208 n218 320
r374 n217 n218 3.2000000000000002
r375 n209 n219 21.333333333333332
r376 n218 n219 4.0960000000000001
r377 n210 n220 320
r378 n219 n220 4.0960000000000001
r379 n211 n221 27.826086956521738
r380 n220 n221 3.2000000000000002
r381 n212 n222 71.111111111111114
r382 n221 n222 4.0960000000000001
r383 n213 n223 320
r384 n214 n224 21.333333333333332
r385 n223 n224 4.0960000000000001
r386 n215 n225 320
r387 n224 n225 4.0960000000000001
r388 n216 n226 71.111111111111114
r389 n217 n227 27.826086956521738
r390 n226 n227 4.0960000000000001
r391 n218 n228 320
r392 n227 n228 3.2000000000000002
r393 n219 n229 21.333333333333332
r394 n228 n229 4.0960000000000001
r395 n220 n230 320
r396 n229 n230 4.0960000000000001
r397 n221 n231 27.826086956521738
r398 n230 n231 3.2000000000000002
r399 n222 n232 71.111111111111114
r400 n231 n232 4.0960000000000001
r401 n223 n233 320
r402 n224 n234 21.333333333333332
r403 n233 n234 4.0960000000000001
r404 n225 n235 320
r405 n234 n235 4.0960000000000001
r406 n226 n236 71.111111111111114
r407 n227 n237 27.826086956521738
r408 n236 n237 4.0960000000000001
r409 n228 n238 320
r410 n237 n238 3.2000000000000002
r411 n229 n239 21.333333333333332
r412 n238 n239 4.0960000000000001
r413 n230 n240 320
r414 n239 n240 4.0960000000000001
r415 n231 n241 27.826086956521738
r416 n240 n241 3.2000000000000002
r417 n232 n242 71.111111111111114
r418 n241 n242 4.0960000000000001
r419 n233 n243 320
r420 n234 n244 21.333333333333332
r421 n243 n244 4.0960000000000001
r422 n235 n245 320
r423 n244 n245 4.0960000000000001
r424 n236 n246 71.111111111111114
r425 n237 n247 27.826086956521738
r426 n246 n247 4.0960000000000001
r427 n238 n248 320
r428 n247 n248 3.2000000000000002
r429 n239 n249 21.333333333333332
r430 n248 n249 4.0960000000000001
r431 n240 n250 320
r432 n249 n250 4.0960000000000001
r433 n241 n251 27.826086956521738
r434 n250 n251 3.2000000000000002
r435 n242 n252 71.111111111111114
r436 n251 n252 4.0960000000000001
r437 n243 n253 320
r438 n244 n254 21.333333333333332
r439 n253 n254 4.0960000000000001
r440 n245 n255 320
r441 n254 n255 4.0960000000000001
r442 n246 n256 71.111111111111114
r443 n247 n257 27.826086956521738
r444 n256 n257 4.0960000000000001
r445 n248 n258 320
r446 n257 n258 3.2000000000000002
r447 n249 n259 21.333333333333332
r448 n258 n259 4.0960000000000001
r449 n250 n260 320
r450 n259 n260 4.0960000000000001
r451 n251 n261 27.826086956521738
r452 n260 n261 3.2000000000000002
r453 n252 n262 71.111111111111114
r454 n261 n262 4.0960000000000001
r455 n253 n263 320
r456 n254 n264 21.333333333333332
r457 n263 n264 4.0960000000000001
r458 n255 n265 320
r459 n264 n265 4.0960000000000001
r460 n256 n266 71.111111111111114
r461 n257 n267 27.826086956521738
r462 n266 n267 4.0960000000000001
r463 n258 n268 320
r464 n267 n268 3.2000000000000002
r465 n259 n269 21.333333333333332
r466 n268 n269 4.0960000000000001
r467 n260 n270 320
r468 n269 n270 4.0960000000000001
r469 n261 n271 27.826086956521738
r470 n270 n271 3.2000000000000002
r471 n262 n272 71.111111111111114
r472 n271 n272 4.0960000000000001
r473 n263 n273 320
r474 n264 n274 21.333333333333332
r475 n273 n274 4.0960000000000001
r476 n265 n275 320
r477 n274 n275 4.0960000000000001
r478 n266 n276 71.111111111111114
r479 n267 n277 27.826086956521738
r480 n276 n277 4.0960000000000001
r481 n268 n278 320
r482 n277 n278 3.2000000000000002
r483 n269 n279 21.333333333333332
r484 n278 n279 4.0960000000000001
r485 n270 n280 320
r486 n279 n280 4.0960000000000001
r487 n271 n281 27.826086956521738
r488 n280 n281 3.2000000000000002
r489 n272 n282 71.111111111111114
r490 n281 n282 4.0960000000000001
r491 n273 n283 320
r492 n274 n284 21.333333333333332
r493 n283 n284 4.0960000000000001
r494 n275 n285 320
r495 n284 n285 4.0960000000000001
r496 n276 n286 71.111111111111114
r497 n277 n287 27.826086956521738
r498 n286 n287 4.0960000000000001
r499 n278 n288 320
r500 n287 n288 3.2000000000000002
r501 n279 n289 21.333333333333332
r502 n288 n289 4.0960000000000001
r503 n280 n290 320
r504 n289 n290 4.0960000000000001
r505 n281 n291 27.826086956521738
r506 n290 n291 3.2000000000000002
r507 n282 n292 71.111111111111114
r508 n291 n292 4.0960000000000001
r509 n283 n293 320
r510 n284 n294 21.333333333333332
r511 n293 n294 4.0960000000000001
r512 n285 n295 320
r513 n294 n295 4.0960000000000001
r514 n286 n296 71.111111111111114
r515 n287 n297 27.826086956521738
r516 n296 n297 4.0960000000000001
r517 n288 n298 320
r518 n297 n298 3.2000000000000002
r519 n289 n299 21.333333333333332
r520 n298 n299 4.0960000000000001
r521 n290 n300 320
r522 n299 n300 4.0960000000000001
r523 n291 n301 27.826086956521738
r524 n300 n301 3.2000000000000002
r525 n292 n302 71.111111111111114
r526 n301 n302 4.0960000000000001
r527 n293 n303 320
r528 n294 n304 21.333333333333332
r529 n303 n304 4.0960000000000001
r530 n295 n305 320
r531 n304 n305 4.0960000000000001
r532 n296 n306 71.111111111111114
r533 n297 n307 27.826086956521738
r534 n306 n307 4.0960000000000001
r535 n298 n308 320
r536 n307 n308 3.2000000000000002
r537 n299 n309 21.333333333333332
r538 n308 n309 4.0960000000000001
r539 n300 n310 320
r540 n309 n310 4.0960000000000001
r541 n301 n311 27.826086956521738
r542 n310 n311 3.2000000000000002
r543 n302 n312 71.111111111111114
r544 n311 n312 4.0960000000000001
r545 n303 n313 320
r546 n304 n314 21.333333333333332
r547 n313 n314 4.0960000000000001
r548 n305 n315 320
r549 n314 n315 4.0960000000000001
r550 n306 n316 71.111111111111114
r551 n307 n317 27.826086956521738
r552 n316 n317 4.0960000000000001
r553 n308 n318 320
r554 n317 n318 3.2000000000000002
r555 n309 n319 21.333333333333332
r556 n318 n319 4.0960000000000001
r557 n310 n320 320
r558 n319 n320 4.0960000000000001
r559 n311 n321 27.826086956521738
r560 n320 n321 3.2000000000000002
r561 n312 n322 71.111111111111114
r562 n321 n322 4.0960000000000001
r563 n313 n323 320
r564 n314 n324 21.333333333333332
r565 n323 n324 4.0960000000000001
r566 n315 n325 320
r567 n324 n325 4.0960000000000001
r568 n316 n326 71.111111111111114
r569 n317 n327 27.826086956521738
r570 n326 n327 4.0960000000000001
r571 n318 n328 320
r572 n327 n328 3.2000000000000002
r573 n319 n329 21.333333333333332
r574 n328 n329 4.0960000000000001
r575 n320 n330 320
r576 n329 n330 4.0960000000000001
r577 n321 n331 27.826086956521738
r578 n330 n331 3.2000000000000002
r579 n322 n332 71.111111111111114
r580 n331 n332 4.0960000000000001
r581 n323 n333 320
r582 n324 n334 21.333333333333332
r583 n333 n334 4.0960000000000001
r584 n325 n335 320
r585 n334 n335 4.0960000000000001
r586 n326 n336 71.111111111111114
r587 n327 n337 27.826086956521738
r588 n336 n337 4.0960000000000001
r589 n328 n338 320
r590 n337 n338 3.2000000000000002
r591 n329 n339 21.333333333333332
r592 n338 n339 4.0960000000000001
r593 n330 n340 320
r594 n339 n340 4.0960000000000001
r595 n331 n341 27.826086956521738
r596 n340 n341 3.2000000000000002
r597 n332 n342 71.111111111111114
r598 n341 n342 4.0960000000000001
r599 n333 n343 320
r600 n334 n344 21.333333333333332
r601 n343 n344 4.0960000000000001
r602 n335 n345 320
r603 n344 n345 4.0960000000000001
r604 n336 n346 71.111111111111114
r605 n337 n347 27.826086956521738
r606 n346 n347 4.0960000000000001
r607 n338 n348 320
r608 n347 n348 3.2000000000000002
r609 n339 n349 21.333333333333332
r610 n348 n349 4.0960000000000001
r611 n340 n350 320
r612 n349 n350 4.0960000000000001
r613 n341 n351 27.826086956521738
r614 n350 n351 3.2000000000000002
r615 n342 n352 71.111111111111114
r616 n351 n352 4.0960000000000001
r617 n343 n353 320
r618 n344 n354 21.333333333333332
r619 n353 n354 4.0960000000000001
r620 n345 n355 320
r621 n354 n355 4.0960000000000001
r622 n346 n356 71.111111111111114
r623 n347 n357 27.826086956521738
r624 n356 n357 4.0960000000000001
r625 n348 n358 320
r626 n357 n358 3.2000000000000002
r627 n349 n359 21.333333333333332
r628 n358 n359 4.0960000000000001
r629 n350 n360 320
r630 n359 n360 4.0960000000000001
r631 n351 n361 27.826086956521738
r632 n360 n361 3.2000000000000002
r633 n352 n362 71.111111111111114
r634 n361 n362 4.0960000000000001
r635 n353 n363 320
r636 n354 n364 21.333333333333332
r637 n363 n364 4.0960000000000001
r638 n355 n365 320
r639 n364 n365 4.0960000000000001
r640 n356 n366 71.111111111111114
r641 n357 n367 27.826086956521738
r642 n366 n367 4.0960000000000001
r643 n358 n368 320
r644 n367 n368 3.2000000000000002
r645 n359 n369 21.333333333333332
r646 n368 n369 4.0960000000000001
r647 n360 n370 320
r648 n369 n370 4.0960000000000001
r649 n361 n371 27.826086956521738
r650 n370 n371 3.2000000000000002
r651 n362 n372 71.111111111111114
r652 n371 n372 4.0960000000000001
r653 n363 n373 320
r654 n364 n374 21.333333333333332
r655 n373 n374 4.0960000000000001
r656 n365 n375 320
r657 n374 n375 4.0960000000000001
r658 n366 n376 71.111111111111114
r659 n367 n377 27.826086956521738
r660 n376 n377 4.0960000000000001
r661 n368 n378 320
r662 n377 n378 3.2000000000000002
r663 n369 n379 21.333333333333332
r664 n378 n379 4.0960000000000001
r665 n370 n380 320
r666 n379 n380 4.0960000000000001
r667 n371 n381 27.826086956521738
r668 n380 n381 3.2000000000000002
r669 n372 n382 71.111111111111114
r670 n381 n382 4.0960000000000001
r671 n373 n383 320
r672 n374 n384 21.333333333333332
r673 n383 n384 4.0960000000000001
r674 n375 n385 320
r675 n384 n385 4.0960000000000001
r676 n376 n386 71.111111111111114
r677 n377 n387 27.826086956521738
r678 n386 n387 4.0960000000000001
r679 n378 n388 320
r680 n387 n388 3.2000000000000002
r681 n379 n389 21.333333333333332
r682 n388 n389 4.0960000000000001
r683 n380 n390 320
r684 n389 n390 4.0960000000000001
r685 n381 n391 27.826086956521738
r686 n390 n391 3.2000000000000002
r687 n382 n392 71.111111111111114
r688 n391 n392 4.0960000000000001
r689 n383 n393 320
r690 n384 n394 21.333333333333332
r691 n393 n394 4.0960000000000001
r692 n385 n395 320
r693 n394 n395 4.0960000000000001
r694 n386 n396 71.111111111111114
r695 n387 n397 27.826086956521738
r696 n396 n397 4.0960000000000001
r697 n388 n398 320
r698 n397 n398 3.2000000000000002
r699 n389 n399 21.333333333333332
r700 n398 n399 4.0960000000000001
r701 n390 n400 320
r702 n399 n400 4.0960000000000001
r703 n391 n401 27.826086956521738
r704 n400 n401 3.2000000000000002
r705 n392 n402 71.111111111111114
r706 n401 n402 4.0960000000000001
r707 n393 n403 320
r708 n394 n404 21.333333333333332
r709 n403 n404 4.0960000000000001
r710 n395 n405 320
r711 n404 n405 4.0960000000000001
r712 n396 n406 71.111111111111114
r713 n397 n407 27.826086956521738
r714 n406 n407 4.0960000000000001
r715 n398 n408 320
r716 n407 n408 3.2000000000000002
r717 n399 n409 21.333333333333332
r718 n408 n409 4.0960000000000001
r719 n400 n410 320
r720 n409 n410 4.0960000000000001
r721 n401 n411 27.826086956521738
r722 n410 n411 3.2000000000000002
r723 n402 n412 71.111111111111114
r724 n411 n412 4.0960000000000001
r725 n403 n413 320
r726 n404 n414 21.333333333333332
r727 n413 n414 4.0960000000000001
r728 n405 n415 320
r729 n414 n415 4.0960000000000001
r730 n406 n416 71.111111111111114
r731 n407 n417 27.826086956521738
r732 n416 n417 4.0960000000000001
r733 n408 n418 320
r734 n417 n418 3.2000000000000002
r735 n409 n419 21.333333333333332
r736 n418 n419 4.0960000000000001
r737 n410 n420 320
r738 n419 n420 4.0960000000000001
r739 n411 n421 27.826086956521738
r740 n420 n421 3.2000000000000002
r741 n412 n422 71.111111111111114
r742 n421 n422 4.0960000000000001
r743 n413 n423 320
r744 n414 n424 21.333333333333332
r745 n423 n424 4.0960000000000001
r746 n415 n425 320
r747 n424 n425 4.0960000000000001
r748 n416 n426 71.111111111111114
r749 n417 n427 27.826086956521738
r750 n426 n427 4.0960000000000001
r751 n418 n428 320
r752 n427 n428 3.2000000000000002
r753 n419 n429 21.333333333333332
r754 n428 n429 4.0960000000000001
r755 n420 n430 320
r756 n429 n430 4.0960000000000001
r757 n421 n431 27.826086956521738
r758 n430 n431 3.2000000000000002
r759 n422 n432 71.111111111111114
r760 n431 n432 4.0960000000000001
r761 n423 n433 320
r762 n424 n434 21.333333333333332
r763 n433 n434 4.0960000000000001
r764 n425 n435 320
r765 n434 n435 4.0960000000000001
r766 n426 n436 71.111111111111114
r767 n427 n437 27.826086956521738
r768 n436 n437 4.0960000000000001
r769 n428 n438 320
r770 n437 n438 3.2000000000000002
r771 n429 n439 21.333333333333332
r772 n438 n439 4.0960000000000001
r773 n430 n440 320
r774 n439 n440 4.0960000000000001
r775 n431 n441 27.826086956521738
r776 n440 n441 3.2000000000000002
r777 n432 n442 71.111111111111114
r778 n441 n442 4.0960000000000001
r779 n433 n443 320
r780 n434 n444 21.333333333333332
r781 n443 n444 4.0960000000000001
r782 n435 n445 320
r783 n444 n445 4.0960000000000001
r784 n436 n446 71.111111111111114
r785 n437 n447 27.826086956521738
r786 n446 n447 4.0960000000000001
r787 n438 n448 320
r788 n447 n448 3.2000000000000002
r789 n439 n449 21.333333333333332
r790 n448 n449 4.0960000000000001
r791 n440 n450 320
r792 n449 n450 4.0960000000000001
r793 n441 n451 27.826086956521738
r794 n450 n451 3.2000000000000002
r795 n442 n452 71.111111111111114
r796 n451 n452 4.0960000000000001
r797 n443 n453 320
r798 n444 n454 21.333333333333332
r799 n453 n454 4.0960000000000001
r800 n445 n455 320
r801 n454 n455 4.0960000000000001
r802 n446 n456 71.111111111111114
r803 n447 n457 27.826086956521738
r804 n456 n457 4.0960000000000001
r805 n448 n458 320
r806 n457 n458 3.2000000000000002
r807 n449 n459 21.333333333333332
r808 n458 n459 4.0960000000000001
r809 n450 n460 320
r810 n459 n460 4.0960000000000001
r811 n451 n461 27.826086956521738
r812 n460 n461 3.2000000000000002
r813 n452 n462 71.111111111111114
r814 n461 n462 4.0960000000000001
r815 n453 n463 320
r816 n454 n464 21.333333333333332
r817 n463 n464 4.0960000000000001
r818 n455 n465 320
r819 n464 n465 4.0960000000000001
r820 n456 n466 71.111111111111114
r821 n457 n467 27.826086956521738
r822 n466 n467 4.0960000000000001
r823 n458 n468 320
r824 n467 n468 3.2000000000000002
r825 n459 n469 21.333333333333332
r826 n468 n469 4.0960000000000001
r827 n460 n470 320
r828 n469 n470 4.0960000000000001
r829 n461 n471 27.826086956521738
r830 n470 n471 3.2000000000000002
r831 n462 n472 71.111111111111114
r832 n471 n472 4.0960000000000001
r833 n463 n473 320
r834 n464 n474 21.333333333333332
r835 n473 n474 4.0960000000000001
r836 n465 n475 320
r837 n474 n475 4.0960000000000001
r838 n466 n476 71.111111111111114
r839 n467 n477 27.826086956521738
r840 n476 n477 4.0960000000000001
r841 n468 n478 320
r842 n477 n478 3.2000000000000002
r843 n469 n479 21.333333333333332
r844 n478 n479 4.0960000000000001
r845 n470 n480 320
r846 n479 n480 4.0960000000000001
r847 n471 n481 27.826086956521738
r848 n480 n481 3.2000000000000002
r849 n472 n482 71.111111111111114
r850 n481 n482 4.0960000000000001
r851 n473 n483 320
r852 n474 n484 21.333333333333332
r853 n483 n484 4.0960000000000001
r854 n475 n485 320
r855 n484 n485 4.0960000000000001
r856 n476 n486 71.111111111111114
r857 n477 n487 27.826086956521738
r858 n486 n487 4.0960000000000001
r859 n478 n488 320
r860 n487 n488 3.2000000000000002
r861 n479 n489 21.333333333333332
r862 n488 n489 4.0960000000000001
r863 n480 n490 320
r864 n489 n490 4.0960000000000001
r865 n481 n491 27.826086956521738
r866 n490 n491 3.2000000000000002
r867 n482 n492 71.111111111111114
r868 n491 n492 4.0960000000000001
r869 n483 n493 320
r870 n484 n494 21.333333333333332
r871 n493 n494 4.0960000000000001
r872 n485 n495 320
r873 n494 n495 4.0960000000000001
r874 n486 n496 71.111111111111114
r875 n487 n497 27.826086956521738
r876 n496 n497 4.0960000000000001
r877 n488 n498 320
r878 n497 n498 3.2000000000000002
r879 n489 n499 21.333333333333332
r880 n498 n499 4.0960000000000001
r881 n490 n500 320
r882 n499 n500 4.0960000000000001
r883 n491 n501 27.826086956521738
r884 n500 n501 3.2000000000000002
r885 n492 n502 71.111111111111114
r886 n501 n502 4.0960000000000001
r887 n493 n503 320
r888 n494 n504 21.333333333333332
r889 n503 n504 4.0960000000000001
r890 n495 n505 320
r891 n504 n505 4.0960000000000001
r892 n496 n506 71.111111111111114
r893 n497 n507 27.826086956521738
r894 n506 n507 4.0960000000000001
r895 n498 n508 320
r896 n507 n508 3.2000000000000002
r897 n499 n509 21.333333333333332
r898 n508 n509 4.0960000000000001
r899 n500 n510 320
r900 n509 n510 4.0960000000000001
r901 n501 n511 27.826086956521738
r902 n510 n511 3.2000000000000002
r903 n502 n512 71.111111111111114
r904 n511 n512 4.0960000000000001
r905 n503 n513 320
r906 n504 n514 21.333333333333332
r907 n513 n514 4.0960000000000001
r908 n505 n515 320
r909 n514 n515 4.0960000000000001
r910 n506 n516 71.111111111111114
r911 n507 n517 27.826086956521738
r912 n516 n517 4.0960000000000001
r913 n508 n518 320
r914 n517 n518 3.2000000000000002
r915 n509 n519 21.333333333333332
r916 n518 n519 4.0960000000000001
r917 n510 n520 320
r918 n519 n520 4.0960000000000001
r919 n511 n521 27.826086956521738
r920 n520 n521 3.2000000000000002
r921 n512 n522 71.111111111111114
r922 n521 n522 4.0960000000000001
r923 n513 n523 320
r924 n514 n524 21.333333333333332
r925 n523 n524 4.0960000000000001
r926 n515 n525 320
r927 n524 n525 4.0960000000000001
r928 n518 n526 288
r929 n519 n527 19.199999999999999
r930 n526 n527 5.1200000000000001
r931 n520 n528 288
r932 n527 n528 5.1200000000000001
r933 n523 n529 288
r934 n524 n530 19.199999999999999
r935 n529 n530 5.1200000000000001
r936 n525 n531 288
r937 n530 n531 5.1200000000000001
r938 n532 n533 1.6372093023255814
r939 n533 n534 1.4883720930232558
r940 n534 n535 4.7627906976744185
r941 n526 n536 265.60000000000002
r942 n535 n536 3.7209302325581395
r943 n527 n537 17.706666666666667
r944 n536 n537 4.7627906976744185
r945 n528 n538 265.60000000000002
r946 n537 n538 4.7627906976744185
r947 n538 n539 3.7209302325581395
r948 n539 n540 4.7627906976744185
r949 n540 n541 1.4883720930232558
r950 n541 n542 1.6372093023255814
r951 n543 n544 2.9767441860465116
r952 n544 n545 4.9116279069767446
r953 n529 n546 265.60000000000002
r954 n545 n546 3.7209302325581395
r955 n530 n547 17.706666666666667
r956 n546 n547 4.7627906976744185
r957 n531 n548 265.60000000000002
r958 n547 n548 4.7627906976744185
r959 n548 n549 3.7209302325581395
r960 n549 n550 4.9116279069767446
r961 n550 n551 2.9767441860465116
r962 n532 n552 49.280000000000001
r963 n533 n553 492.80000000000001
r964 n552 n553 2.0705882352941178
r965 n534 n554 54.755555555555553
r966 n553 n554 1.8823529411764706
r967 n535 n555 21.42608695652174
r968 n554 n555 6.0235294117647058
r969 n536 n556 246.40000000000001
r970 n555 n556 4.7058823529411766
r971 n537 n557 16.426666666666666
r972 n556 n557 6.0235294117647058
r973 n538 n558 246.40000000000001
r974 n557 n558 6.0235294117647058
r975 n539 n559 21.42608695652174
r976 n558 n559 4.7058823529411766
r977 n540 n560 54.755555555555553
r978 n559 n560 6.0235294117647058
r979 n541 n561 492.80000000000001
r980 n560 n561 1.8823529411764706
r981 n542 n562 49.280000000000001
r982 n561 n562 2.0705882352941178
r983 n543 n563 49.280000000000001
r984 n544 n564 49.280000000000001
r985 n563 n564 3.7647058823529411
r986 n545 n565 21.42608695652174
r987 n564 n565 6.2117647058823531
r988 n546 n566 246.40000000000001
r989 n565 n566 4.7058823529411766
r990 n547 n567 16.426666666666666
r991 n566 n567 6.0235294117647058
r992 n548 n568 246.40000000000001
r993 n567 n568 6.0235294117647058
r994 n549 n569 21.42608695652174
r995 n568 n569 4.7058823529411766
r996 n550 n570 49.280000000000001
r997 n569 n570 6.2117647058823531
r998 n551 n571 49.280000000000001
r999 n570 n571 3.7647058823529411
r1000 n552 n572 49.280000000000001
r1001 n553 n573 492.80000000000001
r1002 n572 n573 1.6372093023255814
r1003 n554 n574 54.755555555555553
r1004 n573 n574 1.4883720930232558
r1005 n555 n575 21.42608695652174
r1006 n574 n575 4.7627906976744185
r1007 n556 n576 246.40000000000001
r1008 n575 n576 3.7209302325581395
r1009 n557 n577 16.426666666666666
r1010 n576 n577 4.7627906976744185
r1011 n558 n578 246.40000000000001
r1012 n577 n578 4.7627906976744185
r1013 n559 n579 21.42608695652174
r1014 n578 n579 3.7209302325581395
r1015 n560 n580 54.755555555555553
r1016 n579 n580 4.7627906976744185
r1017 n561 n581 492.80000000000001
r1018 n580 n581 1.4883720930232558
r1019 n562 n582 49.280000000000001
r1020 n581 n582 1.6372093023255814
r1021 n563 n583 49.280000000000001
r1022 n564 n584 49.280000000000001
r1023 n583 n584 2.9767441860465116
r1024 n565 n585 21.42608695652174
r1025 n584 n585 4.9116279069767446
r1026 n566 n586 246.40000000000001
r1027 n585 n586 3.7209302325581395
r1028 n567 n587 16.426666666666666
r1029 n586 n587 4.7627906976744185
r1030 n568 n588 246.40000000000001
r1031 n587 n588 4.7627906976744185
r1032 n569 n589 21.42608695652174
r1033 n588 n589 3.7209302325581395
r1034 n570 n590 49.280000000000001
r1035 n589 n590 4.9116279069767446
r1036 n571 n591 49.280000000000001
r1037 n590 n591 2.9767441860465116
r1038 n592 n593 208
r1039 n593 n594 198.40000000000001
r1040 n594 n595 208
r1041 n595 n596 185.59999999999999
r1042 n596 n597 89.599999999999994
r1043 n597 n598 44.799999999999997
r1044 n598 n599 38.399999999999999
r1045 n599 n600 108.8
r1046 n600 n601 108.8
r1047 n601 n602 121.59999999999999
r1048 n602 n603 121.59999999999999
r1049 n603 n604 48
r1050 n604 n605 80
r1051 n605 n606 60.799999999999997
r1052 n606 n607 28.800000000000001
r1053 n607 n608 19.199999999999999
r1054 n608 n609 41.600000000000001
r1055 n609 n610 96
r1056 n610 n611 73.599999999999994
r1057 n611 n612 12.800000000000001
r1058 n612 n613 35.200000000000003
r1059 n613 n614 67.200000000000003
r1060 n614 n615 67.200000000000003
r1061 n615 n616 35.200000000000003
r1062 n616 n617 12.800000000000001
r1063 n617 n618 73.599999999999994
r1064 n618 n619 115.2
r1065 n619 n620 54.399999999999999
r1066 n620 n621 108.8
r1067 n621 n622 108.8
r1068 n622 n623 44.799999999999997
r1069 n623 n624 51.200000000000003
r1070 n624 n625 76.799999999999997
r1071 n625 n626 172.80000000000001
r1072 n626 n627 124.8
r1073 n627 n628 48
r1074 n628 n629 54.399999999999999
r1075 n629 n630 32
r1076 n630 n631 19.199999999999999
r1077 n631 n632 16
r1078 n632 n633 32
r1079 n633 n634 96
r1080 n634 n635 76.799999999999997
r1081 n635 n636 16
r1082 n636 n637 19.199999999999999
r1083 n637 n638 22.399999999999999
r1084 n638 n639 22.399999999999999
r1085 n639 n640 41.600000000000001
r1086 n640 n641 188.80000000000001
r1087 n641 n642 265.60000000000002
r1088 n643 n644 204.80000000000001
r1089 n644 n645 192
r1090 n645 n646 204.80000000000001
r1091 n646 n647 185.59999999999999
r1092 n647 n648 89.599999999999994
r1093 n648 n649 44.799999999999997
r1094 n649 n650 38.399999999999999
r1095 n650 n651 108.8
r1096 n651 n652 108.8
r1097 n652 n653 121.59999999999999
r1098 n653 n654 121.59999999999999
r1099 n654 n655 108.8
r1100 n655 n656 108.8
r1101 n656 n657 121.59999999999999
r1102 n657 n658 121.59999999999999
r1103 n658 n659 108.8
r1104 n659 n660 108.8
r1105 n660 n661 121.59999999999999
r1106 n661 n662 121.59999999999999
r1107 n662 n663 108.8
r1108 n663 n664 108.8
r1109 n664 n665 121.59999999999999
r1110 n665 n666 121.59999999999999
r1111 n666 n667 108.8
r1112 n667 n668 108.8
r1113 n668 n669 121.59999999999999
r1114 n669 n670 121.59999999999999
r1115 n670 n671 108.8
r1116 n671 n672 108.8
r1117 n672 n673 121.59999999999999
r1118 n673 n674 121.59999999999999
r1119 n674 n675 108.8
r1120 n675 n676 108.8
r1121 n676 n677 121.59999999999999
r1122 n677 n678 121.59999999999999
r1123 n678 n679 108.8
r1124 n679 n680 108.8
r1125 n680 n681 54.399999999999999
r1126 n681 n682 86.400000000000006
r1127 n682 n683 67.200000000000003
r1128 n683 n684 35.200000000000003
r1129 n684 n685 12.800000000000001
r1130 n685 n686 32
r1131 n686 n687 96
r1132 n687 n688 73.599999999999994
r1133 n688 n689 6.4000000000000004
r1134 n689 n690 6.4000000000000004
r1135 n690 n691 35.200000000000003
r1136 n691 n692 70.400000000000006
r1137 n692 n693 64
r1138 n693 n694 32
r1139 n694 n695 16
r1140 n695 n696 16
r1141 n696 n697 25.600000000000001
r1142 n697 n698 57.600000000000001
r1143 n698 n699 83.200000000000003
r1144 n699 n700 51.200000000000003
r1145 n700 n701 121.59999999999999
r1146 n701 n702 121.59999999999999
r1147 n702 n703 108.8
r1148 n703 n704 108.8
r1149 n704 n705 121.59999999999999
r1150 n705 n706 121.59999999999999
r1151 n706 n707 108.8
r1152 n707 n708 108.8
r1153 n708 n709 121.59999999999999
r1154 n709 n710 121.59999999999999
r1155 n710 n711 108.8
r1156 n711 n712 108.8
r1157 n712 n713 121.59999999999999
r1158 n713 n714 121.59999999999999
r1159 n714 n715 108.8
r1160 n715 n716 108.8
r1161 n716 n717 121.59999999999999
r1162 n717 n718 121.59999999999999
r1163 n718 n719 108.8
r1164 n719 n720 108.8
r1165 n720 n721 121.59999999999999
r1166 n721 n722 121.59999999999999
r1167 n722 n723 108.8
r1168 n723 n724 108.8
r1169 n724 n725 121.59999999999999
r1170 n725 n726 121.59999999999999
r1171 n726 n727 108.8
r1172 n727 n728 108.8
r1173 n728 n729 44.799999999999997
r1174 n729 n730 51.200000000000003
r1175 n730 n731 76.799999999999997
r1176 n731 n732 172.80000000000001
r1177 n732 n733 115.2
r1178 n733 n734 38.399999999999999
r1179 n734 n735 54.399999999999999
r1180 n735 n736 32
r1181 n736 n737 19.199999999999999
r1182 n737 n738 16
r1183 n738 n739 41.600000000000001
r1184 n739 n740 96
r1185 n740 n741 67.200000000000003
r1186 n741 n742 16
r1187 n742 n743 19.199999999999999
r1188 n743 n744 32
r1189 n744 n745 54.399999999999999
r1190 n745 n746 188.80000000000001
r1191 n746 n747 265.60000000000002
r1192 n592 n748 6.0235294117647058
r1193 n593 n749 6.6064516129032258
r1194 n748 n749 13.866666666666667
r1195 n594 n750 6.6064516129032258
r1196 n749 n750 13.226666666666667
r1197 n595 n751 6.0235294117647058
r1198 n750 n751 13.866666666666667
r1199 n596 n752 8.5333333333333332
r1200 n751 n752 12.373333333333333
r1201 n597 n753 51.200000000000003
r1202 n752 n753 5.9733333333333336
r1203 n598 n754 20.48
r1204 n753 n754 2.9866666666666668
r1205 n599 n755 102.40000000000001
r1206 n754 n755 2.5600000000000001
r1207 n600 n756 6.4000000000000004
r1208 n755 n756 7.253333333333333
r1209 n601 n757 102.40000000000001
r1210 n756 n757 7.253333333333333
r1211 n602 n758 5.6888888888888891
r1212 n757 n758 8.1066666666666674
r1213 n603 n759 102.40000000000001
r1214 n758 n759 8.1066666666666674
r1215 n604 n760 15.753846153846155
r1216 n759 n760 3.2000000000000002
r1217 n605 n761 17.066666666666666
r1218 n760 n761 5.333333333333333
r1219 n606 n762 29.257142857142856
r1220 n761 n762 4.0533333333333337
r1221 n607 n763 102.40000000000001
r1222 n762 n763 1.9199999999999999
r1223 n608 n764 51.200000000000003
r1224 n763 n764 1.28
r1225 n609 n765 22.755555555555556
r1226 n764 n765 2.7733333333333334
r1227 n610 n766 9.7523809523809533
r1228 n765 n766 6.4000000000000004
r1229 n611 n767 102.40000000000001
r1230 n766 n767 4.9066666666666663
r1231 n612 n768 102.40000000000001
r1232 n767 n768 0.85333333333333339
r1233 n613 n769 22.755555555555556
r1234 n768 n769 2.3466666666666667
r1235 n614 n770 17.066666666666666
r1236 n769 n770 4.4800000000000004
r1237 n615 n771 22.755555555555556
r1238 n770 n771 4.4800000000000004
r1239 n616 n772 102.40000000000001
r1240 n771 n772 2.3466666666666667
r1241 n617 n773 102.40000000000001
r1242 n772 n773 0.85333333333333339
r1243 n618 n774 9.7523809523809533
r1244 n773 n774 4.9066666666666663
r1245 n619 n775 13.653333333333334
r1246 n774 n775 7.6799999999999997
r1247 n620 n776 102.40000000000001
r1248 n775 n776 3.6266666666666665
r1249 n621 n777 6.4000000000000004
r1250 n776 n777 7.253333333333333
r1251 n622 n778 102.40000000000001
r1252 n777 n778 7.253333333333333
r1253 n623 n779 17.066666666666666
r1254 n778 n779 2.9866666666666668
r1255 n624 n780 51.200000000000003
r1256 n779 n780 3.4133333333333336
r1257 n625 n781 10.24
r1258 n780 n781 5.1200000000000001
r1259 n626 n782 6.0235294117647058
r1260 n781 n782 11.52
r1261 n627 n783 40.960000000000001
r1262 n782 n783 8.3200000000000003
r1263 n628 n784 20.48
r1264 n783 n784 3.2000000000000002
r1265 n629 n785 29.257142857142856
r1266 n784 n785 3.6266666666666665
r1267 n630 n786 68.266666666666666
r1268 n785 n786 2.1333333333333333
r1269 n631 n787 68.266666666666666
r1270 n786 n787 1.28
r1271 n632 n788 102.40000000000001
r1272 n787 n788 1.0666666666666667
r1273 n633 n789 25.600000000000001
r1274 n788 n789 2.1333333333333333
r1275 n634 n790 9.3090909090909086
r1276 n789 n790 6.4000000000000004
r1277 n635 n791 102.40000000000001
r1278 n790 n791 5.1200000000000001
r1279 n636 n792 68.266666666666666
r1280 n791 n792 1.0666666666666667
r1281 n637 n793 68.266666666666666
r1282 n792 n793 1.28
r1283 n638 n794 51.200000000000003
r1284 n793 n794 1.4933333333333334
r1285 n639 n795 68.266666666666666
r1286 n794 n795 1.4933333333333334
r1287 n640 n796 20.48
r1288 n795 n796 2.7733333333333334
r1289 n641 n797 4.1795918367346943
r1290 n796 n797 12.586666666666666
r1291 n642 n798 6.0235294117647058
r1292 n797 n798 17.706666666666667
r1293 n643 n799 6.0235294117647058
r1294 n644 n800 6.8266666666666671
r1295 n799 n800 13.653333333333334
r1296 n645 n801 6.8266666666666671
r1297 n800 n801 12.800000000000001
r1298 n646 n802 6.0235294117647058
r1299 n801 n802 13.653333333333334
r1300 n647 n803 8.5333333333333332
r1301 n802 n803 12.373333333333333
r1302 n648 n804 51.200000000000003
r1303 n803 n804 5.9733333333333336
r1304 n649 n805 20.48
r1305 n804 n805 2.9866666666666668
r1306 n650 n806 102.40000000000001
r1307 n805 n806 2.5600000000000001
r1308 n651 n807 6.4000000000000004
r1309 n806 n807 7.253333333333333
r1310 n652 n808 102.40000000000001
r1311 n807 n808 7.253333333333333
r1312 n653 n809 5.6888888888888891
r1313 n808 n809 8.1066666666666674
r1314 n654 n810 102.40000000000001
r1315 n809 n810 8.1066666666666674
r1316 n655 n811 6.4000000000000004
r1317 n810 n811 7.253333333333333
r1318 n656 n812 102.40000000000001
r1319 n811 n812 7.253333333333333
r1320 n657 n813 5.6888888888888891
r1321 n812 n813 8.1066666666666674
r1322 n658 n814 102.40000000000001
r1323 n813 n814 8.1066666666666674
r1324 n659 n815 6.4000000000000004
r1325 n814 n815 7.253333333333333
r1326 n660 n816 102.40000000000001
r1327 n815 n816 7.253333333333333
r1328 n661 n817 5.6888888888888891
r1329 n816 n817 8.1066666666666674
r1330 n662 n818 102.40000000000001
r1331 n817 n818 8.1066666666666674
r1332 n663 n819 6.4000000000000004
r1333 n818 n819 7.253333333333333
r1334 n664 n820 102.40000000000001
r1335 n819 n820 7.253333333333333
r1336 n665 n821 5.6888888888888891
r1337 n820 n821 8.1066666666666674
r1338 n666 n822 102.40000000000001
r1339 n821 n822 8.1066666666666674
r1340 n667 n823 6.4000000000000004
r1341 n822 n823 7.253333333333333
r1342 n668 n824 102.40000000000001
r1343 n823 n824 7.253333333333333
r1344 n669 n825 5.6888888888888891
r1345 n824 n825 8.1066666666666674
r1346 n670 n826 102.40000000000001
r1347 n825 n826 8.1066666666666674
r1348 n671 n827 6.4000000000000004
r1349 n826 n827 7.253333333333333
r1350 n672 n828 102.40000000000001
r1351 n827 n828 7.253333333333333
r1352 n673 n829 5.6888888888888891
r1353 n828 n829 8.1066666666666674
r1354 n674 n830 102.40000000000001
r1355 n829 n830 8.1066666666666674
r1356 n675 n831 6.4000000000000004
r1357 n830 n831 7.253333333333333
r1358 n676 n832 102.40000000000001
r1359 n831 n832 7.253333333333333
r1360 n677 n833 5.6888888888888891
r1361 n832 n833 8.1066666666666674
r1362 n678 n834 102.40000000000001
r1363 n833 n834 8.1066666666666674
r1364 n679 n835 6.4000000000000004
r1365 n834 n835 7.253333333333333
r1366 n680 n836 102.40000000000001
r1367 n835 n836 7.253333333333333
r1368 n681 n837 13.653333333333334
r1369 n836 n837 3.6266666666666665
r1370 n682 n838 17.066666666666666
r1371 n837 n838 5.7599999999999998
r1372 n683 n839 22.755555555555556
r1373 n838 n839 4.4800000000000004
r1374 n684 n840 102.40000000000001
r1375 n839 n840 2.3466666666666667
r1376 n685 n841 102.40000000000001
r1377 n840 n841 0.85333333333333339
r1378 n686 n842 25.600000000000001
r1379 n841 n842 2.1333333333333333
r1380 n687 n843 9.3090909090909086
r1381 n842 n843 6.4000000000000004
r1382 n688 n844 204.80000000000001
r1383 n843 n844 4.9066666666666663
r1384 n689 n845 204.80000000000001
r1385 n844 n845 0.42666666666666669
r1386 n690 n846 204.80000000000001
r1387 n845 n846 0.42666666666666669
r1388 n691 n847 20.48
r1389 n846 n847 2.3466666666666667
r1390 n692 n848 17.066666666666666
r1391 n847 n848 4.6933333333333334
r1392 n693 n849 25.600000000000001
r1393 n848 n849 4.2666666666666666
r1394 n694 n850 102.40000000000001
r1395 n849 n850 2.1333333333333333
r1396 n695 n851 68.266666666666666
r1397 n850 n851 1.0666666666666667
r1398 n696 n852 102.40000000000001
r1399 n851 n852 1.0666666666666667
r1400 n697 n853 34.133333333333333
r1401 n852 n853 1.7066666666666668
r1402 n698 n854 17.066666666666666
r1403 n853 n854 3.8399999999999999
r1404 n699 n855 14.628571428571428
r1405 n854 n855 5.5466666666666669
r1406 n700 n856 102.40000000000001
r1407 n855 n856 3.4133333333333336
r1408 n701 n857 5.6888888888888891
r1409 n856 n857 8.1066666666666674
r1410 n702 n858 102.40000000000001
r1411 n857 n858 8.1066666666666674
r1412 n703 n859 6.4000000000000004
r1413 n858 n859 7.253333333333333
r1414 n704 n860 102.40000000000001
r1415 n859 n860 7.253333333333333
r1416 n705 n861 5.6888888888888891
r1417 n860 n861 8.1066666666666674
r1418 n706 n862 102.40000000000001
r1419 n861 n862 8.1066666666666674
r1420 n707 n863 6.4000000000000004
r1421 n862 n863 7.253333333333333
r1422 n708 n864 102.40000000000001
r1423 n863 n864 7.253333333333333
r1424 n709 n865 5.6888888888888891
r1425 n864 n865 8.1066666666666674
r1426 n710 n866 102.40000000000001
r1427 n865 n866 8.1066666666666674
r1428 n711 n867 6.4000000000000004
r1429 n866 n867 7.253333333333333
r1430 n712 n868 102.40000000000001
r1431 n867 n868 7.253333333333333
r1432 n713 n869 5.6888888888888891
r1433 n868 n869 8.1066666666666674
r1434 n714 n870 102.40000000000001
r1435 n869 n870 8.1066666666666674
r1436 n715 n871 6.4000000000000004
r1437 n870 n871 7.253333333333333
r1438 n716 n872 102.40000000000001
r1439 n871 n872 7.253333333333333
r1440 n717 n873 5.6888888888888891
r1441 n872 n873 8.1066666666666674
r1442 n718 n874 102.40000000000001
r1443 n873 n874 8.1066666666666674
r1444 n719 n875 6.4000000000000004
r1445 n874 n875 7.253333333333333
r1446 n720 n876 102.40000000000001
r1447 n875 n876 7.253333333333333
r1448 n721 n877 5.6888888888888891
r1449 n876 n877 8.1066666666666674
r1450 n722 n878 102.40000000000001
r1451 n877 n878 8.1066666666666674
r1452 n723 n879 6.4000000000000004
r1453 n878 n879 7.253333333333333
r1454 n724 n880 102.40000000000001
r1455 n879 n880 7.253333333333333
r1456 n725 n881 5.6888888888888891
r1457 n880 n881 8.1066666666666674
r1458 n726 n882 102.40000000000001
r1459 n881 n882 8.1066666666666674
r1460 n727 n883 6.4000000000000004
r1461 n882 n883 7.253333333333333
r1462 n728 n884 102.40000000000001
r1463 n883 n884 7.253333333333333
r1464 n729 n885 17.066666666666666
r1465 n884 n885 2.9866666666666668
r1466 n730 n886 51.200000000000003
r1467 n885 n886 3.4133333333333336
r1468 n731 n887 10.24
r1469 n886 n887 5.1200000000000001
r1470 n732 n888 6.0235294117647058
r1471 n887 n888 11.52
r1472 n733 n889 102.40000000000001
r1473 n888 n889 7.6799999999999997
r1474 n734 n890 20.48
r1475 n889 n890 2.5600000000000001
r1476 n735 n891 29.257142857142856
r1477 n890 n891 3.6266666666666665
r1478 n736 n892 68.266666666666666
r1479 n891 n892 2.1333333333333333
r1480 n737 n893 68.266666666666666
r1481 n892 n893 1.28
r1482 n738 n894 102.40000000000001
r1483 n893 n894 1.0666666666666667
r1484 n739 n895 18.618181818181817
r1485 n894 n895 2.7733333333333334
r1486 n740 n896 10.778947368421052
r1487 n895 n896 6.4000000000000004
r1488 n741 n897 102.40000000000001
r1489 n896 n897 4.4800000000000004
r1490 n742 n898 68.266666666666666
r1491 n897 n898 1.0666666666666667
r1492 n743 n899 68.266666666666666
r1493 n898 n899 1.28
r1494 n744 n900 29.257142857142856
r1495 n899 n900 2.1333333333333333
r1496 n745 n901 20.48
r1497 n900 n901 3.6266666666666665
r1498 n746 n902 4.1795918367346943
r1499 n901 n902 12.586666666666666
r1500 n747 n903 6.0235294117647058
r1501 n902 n903 17.706666666666667
r1502 n748 n904 6.0235294117647058
r1503 n749 n905 6.6064516129032258
r1504 n904 n905 208
r1505 n750 n906 6.6064516129032258
r1506 n905 n906 198.40000000000001
r1507 n751 n907 6.0235294117647058
r1508 n906 n907 208
r1509 n752 n908 8.5333333333333332
r1510 n907 n908 185.59999999999999
r1511 n753 n909 51.200000000000003
r1512 n908 n909 89.599999999999994
r1513 n754 n910 20.48
r1514 n909 n910 44.799999999999997
r1515 n755 n911 102.40000000000001
r1516 n910 n911 38.399999999999999
r1517 n756 n912 6.4000000000000004
r1518 n911 n912 108.8
r1519 n757 n913 102.40000000000001
r1520 n912 n913 108.8
r1521 n758 n914 5.6888888888888891
r1522 n913 n914 121.59999999999999
r1523 n759 n915 102.40000000000001
r1524 n914 n915 121.59999999999999
r1525 n760 n916 15.753846153846155
r1526 n915 n916 48
r1527 n761 n917 17.066666666666666
r1528 n916 n917 80
r1529 n762 n918 29.257142857142856
r1530 n917 n918 60.799999999999997
r1531 n763 n919 102.40000000000001
r1532 n918 n919 28.800000000000001
r1533 n764 n920 51.200000000000003
r1534 n919 n920 19.199999999999999
r1535 n765 n921 22.755555555555556
r1536 n920 n921 41.600000000000001
r1537 n766 n922 9.7523809523809533
r1538 n921 n922 96
r1539 n767 n923 102.40000000000001
r1540 n922 n923 73.599999999999994
r1541 n768 n924 102.40000000000001
r1542 n923 n924 12.800000000000001
r1543 n769 n925 22.755555555555556
r1544 n924 n925 35.200000000000003
r1545 n770 n926 17.066666666666666
r1546 n925 n926 67.200000000000003
r1547 n771 n927 22.755555555555556
r1548 n926 n927 67.200000000000003
r1549 n772 n928 102.40000000000001
r1550 n927 n928 35.200000000000003
r1551 n773 n929 102.40000000000001
r1552 n928 n929 12.800000000000001
r1553 n774 n930 9.7523809523809533
r1554 n929 n930 73.599999999999994
r1555 n775 n931 13.653333333333334
r1556 n930 n931 115.2
r1557 n776 n932 102.40000000000001
r1558 n931 n932 54.399999999999999
r1559 n777 n933 6.4000000000000004
r1560 n932 n933 108.8
r1561 n778 n934 102.40000000000001
r1562 n933 n934 108.8
r1563 n779 n935 17.066666666666666
r1564 n934 n935 44.799999999999997
r1565 n780 n936 51.200000000000003
r1566 n935 n936 51.200000000000003
r1567 n781 n937 10.24
r1568 n936 n937 76.799999999999997
r1569 n782 n938 6.0235294117647058
r1570 n937 n938 172.80000000000001
r1571 n783 n939 40.960000000000001
r1572 n938 n939 124.8
r1573 n784 n940 20.48
r1574 n939 n940 48
r1575 n785 n941 29.257142857142856
r1576 n940 n941 54.399999999999999
r1577 n786 n942 68.266666666666666
r1578 n941 n942 32
r1579 n787 n943 68.266666666666666
r1580 n942 n943 19.199999999999999
r1581 n788 n944 102.40000000000001
r1582 n943 n944 16
r1583 n789 n945 25.600000000000001
r1584 n944 n945 32
r1585 n790 n946 9.3090909090909086
r1586 n945 n946 96
r1587 n791 n947 102.40000000000001
r1588 n946 n947 76.799999999999997
r1589 n792 n948 68.266666666666666
r1590 n947 n948 16
r1591 n793 n949 68.266666666666666
r1592 n948 n949 19.199999999999999
r1593 n794 n950 51.200000000000003
r1594 n949 n950 22.399999999999999
r1595 n795 n951 68.266666666666666
r1596 n950 n951 22.399999999999999
r1597 n796 n952 20.48
r1598 n951 n952 41.600000000000001
r1599 n797 n953 4.1795918367346943
r1600 n952 n953 188.80000000000001
r1601 n798 n954 6.0235294117647058
r1602 n953 n954 265.60000000000002
r1603 n799 n955 6.0235294117647058
r1604 n800 n956 6.8266666666666671
r1605 n955 n956 204.80000000000001
r1606 n801 n957 6.8266666666666671
r1607 n956 n957 192
r1608 n802 n958 6.0235294117647058
r1609 n957 n958 204.80000000000001
r1610 n803 n959 8.5333333333333332
r1611 n958 n959 185.59999999999999
r1612 n804 n960 51.200000000000003
r1613 n959 n960 89.599999999999994
r1614 n805 n961 20.48
r1615 n960 n961 44.799999999999997
r1616 n806 n962 102.40000000000001
r1617 n961 n962 38.399999999999999
r1618 n807 n963 6.4000000000000004
r1619 n962 n963 108.8
r1620 n808 n964 102.40000000000001
r1621 n963 n964 108.8
r1622 n809 n965 5.6888888888888891
r1623 n964 n965 121.59999999999999
r1624 n810 n966 102.40000000000001
r1625 n965 n966 121.59999999999999
r1626 n811 n967 6.4000000000000004
r1627 n966 n967 108.8
r1628 n812 n968 102.40000000000001
r1629 n967 n968 108.8
r1630 n813 n969 5.6888888888888891
r1631 n968 n969 121.59999999999999
r1632 n814 n970 102.40000000000001
r1633 n969 n970 121.59999999999999
r1634 n815 n971 6.4000000000000004
r1635 n970 n971 108.8
r1636 n816 n972 102.40000000000001
r1637 n971 n972 108.8
r1638 n817 n973 5.6888888888888891
r1639 n972 n973 121.59999999999999
r1640 n818 n974 102.40000000000001
r1641 n973 n974 121.59999999999999
r1642 n819 n975 6.4000000000000004
r1643 n974 n975 108.8
r1644 n820 n976 102.40000000000001
r1645 n975 n976 108.8
r1646 n821 n977 5.6888888888888891
r1647 n976 n977 121.59999999999999
r1648 n822 n978 102.40000000000001
r1649 n977 n978 121.59999999999999
r1650 n823 n979 6.4000000000000004
r1651 n978 n979 108.8
r1652 n824 n980 102.40000000000001
r1653 n979 n980 108.8
r1654 n825 n981 5.6888888888888891
r1655 n980 n981 121.59999999999999
r1656 n826 n982 102.40000000000001
r1657 n981 n982 121.59999999999999
r1658 n827 n983 6.4000000000000004
r1659 n982 n983 108.8
r1660 n828 n984 102.40000000000001
r1661 n983 n984 108.8
r1662 n829 n985 5.6888888888888891
r1663 n984 n985 121.59999999999999
r1664 n830 n986 102.40000000000001
r1665 n985 n986 121.59999999999999
r1666 n831 n987 6.4000000000000004
r1667 n986 n987 108.8
r1668 n832 n988 102.40000000000001
r1669 n987 n988 108.8
r1670 n833 n989 5.6888888888888891
r1671 n988 n989 121.59999999999999
r1672 n834 n990 102.40000000000001
r1673 n989 n990 121.59999999999999
r1674 n835 n991 6.4000000000000004
r1675 n990 n991 108.8
r1676 n836 n992 102.40000000000001
r1677 n991 n992 108.8
r1678 n837 n993 13.653333333333334
r1679 n992 n993 54.399999999999999
r1680 n838 n994 17.066666666666666
r1681 n993 n994 86.400000000000006
r1682 n839 n995 22.755555555555556
r1683 n994 n995 67.200000000000003
r1684 n840 n996 102.40000000000001
r1685 n995 n996 35.200000000000003
r1686 n841 n997 102.40000000000001
r1687 n996 n997 12.800000000000001
r1688 n842 n998 25.600000000000001
r1689 n997 n998 32
r1690 n843 n999 9.3090909090909086
r1691 n998 n999 96
r1692 n844 n1000 204.80000000000001
r1693 n999 n1000 73.599999999999994
r1694 n845 n1001 204.80000000000001
r1695 n1000 n1001 6.4000000000000004
r1696 n846 n1002 204.80000000000001
r1697 n1001 n1002 6.4000000000000004
r1698 n847 n1003 20.48
r1699 n1002 n1003 35.200000000000003
r1700 n848 n1004 17.066666666666666
r1701 n1003 n1004 70.400000000000006
r1702 n849 n1005 25.600000000000001
r1703 n1004 n1005 64
r1704 n850 n1006 102.40000000000001
r1705 n1005 n1006 32
r1706 n851 n1007 68.266666666666666
r1707 n1006 n1007 16
r1708 n852 n1008 102.40000000000001
r1709 n1007 n1008 16
r1710 n853 n1009 34.133333333333333
r1711 n1008 n1009 25.600000000000001
r1712 n854 n1010 17.066666666666666
r1713 n1009 n1010 57.600000000000001
r1714 n855 n1011 14.628571428571428
r1715 n1010 n1011 83.200000000000003
r1716 n856 n1012 102.40000000000001
r1717 n1011 n1012 51.200000000000003
r1718 n857 n1013 5.6888888888888891
r1719 n1012 n1013 121.59999999999999
r1720 n858 n1014 102.40000000000001
r1721 n1013 n1014 121.59999999999999
r1722 n859 n1015 6.4000000000000004
r1723 n1014 n1015 108.8
r1724 n860 n1016 102.40000000000001
r1725 n1015 n1016 108.8
r1726 n861 n1017 5.6888888888888891
r1727 n1016 n1017 121.59999999999999
r1728 n862 n1018 102.40000000000001
r1729 n1017 n1018 121.59999999999999
r1730 n863 n1019 6.4000000000000004
r1731 n1018 n1019 108.8
r1732 n864 n1020 102.40000000000001
r1733 n1019 n1020 108.8
r1734 n865 n1021 5.6888888888888891
r1735 n1020 n1021 121.59999999999999
r1736 n866 n1022 102.40000000000001
r1737 n1021 n1022 121.59999999999999
r1738 n867 n1023 6.4000000000000004
r1739 n1022 n1023 108.8
r1740 n868 n1024 102.40000000000001
r1741 n1023 n1024 108.8
r1742 n869 n1025 5.6888888888888891
r1743 n1024 n1025 121.59999999999999
r1744 n870 n1026 102.40000000000001
r1745 n1025 n1026 121.59999999999999
r1746 n871 n1027 6.4000000000000004
r1747 n1026 n1027 108.8
r1748 n872 n1028 102.40000000000001
r1749 n1027 n1028 108.8
r1750 n873 n1029 5.6888888888888891
r1751 n1028 n1029 121.59999999999999
r1752 n874 n1030 102.40000000000001
r1753 n1029 n1030 121.59999999999999
r1754 n875 n1031 6.4000000000000004
r1755 n1030 n1031 108.8
r1756 n876 n1032 102.40000000000001
r1757 n1031 n1032 108.8
r1758 n877 n1033 5.6888888888888891
r1759 n1032 n1033 121.59999999999999
r1760 n878 n1034 102.40000000000001
r1761 n1033 n1034 121.59999999999999
r1762 n879 n1035 6.4000000000000004
r1763 n1034 n1035 108.8
r1764 n880 n1036 102.40000000000001
r1765 n1035 n1036 108.8
r1766 n881 n1037 5.6888888888888891
r1767 n1036 n1037 121.59999999999999
r1768 n882 n1038 102.40000000000001
r1769 n1037 n1038 121.59999999999999
r1770 n883 n1039 6.4000000000000004
r1771 n1038 n1039 108.8
r1772 n884 n1040 102.40000000000001
r1773 n1039 n1040 108.8
r1774 n885 n1041 17.066666666666666
r1775 n1040 n1041 44.799999999999997
r1776 n886 n1042 51.200000000000003
r1777 n1041 n1042 51.200000000000003
r1778 n887 n1043 10.24
r1779 n1042 n1043 76.799999999999997
r1780 n888 n1044 6.0235294117647058
r1781 n1043 n1044 172.80000000000001
r1782 n889 n1045 102.40000000000001
r1783 n1044 n1045 115.2
r1784 n890 n1046 20.48
r1785 n1045 n1046 38.399999999999999
r1786 n891 n1047 29.257142857142856
r1787 n1046 n1047 54.399999999999999
r1788 n892 n1048 68.266666666666666
r1789 n1047 n1048 32
r1790 n893 n1049 68.266666666666666
r1791 n1048 n1049 19.199999999999999
r1792 n894 n1050 102.40000000000001
r1793 n1049 n1050 16
r1794 n895 n1051 18.618181818181817
r1795 n1050 n1051 41.600000000000001
r1796 n896 n1052 10.778947368421052
r1797 n1051 n1052 96
r1798 n897 n1053 102.40000000000001
r1799 n1052 n1053 67.200000000000003
r1800 n898 n1054 68.266666666666666
r1801 n1053 n1054 16
r1802 n899 n1055 68.266666666666666
r1803 n1054 n1055 19.199999999999999
r1804 n900 n1056 29.257142857142856
r1805 n1055 n1056 32
r1806 n901 n1057 20.48
r1807 n1056 n1057 54.399999999999999
r1808 n902 n1058 4.1795918367346943
r1809 n1057 n1058 188.80000000000001
r1810 n903 n1059 6.0235294117647058
r1811 n1058 n1059 265.60000000000002
r1812 n904 n1060 2.447058823529412
r1813 n954 n1061 2.447058823529412
r1814 n955 n1062 2.447058823529412
r1815 n1059 n1063 2.447058823529412
r1816 n1060 n1064 2.447058823529412
r1817 n1061 n1065 2.447058823529412
r1818 n1062 n1066 2.447058823529412
r1819 n1063 n1067 2.447058823529412
r1820 n1064 n1068 6.2117647058823531
r1821 n1065 n1069 6.2117647058823531
r1822 n1066 n1070 6.2117647058823531
r1823 n1067 n1071 6.2117647058823531
r1824 n1068 n1072 11.670588235294117
r1825 n1069 n1073 11.670588235294117
r1826 n1070 n1074 11.670588235294117
r1827 n1071 n1075 11.670588235294117
r1828 n1072 n1076 8.4705882352941178
r1829 n1073 n1077 8.4705882352941178
r1830 n1074 n1078 8.4705882352941178
r1831 n1075 n1079 8.4705882352941178
r1832 n1076 n1080 3.0117647058823529
r1833 n1077 n1081 3.0117647058823529
r1834 n1078 n1082 3.0117647058823529
r1835 n1079 n1083 3.0117647058823529
r1836 n1080 n1084 1.3176470588235294
r1837 n1081 n1085 1.3176470588235294
r1838 n1082 n1086 1.3176470588235294
r1839 n1083 n1087 1.3176470588235294
r1840 n1084 n1088 2.0705882352941178
r1841 n1085 n1089 2.0705882352941178
r1842 n1086 n1090 2.0705882352941178
r1843 n1087 n1091 2.0705882352941178
r1844 n1088 n1092 1.5058823529411764
r1845 n1093 n1094 44.799999999999997
r1846 n1094 n1095 38.399999999999999
r1847 n1095 n1096 108.8
r1848 n1096 n1097 108.8
r1849 n1097 n1098 121.59999999999999
r1850 n1098 n1099 121.59999999999999
r1851 n1099 n1100 48
r1852 n1100 n1101 80
r1853 n1101 n1102 60.799999999999997
r1854 n1102 n1103 28.800000000000001
r1855 n1103 n1104 19.199999999999999
r1856 n1104 n1105 41.600000000000001
r1857 n1105 n1106 96
r1858 n1106 n1107 73.599999999999994
r1859 n1107 n1108 12.800000000000001
r1860 n1108 n1109 35.200000000000003
r1861 n1109 n1110 67.200000000000003
r1862 n1110 n1111 67.200000000000003
r1863 n1111 n1112 35.200000000000003
r1864 n1112 n1113 12.800000000000001
r1865 n1113 n1114 73.599999999999994
r1866 n1114 n1115 115.2
r1867 n1115 n1116 54.399999999999999
r1868 n1116 n1117 108.8
r1869 n1117 n1118 108.8
r1870 n1118 n1119 44.799999999999997
r1871 n1119 n1120 51.200000000000003
r1872 n1089 n1121 1.5058823529411764
r1873 n1090 n1122 1.5058823529411764
r1874 n1123 n1124 44.799999999999997
r1875 n1124 n1125 38.399999999999999
r1876 n1125 n1126 108.8
r1877 n1126 n1127 108.8
r1878 n1127 n1128 121.59999999999999
r1879 n1128 n1129 121.59999999999999
r1880 n1129 n1130 108.8
r1881 n1130 n1131 108.8
r1882 n1131 n1132 121.59999999999999
r1883 n1132 n1133 121.59999999999999
r1884 n1133 n1134 108.8
r1885 n1134 n1135 108.8
r1886 n1135 n1136 121.59999999999999
r1887 n1136 n1137 121.59999999999999
r1888 n1137 n1138 108.8
r1889 n1138 n1139 108.8
r1890 n1139 n1140 121.59999999999999
r1891 n1140 n1141 121.59999999999999
r1892 n1141 n1142 108.8
r1893 n1142 n1143 108.8
r1894 n1143 n1144 121.59999999999999
r1895 n1144 n1145 121.59999999999999
r1896 n1145 n1146 108.8
r1897 n1146 n1147 108.8
r1898 n1147 n1148 121.59999999999999
r1899 n1148 n1149 121.59999999999999
r1900 n1149 n1150 108.8
r1901 n1150 n1151 108.8
r1902 n1151 n1152 121.59999999999999
r1903 n1152 n1153 121.59999999999999
r1904 n1153 n1154 108.8
r1905 n1154 n1155 108.8
r1906 n1155 n1156 54.399999999999999
r1907 n1156 n1157 86.400000000000006
r1908 n1157 n1158 67.200000000000003
r1909 n1158 n1159 35.200000000000003
r1910 n1159 n1160 12.800000000000001
r1911 n1160 n1161 32
r1912 n1161 n1162 96
r1913 n1162 n1163 73.599999999999994
r1914 n1163 n1164 6.4000000000000004
r1915 n1164 n1165 6.4000000000000004
r1916 n1165 n1166 35.200000000000003
r1917 n1166 n1167 70.400000000000006
r1918 n1167 n1168 64
r1919 n1168 n1169 32
r1920 n1169 n1170 16
r1921 n1170 n1171 16
r1922 n1171 n1172 25.600000000000001
r1923 n1172 n1173 57.600000000000001
r1924 n1173 n1174 83.200000000000003
r1925 n1174 n1175 51.200000000000003
r1926 n1175 n1176 121.59999999999999
r1927 n1176 n1177 121.59999999999999
r1928 n1177 n1178 108.8
r1929 n1178 n1179 108.8
r1930 n1179 n1180 121.59999999999999
r1931 n1180 n1181 121.59999999999999
r1932 n1181 n1182 108.8
r1933 n1182 n1183 108.8
r1934 n1183 n1184 121.59999999999999
r1935 n1184 n1185 121.59999999999999
r1936 n1185 n1186 108.8
r1937 n1186 n1187 108.8
r1938 n1187 n1188 121.59999999999999
r1939 n1188 n1189 121.59999999999999
r1940 n1189 n1190 108.8
r1941 n1190 n1191 108.8
r1942 n1191 n1192 121.59999999999999
r1943 n1192 n1193 121.59999999999999
r1944 n1193 n1194 108.8
r1945 n1194 n1195 108.8
r1946 n1195 n1196 121.59999999999999
r1947 n1196 n1197 121.59999999999999
r1948 n1197 n1198 108.8
r1949 n1198 n1199 108.8
r1950 n1199 n1200 121.59999999999999
r1951 n1200 n1201 121.59999999999999
r1952 n1201 n1202 108.8
r1953 n1202 n1203 108.8
r1954 n1203 n1204 44.799999999999997
r1955 n1204 n1205 51.200000000000003
r1956 n1091 n1206 1.5058823529411764
r1957 n1092 n1207 1.3176470588235294
r1958 n1093 n1208 11.199999999999999
r1959 n1094 n1209 4.4800000000000004
r1960 n1208 n1209 17.920000000000002
r1961 n1095 n1210 22.399999999999999
r1962 n1209 n1210 15.359999999999999
r1963 n1096 n1211 1.3999999999999999
r1964 n1210 n1211 43.520000000000003
r1965 n1097 n1212 22.399999999999999
r1966 n1211 n1212 43.520000000000003
r1967 n1098 n1213 1.2444444444444445
r1968 n1212 n1213 48.640000000000001
r1969 n1099 n1214 22.399999999999999
r1970 n1213 n1214 48.640000000000001
r1971 n1100 n1215 3.4461538461538463
r1972 n1214 n1215 19.199999999999999
r1973 n1101 n1216 3.7333333333333334
r1974 n1215 n1216 32
r1975 n1102 n1217 6.4000000000000004
r1976 n1216 n1217 24.32
r1977 n1103 n1218 22.399999999999999
r1978 n1217 n1218 11.52
r1979 n1104 n1219 11.199999999999999
r1980 n1218 n1219 7.6799999999999997
r1981 n1105 n1220 4.9777777777777779
r1982 n1219 n1220 16.640000000000001
r1983 n1106 n1221 2.1333333333333333
r1984 n1220 n1221 38.399999999999999
r1985 n1107 n1222 22.399999999999999
r1986 n1221 n1222 29.440000000000001
r1987 n1108 n1223 22.399999999999999
r1988 n1222 n1223 5.1200000000000001
r1989 n1109 n1224 4.9777777777777779
r1990 n1223 n1224 14.08
r1991 n1110 n1225 3.7333333333333334
r1992 n1224 n1225 26.879999999999999
r1993 n1111 n1226 4.9777777777777779
r1994 n1225 n1226 26.879999999999999
r1995 n1112 n1227 22.399999999999999
r1996 n1226 n1227 14.08
r1997 n1113 n1228 22.399999999999999
r1998 n1227 n1228 5.1200000000000001
r1999 n1114 n1229 2.1333333333333333
r2000 n1228 n1229 29.440000000000001
r2001 n1115 n1230 2.9866666666666668
r2002 n1229 n1230 46.079999999999998
r2003 n1116 n1231 22.399999999999999
r2004 n1230 n1231 21.760000000000002
r2005 n1117 n1232 1.3999999999999999
r2006 n1231 n1232 43.520000000000003
r2007 n1118 n1233 22.399999999999999
r2008 n1232 n1233 43.520000000000003
r2009 n1119 n1234 3.7333333333333334
r2010 n1233 n1234 17.920000000000002
r2011 n1120 n1235 11.199999999999999
r2012 n1234 n1235 20.48
r2013 n1121 n1236 1.3176470588235294
r2014 n1122 n1237 1.3176470588235294
r2015 n1123 n1238 11.199999999999999
r2016 n1124 n1239 4.4800000000000004
r2017 n1238 n1239 17.920000000000002
r2018 n1125 n1240 22.399999999999999
r2019 n1239 n1240 15.359999999999999
r2020 n1126 n1241 1.3999999999999999
r2021 n1240 n1241 43.520000000000003
r2022 n1127 n1242 22.399999999999999
r2023 n1241 n1242 43.520000000000003
r2024 n1128 n1243 1.2444444444444445
r2025 n1242 n1243 48.640000000000001
r2026 n1129 n1244 22.399999999999999
r2027 n1243 n1244 48.640000000000001
r2028 n1130 n1245 1.3999999999999999
r2029 n1244 n1245 43.520000000000003
r2030 n1131 n1246 22.399999999999999
r2031 n1245 n1246 43.520000000000003
r2032 n1132 n1247 1.2444444444444445
r2033 n1246 n1247 48.640000000000001
r2034 n1133 n1248 22.399999999999999
r2035 n1247 n1248 48.640000000000001
r2036 n1134 n1249 1.3999999999999999
r2037 n1248 n1249 43.520000000000003
r2038 n1135 n1250 22.399999999999999
r2039 n1249 n1250 43.520000000000003
r2040 n1136 n1251 1.2444444444444445
r2041 n1250 n1251 48.640000000000001
r2042 n1137 n1252 22.399999999999999
r2043 n1251 n1252 48.640000000000001
r2044 n1138 n1253 1.3999999999999999
r2045 n1252 n1253 43.520000000000003
r2046 n1139 n1254 22.399999999999999
r2047 n1253 n1254 43.520000000000003
r2048 n1140 n1255 1.2444444444444445
r2049 n1254 n1255 48.640000000000001
r2050 n1141 n1256 22.399999999999999
r2051 n1255 n1256 48.640000000000001
r2052 n1142 n1257 1.3999999999999999
r2053 n1256 n1257 43.520000000000003
r2054 n1143 n1258 22.399999999999999
r2055 n1257 n1258 43.520000000000003
r2056 n1144 n1259 1.2444444444444445
r2057 n1258 n1259 48.640000000000001
r2058 n1145 n1260 22.399999999999999
r2059 n1259 n1260 48.640000000000001
r2060 n1146 n1261 1.3999999999999999
r2061 n1260 n1261 43.520000000000003
r2062 n1147 n1262 22.399999999999999
r2063 n1261 n1262 43.520000000000003
r2064 n1148 n1263 1.2444444444444445
r2065 n1262 n1263 48.640000000000001
r2066 n1149 n1264 22.399999999999999
r2067 n1263 n1264 48.640000000000001
r2068 n1150 n1265 1.3999999999999999
r2069 n1264 n1265 43.520000000000003
r2070 n1151 n1266 22.399999999999999
r2071 n1265 n1266 43.520000000000003
r2072 n1152 n1267 1.2444444444444445
r2073 n1266 n1267 48.640000000000001
r2074 n1153 n1268 22.399999999999999
r2075 n1267 n1268 48.640000000000001
r2076 n1154 n1269 1.3999999999999999
r2077 n1268 n1269 43.520000000000003
r2078 n1155 n1270 22.399999999999999
r2079 n1269 n1270 43.520000000000003
r2080 n1156 n1271 2.9866666666666668
r2081 n1270 n1271 21.760000000000002
r2082 n1157 n1272 3.7333333333333334
r2083 n1271 n1272 34.560000000000002
r2084 n1158 n1273 4.9777777777777779
r2085 n1272 n1273 26.879999999999999
r2086 n1159 n1274 22.399999999999999
r2087 n1273 n1274 14.08
r2088 n1160 n1275 22.399999999999999
r2089 n1274 n1275 5.1200000000000001
r2090 n1161 n1276 5.5999999999999996
r2091 n1275 n1276 12.800000000000001
r2092 n1162 n1277 2.0363636363636362
r2093 n1276 n1277 38.399999999999999
r2094 n1163 n1278 44.799999999999997
r2095 n1277 n1278 29.440000000000001
r2096 n1164 n1279 44.799999999999997
r2097 n1278 n1279 2.5600000000000001
r2098 n1165 n1280 44.799999999999997
r2099 n1279 n1280 2.5600000000000001
r2100 n1166 n1281 4.4800000000000004
r2101 n1280 n1281 14.08
r2102 n1167 n1282 3.7333333333333334
r2103 n1281 n1282 28.16
r2104 n1168 n1283 5.5999999999999996
r2105 n1282 n1283 25.600000000000001
r2106 n1169 n1284 22.399999999999999
r2107 n1283 n1284 12.800000000000001
r2108 n1170 n1285 14.933333333333334
r2109 n1284 n1285 6.4000000000000004
r2110 n1171 n1286 22.399999999999999
r2111 n1285 n1286 6.4000000000000004
r2112 n1172 n1287 7.4666666666666668
r2113 n1286 n1287 10.24
r2114 n1173 n1288 3.7333333333333334
r2115 n1287 n1288 23.039999999999999
r2116 n1174 n1289 3.2000000000000002
r2117 n1288 n1289 33.280000000000001
r2118 n1175 n1290 22.399999999999999
r2119 n1289 n1290 20.48
r2120 n1176 n1291 1.2444444444444445
r2121 n1290 n1291 48.640000000000001
r2122 n1177 n1292 22.399999999999999
r2123 n1291 n1292 48.640000000000001
r2124 n1178 n1293 1.3999999999999999
r2125 n1292 n1293 43.520000000000003
r2126 n1179 n1294 22.399999999999999
r2127 n1293 n1294 43.520000000000003
r2128 n1180 n1295 1.2444444444444445
r2129 n1294 n1295 48.640000000000001
r2130 n1181 n1296 22.399999999999999
r2131 n1295 n1296 48.640000000000001
r2132 n1182 n1297 1.3999999999999999
r2133 n1296 n1297 43.520000000000003
r2134 n1183 n1298 22.399999999999999
r2135 n1297 n1298 43.520000000000003
r2136 n1184 n1299 1.2444444444444445
r2137 n1298 n1299 48.640000000000001
r2138 n1185 n1300 22.399999999999999
r2139 n1299 n1300 48.640000000000001
r2140 n1186 n1301 1.3999999999999999
r2141 n1300 n1301 43.520000000000003
r2142 n1187 n1302 22.399999999999999
r2143 n1301 n1302 43.520000000000003
r2144 n1188 n1303 1.2444444444444445
r2145 n1302 n1303 48.640000000000001
r2146 n1189 n1304 22.399999999999999
r2147 n1303 n1304 48.640000000000001
r2148 n1190 n1305 1.3999999999999999
r2149 n1304 n1305 43.520000000000003
r2150 n1191 n1306 22.399999999999999
r2151 n1305 n1306 43.520000000000003
r2152 n1192 n1307 1.2444444444444445
r2153 n1306 n1307 48.640000000000001
r2154 n1193 n1308 22.399999999999999
r2155 n1307 n1308 48.640000000000001
r2156 n1194 n1309 1.3999999999999999
r2157 n1308 n1309 43.520000000000003
r2158 n1195 n1310 22.399999999999999
r2159 n1309 n1310 43.520000000000003
r2160 n1196 n1311 1.2444444444444445
r2161 n1310 n1311 48.640000000000001
r2162 n1197 n1312 22.399999999999999
r2163 n1311 n1312 48.640000000000001
r2164 n1198 n1313 1.3999999999999999
r2165 n1312 n1313 43.520000000000003
r2166 n1199 n1314 22.399999999999999
r2167 n1313 n1314 43.520000000000003
r2168 n1200 n1315 1.2444444444444445
r2169 n1314 n1315 48.640000000000001
r2170 n1201 n1316 22.399999999999999
r2171 n1315 n1316 48.640000000000001
r2172 n1202 n1317 1.3999999999999999
r2173 n1316 n1317 43.520000000000003
r2174 n1203 n1318 22.399999999999999
r2175 n1317 n1318 43.520000000000003
r2176 n1204 n1319 3.7333333333333334
r2177 n1318 n1319 17.920000000000002
r2178 n1205 n1320 11.199999999999999
r2179 n1319 n1320 20.48
r2180 n1206 n1321 1.3176470588235294
r2181 n1207 n1322 3.7647058823529411
r2182 n1208 n1323 32
r2183 n1209 n1324 12.800000000000001
r2184 n1323 n1324 5.9733333333333336
r2185 n1210 n1325 64
r2186 n1324 n1325 5.1200000000000001
r2187 n1211 n1326 4
r2188 n1325 n1326 14.506666666666666
r2189 n1212 n1327 64
r2190 n1326 n1327 14.506666666666666
r2191 n1213 n1328 3.5555555555555554
r2192 n1327 n1328 16.213333333333335
r2193 n1214 n1329 64
r2194 n1328 n1329 16.213333333333335
r2195 n1215 n1330 9.8461538461538467
r2196 n1329 n1330 6.4000000000000004
r2197 n1216 n1331 10.666666666666666
r2198 n1330 n1331 10.666666666666666
r2199 n1217 n1332 18.285714285714285
r2200 n1331 n1332 8.1066666666666674
r2201 n1218 n1333 64
r2202 n1332 n1333 3.8399999999999999
r2203 n1219 n1334 32
r2204 n1333 n1334 2.5600000000000001
r2205 n1220 n1335 14.222222222222221
r2206 n1334 n1335 5.5466666666666669
r2207 n1221 n1336 6.0952380952380949
r2208 n1335 n1336 12.800000000000001
r2209 n1222 n1337 64
r2210 n1336 n1337 9.8133333333333326
r2211 n1223 n1338 64
r2212 n1337 n1338 1.7066666666666668
r2213 n1224 n1339 14.222222222222221
r2214 n1338 n1339 4.6933333333333334
r2215 n1225 n1340 10.666666666666666
r2216 n1339 n1340 8.9600000000000009
r2217 n1226 n1341 14.222222222222221
r2218 n1340 n1341 8.9600000000000009
r2219 n1227 n1342 64
r2220 n1341 n1342 4.6933333333333334
r2221 n1228 n1343 64
r2222 n1342 n1343 1.7066666666666668
r2223 n1229 n1344 6.0952380952380949
r2224 n1343 n1344 9.8133333333333326
r2225 n1230 n1345 8.5333333333333332
r2226 n1344 n1345 15.359999999999999
r2227 n1231 n1346 64
r2228 n1345 n1346 7.253333333333333
r2229 n1232 n1347 4
r2230 n1346 n1347 14.506666666666666
r2231 n1233 n1348 64
r2232 n1347 n1348 14.506666666666666
r2233 n1234 n1349 10.666666666666666
r2234 n1348 n1349 5.9733333333333336
r2235 n1235 n1350 32
r2236 n1349 n1350 6.8266666666666671
r2237 n1236 n1351 3.7647058823529411
r2238 n1237 n1352 3.7647058823529411
r2239 n1238 n1353 32
r2240 n1239 n1354 12.800000000000001
r2241 n1353 n1354 5.9733333333333336
r2242 n1240 n1355 64
r2243 n1354 n1355 5.1200000000000001
r2244 n1241 n1356 4
r2245 n1355 n1356 14.506666666666666
r2246 n1242 n1357 64
r2247 n1356 n1357 14.506666666666666
r2248 n1243 n1358 3.5555555555555554
r2249 n1357 n1358 16.213333333333335
r2250 n1244 n1359 64
r2251 n1358 n1359 16.213333333333335
r2252 n1245 n1360 4
r2253 n1359 n1360 14.506666666666666
r2254 n1246 n1361 64
r2255 n1360 n1361 14.506666666666666
r2256 n1247 n1362 3.5555555555555554
r2257 n1361 n1362 16.213333333333335
r2258 n1248 n1363 64
r2259 n1362 n1363 16.213333333333335
r2260 n1249 n1364 4
r2261 n1363 n1364 14.506666666666666
r2262 n1250 n1365 64
r2263 n1364 n1365 14.506666666666666
r2264 n1251 n1366 3.5555555555555554
r2265 n1365 n1366 16.213333333333335
r2266 n1252 n1367 64
r2267 n1366 n1367 16.213333333333335
r2268 n1253 n1368 4
r2269 n1367 n1368 14.506666666666666
r2270 n1254 n1369 64
r2271 n1368 n1369 14.506666666666666
r2272 n1255 n1370 3.5555555555555554
r2273 n1369 n1370 16.213333333333335
r2274 n1256 n1371 64
r2275 n1370 n1371 16.213333333333335
r2276 n1257 n1372 4
r2277 n1371 n1372 14.506666666666666
r2278 n1258 n1373 64
r2279 n1372 n1373 14.506666666666666
r2280 n1259 n1374 3.5555555555555554
r2281 n1373 n1374 16.213333333333335
r2282 n1260 n1375 64
r2283 n1374 n1375 16.213333333333335
r2284 n1261 n1376 4
r2285 n1375 n1376 14.506666666666666
r2286 n1262 n1377 64
r2287 n1376 n1377 14.506666666666666
r2288 n1263 n1378 3.5555555555555554
r2289 n1377 n1378 16.213333333333335
r2290 n1264 n1379 64
r2291 n1378 n1379 16.213333333333335
r2292 n1265 n1380 4
r2293 n1379 n1380 14.506666666666666
r2294 n1266 n1381 64
r2295 n1380 n1381 14.506666666666666
r2296 n1267 n1382 3.5555555555555554
r2297 n1381 n1382 16.213333333333335
r2298 n1268 n1383 64
r2299 n1382 n1383 16.213333333333335
r2300 n1269 n1384 4
r2301 n1383 n1384 14.506666666666666
r2302 n1270 n1385 64
r2303 n1384 n1385 14.506666666666666
r2304 n1271 n1386 8.5333333333333332
r2305 n1385 n1386 7.253333333333333
r2306 n1272 n1387 10.666666666666666
r2307 n1386 n1387 11.52
r2308 n1273 n1388 14.222222222222221
r2309 n1387 n1388 8.9600000000000009
r2310 n1274 n1389 64
r2311 n1388 n1389 4.6933333333333334
r2312 n1275 n1390 64
r2313 n1389 n1390 1.7066666666666668
r2314 n1276 n1391 16
r2315 n1390 n1391 4.2666666666666666
r2316 n1277 n1392 5.8181818181818183
r2317 n1391 n1392 12.800000000000001
r2318 n1278 n1393 128
r2319 n1392 n1393 9.8133333333333326
r2320 n1279 n1394 128
r2321 n1393 n1394 0.85333333333333339
r2322 n1280 n1395 128
r2323 n1394 n1395 0.85333333333333339
r2324 n1281 n1396 12.800000000000001
r2325 n1395 n1396 4.6933333333333334
r2326 n1282 n1397 10.666666666666666
r2327 n1396 n1397 9.3866666666666667
r2328 n1283 n1398 16
r2329 n1397 n1398 8.5333333333333332
r2330 n1284 n1399 64
r2331 n1398 n1399 4.2666666666666666
r2332 n1285 n1400 42.666666666666664
r2333 n1399 n1400 2.1333333333333333
r2334 n1286 n1401 64
r2335 n1400 n1401 2.1333333333333333
r2336 n1287 n1402 21.333333333333332
r2337 n1401 n1402 3.4133333333333336
r2338 n1288 n1403 10.666666666666666
r2339 n1402 n1403 7.6799999999999997
r2340 n1289 n1404 9.1428571428571423
r2341 n1403 n1404 11.093333333333334
r2342 n1290 n1405 64
r2343 n1404 n1405 6.8266666666666671
r2344 n1291 n1406 3.5555555555555554
r2345 n1405 n1406 16.213333333333335
r2346 n1292 n1407 64
r2347 n1406 n1407 16.213333333333335
r2348 n1293 n1408 4
r2349 n1407 n1408 14.506666666666666
r2350 n1294 n1409 64
r2351 n1408 n1409 14.506666666666666
r2352 n1295 n1410 3.5555555555555554
r2353 n1409 n1410 16.213333333333335
r2354 n1296 n1411 64
r2355 n1410 n1411 16.213333333333335
r2356 n1297 n1412 4
r2357 n1411 n1412 14.506666666666666
r2358 n1298 n1413 64
r2359 n1412 n1413 14.506666666666666
r2360 n1299 n1414 3.5555555555555554
r2361 n1413 n1414 16.213333333333335
r2362 n1300 n1415 64
r2363 n1414 n1415 16.213333333333335
r2364 n1301 n1416 4
r2365 n1415 n1416 14.506666666666666
r2366 n1302 n1417 64
r2367 n1416 n1417 14.506666666666666
r2368 n1303 n1418 3.5555555555555554
r2369 n1417 n1418 16.213333333333335
r2370 n1304 n1419 64
r2371 n1418 n1419 16.213333333333335
r2372 n1305 n1420 4
r2373 n1419 n1420 14.506666666666666
r2374 n1306 n1421 64
r2375 n1420 n1421 14.506666666666666
r2376 n1307 n1422 3.5555555555555554
r2377 n1421 n1422 16.213333333333335
r2378 n1308 n1423 64
r2379 n1422 n1423 16.213333333333335
r2380 n1309 n1424 4
r2381 n1423 n1424 14.506666666666666
r2382 n1310 n1425 64
r2383 n1424 n1425 14.506666666666666
r2384 n1311 n1426 3.5555555555555554
r2385 n1425 n1426 16.213333333333335
r2386 n1312 n1427 64
r2387 n1426 n1427 16.213333333333335
r2388 n1313 n1428 4
r2389 n1427 n1428 14.506666666666666
r2390 n1314 n1429 64
r2391 n1428 n1429 14.506666666666666
r2392 n1315 n1430 3.5555555555555554
r2393 n1429 n1430 16.213333333333335
r2394 n1316 n1431 64
r2395 n1430 n1431 16.213333333333335
r2396 n1317 n1432 4
r2397 n1431 n1432 14.506666666666666
r2398 n1318 n1433 64
r2399 n1432 n1433 14.506666666666666
r2400 n1319 n1434 10.666666666666666
r2401 n1433 n1434 5.9733333333333336
r2402 n1320 n1435 32
r2403 n1434 n1435 6.8266666666666671
r2404 n1321 n1436 3.7647058823529411
r2405 n1322 n1437 3.388235294117647
r2406 n1323 n1438 28.800000000000001
r2407 n1324 n1439 11.52
r2408 n1438 n1439 29.866666666666667
r2409 n1325 n1440 57.600000000000001
r2410 n1439 n1440 25.600000000000001
r2411 n1326 n1441 3.6000000000000001
r2412 n1440 n1441 72.533333333333331
r2413 n1327 n1442 57.600000000000001
r2414 n1441 n1442 72.533333333333331
r2415 n1328 n1443 3.2000000000000002
r2416 n1442 n1443 81.066666666666663
r2417 n1329 n1444 57.600000000000001
r2418 n1443 n1444 81.066666666666663
r2419 n1330 n1445 8.861538461538462
r2420 n1444 n1445 32
r2421 n1331 n1446 9.5999999999999996
r2422 n1445 n1446 53.333333333333336
r2423 n1332 n1447 16.457142857142856
r2424 n1446 n1447 40.533333333333331
r2425 n1333 n1448 57.600000000000001
r2426 n1447 n1448 19.199999999999999
r2427 n1334 n1449 28.800000000000001
r2428 n1448 n1449 12.800000000000001
r2429 n1335 n1450 12.800000000000001
r2430 n1449 n1450 27.733333333333334
r2431 n1336 n1451 5.4857142857142858
r2432 n1450 n1451 64
r2433 n1337 n1452 57.600000000000001
r2434 n1451 n1452 49.06666666666667
r2435 n1338 n1453 57.600000000000001
r2436 n1452 n1453 8.5333333333333332
r2437 n1339 n1454 12.800000000000001
r2438 n1453 n1454 23.466666666666665
r2439 n1340 n1455 9.5999999999999996
r2440 n1454 n1455 44.799999999999997
r2441 n1341 n1456 12.800000000000001
r2442 n1455 n1456 44.799999999999997
r2443 n1342 n1457 57.600000000000001
r2444 n1456 n1457 23.466666666666665
r2445 n1343 n1458 57.600000000000001
r2446 n1457 n1458 8.5333333333333332
r2447 n1344 n1459 5.4857142857142858
r2448 n1458 n1459 49.06666666666667
r2449 n1345 n1460 7.6799999999999997
r2450 n1459 n1460 76.799999999999997
r2451 n1346 n1461 57.600000000000001
r2452 n1460 n1461 36.266666666666666
r2453 n1347 n1462 3.6000000000000001
r2454 n1461 n1462 72.533333333333331
r2455 n1348 n1463 57.600000000000001
r2456 n1462 n1463 72.533333333333331
r2457 n1349 n1464 9.5999999999999996
r2458 n1463 n1464 29.866666666666667
r2459 n1350 n1465 28.800000000000001
r2460 n1464 n1465 34.133333333333333
r2461 n1351 n1466 3.388235294117647
r2462 n1352 n1467 3.388235294117647
r2463 n1353 n1468 28.800000000000001
r2464 n1354 n1469 11.52
r2465 n1468 n1469 29.866666666666667
r2466 n1355 n1470 57.600000000000001
r2467 n1469 n1470 25.600000000000001
r2468 n1356 n1471 3.6000000000000001
r2469 n1470 n1471 72.533333333333331
r2470 n1357 n1472 57.600000000000001
r2471 n1471 n1472 72.533333333333331
r2472 n1358 n1473 3.2000000000000002
r2473 n1472 n1473 81.066666666666663
r2474 n1359 n1474 57.600000000000001
r2475 n1473 n1474 81.066666666666663
r2476 n1360 n1475 3.6000000000000001
r2477 n1474 n1475 72.533333333333331
r2478 n1361 n1476 57.600000000000001
r2479 n1475 n1476 72.533333333333331
r2480 n1362 n1477 3.2000000000000002
r2481 n1476 n1477 81.066666666666663
r2482 n1363 n1478 57.600000000000001
r2483 n1477 n1478 81.066666666666663
r2484 n1364 n1479 3.6000000000000001
r2485 n1478 n1479 72.533333333333331
r2486 n1365 n1480 57.600000000000001
r2487 n1479 n1480 72.533333333333331
r2488 n1366 n1481 3.2000000000000002
r2489 n1480 n1481 81.066666666666663
r2490 n1367 n1482 57.600000000000001
r2491 n1481 n1482 81.066666666666663
r2492 n1368 n1483 3.6000000000000001
r2493 n1482 n1483 72.533333333333331
r2494 n1369 n1484 57.600000000000001
r2495 n1483 n1484 72.533333333333331
r2496 n1370 n1485 3.2000000000000002
r2497 n1484 n1485 81.066666666666663
r2498 n1371 n1486 57.600000000000001
r2499 n1485 n1486 81.066666666666663
r2500 n1372 n1487 3.6000000000000001
r2501 n1486 n1487 72.533333333333331
r2502 n1373 n1488 57.600000000000001
r2503 n1487 n1488 72.533333333333331
r2504 n1374 n1489 3.2000000000000002
r2505 n1488 n1489 81.066666666666663
r2506 n1375 n1490 57.600000000000001
r2507 n1489 n1490 81.066666666666663
r2508 n1376 n1491 3.6000000000000001
r2509 n1490 n1491 72.533333333333331
r2510 n1377 n1492 57.600000000000001
r2511 n1491 n1492 72.533333333333331
r2512 n1378 n1493 3.2000000000000002
r2513 n1492 n1493 81.066666666666663
r2514 n1379 n1494 57.600000000000001
r2515 n1493 n1494 81.066666666666663
r2516 n1380 n1495 3.6000000000000001
r2517 n1494 n1495 72.533333333333331
r2518 n1381 n1496 57.600000000000001
r2519 n1495 n1496 72.533333333333331
r2520 n1382 n1497 3.2000000000000002
r2521 n1496 n1497 81.066666666666663
r2522 n1383 n1498 57.600000000000001
r2523 n1497 n1498 81.066666666666663
r2524 n1384 n1499 3.6000000000000001
r2525 n1498 n1499 72.533333333333331
r2526 n1385 n1500 57.600000000000001
r2527 n1499 n1500 72.533333333333331
r2528 n1386 n1501 7.6799999999999997
r2529 n1500 n1501 36.266666666666666
r2530 n1387 n1502 9.5999999999999996
r2531 n1501 n1502 57.600000000000001
r2532 n1388 n1503 12.800000000000001
r2533 n1502 n1503 44.799999999999997
r2534 n1389 n1504 57.600000000000001
r2535 n1503 n1504 23.466666666666665
r2536 n1390 n1505 57.600000000000001
r2537 n1504 n1505 8.5333333333333332
r2538 n1391 n1506 14.4
r2539 n1505 n1506 21.333333333333332
r2540 n1392 n1507 5.2363636363636363
r2541 n1506 n1507 64
r2542 n1393 n1508 115.2
r2543 n1507 n1508 49.06666666666667
r2544 n1394 n1509 115.2
r2545 n1508 n1509 4.2666666666666666
r2546 n1395 n1510 115.2
r2547 n1509 n1510 4.2666666666666666
r2548 n1396 n1511 11.52
r2549 n1510 n1511 23.466666666666665
r2550 n1397 n1512 9.5999999999999996
r2551 n1511 n1512 46.93333333333333
r2552 n1398 n1513 14.4
r2553 n1512 n1513 42.666666666666664
r2554 n1399 n1514 57.600000000000001
r2555 n1513 n1514 21.333333333333332
r2556 n1400 n1515 38.399999999999999
r2557 n1514 n1515 10.666666666666666
r2558 n1401 n1516 57.600000000000001
r2559 n1515 n1516 10.666666666666666
r2560 n1402 n1517 19.199999999999999
r2561 n1516 n1517 17.066666666666666
r2562 n1403 n1518 9.5999999999999996
r2563 n1517 n1518 38.399999999999999
r2564 n1404 n1519 8.2285714285714278
r2565 n1518 n1519 55.466666666666669
r2566 n1405 n1520 57.600000000000001
r2567 n1519 n1520 34.133333333333333
r2568 n1406 n1521 3.2000000000000002
r2569 n1520 n1521 81.066666666666663
r2570 n1407 n1522 57.600000000000001
r2571 n1521 n1522 81.066666666666663
r2572 n1408 n1523 3.6000000000000001
r2573 n1522 n1523 72.533333333333331
r2574 n1409 n1524 57.600000000000001
r2575 n1523 n1524 72.533333333333331
r2576 n1410 n1525 3.2000000000000002
r2577 n1524 n1525 81.066666666666663
r2578 n1411 n1526 57.600000000000001
r2579 n1525 n1526 81.066666666666663
r2580 n1412 n1527 3.6000000000000001
r2581 n1526 n1527 72.533333333333331
r2582 n1413 n1528 57.600000000000001
r2583 n1527 n1528 72.533333333333331
r2584 n1414 n1529 3.2000000000000002
r2585 n1528 n1529 81.066666666666663
r2586 n1415 n1530 57.600000000000001
r2587 n1529 n1530 81.066666666666663
r2588 n1416 n1531 3.6000000000000001
r2589 n1530 n1531 72.533333333333331
r2590 n1417 n1532 57.600000000000001
r2591 n1531 n1532 72.533333333333331
r2592 n1418 n1533 3.2000000000000002
r2593 n1532 n1533 81.066666666666663
r2594 n1419 n1534 57.600000000000001
r2595 n1533 n1534 81.066666666666663
r2596 n1420 n1535 3.6000000000000001
r2597 n1534 n1535 72.533333333333331
r2598 n1421 n1536 57.600000000000001
r2599 n1535 n1536 72.533333333333331
r2600 n1422 n1537 3.2000000000000002
r2601 n1536 n1537 81.066666666666663
r2602 n1423 n1538 57.600000000000001
r2603 n1537 n1538 81.066666666666663
r2604 n1424 n1539 3.6000000000000001
r2605 n1538 n1539 72.533333333333331
r2606 n1425 n1540 57.600000000000001
r2607 n1539 n1540 72.533333333333331
r2608 n1426 n1541 3.2000000000000002
r2609 n1540 n1541 81.066666666666663
r2610 n1427 n1542 57.600000000000001
r2611 n1541 n1542 81.066666666666663
r2612 n1428 n1543 3.6000000000000001
r2613 n1542 n1543 72.533333333333331
r2614 n1429 n1544 57.600000000000001
r2615 n1543 n1544 72.533333333333331
r2616 n1430 n1545 3.2000000000000002
r2617 n1544 n1545 81.066666666666663
r2618 n1431 n1546 57.600000000000001
r2619 n1545 n1546 81.066666666666663
r2620 n1432 n1547 3.6000000000000001
r2621 n1546 n1547 72.533333333333331
r2622 n1433 n1548 57.600000000000001
r2623 n1547 n1548 72.533333333333331
r2624 n1434 n1549 9.5999999999999996
r2625 n1548 n1549 29.866666666666667
r2626 n1435 n1550 28.800000000000001
r2627 n1549 n1550 34.133333333333333
r2628 n1436 n1551 3.388235294117647
r2629 n1437 n1552 1.3176470588235294
r2630 n1438 n1553 11.199999999999999
r2631 n1439 n1554 4.4800000000000004
r2632 n1553 n1554 22.399999999999999
r2633 n1440 n1555 22.399999999999999
r2634 n1554 n1555 19.199999999999999
r2635 n1441 n1556 1.3999999999999999
r2636 n1555 n1556 54.399999999999999
r2637 n1442 n1557 22.399999999999999
r2638 n1556 n1557 54.399999999999999
r2639 n1443 n1558 1.2444444444444445
r2640 n1557 n1558 60.799999999999997
r2641 n1444 n1559 22.399999999999999
r2642 n1558 n1559 60.799999999999997
r2643 n1445 n1560 3.4461538461538463
r2644 n1559 n1560 24
r2645 n1446 n1561 3.7333333333333334
r2646 n1560 n1561 40
r2647 n1447 n1562 6.4000000000000004
r2648 n1561 n1562 30.399999999999999
r2649 n1448 n1563 22.399999999999999
r2650 n1562 n1563 14.4
r2651 n1449 n1564 11.199999999999999
r2652 n1563 n1564 9.5999999999999996
r2653 n1450 n1565 4.9777777777777779
r2654 n1564 n1565 20.800000000000001
r2655 n1451 n1566 2.1333333333333333
r2656 n1565 n1566 48
r2657 n1452 n1567 22.399999999999999
r2658 n1566 n1567 36.799999999999997
r2659 n1453 n1568 22.399999999999999
r2660 n1567 n1568 6.4000000000000004
r2661 n1454 n1569 4.9777777777777779
r2662 n1568 n1569 17.600000000000001
r2663 n1455 n1570 3.7333333333333334
r2664 n1569 n1570 33.600000000000001
r2665 n1456 n1571 4.9777777777777779
r2666 n1570 n1571 33.600000000000001
r2667 n1457 n1572 22.399999999999999
r2668 n1571 n1572 17.600000000000001
r2669 n1458 n1573 22.399999999999999
r2670 n1572 n1573 6.4000000000000004
r2671 n1459 n1574 2.1333333333333333
r2672 n1573 n1574 36.799999999999997
r2673 n1460 n1575 2.9866666666666668
r2674 n1574 n1575 57.600000000000001
r2675 n1461 n1576 22.399999999999999
r2676 n1575 n1576 27.199999999999999
r2677 n1462 n1577 1.3999999999999999
r2678 n1576 n1577 54.399999999999999
r2679 n1463 n1578 22.399999999999999
r2680 n1577 n1578 54.399999999999999
r2681 n1464 n1579 3.7333333333333334
r2682 n1578 n1579 22.399999999999999
r2683 n1465 n1580 11.199999999999999
r2684 n1579 n1580 25.600000000000001
r2685 n1466 n1581 1.3176470588235294
r2686 n1467 n1582 1.3176470588235294
r2687 n1468 n1583 11.199999999999999
r2688 n1469 n1584 4.4800000000000004
r2689 n1583 n1584 22.399999999999999
r2690 n1470 n1585 22.399999999999999
r2691 n1584 n1585 19.199999999999999
r2692 n1471 n1586 1.3999999999999999
r2693 n1585 n1586 54.399999999999999
r2694 n1472 n1587 22.399999999999999
r2695 n1586 n1587 54.399999999999999
r2696 n1473 n1588 1.2444444444444445
r2697 n1587 n1588 60.799999999999997
r2698 n1474 n1589 22.399999999999999
r2699 n1588 n1589 60.799999999999997
r2700 n1475 n1590 1.3999999999999999
r2701 n1589 n1590 54.399999999999999
r2702 n1476 n1591 22.399999999999999
r2703 n1590 n1591 54.399999999999999
r2704 n1477 n1592 1.2444444444444445
r2705 n1591 n1592 60.799999999999997
r2706 n1478 n1593 22.399999999999999
r2707 n1592 n1593 60.799999999999997
r2708 n1479 n1594 1.3999999999999999
r2709 n1593 n1594 54.399999999999999
r2710 n1480 n1595 22.399999999999999
r2711 n1594 n1595 54.399999999999999
r2712 n1481 n1596 1.2444444444444445
r2713 n1595 n1596 60.799999999999997
r2714 n1482 n1597 22.399999999999999
r2715 n1596 n1597 60.799999999999997
r2716 n1483 n1598 1.3999999999999999
r2717 n1597 n1598 54.399999999999999
r2718 n1484 n1599 22.399999999999999
r2719 n1598 n1599 54.399999999999999
r2720 n1485 n1600 1.2444444444444445
r2721 n1599 n1600 60.799999999999997
r2722 n1486 n1601 22.399999999999999
r2723 n1600 n1601 60.799999999999997
r2724 n1487 n1602 1.3999999999999999
r2725 n1601 n1602 54.399999999999999
r2726 n1488 n1603 22.399999999999999
r2727 n1602 n1603 54.399999999999999
r2728 n1489 n1604 1.2444444444444445
r2729 n1603 n1604 60.799999999999997
r2730 n1490 n1605 22.399999999999999
r2731 n1604 n1605 60.799999999999997
r2732 n1491 n1606 1.3999999999999999
r2733 n1605 n1606 54.399999999999999
r2734 n1492 n1607 22.399999999999999
r2735 n1606 n1607 54.399999999999999
r2736 n1493 n1608 1.2444444444444445
r2737 n1607 n1608 60.799999999999997
r2738 n1494 n1609 22.399999999999999
r2739 n1608 n1609 60.799999999999997
r2740 n1495 n1610 1.3999999999999999
r2741 n1609 n1610 54.399999999999999
r2742 n1496 n1611 22.399999999999999
r2743 n1610 n1611 54.399999999999999
r2744 n1497 n1612 1.2444444444444445
r2745 n1611 n1612 60.799999999999997
r2746 n1498 n1613 22.399999999999999
r2747 n1612 n1613 60.799999999999997
r2748 n1499 n1614 1.3999999999999999
r2749 n1613 n1614 54.399999999999999
r2750 n1500 n1615 22.399999999999999
r2751 n1614 n1615 54.399999999999999
r2752 n1501 n1616 2.9866666666666668
r2753 n1615 n1616 27.199999999999999
r2754 n1502 n1617 3.7333333333333334
r2755 n1616 n1617 43.200000000000003
r2756 n1503 n1618 4.9777777777777779
r2757 n1617 n1618 33.600000000000001
r2758 n1504 n1619 22.399999999999999
r2759 n1618 n1619 17.600000000000001
r2760 n1505 n1620 22.399999999999999
r2761 n1619 n1620 6.4000000000000004
r2762 n1506 n1621 5.5999999999999996
r2763 n1620 n1621 16
r2764 n1507 n1622 2.0363636363636362
r2765 n1621 n1622 48
r2766 n1508 n1623 44.799999999999997
r2767 n1622 n1623 36.799999999999997
r2768 n1509 n1624 44.799999999999997
r2769 n1623 n1624 3.2000000000000002
r2770 n1510 n1625 44.799999999999997
r2771 n1624 n1625 3.2000000000000002
r2772 n1511 n1626 4.4800000000000004
r2773 n1625 n1626 17.600000000000001
r2774 n1512 n1627 3.7333333333333334
r2775 n1626 n1627 35.200000000000003
r2776 n1513 n1628 5.5999999999999996
r2777 n1627 n1628 32
r2778 n1514 n1629 22.399999999999999
r2779 n1628 n1629 16
r2780 n1515 n1630 14.933333333333334
r2781 n1629 n1630 8
r2782 n1516 n1631 22.399999999999999
r2783 n1630 n1631 8
r2784 n1517 n1632 7.4666666666666668
r2785 n1631 n1632 12.800000000000001
r2786 n1518 n1633 3.7333333333333334
r2787 n1632 n1633 28.800000000000001
r2788 n1519 n1634 3.2000000000000002
r2789 n1633 n1634 41.600000000000001
r2790 n1520 n1635 22.399999999999999
r2791 n1634 n1635 25.600000000000001
r2792 n1521 n1636 1.2444444444444445
r2793 n1635 n1636 60.799999999999997
r2794 n1522 n1637 22.399999999999999
r2795 n1636 n1637 60.799999999999997
r2796 n1523 n1638 1.3999999999999999
r2797 n1637 n1638 54.399999999999999
r2798 n1524 n1639 22.399999999999999
r2799 n1638 n1639 54.399999999999999
r2800 n1525 n1640 1.2444444444444445
r2801 n1639 n1640 60.799999999999997
r2802 n1526 n1641 22.399999999999999
r2803 n1640 n1641 60.799999999999997
r2804 n1527 n1642 1.3999999999999999
r2805 n1641 n1642 54.399999999999999
r2806 n1528 n1643 22.399999999999999
r2807 n1642 n1643 54.399999999999999
r2808 n1529 n1644 1.2444444444444445
r2809 n1643 n1644 60.799999999999997
r2810 n1530 n1645 22.399999999999999
r2811 n1644 n1645 60.799999999999997
r2812 n1531 n1646 1.3999999999999999
r2813 n1645 n1646 54.399999999999999
r2814 n1532 n1647 22.399999999999999
r2815 n1646 n1647 54.399999999999999
r2816 n1533 n1648 1.2444444444444445
r2817 n1647 n1648 60.799999999999997
r2818 n1534 n1649 22.399999999999999
r2819 n1648 n1649 60.799999999999997
r2820 n1535 n1650 1.3999999999999999
r2821 n1649 n1650 54.399999999999999
r2822 n1536 n1651 22.399999999999999
r2823 n1650 n1651 54.399999999999999
r2824 n1537 n1652 1.2444444444444445
r2825 n1651 n1652 60.799999999999997
r2826 n1538 n1653 22.399999999999999
r2827 n1652 n1653 60.799999999999997
r2828 n1539 n1654 1.3999999999999999
r2829 n1653 n1654 54.399999999999999
r2830 n1540 n1655 22.399999999999999
r2831 n1654 n1655 54.399999999999999
r2832 n1541 n1656 1.2444444444444445
r2833 n1655 n1656 60.799999999999997
r2834 n1542 n1657 22.399999999999999
r2835 n1656 n1657 60.799999999999997
r2836 n1543 n1658 1.3999999999999999
r2837 n1657 n1658 54.399999999999999
r2838 n1544 n1659 22.399999999999999
r2839 n1658 n1659 54.399999999999999
r2840 n1545 n1660 1.2444444444444445
r2841 n1659 n1660 60.799999999999997
r2842 n1546 n1661 22.399999999999999
r2843 n1660 n1661 60.799999999999997
r2844 n1547 n1662 1.3999999999999999
r2845 n1661 n1662 54.399999999999999
r2846 n1548 n1663 22.399999999999999
r2847 n1662 n1663 54.399999999999999
r2848 n1549 n1664 3.7333333333333334
r2849 n1663 n1664 22.399999999999999
r2850 n1550 n1665 11.199999999999999
r2851 n1664 n1665 25.600000000000001
r2852 n1551 n1666 1.3176470588235294
r2853 n1552 n1667 1.3176470588235294
r2854 n1553 n1668 11.199999999999999
r2855 n1554 n1669 4.4800000000000004
r2856 n1668 n1669 29.866666666666667
r2857 n1555 n1670 22.399999999999999
r2858 n1669 n1670 25.600000000000001
r2859 n1556 n1671 1.3999999999999999
r2860 n1670 n1671 72.533333333333331
r2861 n1557 n1672 22.399999999999999
r2862 n1671 n1672 72.533333333333331
r2863 n1558 n1673 1.2444444444444445
r2864 n1672 n1673 81.066666666666663
r2865 n1559 n1674 22.399999999999999
r2866 n1673 n1674 81.066666666666663
r2867 n1560 n1675 3.4461538461538463
r2868 n1674 n1675 32
r2869 n1561 n1676 3.7333333333333334
r2870 n1675 n1676 53.333333333333336
r2871 n1562 n1677 6.4000000000000004
r2872 n1676 n1677 40.533333333333331
r2873 n1563 n1678 22.399999999999999
r2874 n1677 n1678 19.199999999999999
r2875 n1564 n1679 11.199999999999999
r2876 n1678 n1679 12.800000000000001
r2877 n1565 n1680 4.9777777777777779
r2878 n1679 n1680 27.733333333333334
r2879 n1566 n1681 2.1333333333333333
r2880 n1680 n1681 64
r2881 n1567 n1682 22.399999999999999
r2882 n1681 n1682 49.06666666666667
r2883 n1568 n1683 22.399999999999999
r2884 n1682 n1683 8.5333333333333332
r2885 n1569 n1684 4.9777777777777779
r2886 n1683 n1684 23.466666666666665
r2887 n1570 n1685 3.7333333333333334
r2888 n1684 n1685 44.799999999999997
r2889 n1571 n1686 4.9777777777777779
r2890 n1685 n1686 44.799999999999997
r2891 n1572 n1687 22.399999999999999
r2892 n1686 n1687 23.466666666666665
r2893 n1573 n1688 22.399999999999999
r2894 n1687 n1688 8.5333333333333332
r2895 n1574 n1689 2.1333333333333333
r2896 n1688 n1689 49.06666666666667
r2897 n1575 n1690 2.9866666666666668
r2898 n1689 n1690 76.799999999999997
r2899 n1576 n1691 22.399999999999999
r2900 n1690 n1691 36.266666666666666
r2901 n1577 n1692 1.3999999999999999
r2902 n1691 n1692 72.533333333333331
r2903 n1578 n1693 22.399999999999999
r2904 n1692 n1693 72.533333333333331
r2905 n1579 n1694 3.7333333333333334
r2906 n1693 n1694 29.866666666666667
r2907 n1580 n1695 11.199999999999999
r2908 n1694 n1695 34.133333333333333
r2909 n1696 n1697 21.333333333333332
r2910 n1697 n1698 64
r2911 n1698 n1699 51.200000000000003
r2912 n1581 n1700 1.3176470588235294
r2913 n1582 n1701 1.3176470588235294
r2914 n1583 n1702 11.199999999999999
r2915 n1584 n1703 4.4800000000000004
r2916 n1702 n1703 29.866666666666667
r2917 n1585 n1704 22.399999999999999
r2918 n1703 n1704 25.600000000000001
r2919 n1586 n1705 1.3999999999999999
r2920 n1704 n1705 72.533333333333331
r2921 n1587 n1706 22.399999999999999
r2922 n1705 n1706 72.533333333333331
r2923 n1588 n1707 1.2444444444444445
r2924 n1706 n1707 81.066666666666663
r2925 n1589 n1708 22.399999999999999
r2926 n1707 n1708 81.066666666666663
r2927 n1590 n1709 1.3999999999999999
r2928 n1708 n1709 72.533333333333331
r2929 n1591 n1710 22.399999999999999
r2930 n1709 n1710 72.533333333333331
r2931 n1592 n1711 1.2444444444444445
r2932 n1710 n1711 81.066666666666663
r2933 n1593 n1712 22.399999999999999
r2934 n1711 n1712 81.066666666666663
r2935 n1594 n1713 1.3999999999999999
r2936 n1712 n1713 72.533333333333331
r2937 n1595 n1714 22.399999999999999
r2938 n1713 n1714 72.533333333333331
r2939 n1596 n1715 1.2444444444444445
r2940 n1714 n1715 81.066666666666663
r2941 n1597 n1716 22.399999999999999
r2942 n1715 n1716 81.066666666666663
r2943 n1598 n1717 1.3999999999999999
r2944 n1716 n1717 72.533333333333331
r2945 n1599 n1718 22.399999999999999
r2946 n1717 n1718 72.533333333333331
r2947 n1600 n1719 1.2444444444444445
r2948 n1718 n1719 81.066666666666663
r2949 n1601 n1720 22.399999999999999
r2950 n1719 n1720 81.066666666666663
r2951 n1602 n1721 1.3999999999999999
r2952 n1720 n1721 72.533333333333331
r2953 n1603 n1722 22.399999999999999
r2954 n1721 n1722 72.533333333333331
r2955 n1604 n1723 1.2444444444444445
r2956 n1722 n1723 81.066666666666663
r2957 n1605 n1724 22.399999999999999
r2958 n1723 n1724 81.066666666666663
r2959 n1606 n1725 1.3999999999999999
r2960 n1724 n1725 72.533333333333331
r2961 n1607 n1726 22.399999999999999
r2962 n1725 n1726 72.533333333333331
r2963 n1608 n1727 1.2444444444444445
r2964 n1726 n1727 81.066666666666663
r2965 n1609 n1728 22.399999999999999
r2966 n1727 n1728 81.066666666666663
r2967 n1610 n1729 1.3999999999999999
r2968 n1728 n1729 72.533333333333331
r2969 n1611 n1730 22.399999999999999
r2970 n1729 n1730 72.533333333333331
r2971 n1612 n1731 1.2444444444444445
r2972 n1730 n1731 81.066666666666663
r2973 n1613 n1732 22.399999999999999
r2974 n1731 n1732 81.066666666666663
r2975 n1614 n1733 1.3999999999999999
r2976 n1732 n1733 72.533333333333331
r2977 n1615 n1734 22.399999999999999
r2978 n1733 n1734 72.533333333333331
r2979 n1616 n1735 2.9866666666666668
r2980 n1734 n1735 36.266666666666666
r2981 n1617 n1736 3.7333333333333334
r2982 n1735 n1736 57.600000000000001
r2983 n1618 n1737 4.9777777777777779
r2984 n1736 n1737 44.799999999999997
r2985 n1619 n1738 22.399999999999999
r2986 n1737 n1738 23.466666666666665
r2987 n1620 n1739 22.399999999999999
r2988 n1738 n1739 8.5333333333333332
r2989 n1621 n1740 5.5999999999999996
r2990 n1739 n1740 21.333333333333332
r2991 n1622 n1741 2.0363636363636362
r2992 n1740 n1741 64
r2993 n1623 n1742 44.799999999999997
r2994 n1741 n1742 49.06666666666667
r2995 n1624 n1743 44.799999999999997
r2996 n1742 n1743 4.2666666666666666
r2997 n1625 n1744 44.799999999999997
r2998 n1743 n1744 4.2666666666666666
r2999 n1626 n1745 4.4800000000000004
r3000 n1744 n1745 23.466666666666665
r3001 n1627 n1746 3.7333333333333334
r3002 n1745 n1746 46.93333333333333
r3003 n1628 n1747 5.5999999999999996
r3004 n1746 n1747 42.666666666666664
r3005 n1629 n1748 22.399999999999999
r3006 n1747 n1748 21.333333333333332
r3007 n1630 n1749 14.933333333333334
r3008 n1748 n1749 10.666666666666666
r3009 n1631 n1750 22.399999999999999
r3010 n1749 n1750 10.666666666666666
r3011 n1632 n1751 7.4666666666666668
r3012 n1750 n1751 17.066666666666666
r3013 n1633 n1752 3.7333333333333334
r3014 n1751 n1752 38.399999999999999
r3015 n1634 n1753 3.2000000000000002
r3016 n1752 n1753 55.466666666666669
r3017 n1635 n1754 22.399999999999999
r3018 n1753 n1754 34.133333333333333
r3019 n1636 n1755 1.2444444444444445
r3020 n1754 n1755 81.066666666666663
r3021 n1637 n1756 22.399999999999999
r3022 n1755 n1756 81.066666666666663
r3023 n1638 n1757 1.3999999999999999
r3024 n1756 n1757 72.533333333333331
r3025 n1639 n1758 22.399999999999999
r3026 n1757 n1758 72.533333333333331
r3027 n1640 n1759 1.2444444444444445
r3028 n1758 n1759 81.066666666666663
r3029 n1641 n1760 22.399999999999999
r3030 n1759 n1760 81.066666666666663
r3031 n1642 n1761 1.3999999999999999
r3032 n1760 n1761 72.533333333333331
r3033 n1643 n1762 22.399999999999999
r3034 n1761 n1762 72.533333333333331
r3035 n1644 n1763 1.2444444444444445
r3036 n1762 n1763 81.066666666666663
r3037 n1645 n1764 22.399999999999999
r3038 n1763 n1764 81.066666666666663
r3039 n1646 n1765 1.3999999999999999
r3040 n1764 n1765 72.533333333333331
r3041 n1647 n1766 22.399999999999999
r3042 n1765 n1766 72.533333333333331
r3043 n1648 n1767 1.2444444444444445
r3044 n1766 n1767 81.066666666666663
r3045 n1649 n1768 22.399999999999999
r3046 n1767 n1768 81.066666666666663
r3047 n1650 n1769 1.3999999999999999
r3048 n1768 n1769 72.533333333333331
r3049 n1651 n1770 22.399999999999999
r3050 n1769 n1770 72.533333333333331
r3051 n1652 n1771 1.2444444444444445
r3052 n1770 n1771 81.066666666666663
r3053 n1653 n1772 22.399999999999999
r3054 n1771 n1772 81.066666666666663
r3055 n1654 n1773 1.3999999999999999
r3056 n1772 n1773 72.533333333333331
r3057 n1655 n1774 22.399999999999999
r3058 n1773 n1774 72.533333333333331
r3059 n1656 n1775 1.2444444444444445
r3060 n1774 n1775 81.066666666666663
r3061 n1657 n1776 22.399999999999999
r3062 n1775 n1776 81.066666666666663
r3063 n1658 n1777 1.3999999999999999
r3064 n1776 n1777 72.533333333333331
r3065 n1659 n1778 22.399999999999999
r3066 n1777 n1778 72.533333333333331
r3067 n1660 n1779 1.2444444444444445
r3068 n1778 n1779 81.066666666666663
r3069 n1661 n1780 22.399999999999999
r3070 n1779 n1780 81.066666666666663
r3071 n1662 n1781 1.3999999999999999
r3072 n1780 n1781 72.533333333333331
r3073 n1663 n1782 22.399999999999999
r3074 n1781 n1782 72.533333333333331
r3075 n1664 n1783 3.7333333333333334
r3076 n1782 n1783 29.866666666666667
r3077 n1665 n1784 11.199999999999999
r3078 n1783 n1784 34.133333333333333
r3079 n1785 n1786 27.733333333333334
r3080 n1786 n1787 64
r3081 n1787 n1788 44.799999999999997
r3082 n1666 n1789 1.3176470588235294
r3083 n1667 n1790 0.94117647058823528
r3084 n1668 n1791 8
r3085 n1669 n1792 3.2000000000000002
r3086 n1791 n1792 44.799999999999997
r3087 n1670 n1793 16
r3088 n1792 n1793 38.399999999999999
r3089 n1671 n1794 1
r3090 n1793 n1794 108.8
r3091 n1672 n1795 16
r3092 n1794 n1795 108.8
r3093 n1673 n1796 0.88888888888888884
r3094 n1795 n1796 121.59999999999999
r3095 n1674 n1797 16
r3096 n1796 n1797 121.59999999999999
r3097 n1675 n1798 2.4615384615384617
r3098 n1797 n1798 48
r3099 n1676 n1799 2.6666666666666665
r3100 n1798 n1799 80
r3101 n1677 n1800 4.5714285714285712
r3102 n1799 n1800 60.799999999999997
r3103 n1678 n1801 16
r3104 n1800 n1801 28.800000000000001
r3105 n1679 n1802 8
r3106 n1801 n1802 19.199999999999999
r3107 n1680 n1803 3.5555555555555554
r3108 n1802 n1803 41.600000000000001
r3109 n1681 n1804 1.5238095238095237
r3110 n1803 n1804 96
r3111 n1682 n1805 16
r3112 n1804 n1805 73.599999999999994
r3113 n1683 n1806 16
r3114 n1805 n1806 12.800000000000001
r3115 n1684 n1807 3.5555555555555554
r3116 n1806 n1807 35.200000000000003
r3117 n1685 n1808 2.6666666666666665
r3118 n1807 n1808 67.200000000000003
r3119 n1686 n1809 3.5555555555555554
r3120 n1808 n1809 67.200000000000003
r3121 n1687 n1810 16
r3122 n1809 n1810 35.200000000000003
r3123 n1688 n1811 16
r3124 n1810 n1811 12.800000000000001
r3125 n1689 n1812 1.5238095238095237
r3126 n1811 n1812 73.599999999999994
r3127 n1690 n1813 2.1333333333333333
r3128 n1812 n1813 115.2
r3129 n1691 n1814 16
r3130 n1813 n1814 54.399999999999999
r3131 n1692 n1815 1
r3132 n1814 n1815 108.8
r3133 n1693 n1816 16
r3134 n1815 n1816 108.8
r3135 n1694 n1817 2.6666666666666665
r3136 n1816 n1817 44.799999999999997
r3137 n1695 n1818 8
r3138 n1817 n1818 51.200000000000003
r3139 n1696 n1819 16
r3140 n1697 n1820 4
r3141 n1819 n1820 32
r3142 n1698 n1821 1.4545454545454546
r3143 n1820 n1821 96
r3144 n1699 n1822 16
r3145 n1821 n1822 76.799999999999997
r3146 n1700 n1823 0.94117647058823528
r3147 n1701 n1824 0.94117647058823528
r3148 n1702 n1825 8
r3149 n1703 n1826 3.2000000000000002
r3150 n1825 n1826 44.799999999999997
r3151 n1704 n1827 16
r3152 n1826 n1827 38.399999999999999
r3153 n1705 n1828 1
r3154 n1827 n1828 108.8
r3155 n1706 n1829 16
r3156 n1828 n1829 108.8
r3157 n1707 n1830 0.88888888888888884
r3158 n1829 n1830 121.59999999999999
r3159 n1708 n1831 16
r3160 n1830 n1831 121.59999999999999
r3161 n1709 n1832 1
r3162 n1831 n1832 108.8
r3163 n1710 n1833 16
r3164 n1832 n1833 108.8
r3165 n1711 n1834 0.88888888888888884
r3166 n1833 n1834 121.59999999999999
r3167 n1712 n1835 16
r3168 n1834 n1835 121.59999999999999
r3169 n1713 n1836 1
r3170 n1835 n1836 108.8
r3171 n1714 n1837 16
r3172 n1836 n1837 108.8
r3173 n1715 n1838 0.88888888888888884
r3174 n1837 n1838 121.59999999999999
r3175 n1716 n1839 16
r3176 n1838 n1839 121.59999999999999
r3177 n1717 n1840 1
r3178 n1839 n1840 108.8
r3179 n1718 n1841 16
r3180 n1840 n1841 108.8
r3181 n1719 n1842 0.88888888888888884
r3182 n1841 n1842 121.59999999999999
r3183 n1720 n1843 16
r3184 n1842 n1843 121.59999999999999
r3185 n1721 n1844 1
r3186 n1843 n1844 108.8
r3187 n1722 n1845 16
r3188 n1844 n1845 108.8
r3189 n1723 n1846 0.88888888888888884
r3190 n1845 n1846 121.59999999999999
r3191 n1724 n1847 16
r3192 n1846 n1847 121.59999999999999
r3193 n1725 n1848 1
r3194 n1847 n1848 108.8
r3195 n1726 n1849 16
r3196 n1848 n1849 108.8
r3197 n1727 n1850 0.88888888888888884
r3198 n1849 n1850 121.59999999999999
r3199 n1728 n1851 16
r3200 n1850 n1851 121.59999999999999
r3201 n1729 n1852 1
r3202 n1851 n1852 108.8
r3203 n1730 n1853 16
r3204 n1852 n1853 108.8
r3205 n1731 n1854 0.88888888888888884
r3206 n1853 n1854 121.59999999999999
r3207 n1732 n1855 16
r3208 n1854 n1855 121.59999999999999
r3209 n1733 n1856 1
r3210 n1855 n1856 108.8
r3211 n1734 n1857 16
r3212 n1856 n1857 108.8
r3213 n1735 n1858 2.1333333333333333
r3214 n1857 n1858 54.399999999999999
r3215 n1736 n1859 2.6666666666666665
r3216 n1858 n1859 86.400000000000006
r3217 n1737 n1860 3.5555555555555554
r3218 n1859 n1860 67.200000000000003
r3219 n1738 n1861 16
r3220 n1860 n1861 35.200000000000003
r3221 n1739 n1862 16
r3222 n1861 n1862 12.800000000000001
r3223 n1740 n1863 4
r3224 n1862 n1863 32
r3225 n1741 n1864 1.4545454545454546
r3226 n1863 n1864 96
r3227 n1742 n1865 32
r3228 n1864 n1865 73.599999999999994
r3229 n1743 n1866 32
r3230 n1865 n1866 6.4000000000000004
r3231 n1744 n1867 32
r3232 n1866 n1867 6.4000000000000004
r3233 n1745 n1868 3.2000000000000002
r3234 n1867 n1868 35.200000000000003
r3235 n1746 n1869 2.6666666666666665
r3236 n1868 n1869 70.400000000000006
r3237 n1747 n1870 4
r3238 n1869 n1870 64
r3239 n1748 n1871 16
r3240 n1870 n1871 32
r3241 n1749 n1872 10.666666666666666
r3242 n1871 n1872 16
r3243 n1750 n1873 16
r3244 n1872 n1873 16
r3245 n1751 n1874 5.333333333333333
r3246 n1873 n1874 25.600000000000001
r3247 n1752 n1875 2.6666666666666665
r3248 n1874 n1875 57.600000000000001
r3249 n1753 n1876 2.2857142857142856
r3250 n1875 n1876 83.200000000000003
r3251 n1754 n1877 16
r3252 n1876 n1877 51.200000000000003
r3253 n1755 n1878 0.88888888888888884
r3254 n1877 n1878 121.59999999999999
r3255 n1756 n1879 16
r3256 n1878 n1879 121.59999999999999
r3257 n1757 n1880 1
r3258 n1879 n1880 108.8
r3259 n1758 n1881 16
r3260 n1880 n1881 108.8
r3261 n1759 n1882 0.88888888888888884
r3262 n1881 n1882 121.59999999999999
r3263 n1760 n1883 16
r3264 n1882 n1883 121.59999999999999
r3265 n1761 n1884 1
r3266 n1883 n1884 108.8
r3267 n1762 n1885 16
r3268 n1884 n1885 108.8
r3269 n1763 n1886 0.88888888888888884
r3270 n1885 n1886 121.59999999999999
r3271 n1764 n1887 16
r3272 n1886 n1887 121.59999999999999
r3273 n1765 n1888 1
r3274 n1887 n1888 108.8
r3275 n1766 n1889 16
r3276 n1888 n1889 108.8
r3277 n1767 n1890 0.88888888888888884
r3278 n1889 n1890 121.59999999999999
r3279 n1768 n1891 16
r3280 n1890 n1891 121.59999999999999
r3281 n1769 n1892 1
r3282 n1891 n1892 108.8
r3283 n1770 n1893 16
r3284 n1892 n1893 108.8
r3285 n1771 n1894 0.88888888888888884
r3286 n1893 n1894 121.59999999999999
r3287 n1772 n1895 16
r3288 n1894 n1895 121.59999999999999
r3289 n1773 n1896 1
r3290 n1895 n1896 108.8
r3291 n1774 n1897 16
r3292 n1896 n1897 108.8
r3293 n1775 n1898 0.88888888888888884
r3294 n1897 n1898 121.59999999999999
r3295 n1776 n1899 16
r3296 n1898 n1899 121.59999999999999
r3297 n1777 n1900 1
r3298 n1899 n1900 108.8
r3299 n1778 n1901 16
r3300 n1900 n1901 108.8
r3301 n1779 n1902 0.88888888888888884
r3302 n1901 n1902 121.59999999999999
r3303 n1780 n1903 16
r3304 n1902 n1903 121.59999999999999
r3305 n1781 n1904 1
r3306 n1903 n1904 108.8
r3307 n1782 n1905 16
r3308 n1904 n1905 108.8
r3309 n1783 n1906 2.6666666666666665
r3310 n1905 n1906 44.799999999999997
r3311 n1784 n1907 8
r3312 n1906 n1907 51.200000000000003
r3313 n1785 n1908 16
r3314 n1786 n1909 2.9090909090909092
r3315 n1908 n1909 41.600000000000001
r3316 n1787 n1910 1.6842105263157894
r3317 n1909 n1910 96
r3318 n1788 n1911 16
r3319 n1910 n1911 67.200000000000003
r3320 n1789 n1912 0.94117647058823528
r3321 n1790 n1913 1.5058823529411764
r3322 n1819 n1914 25.600000000000001
r3323 n1820 n1915 6.4000000000000004
r3324 n1914 n1915 10.666666666666666
r3325 n1821 n1916 2.3272727272727272
r3326 n1915 n1916 32
r3327 n1822 n1917 25.600000000000001
r3328 n1916 n1917 25.600000000000001
r3329 n1823 n1918 1.5058823529411764
r3330 n1824 n1919 1.5058823529411764
r3331 n1908 n1920 25.600000000000001
r3332 n1909 n1921 4.6545454545454543
r3333 n1920 n1921 13.866666666666667
r3334 n1910 n1922 2.6947368421052631
r3335 n1921 n1922 32
r3336 n1911 n1923 25.600000000000001
r3337 n1922 n1923 22.399999999999999
r3338 n1912 n1924 1.5058823529411764
r3339 n1913 n1925 1.5058823529411764
r3340 n1914 n1926 25.600000000000001
r3341 n1915 n1927 6.4000000000000004
r3342 n1926 n1927 32
r3343 n1916 n1928 2.3272727272727272
r3344 n1927 n1928 96
r3345 n1917 n1929 25.600000000000001
r3346 n1928 n1929 76.799999999999997
r3347 n1918 n1930 1.5058823529411764
r3348 n1919 n1931 1.5058823529411764
r3349 n1920 n1932 25.600000000000001
r3350 n1921 n1933 4.6545454545454543
r3351 n1932 n1933 41.600000000000001
r3352 n1922 n1934 2.6947368421052631
r3353 n1933 n1934 96
r3354 n1923 n1935 25.600000000000001
r3355 n1934 n1935 67.200000000000003
r3356 n1924 n1936 1.5058823529411764
r3357 n1925 n1937 0.94117647058823528
r3358 n1926 n1938 16
r3359 n1927 n1939 4
r3360 n1938 n1939 21.333333333333332
r3361 n1928 n1940 1.4545454545454546
r3362 n1939 n1940 64
r3363 n1929 n1941 16
r3364 n1940 n1941 51.200000000000003
r3365 n1930 n1942 0.94117647058823528
r3366 n1931 n1943 0.94117647058823528
r3367 n1932 n1944 16
r3368 n1933 n1945 2.9090909090909092
r3369 n1944 n1945 27.733333333333334
r3370 n1934 n1946 1.6842105263157894
r3371 n1945 n1946 64
r3372 n1935 n1947 16
r3373 n1946 n1947 44.799999999999997
r3374 n1936 n1948 0.94117647058823528
r3375 n1937 n1949 0.94117647058823528
r3376 n1938 n1950 16
r3377 n1939 n1951 4
r3378 n1950 n1951 32
r3379 n1940 n1952 1.4545454545454546
r3380 n1951 n1952 96
r3381 n1941 n1953 16
r3382 n1952 n1953 76.799999999999997
r3383 n1942 n1954 0.94117647058823528
r3384 n1943 n1955 0.94117647058823528
r3385 n1944 n1956 16
r3386 n1945 n1957 2.9090909090909092
r3387 n1956 n1957 41.600000000000001
r3388 n1946 n1958 1.6842105263157894
r3389 n1957 n1958 96
r3390 n1947 n1959 16
r3391 n1958 n1959 67.200000000000003
r3392 n1948 n1960 0.94117647058823528
r3393 n1949 n1961 6.0235294117647058
r3394 n1950 n1962 102.40000000000001
r3395 n1951 n1963 25.600000000000001
r3396 n1962 n1963 2.1333333333333333
r3397 n1952 n1964 9.3090909090909086
r3398 n1963 n1964 6.4000000000000004
r3399 n1953 n1965 102.40000000000001
r3400 n1964 n1965 5.1200000000000001
r3401 n1954 n1966 6.0235294117647058
r3402 n1955 n1967 6.0235294117647058
r3403 n1956 n1968 102.40000000000001
r3404 n1957 n1969 18.618181818181817
r3405 n1968 n1969 2.7733333333333334
r3406 n1958 n1970 10.778947368421052
r3407 n1969 n1970 6.4000000000000004
r3408 n1959 n1971 102.40000000000001
r3409 n1970 n1971 4.4800000000000004
r3410 n1960 n1972 6.0235294117647058
r3411 n1961 n1973 6.0235294117647058
r3412 n1962 n1974 102.40000000000001
r3413 n1963 n1975 25.600000000000001
r3414 n1974 n1975 32
r3415 n1964 n1976 9.3090909090909086
r3416 n1975 n1976 96
r3417 n1965 n1977 102.40000000000001
r3418 n1976 n1977 76.799999999999997
r3419 n1966 n1978 6.0235294117647058
r3420 n1967 n1979 6.0235294117647058
r3421 n1968 n1980 102.40000000000001
r3422 n1969 n1981 18.618181818181817
r3423 n1980 n1981 41.600000000000001
r3424 n1970 n1982 10.778947368421052
r3425 n1981 n1982 96
r3426 n1971 n1983 102.40000000000001
r3427 n1982 n1983 67.200000000000003
r3428 n1972 n1984 6.0235294117647058
r3429 n1973 n1985 0.94117647058823528
r3430 n1974 n1986 16
r3431 n1975 n1987 4
r3432 n1986 n1987 21.333333333333332
r3433 n1976 n1988 1.4545454545454546
r3434 n1987 n1988 64
r3435 n1977 n1989 16
r3436 n1988 n1989 51.200000000000003
r3437 n1978 n1990 0.94117647058823528
r3438 n1979 n1991 0.94117647058823528
r3439 n1980 n1992 16
r3440 n1981 n1993 2.9090909090909092
r3441 n1992 n1993 27.733333333333334
r3442 n1982 n1994 1.6842105263157894
r3443 n1993 n1994 64
r3444 n1983 n1995 16
r3445 n1994 n1995 44.799999999999997
r3446 n1984 n1996 0.94117647058823528
r3447 n1985 n1997 0.94117647058823528
r3448 n1986 n1998 16
r3449 n1987 n1999 4
r3450 n1998 n1999 32
r3451 n1988 n2000 1.4545454545454546
r3452 n1999 n2000 96
r3453 n1989 n2001 16
r3454 n2000 n2001 76.799999999999997
r3455 n1990 n2002 0.94117647058823528
r3456 n1991 n2003 0.94117647058823528
r3457 n1992 n2004 16
r3458 n1993 n2005 2.9090909090909092
r3459 n2004 n2005 41.600000000000001
r3460 n1994 n2006 1.6842105263157894
r3461 n2005 n2006 96
r3462 n1995 n2007 16
r3463 n2006 n2007 67.200000000000003
r3464 n1996 n2008 0.94117647058823528
r3465 n1997 n2009 1.5058823529411764
r3466 n1998 n2010 25.600000000000001
r3467 n1999 n2011 6.4000000000000004
r3468 n2010 n2011 10.666666666666666
r3469 n2000 n2012 2.3272727272727272
r3470 n2011 n2012 32
r3471 n2001 n2013 25.600000000000001
r3472 n2012 n2013 25.600000000000001
r3473 n2002 n2014 1.5058823529411764
r3474 n2003 n2015 1.5058823529411764
r3475 n2004 n2016 25.600000000000001
r3476 n2005 n2017 4.6545454545454543
r3477 n2016 n2017 13.866666666666667
r3478 n2006 n2018 2.6947368421052631
r3479 n2017 n2018 32
r3480 n2007 n2019 25.600000000000001
r3481 n2018 n2019 22.399999999999999
r3482 n2008 n2020 1.5058823529411764
r3483 n2009 n2021 1.5058823529411764
r3484 n2022 n2023 44.799999999999997
r3485 n2023 n2024 38.399999999999999
r3486 n2024 n2025 108.8
r3487 n2025 n2026 108.8
r3488 n2026 n2027 121.59999999999999
r3489 n2027 n2028 121.59999999999999
r3490 n2028 n2029 48
r3491 n2029 n2030 80
r3492 n2030 n2031 60.799999999999997
r3493 n2031 n2032 28.800000000000001
r3494 n2032 n2033 19.199999999999999
r3495 n2033 n2034 41.600000000000001
r3496 n2034 n2035 96
r3497 n2035 n2036 73.599999999999994
r3498 n2036 n2037 12.800000000000001
r3499 n2037 n2038 35.200000000000003
r3500 n2038 n2039 67.200000000000003
r3501 n2039 n2040 67.200000000000003
r3502 n2040 n2041 35.200000000000003
r3503 n2041 n2042 12.800000000000001
r3504 n2042 n2043 73.599999999999994
r3505 n2043 n2044 115.2
r3506 n2044 n2045 54.399999999999999
r3507 n2045 n2046 108.8
r3508 n2046 n2047 108.8
r3509 n2047 n2048 44.799999999999997
r3510 n2048 n2049 51.200000000000003
r3511 n2010 n2050 25.600000000000001
r3512 n2011 n2051 6.4000000000000004
r3513 n2050 n2051 32
r3514 n2012 n2052 2.3272727272727272
r3515 n2051 n2052 96
r3516 n2013 n2053 25.600000000000001
r3517 n2052 n2053 76.799999999999997
r3518 n2014 n2054 1.5058823529411764
r3519 n2015 n2055 1.5058823529411764
r3520 n2056 n2057 44.799999999999997
r3521 n2057 n2058 38.399999999999999
r3522 n2058 n2059 108.8
r3523 n2059 n2060 108.8
r3524 n2060 n2061 121.59999999999999
r3525 n2061 n2062 121.59999999999999
r3526 n2062 n2063 108.8
r3527 n2063 n2064 108.8
r3528 n2064 n2065 121.59999999999999
r3529 n2065 n2066 121.59999999999999
r3530 n2066 n2067 108.8
r3531 n2067 n2068 108.8
r3532 n2068 n2069 121.59999999999999
r3533 n2069 n2070 121.59999999999999
r3534 n2070 n2071 108.8
r3535 n2071 n2072 108.8
r3536 n2072 n2073 121.59999999999999
r3537 n2073 n2074 121.59999999999999
r3538 n2074 n2075 108.8
r3539 n2075 n2076 108.8
r3540 n2076 n2077 121.59999999999999
r3541 n2077 n2078 121.59999999999999
r3542 n2078 n2079 108.8
r3543 n2079 n2080 108.8
r3544 n2080 n2081 121.59999999999999
r3545 n2081 n2082 121.59999999999999
r3546 n2082 n2083 108.8
r3547 n2083 n2084 108.8
r3548 n2084 n2085 121.59999999999999
r3549 n2085 n2086 121.59999999999999
r3550 n2086 n2087 108.8
r3551 n2087 n2088 108.8
r3552 n2088 n2089 54.399999999999999
r3553 n2089 n2090 86.400000000000006
r3554 n2090 n2091 67.200000000000003
r3555 n2091 n2092 35.200000000000003
r3556 n2092 n2093 12.800000000000001
r3557 n2093 n2094 32
r3558 n2094 n2095 96
r3559 n2095 n2096 73.599999999999994
r3560 n2096 n2097 6.4000000000000004
r3561 n2097 n2098 6.4000000000000004
r3562 n2098 n2099 35.200000000000003
r3563 n2099 n2100 70.400000000000006
r3564 n2100 n2101 64
r3565 n2101 n2102 32
r3566 n2102 n2103 16
r3567 n2103 n2104 16
r3568 n2104 n2105 25.600000000000001
r3569 n2105 n2106 57.600000000000001
r3570 n2106 n2107 83.200000000000003
r3571 n2107 n2108 51.200000000000003
r3572 n2108 n2109 121.59999999999999
r3573 n2109 n2110 121.59999999999999
r3574 n2110 n2111 108.8
r3575 n2111 n2112 108.8
r3576 n2112 n2113 121.59999999999999
r3577 n2113 n2114 121.59999999999999
r3578 n2114 n2115 108.8
r3579 n2115 n2116 108.8
r3580 n2116 n2117 121.59999999999999
r3581 n2117 n2118 121.59999999999999
r3582 n2118 n2119 108.8
r3583 n2119 n2120 108.8
r3584 n2120 n2121 121.59999999999999
r3585 n2121 n2122 121.59999999999999
r3586 n2122 n2123 108.8
r3587 n2123 n2124 108.8
r3588 n2124 n2125 121.59999999999999
r3589 n2125 n2126 121.59999999999999
r3590 n2126 n2127 108.8
r3591 n2127 n2128 108.8
r3592 n2128 n2129 121.59999999999999
r3593 n2129 n2130 121.59999999999999
r3594 n2130 n2131 108.8
r3595 n2131 n2132 108.8
r3596 n2132 n2133 121.59999999999999
r3597 n2133 n2134 121.59999999999999
r3598 n2134 n2135 108.8
r3599 n2135 n2136 108.8
r3600 n2136 n2137 44.799999999999997
r3601 n2137 n2138 51.200000000000003
r3602 n2016 n2139 25.600000000000001
r3603 n2017 n2140 4.6545454545454543
r3604 n2139 n2140 41.600000000000001
r3605 n2018 n2141 2.6947368421052631
r3606 n2140 n2141 96
r3607 n2019 n2142 25.600000000000001
r3608 n2141 n2142 67.200000000000003
r3609 n2020 n2143 1.5058823529411764
r3610 n2021 n2144 0.94117647058823528
r3611 n2022 n2145 8
r3612 n2023 n2146 3.2000000000000002
r3613 n2145 n2146 29.866666666666667
r3614 n2024 n2147 16
r3615 n2146 n2147 25.600000000000001
r3616 n2025 n2148 1
r3617 n2147 n2148 72.533333333333331
r3618 n2026 n2149 16
r3619 n2148 n2149 72.533333333333331
r3620 n2027 n2150 0.88888888888888884
r3621 n2149 n2150 81.066666666666663
r3622 n2028 n2151 16
r3623 n2150 n2151 81.066666666666663
r3624 n2029 n2152 2.4615384615384617
r3625 n2151 n2152 32
r3626 n2030 n2153 2.6666666666666665
r3627 n2152 n2153 53.333333333333336
r3628 n2031 n2154 4.5714285714285712
r3629 n2153 n2154 40.533333333333331
r3630 n2032 n2155 16
r3631 n2154 n2155 19.199999999999999
r3632 n2033 n2156 8
r3633 n2155 n2156 12.800000000000001
r3634 n2034 n2157 3.5555555555555554
r3635 n2156 n2157 27.733333333333334
r3636 n2035 n2158 1.5238095238095237
r3637 n2157 n2158 64
r3638 n2036 n2159 16
r3639 n2158 n2159 49.06666666666667
r3640 n2037 n2160 16
r3641 n2159 n2160 8.5333333333333332
r3642 n2038 n2161 3.5555555555555554
r3643 n2160 n2161 23.466666666666665
r3644 n2039 n2162 2.6666666666666665
r3645 n2161 n2162 44.799999999999997
r3646 n2040 n2163 3.5555555555555554
r3647 n2162 n2163 44.799999999999997
r3648 n2041 n2164 16
r3649 n2163 n2164 23.466666666666665
r3650 n2042 n2165 16
r3651 n2164 n2165 8.5333333333333332
r3652 n2043 n2166 1.5238095238095237
r3653 n2165 n2166 49.06666666666667
r3654 n2044 n2167 2.1333333333333333
r3655 n2166 n2167 76.799999999999997
r3656 n2045 n2168 16
r3657 n2167 n2168 36.266666666666666
r3658 n2046 n2169 1
r3659 n2168 n2169 72.533333333333331
r3660 n2047 n2170 16
r3661 n2169 n2170 72.533333333333331
r3662 n2048 n2171 2.6666666666666665
r3663 n2170 n2171 29.866666666666667
r3664 n2049 n2172 8
r3665 n2171 n2172 34.133333333333333
r3666 n2050 n2173 16
r3667 n2051 n2174 4
r3668 n2173 n2174 21.333333333333332
r3669 n2052 n2175 1.4545454545454546
r3670 n2174 n2175 64
r3671 n2053 n2176 16
r3672 n2175 n2176 51.200000000000003
r3673 n2054 n2177 0.94117647058823528
r3674 n2055 n2178 0.94117647058823528
r3675 n2056 n2179 8
r3676 n2057 n2180 3.2000000000000002
r3677 n2179 n2180 29.866666666666667
r3678 n2058 n2181 16
r3679 n2180 n2181 25.600000000000001
r3680 n2059 n2182 1
r3681 n2181 n2182 72.533333333333331
r3682 n2060 n2183 16
r3683 n2182 n2183 72.533333333333331
r3684 n2061 n2184 0.88888888888888884
r3685 n2183 n2184 81.066666666666663
r3686 n2062 n2185 16
r3687 n2184 n2185 81.066666666666663
r3688 n2063 n2186 1
r3689 n2185 n2186 72.533333333333331
r3690 n2064 n2187 16
r3691 n2186 n2187 72.533333333333331
r3692 n2065 n2188 0.88888888888888884
r3693 n2187 n2188 81.066666666666663
r3694 n2066 n2189 16
r3695 n2188 n2189 81.066666666666663
r3696 n2067 n2190 1
r3697 n2189 n2190 72.533333333333331
r3698 n2068 n2191 16
r3699 n2190 n2191 72.533333333333331
r3700 n2069 n2192 0.88888888888888884
r3701 n2191 n2192 81.066666666666663
r3702 n2070 n2193 16
r3703 n2192 n2193 81.066666666666663
r3704 n2071 n2194 1
r3705 n2193 n2194 72.533333333333331
r3706 n2072 n2195 16
r3707 n2194 n2195 72.533333333333331
r3708 n2073 n2196 0.88888888888888884
r3709 n2195 n2196 81.066666666666663
r3710 n2074 n2197 16
r3711 n2196 n2197 81.066666666666663
r3712 n2075 n2198 1
r3713 n2197 n2198 72.533333333333331
r3714 n2076 n2199 16
r3715 n2198 n2199 72.533333333333331
r3716 n2077 n2200 0.88888888888888884
r3717 n2199 n2200 81.066666666666663
r3718 n2078 n2201 16
r3719 n2200 n2201 81.066666666666663
r3720 n2079 n2202 1
r3721 n2201 n2202 72.533333333333331
r3722 n2080 n2203 16
r3723 n2202 n2203 72.533333333333331
r3724 n2081 n2204 0.88888888888888884
r3725 n2203 n2204 81.066666666666663
r3726 n2082 n2205 16
r3727 n2204 n2205 81.066666666666663
r3728 n2083 n2206 1
r3729 n2205 n2206 72.533333333333331
r3730 n2084 n2207 16
r3731 n2206 n2207 72.533333333333331
r3732 n2085 n2208 0.88888888888888884
r3733 n2207 n2208 81.066666666666663
r3734 n2086 n2209 16
r3735 n2208 n2209 81.066666666666663
r3736 n2087 n2210 1
r3737 n2209 n2210 72.533333333333331
r3738 n2088 n2211 16
r3739 n2210 n2211 72.533333333333331
r3740 n2089 n2212 2.1333333333333333
r3741 n2211 n2212 36.266666666666666
r3742 n2090 n2213 2.6666666666666665
r3743 n2212 n2213 57.600000000000001
r3744 n2091 n2214 3.5555555555555554
r3745 n2213 n2214 44.799999999999997
r3746 n2092 n2215 16
r3747 n2214 n2215 23.466666666666665
r3748 n2093 n2216 16
r3749 n2215 n2216 8.5333333333333332
r3750 n2094 n2217 4
r3751 n2216 n2217 21.333333333333332
r3752 n2095 n2218 1.4545454545454546
r3753 n2217 n2218 64
r3754 n2096 n2219 32
r3755 n2218 n2219 49.06666666666667
r3756 n2097 n2220 32
r3757 n2219 n2220 4.2666666666666666
r3758 n2098 n2221 32
r3759 n2220 n2221 4.2666666666666666
r3760 n2099 n2222 3.2000000000000002
r3761 n2221 n2222 23.466666666666665
r3762 n2100 n2223 2.6666666666666665
r3763 n2222 n2223 46.93333333333333
r3764 n2101 n2224 4
r3765 n2223 n2224 42.666666666666664
r3766 n2102 n2225 16
r3767 n2224 n2225 21.333333333333332
r3768 n2103 n2226 10.666666666666666
r3769 n2225 n2226 10.666666666666666
r3770 n2104 n2227 16
r3771 n2226 n2227 10.666666666666666
r3772 n2105 n2228 5.333333333333333
r3773 n2227 n2228 17.066666666666666
r3774 n2106 n2229 2.6666666666666665
r3775 n2228 n2229 38.399999999999999
r3776 n2107 n2230 2.2857142857142856
r3777 n2229 n2230 55.466666666666669
r3778 n2108 n2231 16
r3779 n2230 n2231 34.133333333333333
r3780 n2109 n2232 0.88888888888888884
r3781 n2231 n2232 81.066666666666663
r3782 n2110 n2233 16
r3783 n2232 n2233 81.066666666666663
r3784 n2111 n2234 1
r3785 n2233 n2234 72.533333333333331
r3786 n2112 n2235 16
r3787 n2234 n2235 72.533333333333331
r3788 n2113 n2236 0.88888888888888884
r3789 n2235 n2236 81.066666666666663
r3790 n2114 n2237 16
r3791 n2236 n2237 81.066666666666663
r3792 n2115 n2238 1
r3793 n2237 n2238 72.533333333333331
r3794 n2116 n2239 16
r3795 n2238 n2239 72.533333333333331
r3796 n2117 n2240 0.88888888888888884
r3797 n2239 n2240 81.066666666666663
r3798 n2118 n2241 16
r3799 n2240 n2241 81.066666666666663
r3800 n2119 n2242 1
r3801 n2241 n2242 72.533333333333331
r3802 n2120 n2243 16
r3803 n2242 n2243 72.533333333333331
r3804 n2121 n2244 0.88888888888888884
r3805 n2243 n2244 81.066666666666663
r3806 n2122 n2245 16
r3807 n2244 n2245 81.066666666666663
r3808 n2123 n2246 1
r3809 n2245 n2246 72.533333333333331
r3810 n2124 n2247 16
r3811 n2246 n2247 72.533333333333331
r3812 n2125 n2248 0.88888888888888884
r3813 n2247 n2248 81.066666666666663
r3814 n2126 n2249 16
r3815 n2248 n2249 81.066666666666663
r3816 n2127 n2250 1
r3817 n2249 n2250 72.533333333333331
r3818 n2128 n2251 16
r3819 n2250 n2251 72.533333333333331
r3820 n2129 n2252 0.88888888888888884
r3821 n2251 n2252 81.066666666666663
r3822 n2130 n2253 16
r3823 n2252 n2253 81.066666666666663
r3824 n2131 n2254 1
r3825 n2253 n2254 72.533333333333331
r3826 n2132 n2255 16
r3827 n2254 n2255 72.533333333333331
r3828 n2133 n2256 0.88888888888888884
r3829 n2255 n2256 81.066666666666663
r3830 n2134 n2257 16
r3831 n2256 n2257 81.066666666666663
r3832 n2135 n2258 1
r3833 n2257 n2258 72.533333333333331
r3834 n2136 n2259 16
r3835 n2258 n2259 72.533333333333331
r3836 n2137 n2260 2.6666666666666665
r3837 n2259 n2260 29.866666666666667
r3838 n2138 n2261 8
r3839 n2260 n2261 34.133333333333333
r3840 n2139 n2262 16
r3841 n2140 n2263 2.9090909090909092
r3842 n2262 n2263 27.733333333333334
r3843 n2141 n2264 1.6842105263157894
r3844 n2263 n2264 64
r3845 n2142 n2265 16
r3846 n2264 n2265 44.799999999999997
r3847 n2143 n2266 0.94117647058823528
r3848 n2144 n2267 1.3176470588235294
r3849 n2145 n2268 11.199999999999999
r3850 n2146 n2269 4.4800000000000004
r3851 n2268 n2269 22.399999999999999
r3852 n2147 n2270 22.399999999999999
r3853 n2269 n2270 19.199999999999999
r3854 n2148 n2271 1.3999999999999999
r3855 n2270 n2271 54.399999999999999
r3856 n2149 n2272 22.399999999999999
r3857 n2271 n2272 54.399999999999999
r3858 n2150 n2273 1.2444444444444445
r3859 n2272 n2273 60.799999999999997
r3860 n2151 n2274 22.399999999999999
r3861 n2273 n2274 60.799999999999997
r3862 n2152 n2275 3.4461538461538463
r3863 n2274 n2275 24
r3864 n2153 n2276 3.7333333333333334
r3865 n2275 n2276 40
r3866 n2154 n2277 6.4000000000000004
r3867 n2276 n2277 30.399999999999999
r3868 n2155 n2278 22.399999999999999
r3869 n2277 n2278 14.4
r3870 n2156 n2279 11.199999999999999
r3871 n2278 n2279 9.5999999999999996
r3872 n2157 n2280 4.9777777777777779
r3873 n2279 n2280 20.800000000000001
r3874 n2158 n2281 2.1333333333333333
r3875 n2280 n2281 48
r3876 n2159 n2282 22.399999999999999
r3877 n2281 n2282 36.799999999999997
r3878 n2160 n2283 22.399999999999999
r3879 n2282 n2283 6.4000000000000004
r3880 n2161 n2284 4.9777777777777779
r3881 n2283 n2284 17.600000000000001
r3882 n2162 n2285 3.7333333333333334
r3883 n2284 n2285 33.600000000000001
r3884 n2163 n2286 4.9777777777777779
r3885 n2285 n2286 33.600000000000001
r3886 n2164 n2287 22.399999999999999
r3887 n2286 n2287 17.600000000000001
r3888 n2165 n2288 22.399999999999999
r3889 n2287 n2288 6.4000000000000004
r3890 n2166 n2289 2.1333333333333333
r3891 n2288 n2289 36.799999999999997
r3892 n2167 n2290 2.9866666666666668
r3893 n2289 n2290 57.600000000000001
r3894 n2168 n2291 22.399999999999999
r3895 n2290 n2291 27.199999999999999
r3896 n2169 n2292 1.3999999999999999
r3897 n2291 n2292 54.399999999999999
r3898 n2170 n2293 22.399999999999999
r3899 n2292 n2293 54.399999999999999
r3900 n2171 n2294 3.7333333333333334
r3901 n2293 n2294 22.399999999999999
r3902 n2172 n2295 11.199999999999999
r3903 n2294 n2295 25.600000000000001
r3904 n2177 n2296 1.3176470588235294
r3905 n2178 n2297 1.3176470588235294
r3906 n2179 n2298 11.199999999999999
r3907 n2180 n2299 4.4800000000000004
r3908 n2298 n2299 22.399999999999999
r3909 n2181 n2300 22.399999999999999
r3910 n2299 n2300 19.199999999999999
r3911 n2182 n2301 1.3999999999999999
r3912 n2300 n2301 54.399999999999999
r3913 n2183 n2302 22.399999999999999
r3914 n2301 n2302 54.399999999999999
r3915 n2184 n2303 1.2444444444444445
r3916 n2302 n2303 60.799999999999997
r3917 n2185 n2304 22.399999999999999
r3918 n2303 n2304 60.799999999999997
r3919 n2186 n2305 1.3999999999999999
r3920 n2304 n2305 54.399999999999999
r3921 n2187 n2306 22.399999999999999
r3922 n2305 n2306 54.399999999999999
r3923 n2188 n2307 1.2444444444444445
r3924 n2306 n2307 60.799999999999997
r3925 n2189 n2308 22.399999999999999
r3926 n2307 n2308 60.799999999999997
r3927 n2190 n2309 1.3999999999999999
r3928 n2308 n2309 54.399999999999999
r3929 n2191 n2310 22.399999999999999
r3930 n2309 n2310 54.399999999999999
r3931 n2192 n2311 1.2444444444444445
r3932 n2310 n2311 60.799999999999997
r3933 n2193 n2312 22.399999999999999
r3934 n2311 n2312 60.799999999999997
r3935 n2194 n2313 1.3999999999999999
r3936 n2312 n2313 54.399999999999999
r3937 n2195 n2314 22.399999999999999
r3938 n2313 n2314 54.399999999999999
r3939 n2196 n2315 1.2444444444444445
r3940 n2314 n2315 60.799999999999997
r3941 n2197 n2316 22.399999999999999
r3942 n2315 n2316 60.799999999999997
r3943 n2198 n2317 1.3999999999999999
r3944 n2316 n2317 54.399999999999999
r3945 n2199 n2318 22.399999999999999
r3946 n2317 n2318 54.399999999999999
r3947 n2200 n2319 1.2444444444444445
r3948 n2318 n2319 60.799999999999997
r3949 n2201 n2320 22.399999999999999
r3950 n2319 n2320 60.799999999999997
r3951 n2202 n2321 1.3999999999999999
r3952 n2320 n2321 54.399999999999999
r3953 n2203 n2322 22.399999999999999
r3954 n2321 n2322 54.399999999999999
r3955 n2204 n2323 1.2444444444444445
r3956 n2322 n2323 60.799999999999997
r3957 n2205 n2324 22.399999999999999
r3958 n2323 n2324 60.799999999999997
r3959 n2206 n2325 1.3999999999999999
r3960 n2324 n2325 54.399999999999999
r3961 n2207 n2326 22.399999999999999
r3962 n2325 n2326 54.399999999999999
r3963 n2208 n2327 1.2444444444444445
r3964 n2326 n2327 60.799999999999997
r3965 n2209 n2328 22.399999999999999
r3966 n2327 n2328 60.799999999999997
r3967 n2210 n2329 1.3999999999999999
r3968 n2328 n2329 54.399999999999999
r3969 n2211 n2330 22.399999999999999
r3970 n2329 n2330 54.399999999999999
r3971 n2212 n2331 2.9866666666666668
r3972 n2330 n2331 27.199999999999999
r3973 n2213 n2332 3.7333333333333334
r3974 n2331 n2332 43.200000000000003
r3975 n2214 n2333 4.9777777777777779
r3976 n2332 n2333 33.600000000000001
r3977 n2215 n2334 22.399999999999999
r3978 n2333 n2334 17.600000000000001
r3979 n2216 n2335 22.399999999999999
r3980 n2334 n2335 6.4000000000000004
r3981 n2217 n2336 5.5999999999999996
r3982 n2335 n2336 16
r3983 n2218 n2337 2.0363636363636362
r3984 n2336 n2337 48
r3985 n2219 n2338 44.799999999999997
r3986 n2337 n2338 36.799999999999997
r3987 n2220 n2339 44.799999999999997
r3988 n2338 n2339 3.2000000000000002
r3989 n2221 n2340 44.799999999999997
r3990 n2339 n2340 3.2000000000000002
r3991 n2222 n2341 4.4800000000000004
r3992 n2340 n2341 17.600000000000001
r3993 n2223 n2342 3.7333333333333334
r3994 n2341 n2342 35.200000000000003
r3995 n2224 n2343 5.5999999999999996
r3996 n2342 n2343 32
r3997 n2225 n2344 22.399999999999999
r3998 n2343 n2344 16
r3999 n2226 n2345 14.933333333333334
r4000 n2344 n2345 8
r4001 n2227 n2346 22.399999999999999
r4002 n2345 n2346 8
r4003 n2228 n2347 7.4666666666666668
r4004 n2346 n2347 12.800000000000001
r4005 n2229 n2348 3.7333333333333334
r4006 n2347 n2348 28.800000000000001
r4007 n2230 n2349 3.2000000000000002
r4008 n2348 n2349 41.600000000000001
r4009 n2231 n2350 22.399999999999999
r4010 n2349 n2350 25.600000000000001
r4011 n2232 n2351 1.2444444444444445
r4012 n2350 n2351 60.799999999999997
r4013 n2233 n2352 22.399999999999999
r4014 n2351 n2352 60.799999999999997
r4015 n2234 n2353 1.3999999999999999
r4016 n2352 n2353 54.399999999999999
r4017 n2235 n2354 22.399999999999999
r4018 n2353 n2354 54.399999999999999
r4019 n2236 n2355 1.2444444444444445
r4020 n2354 n2355 60.799999999999997
r4021 n2237 n2356 22.399999999999999
r4022 n2355 n2356 60.799999999999997
r4023 n2238 n2357 1.3999999999999999
r4024 n2356 n2357 54.399999999999999
r4025 n2239 n2358 22.399999999999999
r4026 n2357 n2358 54.399999999999999
r4027 n2240 n2359 1.2444444444444445
r4028 n2358 n2359 60.799999999999997
r4029 n2241 n2360 22.399999999999999
r4030 n2359 n2360 60.799999999999997
r4031 n2242 n2361 1.3999999999999999
r4032 n2360 n2361 54.399999999999999
r4033 n2243 n2362 22.399999999999999
r4034 n2361 n2362 54.399999999999999
r4035 n2244 n2363 1.2444444444444445
r4036 n2362 n2363 60.799999999999997
r4037 n2245 n2364 22.399999999999999
r4038 n2363 n2364 60.799999999999997
r4039 n2246 n2365 1.3999999999999999
r4040 n2364 n2365 54.399999999999999
r4041 n2247 n2366 22.399999999999999
r4042 n2365 n2366 54.399999999999999
r4043 n2248 n2367 1.2444444444444445
r4044 n2366 n2367 60.799999999999997
r4045 n2249 n2368 22.399999999999999
r4046 n2367 n2368 60.799999999999997
r4047 n2250 n2369 1.3999999999999999
r4048 n2368 n2369 54.399999999999999
r4049 n2251 n2370 22.399999999999999
r4050 n2369 n2370 54.399999999999999
r4051 n2252 n2371 1.2444444444444445
r4052 n2370 n2371 60.799999999999997
r4053 n2253 n2372 22.399999999999999
r4054 n2371 n2372 60.799999999999997
r4055 n2254 n2373 1.3999999999999999
r4056 n2372 n2373 54.399999999999999
r4057 n2255 n2374 22.399999999999999
r4058 n2373 n2374 54.399999999999999
r4059 n2256 n2375 1.2444444444444445
r4060 n2374 n2375 60.799999999999997
r4061 n2257 n2376 22.399999999999999
r4062 n2375 n2376 60.799999999999997
r4063 n2258 n2377 1.3999999999999999
r4064 n2376 n2377 54.399999999999999
r4065 n2259 n2378 22.399999999999999
r4066 n2377 n2378 54.399999999999999
r4067 n2260 n2379 3.7333333333333334
r4068 n2378 n2379 22.399999999999999
r4069 n2261 n2380 11.199999999999999
r4070 n2379 n2380 25.600000000000001
r4071 n2266 n2381 1.3176470588235294
r4072 n2267 n2382 1.3176470588235294
r4073 n2268 n2383 11.199999999999999
r4074 n2269 n2384 4.4800000000000004
r4075 n2383 n2384 29.866666666666667
r4076 n2270 n2385 22.399999999999999
r4077 n2384 n2385 25.600000000000001
r4078 n2271 n2386 1.3999999999999999
r4079 n2385 n2386 72.533333333333331
r4080 n2272 n2387 22.399999999999999
r4081 n2386 n2387 72.533333333333331
r4082 n2273 n2388 1.2444444444444445
r4083 n2387 n2388 81.066666666666663
r4084 n2274 n2389 22.399999999999999
r4085 n2388 n2389 81.066666666666663
r4086 n2275 n2390 3.4461538461538463
r4087 n2389 n2390 32
r4088 n2276 n2391 3.7333333333333334
r4089 n2390 n2391 53.333333333333336
r4090 n2277 n2392 6.4000000000000004
r4091 n2391 n2392 40.533333333333331
r4092 n2278 n2393 22.399999999999999
r4093 n2392 n2393 19.199999999999999
r4094 n2279 n2394 11.199999999999999
r4095 n2393 n2394 12.800000000000001
r4096 n2280 n2395 4.9777777777777779
r4097 n2394 n2395 27.733333333333334
r4098 n2281 n2396 2.1333333333333333
r4099 n2395 n2396 64
r4100 n2282 n2397 22.399999999999999
r4101 n2396 n2397 49.06666666666667
r4102 n2283 n2398 22.399999999999999
r4103 n2397 n2398 8.5333333333333332
r4104 n2284 n2399 4.9777777777777779
r4105 n2398 n2399 23.466666666666665
r4106 n2285 n2400 3.7333333333333334
r4107 n2399 n2400 44.799999999999997
r4108 n2286 n2401 4.9777777777777779
r4109 n2400 n2401 44.799999999999997
r4110 n2287 n2402 22.399999999999999
r4111 n2401 n2402 23.466666666666665
r4112 n2288 n2403 22.399999999999999
r4113 n2402 n2403 8.5333333333333332
r4114 n2289 n2404 2.1333333333333333
r4115 n2403 n2404 49.06666666666667
r4116 n2290 n2405 2.9866666666666668
r4117 n2404 n2405 76.799999999999997
r4118 n2291 n2406 22.399999999999999
r4119 n2405 n2406 36.266666666666666
r4120 n2292 n2407 1.3999999999999999
r4121 n2406 n2407 72.533333333333331
r4122 n2293 n2408 22.399999999999999
r4123 n2407 n2408 72.533333333333331
r4124 n2294 n2409 3.7333333333333334
r4125 n2408 n2409 29.866666666666667
r4126 n2295 n2410 11.199999999999999
r4127 n2409 n2410 34.133333333333333
r4128 n2296 n2411 1.3176470588235294
r4129 n2297 n2412 1.3176470588235294
r4130 n2298 n2413 11.199999999999999
r4131 n2299 n2414 4.4800000000000004
r4132 n2413 n2414 29.866666666666667
r4133 n2300 n2415 22.399999999999999
r4134 n2414 n2415 25.600000000000001
r4135 n2301 n2416 1.3999999999999999
r4136 n2415 n2416 72.533333333333331
r4137 n2302 n2417 22.399999999999999
r4138 n2416 n2417 72.533333333333331
r4139 n2303 n2418 1.2444444444444445
r4140 n2417 n2418 81.066666666666663
r4141 n2304 n2419 22.399999999999999
r4142 n2418 n2419 81.066666666666663
r4143 n2305 n2420 1.3999999999999999
r4144 n2419 n2420 72.533333333333331
r4145 n2306 n2421 22.399999999999999
r4146 n2420 n2421 72.533333333333331
r4147 n2307 n2422 1.2444444444444445
r4148 n2421 n2422 81.066666666666663
r4149 n2308 n2423 22.399999999999999
r4150 n2422 n2423 81.066666666666663
r4151 n2309 n2424 1.3999999999999999
r4152 n2423 n2424 72.533333333333331
r4153 n2310 n2425 22.399999999999999
r4154 n2424 n2425 72.533333333333331
r4155 n2311 n2426 1.2444444444444445
r4156 n2425 n2426 81.066666666666663
r4157 n2312 n2427 22.399999999999999
r4158 n2426 n2427 81.066666666666663
r4159 n2313 n2428 1.3999999999999999
r4160 n2427 n2428 72.533333333333331
r4161 n2314 n2429 22.399999999999999
r4162 n2428 n2429 72.533333333333331
r4163 n2315 n2430 1.2444444444444445
r4164 n2429 n2430 81.066666666666663
r4165 n2316 n2431 22.399999999999999
r4166 n2430 n2431 81.066666666666663
r4167 n2317 n2432 1.3999999999999999
r4168 n2431 n2432 72.533333333333331
r4169 n2318 n2433 22.399999999999999
r4170 n2432 n2433 72.533333333333331
r4171 n2319 n2434 1.2444444444444445
r4172 n2433 n2434 81.066666666666663
r4173 n2320 n2435 22.399999999999999
r4174 n2434 n2435 81.066666666666663
r4175 n2321 n2436 1.3999999999999999
r4176 n2435 n2436 72.533333333333331
r4177 n2322 n2437 22.399999999999999
r4178 n2436 n2437 72.533333333333331
r4179 n2323 n2438 1.2444444444444445
r4180 n2437 n2438 81.066666666666663
r4181 n2324 n2439 22.399999999999999
r4182 n2438 n2439 81.066666666666663
r4183 n2325 n2440 1.3999999999999999
r4184 n2439 n2440 72.533333333333331
r4185 n2326 n2441 22.399999999999999
r4186 n2440 n2441 72.533333333333331
r4187 n2327 n2442 1.2444444444444445
r4188 n2441 n2442 81.066666666666663
r4189 n2328 n2443 22.399999999999999
r4190 n2442 n2443 81.066666666666663
r4191 n2329 n2444 1.3999999999999999
r4192 n2443 n2444 72.533333333333331
r4193 n2330 n2445 22.399999999999999
r4194 n2444 n2445 72.533333333333331
r4195 n2331 n2446 2.9866666666666668
r4196 n2445 n2446 36.266666666666666
r4197 n2332 n2447 3.7333333333333334
r4198 n2446 n2447 57.600000000000001
r4199 n2333 n2448 4.9777777777777779
r4200 n2447 n2448 44.799999999999997
r4201 n2334 n2449 22.399999999999999
r4202 n2448 n2449 23.466666666666665
r4203 n2335 n2450 22.399999999999999
r4204 n2449 n2450 8.5333333333333332
r4205 n2336 n2451 5.5999999999999996
r4206 n2450 n2451 21.333333333333332
r4207 n2337 n2452 2.0363636363636362
r4208 n2451 n2452 64
r4209 n2338 n2453 44.799999999999997
r4210 n2452 n2453 49.06666666666667
r4211 n2339 n2454 44.799999999999997
r4212 n2453 n2454 4.2666666666666666
r4213 n2340 n2455 44.799999999999997
r4214 n2454 n2455 4.2666666666666666
r4215 n2341 n2456 4.4800000000000004
r4216 n2455 n2456 23.466666666666665
r4217 n2342 n2457 3.7333333333333334
r4218 n2456 n2457 46.93333333333333
r4219 n2343 n2458 5.5999999999999996
r4220 n2457 n2458 42.666666666666664
r4221 n2344 n2459 22.399999999999999
r4222 n2458 n2459 21.333333333333332
r4223 n2345 n2460 14.933333333333334
r4224 n2459 n2460 10.666666666666666
r4225 n2346 n2461 22.399999999999999
r4226 n2460 n2461 10.666666666666666
r4227 n2347 n2462 7.4666666666666668
r4228 n2461 n2462 17.066666666666666
r4229 n2348 n2463 3.7333333333333334
r4230 n2462 n2463 38.399999999999999
r4231 n2349 n2464 3.2000000000000002
r4232 n2463 n2464 55.466666666666669
r4233 n2350 n2465 22.399999999999999
r4234 n2464 n2465 34.133333333333333
r4235 n2351 n2466 1.2444444444444445
r4236 n2465 n2466 81.066666666666663
r4237 n2352 n2467 22.399999999999999
r4238 n2466 n2467 81.066666666666663
r4239 n2353 n2468 1.3999999999999999
r4240 n2467 n2468 72.533333333333331
r4241 n2354 n2469 22.399999999999999
r4242 n2468 n2469 72.533333333333331
r4243 n2355 n2470 1.2444444444444445
r4244 n2469 n2470 81.066666666666663
r4245 n2356 n2471 22.399999999999999
r4246 n2470 n2471 81.066666666666663
r4247 n2357 n2472 1.3999999999999999
r4248 n2471 n2472 72.533333333333331
r4249 n2358 n2473 22.399999999999999
r4250 n2472 n2473 72.533333333333331
r4251 n2359 n2474 1.2444444444444445
r4252 n2473 n2474 81.066666666666663
r4253 n2360 n2475 22.399999999999999
r4254 n2474 n2475 81.066666666666663
r4255 n2361 n2476 1.3999999999999999
r4256 n2475 n2476 72.533333333333331
r4257 n2362 n2477 22.399999999999999
r4258 n2476 n2477 72.533333333333331
r4259 n2363 n2478 1.2444444444444445
r4260 n2477 n2478 81.066666666666663
r4261 n2364 n2479 22.399999999999999
r4262 n2478 n2479 81.066666666666663
r4263 n2365 n2480 1.3999999999999999
r4264 n2479 n2480 72.533333333333331
r4265 n2366 n2481 22.399999999999999
r4266 n2480 n2481 72.533333333333331
r4267 n2367 n2482 1.2444444444444445
r4268 n2481 n2482 81.066666666666663
r4269 n2368 n2483 22.399999999999999
r4270 n2482 n2483 81.066666666666663
r4271 n2369 n2484 1.3999999999999999
r4272 n2483 n2484 72.533333333333331
r4273 n2370 n2485 22.399999999999999
r4274 n2484 n2485 72.533333333333331
r4275 n2371 n2486 1.2444444444444445
r4276 n2485 n2486 81.066666666666663
r4277 n2372 n2487 22.399999999999999
r4278 n2486 n2487 81.066666666666663
r4279 n2373 n2488 1.3999999999999999
r4280 n2487 n2488 72.533333333333331
r4281 n2374 n2489 22.399999999999999
r4282 n2488 n2489 72.533333333333331
r4283 n2375 n2490 1.2444444444444445
r4284 n2489 n2490 81.066666666666663
r4285 n2376 n2491 22.399999999999999
r4286 n2490 n2491 81.066666666666663
r4287 n2377 n2492 1.3999999999999999
r4288 n2491 n2492 72.533333333333331
r4289 n2378 n2493 22.399999999999999
r4290 n2492 n2493 72.533333333333331
r4291 n2379 n2494 3.7333333333333334
r4292 n2493 n2494 29.866666666666667
r4293 n2380 n2495 11.199999999999999
r4294 n2494 n2495 34.133333333333333
r4295 n2381 n2496 1.3176470588235294
r4296 n2382 n2497 3.388235294117647
r4297 n2383 n2498 28.800000000000001
r4298 n2384 n2499 11.52
r4299 n2498 n2499 5.9733333333333336
r4300 n2385 n2500 57.600000000000001
r4301 n2499 n2500 5.1200000000000001
r4302 n2386 n2501 3.6000000000000001
r4303 n2500 n2501 14.506666666666666
r4304 n2387 n2502 57.600000000000001
r4305 n2501 n2502 14.506666666666666
r4306 n2388 n2503 3.2000000000000002
r4307 n2502 n2503 16.213333333333335
r4308 n2389 n2504 57.600000000000001
r4309 n2503 n2504 16.213333333333335
r4310 n2390 n2505 8.861538461538462
r4311 n2504 n2505 6.4000000000000004
r4312 n2391 n2506 9.5999999999999996
r4313 n2505 n2506 10.666666666666666
r4314 n2392 n2507 16.457142857142856
r4315 n2506 n2507 8.1066666666666674
r4316 n2393 n2508 57.600000000000001
r4317 n2507 n2508 3.8399999999999999
r4318 n2394 n2509 28.800000000000001
r4319 n2508 n2509 2.5600000000000001
r4320 n2395 n2510 12.800000000000001
r4321 n2509 n2510 5.5466666666666669
r4322 n2396 n2511 5.4857142857142858
r4323 n2510 n2511 12.800000000000001
r4324 n2397 n2512 57.600000000000001
r4325 n2511 n2512 9.8133333333333326
r4326 n2398 n2513 57.600000000000001
r4327 n2512 n2513 1.7066666666666668
r4328 n2399 n2514 12.800000000000001
r4329 n2513 n2514 4.6933333333333334
r4330 n2400 n2515 9.5999999999999996
r4331 n2514 n2515 8.9600000000000009
r4332 n2401 n2516 12.800000000000001
r4333 n2515 n2516 8.9600000000000009
r4334 n2402 n2517 57.600000000000001
r4335 n2516 n2517 4.6933333333333334
r4336 n2403 n2518 57.600000000000001
r4337 n2517 n2518 1.7066666666666668
r4338 n2404 n2519 5.4857142857142858
r4339 n2518 n2519 9.8133333333333326
r4340 n2405 n2520 7.6799999999999997
r4341 n2519 n2520 15.359999999999999
r4342 n2406 n2521 57.600000000000001
r4343 n2520 n2521 7.253333333333333
r4344 n2407 n2522 3.6000000000000001
r4345 n2521 n2522 14.506666666666666
r4346 n2408 n2523 57.600000000000001
r4347 n2522 n2523 14.506666666666666
r4348 n2409 n2524 9.5999999999999996
r4349 n2523 n2524 5.9733333333333336
r4350 n2410 n2525 28.800000000000001
r4351 n2524 n2525 6.8266666666666671
r4352 n2411 n2526 3.388235294117647
r4353 n2412 n2527 3.388235294117647
r4354 n2413 n2528 28.800000000000001
r4355 n2414 n2529 11.52
r4356 n2528 n2529 5.9733333333333336
r4357 n2415 n2530 57.600000000000001
r4358 n2529 n2530 5.1200000000000001
r4359 n2416 n2531 3.6000000000000001
r4360 n2530 n2531 14.506666666666666
r4361 n2417 n2532 57.600000000000001
r4362 n2531 n2532 14.506666666666666
r4363 n2418 n2533 3.2000000000000002
r4364 n2532 n2533 16.213333333333335
r4365 n2419 n2534 57.600000000000001
r4366 n2533 n2534 16.213333333333335
r4367 n2420 n2535 3.6000000000000001
r4368 n2534 n2535 14.506666666666666
r4369 n2421 n2536 57.600000000000001
r4370 n2535 n2536 14.506666666666666
r4371 n2422 n2537 3.2000000000000002
r4372 n2536 n2537 16.213333333333335
r4373 n2423 n2538 57.600000000000001
r4374 n2537 n2538 16.213333333333335
r4375 n2424 n2539 3.6000000000000001
r4376 n2538 n2539 14.506666666666666
r4377 n2425 n2540 57.600000000000001
r4378 n2539 n2540 14.506666666666666
r4379 n2426 n2541 3.2000000000000002
r4380 n2540 n2541 16.213333333333335
r4381 n2427 n2542 57.600000000000001
r4382 n2541 n2542 16.213333333333335
r4383 n2428 n2543 3.6000000000000001
r4384 n2542 n2543 14.506666666666666
r4385 n2429 n2544 57.600000000000001
r4386 n2543 n2544 14.506666666666666
r4387 n2430 n2545 3.2000000000000002
r4388 n2544 n2545 16.213333333333335
r4389 n2431 n2546 57.600000000000001
r4390 n2545 n2546 16.213333333333335
r4391 n2432 n2547 3.6000000000000001
r4392 n2546 n2547 14.506666666666666
r4393 n2433 n2548 57.600000000000001
r4394 n2547 n2548 14.506666666666666
r4395 n2434 n2549 3.2000000000000002
r4396 n2548 n2549 16.213333333333335
r4397 n2435 n2550 57.600000000000001
r4398 n2549 n2550 16.213333333333335
r4399 n2436 n2551 3.6000000000000001
r4400 n2550 n2551 14.506666666666666
r4401 n2437 n2552 57.600000000000001
r4402 n2551 n2552 14.506666666666666
r4403 n2438 n2553 3.2000000000000002
r4404 n2552 n2553 16.213333333333335
r4405 n2439 n2554 57.600000000000001
r4406 n2553 n2554 16.213333333333335
r4407 n2440 n2555 3.6000000000000001
r4408 n2554 n2555 14.506666666666666
r4409 n2441 n2556 57.600000000000001
r4410 n2555 n2556 14.506666666666666
r4411 n2442 n2557 3.2000000000000002
r4412 n2556 n2557 16.213333333333335
r4413 n2443 n2558 57.600000000000001
r4414 n2557 n2558 16.213333333333335
r4415 n2444 n2559 3.6000000000000001
r4416 n2558 n2559 14.506666666666666
r4417 n2445 n2560 57.600000000000001
r4418 n2559 n2560 14.506666666666666
r4419 n2446 n2561 7.6799999999999997
r4420 n2560 n2561 7.253333333333333
r4421 n2447 n2562 9.5999999999999996
r4422 n2561 n2562 11.52
r4423 n2448 n2563 12.800000000000001
r4424 n2562 n2563 8.9600000000000009
r4425 n2449 n2564 57.600000000000001
r4426 n2563 n2564 4.6933333333333334
r4427 n2450 n2565 57.600000000000001
r4428 n2564 n2565 1.7066666666666668
r4429 n2451 n2566 14.4
r4430 n2565 n2566 4.2666666666666666
r4431 n2452 n2567 5.2363636363636363
r4432 n2566 n2567 12.800000000000001
r4433 n2453 n2568 115.2
r4434 n2567 n2568 9.8133333333333326
r4435 n2454 n2569 115.2
r4436 n2568 n2569 0.85333333333333339
r4437 n2455 n2570 115.2
r4438 n2569 n2570 0.85333333333333339
r4439 n2456 n2571 11.52
r4440 n2570 n2571 4.6933333333333334
r4441 n2457 n2572 9.5999999999999996
r4442 n2571 n2572 9.3866666666666667
r4443 n2458 n2573 14.4
r4444 n2572 n2573 8.5333333333333332
r4445 n2459 n2574 57.600000000000001
r4446 n2573 n2574 4.2666666666666666
r4447 n2460 n2575 38.399999999999999
r4448 n2574 n2575 2.1333333333333333
r4449 n2461 n2576 57.600000000000001
r4450 n2575 n2576 2.1333333333333333
r4451 n2462 n2577 19.199999999999999
r4452 n2576 n2577 3.4133333333333336
r4453 n2463 n2578 9.5999999999999996
r4454 n2577 n2578 7.6799999999999997
r4455 n2464 n2579 8.2285714285714278
r4456 n2578 n2579 11.093333333333334
r4457 n2465 n2580 57.600000000000001
r4458 n2579 n2580 6.8266666666666671
r4459 n2466 n2581 3.2000000000000002
r4460 n2580 n2581 16.213333333333335
r4461 n2467 n2582 57.600000000000001
r4462 n2581 n2582 16.213333333333335
r4463 n2468 n2583 3.6000000000000001
r4464 n2582 n2583 14.506666666666666
r4465 n2469 n2584 57.600000000000001
r4466 n2583 n2584 14.506666666666666
r4467 n2470 n2585 3.2000000000000002
r4468 n2584 n2585 16.213333333333335
r4469 n2471 n2586 57.600000000000001
r4470 n2585 n2586 16.213333333333335
r4471 n2472 n2587 3.6000000000000001
r4472 n2586 n2587 14.506666666666666
r4473 n2473 n2588 57.600000000000001
r4474 n2587 n2588 14.506666666666666
r4475 n2474 n2589 3.2000000000000002
r4476 n2588 n2589 16.213333333333335
r4477 n2475 n2590 57.600000000000001
r4478 n2589 n2590 16.213333333333335
r4479 n2476 n2591 3.6000000000000001
r4480 n2590 n2591 14.506666666666666
r4481 n2477 n2592 57.600000000000001
r4482 n2591 n2592 14.506666666666666
r4483 n2478 n2593 3.2000000000000002
r4484 n2592 n2593 16.213333333333335
r4485 n2479 n2594 57.600000000000001
r4486 n2593 n2594 16.213333333333335
r4487 n2480 n2595 3.6000000000000001
r4488 n2594 n2595 14.506666666666666
r4489 n2481 n2596 57.600000000000001
r4490 n2595 n2596 14.506666666666666
r4491 n2482 n2597 3.2000000000000002
r4492 n2596 n2597 16.213333333333335
r4493 n2483 n2598 57.600000000000001
r4494 n2597 n2598 16.213333333333335
r4495 n2484 n2599 3.6000000000000001
r4496 n2598 n2599 14.506666666666666
r4497 n2485 n2600 57.600000000000001
r4498 n2599 n2600 14.506666666666666
r4499 n2486 n2601 3.2000000000000002
r4500 n2600 n2601 16.213333333333335
r4501 n2487 n2602 57.600000000000001
r4502 n2601 n2602 16.213333333333335
r4503 n2488 n2603 3.6000000000000001
r4504 n2602 n2603 14.506666666666666
r4505 n2489 n2604 57.600000000000001
r4506 n2603 n2604 14.506666666666666
r4507 n2490 n2605 3.2000000000000002
r4508 n2604 n2605 16.213333333333335
r4509 n2491 n2606 57.600000000000001
r4510 n2605 n2606 16.213333333333335
r4511 n2492 n2607 3.6000000000000001
r4512 n2606 n2607 14.506666666666666
r4513 n2493 n2608 57.600000000000001
r4514 n2607 n2608 14.506666666666666
r4515 n2494 n2609 9.5999999999999996
r4516 n2608 n2609 5.9733333333333336
r4517 n2495 n2610 28.800000000000001
r4518 n2609 n2610 6.8266666666666671
r4519 n2496 n2611 3.388235294117647
r4520 n2497 n2612 3.7647058823529411
r4521 n2498 n2613 32
r4522 n2499 n2614 12.800000000000001
r4523 n2613 n2614 17.920000000000002
r4524 n2500 n2615 64
r4525 n2614 n2615 15.359999999999999
r4526 n2501 n2616 4
r4527 n2615 n2616 43.520000000000003
r4528 n2502 n2617 64
r4529 n2616 n2617 43.520000000000003
r4530 n2503 n2618 3.5555555555555554
r4531 n2617 n2618 48.640000000000001
r4532 n2504 n2619 64
r4533 n2618 n2619 48.640000000000001
r4534 n2505 n2620 9.8461538461538467
r4535 n2619 n2620 19.199999999999999
r4536 n2506 n2621 10.666666666666666
r4537 n2620 n2621 32
r4538 n2507 n2622 18.285714285714285
r4539 n2621 n2622 24.32
r4540 n2508 n2623 64
r4541 n2622 n2623 11.52
r4542 n2509 n2624 32
r4543 n2623 n2624 7.6799999999999997
r4544 n2510 n2625 14.222222222222221
r4545 n2624 n2625 16.640000000000001
r4546 n2511 n2626 6.0952380952380949
r4547 n2625 n2626 38.399999999999999
r4548 n2512 n2627 64
r4549 n2626 n2627 29.440000000000001
r4550 n2513 n2628 64
r4551 n2627 n2628 5.1200000000000001
r4552 n2514 n2629 14.222222222222221
r4553 n2628 n2629 14.08
r4554 n2515 n2630 10.666666666666666
r4555 n2629 n2630 26.879999999999999
r4556 n2516 n2631 14.222222222222221
r4557 n2630 n2631 26.879999999999999
r4558 n2517 n2632 64
r4559 n2631 n2632 14.08
r4560 n2518 n2633 64
r4561 n2632 n2633 5.1200000000000001
r4562 n2519 n2634 6.0952380952380949
r4563 n2633 n2634 29.440000000000001
r4564 n2520 n2635 8.5333333333333332
r4565 n2634 n2635 46.079999999999998
r4566 n2521 n2636 64
r4567 n2635 n2636 21.760000000000002
r4568 n2522 n2637 4
r4569 n2636 n2637 43.520000000000003
r4570 n2523 n2638 64
r4571 n2637 n2638 43.520000000000003
r4572 n2524 n2639 10.666666666666666
r4573 n2638 n2639 17.920000000000002
r4574 n2525 n2640 32
r4575 n2639 n2640 20.48
r4576 n2526 n2641 3.7647058823529411
r4577 n2527 n2642 3.7647058823529411
r4578 n2528 n2643 32
r4579 n2529 n2644 12.800000000000001
r4580 n2643 n2644 17.920000000000002
r4581 n2530 n2645 64
r4582 n2644 n2645 15.359999999999999
r4583 n2531 n2646 4
r4584 n2645 n2646 43.520000000000003
r4585 n2532 n2647 64
r4586 n2646 n2647 43.520000000000003
r4587 n2533 n2648 3.5555555555555554
r4588 n2647 n2648 48.640000000000001
r4589 n2534 n2649 64
r4590 n2648 n2649 48.640000000000001
r4591 n2535 n2650 4
r4592 n2649 n2650 43.520000000000003
r4593 n2536 n2651 64
r4594 n2650 n2651 43.520000000000003
r4595 n2537 n2652 3.5555555555555554
r4596 n2651 n2652 48.640000000000001
r4597 n2538 n2653 64
r4598 n2652 n2653 48.640000000000001
r4599 n2539 n2654 4
r4600 n2653 n2654 43.520000000000003
r4601 n2540 n2655 64
r4602 n2654 n2655 43.520000000000003
r4603 n2541 n2656 3.5555555555555554
r4604 n2655 n2656 48.640000000000001
r4605 n2542 n2657 64
r4606 n2656 n2657 48.640000000000001
r4607 n2543 n2658 4
r4608 n2657 n2658 43.520000000000003
r4609 n2544 n2659 64
r4610 n2658 n2659 43.520000000000003
r4611 n2545 n2660 3.5555555555555554
r4612 n2659 n2660 48.640000000000001
r4613 n2546 n2661 64
r4614 n2660 n2661 48.640000000000001
r4615 n2547 n2662 4
r4616 n2661 n2662 43.520000000000003
r4617 n2548 n2663 64
r4618 n2662 n2663 43.520000000000003
r4619 n2549 n2664 3.5555555555555554
r4620 n2663 n2664 48.640000000000001
r4621 n2550 n2665 64
r4622 n2664 n2665 48.640000000000001
r4623 n2551 n2666 4
r4624 n2665 n2666 43.520000000000003
r4625 n2552 n2667 64
r4626 n2666 n2667 43.520000000000003
r4627 n2553 n2668 3.5555555555555554
r4628 n2667 n2668 48.640000000000001
r4629 n2554 n2669 64
r4630 n2668 n2669 48.640000000000001
r4631 n2555 n2670 4
r4632 n2669 n2670 43.520000000000003
r4633 n2556 n2671 64
r4634 n2670 n2671 43.520000000000003
r4635 n2557 n2672 3.5555555555555554
r4636 n2671 n2672 48.640000000000001
r4637 n2558 n2673 64
r4638 n2672 n2673 48.640000000000001
r4639 n2559 n2674 4
r4640 n2673 n2674 43.520000000000003
r4641 n2560 n2675 64
r4642 n2674 n2675 43.520000000000003
r4643 n2561 n2676 8.5333333333333332
r4644 n2675 n2676 21.760000000000002
r4645 n2562 n2677 10.666666666666666
r4646 n2676 n2677 34.560000000000002
r4647 n2563 n2678 14.222222222222221
r4648 n2677 n2678 26.879999999999999
r4649 n2564 n2679 64
r4650 n2678 n2679 14.08
r4651 n2565 n2680 64
r4652 n2679 n2680 5.1200000000000001
r4653 n2566 n2681 16
r4654 n2680 n2681 12.800000000000001
r4655 n2567 n2682 5.8181818181818183
r4656 n2681 n2682 38.399999999999999
r4657 n2568 n2683 128
r4658 n2682 n2683 29.440000000000001
r4659 n2569 n2684 128
r4660 n2683 n2684 2.5600000000000001
r4661 n2570 n2685 128
r4662 n2684 n2685 2.5600000000000001
r4663 n2571 n2686 12.800000000000001
r4664 n2685 n2686 14.08
r4665 n2572 n2687 10.666666666666666
r4666 n2686 n2687 28.16
r4667 n2573 n2688 16
r4668 n2687 n2688 25.600000000000001
r4669 n2574 n2689 64
r4670 n2688 n2689 12.800000000000001
r4671 n2575 n2690 42.666666666666664
r4672 n2689 n2690 6.4000000000000004
r4673 n2576 n2691 64
r4674 n2690 n2691 6.4000000000000004
r4675 n2577 n2692 21.333333333333332
r4676 n2691 n2692 10.24
r4677 n2578 n2693 10.666666666666666
r4678 n2692 n2693 23.039999999999999
r4679 n2579 n2694 9.1428571428571423
r4680 n2693 n2694 33.280000000000001
r4681 n2580 n2695 64
r4682 n2694 n2695 20.48
r4683 n2581 n2696 3.5555555555555554
r4684 n2695 n2696 48.640000000000001
r4685 n2582 n2697 64
r4686 n2696 n2697 48.640000000000001
r4687 n2583 n2698 4
r4688 n2697 n2698 43.520000000000003
r4689 n2584 n2699 64
r4690 n2698 n2699 43.520000000000003
r4691 n2585 n2700 3.5555555555555554
r4692 n2699 n2700 48.640000000000001
r4693 n2586 n2701 64
r4694 n2700 n2701 48.640000000000001
r4695 n2587 n2702 4
r4696 n2701 n2702 43.520000000000003
r4697 n2588 n2703 64
r4698 n2702 n2703 43.520000000000003
r4699 n2589 n2704 3.5555555555555554
r4700 n2703 n2704 48.640000000000001
r4701 n2590 n2705 64
r4702 n2704 n2705 48.640000000000001
r4703 n2591 n2706 4
r4704 n2705 n2706 43.520000000000003
r4705 n2592 n2707 64
r4706 n2706 n2707 43.520000000000003
r4707 n2593 n2708 3.5555555555555554
r4708 n2707 n2708 48.640000000000001
r4709 n2594 n2709 64
r4710 n2708 n2709 48.640000000000001
r4711 n2595 n2710 4
r4712 n2709 n2710 43.520000000000003
r4713 n2596 n2711 64
r4714 n2710 n2711 43.520000000000003
r4715 n2597 n2712 3.5555555555555554
r4716 n2711 n2712 48.640000000000001
r4717 n2598 n2713 64
r4718 n2712 n2713 48.640000000000001
r4719 n2599 n2714 4
r4720 n2713 n2714 43.520000000000003
r4721 n2600 n2715 64
r4722 n2714 n2715 43.520000000000003
r4723 n2601 n2716 3.5555555555555554
r4724 n2715 n2716 48.640000000000001
r4725 n2602 n2717 64
r4726 n2716 n2717 48.640000000000001
r4727 n2603 n2718 4
r4728 n2717 n2718 43.520000000000003
r4729 n2604 n2719 64
r4730 n2718 n2719 43.520000000000003
r4731 n2605 n2720 3.5555555555555554
r4732 n2719 n2720 48.640000000000001
r4733 n2606 n2721 64
r4734 n2720 n2721 48.640000000000001
r4735 n2607 n2722 4
r4736 n2721 n2722 43.520000000000003
r4737 n2608 n2723 64
r4738 n2722 n2723 43.520000000000003
r4739 n2609 n2724 10.666666666666666
r4740 n2723 n2724 17.920000000000002
r4741 n2610 n2725 32
r4742 n2724 n2725 20.48
r4743 n2611 n2726 3.7647058823529411
r4744 n2612 n2727 1.3176470588235294
r4745 n2613 n2728 11.199999999999999
r4746 n2614 n2729 4.4800000000000004
r4747 n2728 n2729 44.799999999999997
r4748 n2615 n2730 22.399999999999999
r4749 n2729 n2730 38.399999999999999
r4750 n2616 n2731 1.3999999999999999
r4751 n2730 n2731 108.8
r4752 n2617 n2732 22.399999999999999
r4753 n2731 n2732 108.8
r4754 n2618 n2733 1.2444444444444445
r4755 n2732 n2733 121.59999999999999
r4756 n2619 n2734 22.399999999999999
r4757 n2733 n2734 121.59999999999999
r4758 n2620 n2735 3.4461538461538463
r4759 n2734 n2735 48
r4760 n2621 n2736 3.7333333333333334
r4761 n2735 n2736 80
r4762 n2622 n2737 6.4000000000000004
r4763 n2736 n2737 60.799999999999997
r4764 n2623 n2738 22.399999999999999
r4765 n2737 n2738 28.800000000000001
r4766 n2624 n2739 11.199999999999999
r4767 n2738 n2739 19.199999999999999
r4768 n2625 n2740 4.9777777777777779
r4769 n2739 n2740 41.600000000000001
r4770 n2626 n2741 2.1333333333333333
r4771 n2740 n2741 96
r4772 n2627 n2742 22.399999999999999
r4773 n2741 n2742 73.599999999999994
r4774 n2628 n2743 22.399999999999999
r4775 n2742 n2743 12.800000000000001
r4776 n2629 n2744 4.9777777777777779
r4777 n2743 n2744 35.200000000000003
r4778 n2630 n2745 3.7333333333333334
r4779 n2744 n2745 67.200000000000003
r4780 n2631 n2746 4.9777777777777779
r4781 n2745 n2746 67.200000000000003
r4782 n2632 n2747 22.399999999999999
r4783 n2746 n2747 35.200000000000003
r4784 n2633 n2748 22.399999999999999
r4785 n2747 n2748 12.800000000000001
r4786 n2634 n2749 2.1333333333333333
r4787 n2748 n2749 73.599999999999994
r4788 n2635 n2750 2.9866666666666668
r4789 n2749 n2750 115.2
r4790 n2636 n2751 22.399999999999999
r4791 n2750 n2751 54.399999999999999
r4792 n2637 n2752 1.3999999999999999
r4793 n2751 n2752 108.8
r4794 n2638 n2753 22.399999999999999
r4795 n2752 n2753 108.8
r4796 n2639 n2754 3.7333333333333334
r4797 n2753 n2754 44.799999999999997
r4798 n2640 n2755 11.199999999999999
r4799 n2754 n2755 51.200000000000003
r4800 n2641 n2756 1.3176470588235294
r4801 n2642 n2757 1.3176470588235294
r4802 n2643 n2758 11.199999999999999
r4803 n2644 n2759 4.4800000000000004
r4804 n2758 n2759 44.799999999999997
r4805 n2645 n2760 22.399999999999999
r4806 n2759 n2760 38.399999999999999
r4807 n2646 n2761 1.3999999999999999
r4808 n2760 n2761 108.8
r4809 n2647 n2762 22.399999999999999
r4810 n2761 n2762 108.8
r4811 n2648 n2763 1.2444444444444445
r4812 n2762 n2763 121.59999999999999
r4813 n2649 n2764 22.399999999999999
r4814 n2763 n2764 121.59999999999999
r4815 n2650 n2765 1.3999999999999999
r4816 n2764 n2765 108.8
r4817 n2651 n2766 22.399999999999999
r4818 n2765 n2766 108.8
r4819 n2652 n2767 1.2444444444444445
r4820 n2766 n2767 121.59999999999999
r4821 n2653 n2768 22.399999999999999
r4822 n2767 n2768 121.59999999999999
r4823 n2654 n2769 1.3999999999999999
r4824 n2768 n2769 108.8
r4825 n2655 n2770 22.399999999999999
r4826 n2769 n2770 108.8
r4827 n2656 n2771 1.2444444444444445
r4828 n2770 n2771 121.59999999999999
r4829 n2657 n2772 22.399999999999999
r4830 n2771 n2772 121.59999999999999
r4831 n2658 n2773 1.3999999999999999
r4832 n2772 n2773 108.8
r4833 n2659 n2774 22.399999999999999
r4834 n2773 n2774 108.8
r4835 n2660 n2775 1.2444444444444445
r4836 n2774 n2775 121.59999999999999
r4837 n2661 n2776 22.399999999999999
r4838 n2775 n2776 121.59999999999999
r4839 n2662 n2777 1.3999999999999999
r4840 n2776 n2777 108.8
r4841 n2663 n2778 22.399999999999999
r4842 n2777 n2778 108.8
r4843 n2664 n2779 1.2444444444444445
r4844 n2778 n2779 121.59999999999999
r4845 n2665 n2780 22.399999999999999
r4846 n2779 n2780 121.59999999999999
r4847 n2666 n2781 1.3999999999999999
r4848 n2780 n2781 108.8
r4849 n2667 n2782 22.399999999999999
r4850 n2781 n2782 108.8
r4851 n2668 n2783 1.2444444444444445
r4852 n2782 n2783 121.59999999999999
r4853 n2669 n2784 22.399999999999999
r4854 n2783 n2784 121.59999999999999
r4855 n2670 n2785 1.3999999999999999
r4856 n2784 n2785 108.8
r4857 n2671 n2786 22.399999999999999
r4858 n2785 n2786 108.8
r4859 n2672 n2787 1.2444444444444445
r4860 n2786 n2787 121.59999999999999
r4861 n2673 n2788 22.399999999999999
r4862 n2787 n2788 121.59999999999999
r4863 n2674 n2789 1.3999999999999999
r4864 n2788 n2789 108.8
r4865 n2675 n2790 22.399999999999999
r4866 n2789 n2790 108.8
r4867 n2676 n2791 2.9866666666666668
r4868 n2790 n2791 54.399999999999999
r4869 n2677 n2792 3.7333333333333334
r4870 n2791 n2792 86.400000000000006
r4871 n2678 n2793 4.9777777777777779
r4872 n2792 n2793 67.200000000000003
r4873 n2679 n2794 22.399999999999999
r4874 n2793 n2794 35.200000000000003
r4875 n2680 n2795 22.399999999999999
r4876 n2794 n2795 12.800000000000001
r4877 n2681 n2796 5.5999999999999996
r4878 n2795 n2796 32
r4879 n2682 n2797 2.0363636363636362
r4880 n2796 n2797 96
r4881 n2683 n2798 44.799999999999997
r4882 n2797 n2798 73.599999999999994
r4883 n2684 n2799 44.799999999999997
r4884 n2798 n2799 6.4000000000000004
r4885 n2685 n2800 44.799999999999997
r4886 n2799 n2800 6.4000000000000004
r4887 n2686 n2801 4.4800000000000004
r4888 n2800 n2801 35.200000000000003
r4889 n2687 n2802 3.7333333333333334
r4890 n2801 n2802 70.400000000000006
r4891 n2688 n2803 5.5999999999999996
r4892 n2802 n2803 64
r4893 n2689 n2804 22.399999999999999
r4894 n2803 n2804 32
r4895 n2690 n2805 14.933333333333334
r4896 n2804 n2805 16
r4897 n2691 n2806 22.399999999999999
r4898 n2805 n2806 16
r4899 n2692 n2807 7.4666666666666668
r4900 n2806 n2807 25.600000000000001
r4901 n2693 n2808 3.7333333333333334
r4902 n2807 n2808 57.600000000000001
r4903 n2694 n2809 3.2000000000000002
r4904 n2808 n2809 83.200000000000003
r4905 n2695 n2810 22.399999999999999
r4906 n2809 n2810 51.200000000000003
r4907 n2696 n2811 1.2444444444444445
r4908 n2810 n2811 121.59999999999999
r4909 n2697 n2812 22.399999999999999
r4910 n2811 n2812 121.59999999999999
r4911 n2698 n2813 1.3999999999999999
r4912 n2812 n2813 108.8
r4913 n2699 n2814 22.399999999999999
r4914 n2813 n2814 108.8
r4915 n2700 n2815 1.2444444444444445
r4916 n2814 n2815 121.59999999999999
r4917 n2701 n2816 22.399999999999999
r4918 n2815 n2816 121.59999999999999
r4919 n2702 n2817 1.3999999999999999
r4920 n2816 n2817 108.8
r4921 n2703 n2818 22.399999999999999
r4922 n2817 n2818 108.8
r4923 n2704 n2819 1.2444444444444445
r4924 n2818 n2819 121.59999999999999
r4925 n2705 n2820 22.399999999999999
r4926 n2819 n2820 121.59999999999999
r4927 n2706 n2821 1.3999999999999999
r4928 n2820 n2821 108.8
r4929 n2707 n2822 22.399999999999999
r4930 n2821 n2822 108.8
r4931 n2708 n2823 1.2444444444444445
r4932 n2822 n2823 121.59999999999999
r4933 n2709 n2824 22.399999999999999
r4934 n2823 n2824 121.59999999999999
r4935 n2710 n2825 1.3999999999999999
r4936 n2824 n2825 108.8
r4937 n2711 n2826 22.399999999999999
r4938 n2825 n2826 108.8
r4939 n2712 n2827 1.2444444444444445
r4940 n2826 n2827 121.59999999999999
r4941 n2713 n2828 22.399999999999999
r4942 n2827 n2828 121.59999999999999
r4943 n2714 n2829 1.3999999999999999
r4944 n2828 n2829 108.8
r4945 n2715 n2830 22.399999999999999
r4946 n2829 n2830 108.8
r4947 n2716 n2831 1.2444444444444445
r4948 n2830 n2831 121.59999999999999
r4949 n2717 n2832 22.399999999999999
r4950 n2831 n2832 121.59999999999999
r4951 n2718 n2833 1.3999999999999999
r4952 n2832 n2833 108.8
r4953 n2719 n2834 22.399999999999999
r4954 n2833 n2834 108.8
r4955 n2720 n2835 1.2444444444444445
r4956 n2834 n2835 121.59999999999999
r4957 n2721 n2836 22.399999999999999
r4958 n2835 n2836 121.59999999999999
r4959 n2722 n2837 1.3999999999999999
r4960 n2836 n2837 108.8
r4961 n2723 n2838 22.399999999999999
r4962 n2837 n2838 108.8
r4963 n2724 n2839 3.7333333333333334
r4964 n2838 n2839 44.799999999999997
r4965 n2725 n2840 11.199999999999999
r4966 n2839 n2840 51.200000000000003
r4967 n2726 n2841 1.3176470588235294
r4968 n2727 n2842 1.5058823529411764
r4969 n2756 n2843 1.5058823529411764
r4970 n2757 n2844 1.5058823529411764
r4971 n2841 n2845 1.5058823529411764
r4972 n2842 n2846 2.447058823529412
r4973 n2843 n2847 2.447058823529412
r4974 n2844 n2848 2.447058823529412
r4975 n2845 n2849 2.447058823529412
r4976 n2846 n2850 3.9529411764705884
r4977 n2847 n2851 3.9529411764705884
r4978 n2848 n2852 3.9529411764705884
r4979 n2849 n2853 3.9529411764705884
r4980 n2850 n2854 9.7129411764705882
r4981 n2851 n2855 9.7129411764705882
r4982 n2852 n2856 9.7129411764705882
r4983 n2853 n2857 9.7129411764705882
r4984 n2854 n2858 14.117647058823529
r4985 n2855 n2859 14.117647058823529
r4986 n2856 n2860 14.117647058823529
r4987 n2857 n2861 14.117647058823529
r4988 n2858 n2862 13.440000000000001
r4989 n2862 n2863 12.235294117647058
r4990 n2863 n2864 11.670588235294117
r4991 n2864 n2865 12.235294117647058
r4992 n2865 n2866 10.91764705882353
r4993 n2866 n2867 5.2705882352941176
r4994 n2867 n2868 2.6352941176470588
r4995 n2868 n2869 2.2588235294117647
r4996 n2869 n2870 6.4000000000000004
r4997 n2870 n2871 6.4000000000000004
r4998 n2871 n2872 7.1529411764705886
r4999 n2872 n2873 7.1529411764705886
r5000 n2873 n2874 2.8235294117647061
r5001 n2874 n2875 4.7058823529411766
r5002 n2875 n2876 3.5764705882352943
r5003 n2876 n2877 1.6941176470588235
r5004 n2877 n2878 1.1294117647058823
r5005 n2878 n2879 2.447058823529412
r5006 n2879 n2880 5.6470588235294121
r5007 n2880 n2881 4.3294117647058821
r5008 n2881 n2882 0.75294117647058822
r5009 n2882 n2883 2.0705882352941178
r5010 n2883 n2884 3.9529411764705884
r5011 n2884 n2885 3.9529411764705884
r5012 n2885 n2886 2.0705882352941178
r5013 n2886 n2887 0.75294117647058822
r5014 n2887 n2888 4.3294117647058821
r5015 n2888 n2889 6.776470588235294
r5016 n2889 n2890 3.2000000000000002
r5017 n2890 n2891 6.4000000000000004
r5018 n2891 n2892 6.4000000000000004
r5019 n2892 n2893 2.6352941176470588
r5020 n2893 n2894 3.0117647058823529
r5021 n2894 n2895 4.5176470588235293
r5022 n2895 n2896 10.164705882352941
r5023 n2896 n2897 7.341176470588235
r5024 n2897 n2898 2.8235294117647061
r5025 n2898 n2899 3.2000000000000002
r5026 n2899 n2900 1.8823529411764706
r5027 n2900 n2901 1.1294117647058823
r5028 n2901 n2902 0.94117647058823528
r5029 n2902 n2903 1.8823529411764706
r5030 n2903 n2904 5.6470588235294121
r5031 n2904 n2905 4.5176470588235293
r5032 n2905 n2906 0.94117647058823528
r5033 n2906 n2907 1.1294117647058823
r5034 n2907 n2908 1.3176470588235294
r5035 n2908 n2909 1.3176470588235294
r5036 n2909 n2910 2.447058823529412
r5037 n2910 n2911 11.105882352941176
r5038 n2859 n2912 13.440000000000001
r5039 n2911 n2912 15.623529411764705
r5040 n2860 n2913 13.440000000000001
r5041 n2913 n2914 12.047058823529412
r5042 n2914 n2915 11.294117647058824
r5043 n2915 n2916 12.047058823529412
r5044 n2916 n2917 10.91764705882353
r5045 n2917 n2918 5.2705882352941176
r5046 n2918 n2919 2.6352941176470588
r5047 n2919 n2920 2.2588235294117647
r5048 n2920 n2921 6.4000000000000004
r5049 n2921 n2922 6.4000000000000004
r5050 n2922 n2923 7.1529411764705886
r5051 n2923 n2924 7.1529411764705886
r5052 n2924 n2925 6.4000000000000004
r5053 n2925 n2926 6.4000000000000004
r5054 n2926 n2927 7.1529411764705886
r5055 n2927 n2928 7.1529411764705886
r5056 n2928 n2929 6.4000000000000004
r5057 n2929 n2930 6.4000000000000004
r5058 n2930 n2931 7.1529411764705886
r5059 n2931 n2932 7.1529411764705886
r5060 n2932 n2933 6.4000000000000004
r5061 n2933 n2934 6.4000000000000004
r5062 n2934 n2935 7.1529411764705886
r5063 n2935 n2936 7.1529411764705886
r5064 n2936 n2937 6.4000000000000004
r5065 n2937 n2938 6.4000000000000004
r5066 n2938 n2939 7.1529411764705886
r5067 n2939 n2940 7.1529411764705886
r5068 n2940 n2941 6.4000000000000004
r5069 n2941 n2942 6.4000000000000004
r5070 n2942 n2943 7.1529411764705886
r5071 n2943 n2944 7.1529411764705886
r5072 n2944 n2945 6.4000000000000004
r5073 n2945 n2946 6.4000000000000004
r5074 n2946 n2947 7.1529411764705886
r5075 n2947 n2948 7.1529411764705886
r5076 n2948 n2949 6.4000000000000004
r5077 n2949 n2950 6.4000000000000004
r5078 n2950 n2951 3.2000000000000002
r5079 n2951 n2952 5.0823529411764703
r5080 n2952 n2953 3.9529411764705884
r5081 n2953 n2954 2.0705882352941178
r5082 n2954 n2955 0.75294117647058822
r5083 n2955 n2956 1.8823529411764706
r5084 n2956 n2957 5.6470588235294121
r5085 n2957 n2958 4.3294117647058821
r5086 n2958 n2959 0.37647058823529411
r5087 n2959 n2960 0.37647058823529411
r5088 n2960 n2961 2.0705882352941178
r5089 n2961 n2962 4.1411764705882357
r5090 n2962 n2963 3.7647058823529411
r5091 n2963 n2964 1.8823529411764706
r5092 n2964 n2965 0.94117647058823528
r5093 n2965 n2966 0.94117647058823528
r5094 n2966 n2967 1.5058823529411764
r5095 n2967 n2968 3.388235294117647
r5096 n2968 n2969 4.8941176470588239
r5097 n2969 n2970 3.0117647058823529
r5098 n2970 n2971 7.1529411764705886
r5099 n2971 n2972 7.1529411764705886
r5100 n2972 n2973 6.4000000000000004
r5101 n2973 n2974 6.4000000000000004
r5102 n2974 n2975 7.1529411764705886
r5103 n2975 n2976 7.1529411764705886
r5104 n2976 n2977 6.4000000000000004
r5105 n2977 n2978 6.4000000000000004
r5106 n2978 n2979 7.1529411764705886
r5107 n2979 n2980 7.1529411764705886
r5108 n2980 n2981 6.4000000000000004
r5109 n2981 n2982 6.4000000000000004
r5110 n2982 n2983 7.1529411764705886
r5111 n2983 n2984 7.1529411764705886
r5112 n2984 n2985 6.4000000000000004
r5113 n2985 n2986 6.4000000000000004
r5114 n2986 n2987 7.1529411764705886
r5115 n2987 n2988 7.1529411764705886
r5116 n2988 n2989 6.4000000000000004
r5117 n2989 n2990 6.4000000000000004
r5118 n2990 n2991 7.1529411764705886
r5119 n2991 n2992 7.1529411764705886
r5120 n2992 n2993 6.4000000000000004
r5121 n2993 n2994 6.4000000000000004
r5122 n2994 n2995 7.1529411764705886
r5123 n2995 n2996 7.1529411764705886
r5124 n2996 n2997 6.4000000000000004
r5125 n2997 n2998 6.4000000000000004
r5126 n2998 n2999 2.6352941176470588
r5127 n2999 n3000 3.0117647058823529
r5128 n3000 n3001 4.5176470588235293
r5129 n3001 n3002 10.164705882352941
r5130 n3002 n3003 6.776470588235294
r5131 n3003 n3004 2.2588235294117647
r5132 n3004 n3005 3.2000000000000002
r5133 n3005 n3006 1.8823529411764706
r5134 n3006 n3007 1.1294117647058823
r5135 n3007 n3008 0.94117647058823528
r5136 n3008 n3009 2.447058823529412
r5137 n3009 n3010 5.6470588235294121
r5138 n3010 n3011 3.9529411764705884
r5139 n3011 n3012 0.94117647058823528
r5140 n3012 n3013 1.1294117647058823
r5141 n3013 n3014 1.8823529411764706
r5142 n3014 n3015 3.2000000000000002
r5143 n3015 n3016 11.105882352941176
r5144 n2861 n3017 13.440000000000001
r5145 n3016 n3017 15.623529411764705
r5146 n3078 n3079 0.015988372093023256
r5147 n3079 n3080 0.014534883720930232
r5148 n3080 n3081 0.046511627906976744
r5149 n3081 n3082 0.036337209302325583
r5150 n3082 n3083 0.046511627906976744
r5151 n3083 n3084 0.046511627906976744
r5152 n3084 n3085 0.036337209302325583
r5153 n3085 n3086 0.046511627906976744
r5154 n3086 n3087 0.014534883720930232
r5155 n3087 n3088 0.015988372093023256
r5156 n3089 n3090 0.029069767441860465
r5157 n3090 n3091 0.047965116279069769
r5158 n3091 n3092 0.036337209302325583
r5159 n3092 n3093 0.046511627906976744
r5160 n3093 n3094 0.046511627906976744
r5161 n3094 n3095 0.036337209302325583
r5162 n3095 n3096 0.047965116279069769
r5163 n3096 n3097 0.029069767441860465
r5164 n3078 n3098 0.48125000000000001
r5165 n3079 n3099 4.8125
r5166 n3098 n3099 0.020220588235294119
r5167 n3080 n3100 0.53472222222222221
r5168 n3099 n3100 0.018382352941176471
r5169 n3081 n3101 0.20923913043478262
r5170 n3100 n3101 0.058823529411764705
r5171 n3082 n3102 2.40625
r5172 n3101 n3102 0.04595588235294118
r5173 n3083 n3103 0.16041666666666668
r5174 n3102 n3103 0.058823529411764705
r5175 n3084 n3104 2.40625
r5176 n3103 n3104 0.058823529411764705
r5177 n3085 n3105 0.20923913043478262
r5178 n3104 n3105 0.04595588235294118
r5179 n3086 n3106 0.53472222222222221
r5180 n3105 n3106 0.058823529411764705
r5181 n3087 n3107 4.8125
r5182 n3106 n3107 0.018382352941176471
r5183 n3088 n3108 0.48125000000000001
r5184 n3107 n3108 0.020220588235294119
r5185 n3089 n3109 0.48125000000000001
r5186 n3090 n3110 0.48125000000000001
r5187 n3109 n3110 0.036764705882352942
r5188 n3091 n3111 0.20923913043478262
r5189 n3110 n3111 0.060661764705882353
r5190 n3092 n3112 2.40625
r5191 n3111 n3112 0.04595588235294118
r5192 n3093 n3113 0.16041666666666668
r5193 n3112 n3113 0.058823529411764705
r5194 n3094 n3114 2.40625
r5195 n3113 n3114 0.058823529411764705
r5196 n3095 n3115 0.20923913043478262
r5197 n3114 n3115 0.04595588235294118
r5198 n3096 n3116 0.48125000000000001
r5199 n3115 n3116 0.060661764705882353
r5200 n3097 n3117 0.48125000000000001
r5201 n3116 n3117 0.036764705882352942
r5202 n3098 n3118 0.48125000000000001
r5203 n3099 n3119 4.8125
r5204 n3118 n3119 0.015988372093023256
r5205 n3100 n3120 0.53472222222222221
r5206 n3119 n3120 0.014534883720930232
r5207 n3101 n3121 0.20923913043478262
r5208 n3120 n3121 0.046511627906976744
r5209 n3102 n3122 2.40625
r5210 n3121 n3122 0.036337209302325583
r5211 n3103 n3123 0.16041666666666668
r5212 n3122 n3123 0.046511627906976744
r5213 n3104 n3124 2.40625
r5214 n3123 n3124 0.046511627906976744
r5215 n3105 n3125 0.20923913043478262
r5216 n3124 n3125 0.036337209302325583
r5217 n3106 n3126 0.53472222222222221
r5218 n3125 n3126 0.046511627906976744
r5219 n3107 n3127 4.8125
r5220 n3126 n3127 0.014534883720930232
r5221 n3108 n3128 0.48125000000000001
r5222 n3127 n3128 0.015988372093023256
r5223 n3109 n3129 0.48125000000000001
r5224 n3110 n3130 0.48125000000000001
r5225 n3129 n3130 0.029069767441860465
r5226 n3111 n3131 0.20923913043478262
r5227 n3130 n3131 0.047965116279069769
r5228 n3112 n3132 2.40625
r5229 n3131 n3132 0.036337209302325583
r5230 n3113 n3133 0.16041666666666668
r5231 n3132 n3133 0.046511627906976744
r5232 n3114 n3134 2.40625
r5233 n3133 n3134 0.046511627906976744
r5234 n3115 n3135 0.20923913043478262
r5235 n3134 n3135 0.036337209302325583
r5236 n3116 n3136 0.48125000000000001
r5237 n3135 n3136 0.047965116279069769
r5238 n3117 n3137 0.48125000000000001
r5239 n3136 n3137 0.029069767441860465
r5240 n3121 n3138 0.22554347826086957
r5241 n3122 n3139 2.59375
r5242 n3138 n3139 0.0390625
r5243 n3123 n3140 0.17291666666666666
r5244 n3139 n3140 0.050000000000000003
r5245 n3124 n3141 2.59375
r5246 n3140 n3141 0.050000000000000003
r5247 n3125 n3142 0.22554347826086957
r5248 n3141 n3142 0.0390625
r5249 n3131 n3143 0.22554347826086957
r5250 n3132 n3144 2.59375
r5251 n3143 n3144 0.0390625
r5252 n3133 n3145 0.17291666666666666
r5253 n3144 n3145 0.050000000000000003
r5254 n3134 n3146 2.59375
r5255 n3145 n3146 0.050000000000000003
r5256 n3135 n3147 0.22554347826086957
r5257 n3146 n3147 0.0390625
r5258 n3138 n3148 0.21739130434782608
r5259 n3139 n3149 2.5
r5260 n3148 n3149 0.0390625
r5261 n3140 n3150 0.16666666666666666
r5262 n3149 n3150 0.050000000000000003
r5263 n3141 n3151 2.5
r5264 n3150 n3151 0.050000000000000003
r5265 n3142 n3152 0.21739130434782608
r5266 n3151 n3152 0.0390625
r5267 n3143 n3153 0.21739130434782608
r5268 n3144 n3154 2.5
r5269 n3153 n3154 0.0390625
r5270 n3145 n3155 0.16666666666666666
r5271 n3154 n3155 0.050000000000000003
r5272 n3146 n3156 2.5
r5273 n3155 n3156 0.050000000000000003
r5274 n3147 n3157 0.21739130434782608
r5275 n3156 n3157 0.0390625
r5276 n3148 n3158 0.23097826086956522
r5277 n3149 n3159 2.65625
r5278 n3158 n3159 0.034722222222222224
r5279 n3150 n3160 0.17708333333333334
r5280 n3159 n3160 0.044444444444444446
r5281 n3151 n3161 2.65625
r5282 n3160 n3161 0.044444444444444446
r5283 n3152 n3162 0.23097826086956522
r5284 n3161 n3162 0.034722222222222224
r5285 n3153 n3163 0.23097826086956522
r5286 n3154 n3164 2.65625
r5287 n3163 n3164 0.034722222222222224
r5288 n3155 n3165 0.17708333333333334
r5289 n3164 n3165 0.044444444444444446
r5290 n3156 n3166 2.65625
r5291 n3165 n3166 0.044444444444444446
r5292 n3157 n3167 0.23097826086956522
r5293 n3166 n3167 0.034722222222222224
r5294 n3158 n3168 0.20380434782608695
r5295 n3159 n3169 2.34375
r5296 n3168 n3169 0.052083333333333336
r5297 n3160 n3170 0.15625
r5298 n3169 n3170 0.066666666666666666
r5299 n3161 n3171 2.34375
r5300 n3170 n3171 0.066666666666666666
r5301 n3162 n3172 0.20380434782608695
r5302 n3171 n3172 0.052083333333333336
r5303 n3163 n3173 0.20380434782608695
r5304 n3164 n3174 2.34375
r5305 n3173 n3174 0.052083333333333336
r5306 n3165 n3175 0.15625
r5307 n3174 n3175 0.066666666666666666
r5308 n3166 n3176 2.34375
r5309 n3175 n3176 0.066666666666666666
r5310 n3167 n3177 0.20380434782608695
r5311 n3176 n3177 0.052083333333333336
r5312 n3168 n3178 0.14945652173913043
r5313 n3169 n3179 1.71875
r5314 n3178 n3179 0.0625
r5315 n3170 n3180 0.11458333333333333
r5316 n3179 n3180 0.080000000000000002
r5317 n3171 n3181 1.71875
r5318 n3180 n3181 0.080000000000000002
r5319 n3172 n3182 0.14945652173913043
r5320 n3181 n3182 0.0625
r5321 n3173 n3183 0.14945652173913043
r5322 n3174 n3184 1.71875
r5323 n3183 n3184 0.0625
r5324 n3175 n3185 0.11458333333333333
r5325 n3184 n3185 0.080000000000000002
r5326 n3176 n3186 1.71875
r5327 n3185 n3186 0.080000000000000002
r5328 n3177 n3187 0.14945652173913043
r5329 n3186 n3187 0.0625
r5330 n3188 n3189 0.71875
r5331 n3189 n3190 0.125
r5332 n3190 n3191 0.34375
r5333 n3191 n3192 0.65625
r5334 n3192 n3193 0.65625
r5335 n3193 n3194 0.34375
r5336 n3194 n3195 0.125
r5337 n3195 n3196 0.71875
r5338 n3197 n3198 0.71875
r5339 n3198 n3199 0.0625
r5340 n3199 n3200 0.0625
r5341 n3200 n3201 0.34375
r5342 n3201 n3202 0.6875
r5343 n3202 n3203 0.625
r5344 n3203 n3204 0.3125
r5345 n3204 n3205 0.15625
r5346 n3205 n3206 0.15625
r5347 n3206 n3207 0.25
r5348 n3207 n3208 0.5625
r5349 n3188 n3209 0.038690476190476192
r5350 n3189 n3210 0.40625
r5351 n3209 n3210 0.13068181818181818
r5352 n3190 n3211 0.40625
r5353 n3210 n3211 0.022727272727272728
r5354 n3191 n3212 0.090277777777777776
r5355 n3211 n3212 0.0625
r5356 n3192 n3213 0.067708333333333329
r5357 n3212 n3213 0.11931818181818182
r5358 n3193 n3214 0.090277777777777776
r5359 n3213 n3214 0.11931818181818182
r5360 n3194 n3215 0.40625
r5361 n3214 n3215 0.0625
r5362 n3195 n3216 0.40625
r5363 n3215 n3216 0.022727272727272728
r5364 n3196 n3217 0.038690476190476192
r5365 n3216 n3217 0.13068181818181818
r5366 n3197 n3218 0.036931818181818184
r5367 n3198 n3219 0.8125
r5368 n3218 n3219 0.13068181818181818
r5369 n3199 n3220 0.8125
r5370 n3219 n3220 0.011363636363636364
r5371 n3200 n3221 0.8125
r5372 n3220 n3221 0.011363636363636364
r5373 n3201 n3222 0.081250000000000003
r5374 n3221 n3222 0.0625
r5375 n3202 n3223 0.067708333333333329
r5376 n3222 n3223 0.125
r5377 n3203 n3224 0.1015625
r5378 n3223 n3224 0.11363636363636363
r5379 n3204 n3225 0.40625
r5380 n3224 n3225 0.056818181818181816
r5381 n3205 n3226 0.27083333333333331
r5382 n3225 n3226 0.028409090909090908
r5383 n3206 n3227 0.40625
r5384 n3226 n3227 0.028409090909090908
r5385 n3207 n3228 0.13541666666666666
r5386 n3227 n3228 0.045454545454545456
r5387 n3208 n3229 0.067708333333333329
r5388 n3228 n3229 0.10227272727272728
r5389 n3209 n3230 0.038690476190476192
r5390 n3210 n3231 0.40625
r5391 n3230 n3231 0.71875
r5392 n3211 n3232 0.40625
r5393 n3231 n3232 0.125
r5394 n3212 n3233 0.090277777777777776
r5395 n3232 n3233 0.34375
r5396 n3213 n3234 0.067708333333333329
r5397 n3233 n3234 0.65625
r5398 n3214 n3235 0.090277777777777776
r5399 n3234 n3235 0.65625
r5400 n3215 n3236 0.40625
r5401 n3235 n3236 0.34375
r5402 n3216 n3237 0.40625
r5403 n3236 n3237 0.125
r5404 n3217 n3238 0.038690476190476192
r5405 n3237 n3238 0.71875
r5406 n3218 n3239 0.036931818181818184
r5407 n3219 n3240 0.8125
r5408 n3239 n3240 0.71875
r5409 n3220 n3241 0.8125
r5410 n3240 n3241 0.0625
r5411 n3221 n3242 0.8125
r5412 n3241 n3242 0.0625
r5413 n3222 n3243 0.081250000000000003
r5414 n3242 n3243 0.34375
r5415 n3223 n3244 0.067708333333333329
r5416 n3243 n3244 0.6875
r5417 n3224 n3245 0.1015625
r5418 n3244 n3245 0.625
r5419 n3225 n3246 0.40625
r5420 n3245 n3246 0.3125
r5421 n3226 n3247 0.27083333333333331
r5422 n3246 n3247 0.15625
r5423 n3227 n3248 0.40625
r5424 n3247 n3248 0.15625
r5425 n3228 n3249 0.13541666666666666
r5426 n3248 n3249 0.25
r5427 n3229 n3250 0.067708333333333329
r5428 n3249 n3250 0.5625
r5429 n3230 n3251 0.095238095238095233
r5430 n3231 n3252 1
r5431 n3251 n3252 0.04791666666666667
r5432 n3232 n3253 1
r5433 n3252 n3253 0.0083333333333333332
r5434 n3233 n3254 0.22222222222222221
r5435 n3253 n3254 0.022916666666666665
r5436 n3234 n3255 0.16666666666666666
r5437 n3254 n3255 0.043749999999999997
r5438 n3235 n3256 0.22222222222222221
r5439 n3255 n3256 0.043749999999999997
r5440 n3236 n3257 1
r5441 n3256 n3257 0.022916666666666665
r5442 n3237 n3258 1
r5443 n3257 n3258 0.0083333333333333332
r5444 n3238 n3259 0.095238095238095233
r5445 n3258 n3259 0.04791666666666667
r5446 n3239 n3260 0.090909090909090912
r5447 n3240 n3261 2
r5448 n3260 n3261 0.04791666666666667
r5449 n3241 n3262 2
r5450 n3261 n3262 0.0041666666666666666
r5451 n3242 n3263 2
r5452 n3262 n3263 0.0041666666666666666
r5453 n3243 n3264 0.20000000000000001
r5454 n3263 n3264 0.022916666666666665
r5455 n3244 n3265 0.16666666666666666
r5456 n3264 n3265 0.04583333333333333
r5457 n3245 n3266 0.25
r5458 n3265 n3266 0.041666666666666664
r5459 n3246 n3267 1
r5460 n3266 n3267 0.020833333333333332
r5461 n3247 n3268 0.66666666666666663
r5462 n3267 n3268 0.010416666666666666
r5463 n3248 n3269 1
r5464 n3268 n3269 0.010416666666666666
r5465 n3249 n3270 0.33333333333333331
r5466 n3269 n3270 0.016666666666666666
r5467 n3250 n3271 0.16666666666666666
r5468 n3270 n3271 0.037499999999999999
r5469 n3251 n3272 0.095238095238095233
r5470 n3252 n3273 1
r5471 n3272 n3273 0.71875
r5472 n3253 n3274 1
r5473 n3273 n3274 0.125
r5474 n3254 n3275 0.22222222222222221
r5475 n3274 n3275 0.34375
r5476 n3255 n3276 0.16666666666666666
r5477 n3275 n3276 0.65625
r5478 n3256 n3277 0.22222222222222221
r5479 n3276 n3277 0.65625
r5480 n3257 n3278 1
r5481 n3277 n3278 0.34375
r5482 n3258 n3279 1
r5483 n3278 n3279 0.125
r5484 n3259 n3280 0.095238095238095233
r5485 n3279 n3280 0.71875
r5486 n3260 n3281 0.090909090909090912
r5487 n3261 n3282 2
r5488 n3281 n3282 0.71875
r5489 n3262 n3283 2
r5490 n3282 n3283 0.0625
r5491 n3263 n3284 2
r5492 n3283 n3284 0.0625
r5493 n3264 n3285 0.20000000000000001
r5494 n3284 n3285 0.34375
r5495 n3265 n3286 0.16666666666666666
r5496 n3285 n3286 0.6875
r5497 n3266 n3287 0.25
r5498 n3286 n3287 0.625
r5499 n3267 n3288 1
r5500 n3287 n3288 0.3125
r5501 n3268 n3289 0.66666666666666663
r5502 n3288 n3289 0.15625
r5503 n3269 n3290 1
r5504 n3289 n3290 0.15625
r5505 n3270 n3291 0.33333333333333331
r5506 n3290 n3291 0.25
r5507 n3271 n3292 0.16666666666666666
r5508 n3291 n3292 0.5625
r5509 n3272 n3293 0.038690476190476192
r5510 n3273 n3294 0.40625
r5511 n3293 n3294 0.13068181818181818
r5512 n3274 n3295 0.40625
r5513 n3294 n3295 0.022727272727272728
r5514 n3275 n3296 0.090277777777777776
r5515 n3295 n3296 0.0625
r5516 n3276 n3297 0.067708333333333329
r5517 n3296 n3297 0.11931818181818182
r5518 n3277 n3298 0.090277777777777776
r5519 n3297 n3298 0.11931818181818182
r5520 n3278 n3299 0.40625
r5521 n3298 n3299 0.0625
r5522 n3279 n3300 0.40625
r5523 n3299 n3300 0.022727272727272728
r5524 n3280 n3301 0.038690476190476192
r5525 n3300 n3301 0.13068181818181818
r5526 n3281 n3302 0.036931818181818184
r5527 n3282 n3303 0.8125
r5528 n3302 n3303 0.13068181818181818
r5529 n3283 n3304 0.8125
r5530 n3303 n3304 0.011363636363636364
r5531 n3284 n3305 0.8125
r5532 n3304 n3305 0.011363636363636364
r5533 n3285 n3306 0.081250000000000003
r5534 n3305 n3306 0.0625
r5535 n3286 n3307 0.067708333333333329
r5536 n3306 n3307 0.125
r5537 n3287 n3308 0.1015625
r5538 n3307 n3308 0.11363636363636363
r5539 n3288 n3309 0.40625
r5540 n3308 n3309 0.056818181818181816
r5541 n3289 n3310 0.27083333333333331
r5542 n3309 n3310 0.028409090909090908
r5543 n3290 n3311 0.40625
r5544 n3310 n3311 0.028409090909090908
r5545 n3291 n3312 0.13541666666666666
r5546 n3311 n3312 0.045454545454545456
r5547 n3292 n3313 0.067708333333333329
r5548 n3312 n3313 0.10227272727272728
r5549 n3293 n3314 0.038690476190476192
r5550 n3294 n3315 0.40625
r5551 n3314 n3315 0.71875
r5552 n3295 n3316 0.40625
r5553 n3315 n3316 0.125
r5554 n3296 n3317 0.090277777777777776
r5555 n3316 n3317 0.34375
r5556 n3297 n3318 0.067708333333333329
r5557 n3317 n3318 0.65625
r5558 n3298 n3319 0.090277777777777776
r5559 n3318 n3319 0.65625
r5560 n3299 n3320 0.40625
r5561 n3319 n3320 0.34375
r5562 n3300 n3321 0.40625
r5563 n3320 n3321 0.125
r5564 n3301 n3322 0.038690476190476192
r5565 n3321 n3322 0.71875
r5566 n3302 n3323 0.036931818181818184
r5567 n3303 n3324 0.8125
r5568 n3323 n3324 0.71875
r5569 n3304 n3325 0.8125
r5570 n3324 n3325 0.0625
r5571 n3305 n3326 0.8125
r5572 n3325 n3326 0.0625
r5573 n3306 n3327 0.081250000000000003
r5574 n3326 n3327 0.34375
r5575 n3307 n3328 0.067708333333333329
r5576 n3327 n3328 0.6875
r5577 n3308 n3329 0.1015625
r5578 n3328 n3329 0.625
r5579 n3309 n3330 0.40625
r5580 n3329 n3330 0.3125
r5581 n3310 n3331 0.27083333333333331
r5582 n3330 n3331 0.15625
r5583 n3311 n3332 0.40625
r5584 n3331 n3332 0.15625
r5585 n3312 n3333 0.13541666666666666
r5586 n3332 n3333 0.25
r5587 n3313 n3334 0.067708333333333329
r5588 n3333 n3334 0.5625
r5589 n3335 n3336 0.59375
r5590 n3336 n3337 0.28125
r5591 n3337 n3338 0.1875
r5592 n3338 n3339 0.40625
r5593 n3339 n3340 0.9375
r5594 n3340 n3341 0.71875
r5595 n3341 n3342 0.125
r5596 n3342 n3343 0.34375
r5597 n3343 n3344 0.65625
r5598 n3345 n3346 0.65625
r5599 n3346 n3347 0.34375
r5600 n3347 n3348 0.125
r5601 n3348 n3349 0.3125
r5602 n3349 n3350 0.9375
r5603 n3350 n3351 0.71875
r5604 n3351 n3352 0.0625
r5605 n3352 n3353 0.0625
r5606 n3353 n3354 0.34375
r5607 n3354 n3355 0.6875
r5608 n3335 n3356 0.036458333333333336
r5609 n3336 n3357 0.0625
r5610 n3356 n3357 0.23749999999999999
r5611 n3337 n3358 0.21875
r5612 n3357 n3358 0.1125
r5613 n3338 n3359 0.109375
r5614 n3358 n3359 0.074999999999999997
r5615 n3339 n3360 0.048611111111111112
r5616 n3359 n3360 0.16250000000000001
r5617 n3340 n3361 0.020833333333333332
r5618 n3360 n3361 0.375
r5619 n3341 n3362 0.21875
r5620 n3361 n3362 0.28749999999999998
r5621 n3342 n3363 0.21875
r5622 n3362 n3363 0.050000000000000003
r5623 n3343 n3364 0.048611111111111112
r5624 n3363 n3364 0.13750000000000001
r5625 n3344 n3365 0.036458333333333336
r5626 n3364 n3365 0.26250000000000001
r5627 n3345 n3366 0.036458333333333336
r5628 n3346 n3367 0.048611111111111112
r5629 n3366 n3367 0.26250000000000001
r5630 n3347 n3368 0.21875
r5631 n3367 n3368 0.13750000000000001
r5632 n3348 n3369 0.21875
r5633 n3368 n3369 0.050000000000000003
r5634 n3349 n3370 0.0546875
r5635 n3369 n3370 0.125
r5636 n3350 n3371 0.019886363636363636
r5637 n3370 n3371 0.375
r5638 n3351 n3372 0.4375
r5639 n3371 n3372 0.28749999999999998
r5640 n3352 n3373 0.4375
r5641 n3372 n3373 0.025000000000000001
r5642 n3353 n3374 0.4375
r5643 n3373 n3374 0.025000000000000001
r5644 n3354 n3375 0.043749999999999997
r5645 n3374 n3375 0.13750000000000001
r5646 n3355 n3376 0.036458333333333336
r5647 n3375 n3376 0.27500000000000002
r5648 n3377 n3378 0.125
r5649 n3378 n3379 0.35416666666666669
r5650 n3379 n3380 0.35416666666666669
r5651 n3380 n3381 0.39583333333333331
r5652 n3381 n3382 0.39583333333333331
r5653 n3382 n3383 0.15625
r5654 n3356 n3384 0.057291666666666664
r5655 n3383 n3384 0.26041666666666669
r5656 n3357 n3385 0.098214285714285712
r5657 n3384 n3385 0.19791666666666666
r5658 n3358 n3386 0.34375
r5659 n3385 n3386 0.09375
r5660 n3359 n3387 0.171875
r5661 n3386 n3387 0.0625
r5662 n3360 n3388 0.076388888888888895
r5663 n3387 n3388 0.13541666666666666
r5664 n3361 n3389 0.03273809523809524
r5665 n3388 n3389 0.3125
r5666 n3362 n3390 0.34375
r5667 n3389 n3390 0.23958333333333334
r5668 n3363 n3391 0.34375
r5669 n3390 n3391 0.041666666666666664
r5670 n3364 n3392 0.076388888888888895
r5671 n3391 n3392 0.11458333333333333
r5672 n3365 n3393 0.057291666666666664
r5673 n3392 n3393 0.21875
r5674 n3393 n3394 0.21875
r5675 n3394 n3395 0.11458333333333333
r5676 n3395 n3396 0.041666666666666664
r5677 n3396 n3397 0.23958333333333334
r5678 n3397 n3398 0.375
r5679 n3398 n3399 0.17708333333333334
r5680 n3399 n3400 0.35416666666666669
r5681 n3400 n3401 0.35416666666666669
r5682 n3401 n3402 0.14583333333333334
r5683 n3403 n3404 0.125
r5684 n3404 n3405 0.35416666666666669
r5685 n3405 n3406 0.35416666666666669
r5686 n3406 n3407 0.39583333333333331
r5687 n3407 n3408 0.39583333333333331
r5688 n3408 n3409 0.35416666666666669
r5689 n3409 n3410 0.35416666666666669
r5690 n3410 n3411 0.39583333333333331
r5691 n3411 n3412 0.39583333333333331
r5692 n3412 n3413 0.35416666666666669
r5693 n3413 n3414 0.35416666666666669
r5694 n3414 n3415 0.39583333333333331
r5695 n3415 n3416 0.39583333333333331
r5696 n3416 n3417 0.35416666666666669
r5697 n3417 n3418 0.35416666666666669
r5698 n3418 n3419 0.39583333333333331
r5699 n3419 n3420 0.39583333333333331
r5700 n3420 n3421 0.35416666666666669
r5701 n3421 n3422 0.35416666666666669
r5702 n3422 n3423 0.39583333333333331
r5703 n3423 n3424 0.39583333333333331
r5704 n3424 n3425 0.35416666666666669
r5705 n3425 n3426 0.35416666666666669
r5706 n3426 n3427 0.39583333333333331
r5707 n3427 n3428 0.39583333333333331
r5708 n3428 n3429 0.35416666666666669
r5709 n3429 n3430 0.35416666666666669
r5710 n3430 n3431 0.39583333333333331
r5711 n3431 n3432 0.39583333333333331
r5712 n3432 n3433 0.35416666666666669
r5713 n3433 n3434 0.35416666666666669
r5714 n3434 n3435 0.17708333333333334
r5715 n3366 n3436 0.057291666666666664
r5716 n3435 n3436 0.28125
r5717 n3367 n3437 0.076388888888888895
r5718 n3436 n3437 0.21875
r5719 n3368 n3438 0.34375
r5720 n3437 n3438 0.11458333333333333
r5721 n3369 n3439 0.34375
r5722 n3438 n3439 0.041666666666666664
r5723 n3370 n3440 0.0859375
r5724 n3439 n3440 0.10416666666666667
r5725 n3371 n3441 0.03125
r5726 n3440 n3441 0.3125
r5727 n3372 n3442 0.6875
r5728 n3441 n3442 0.23958333333333334
r5729 n3373 n3443 0.6875
r5730 n3442 n3443 0.020833333333333332
r5731 n3374 n3444 0.6875
r5732 n3443 n3444 0.020833333333333332
r5733 n3375 n3445 0.068750000000000006
r5734 n3444 n3445 0.11458333333333333
r5735 n3376 n3446 0.057291666666666664
r5736 n3445 n3446 0.22916666666666666
r5737 n3446 n3447 0.20833333333333334
r5738 n3447 n3448 0.10416666666666667
r5739 n3448 n3449 0.052083333333333336
r5740 n3449 n3450 0.052083333333333336
r5741 n3450 n3451 0.083333333333333329
r5742 n3451 n3452 0.1875
r5743 n3452 n3453 0.27083333333333331
r5744 n3453 n3454 0.16666666666666666
r5745 n3454 n3455 0.39583333333333331
r5746 n3455 n3456 0.39583333333333331
r5747 n3456 n3457 0.35416666666666669
r5748 n3457 n3458 0.35416666666666669
r5749 n3458 n3459 0.39583333333333331
r5750 n3459 n3460 0.39583333333333331
r5751 n3460 n3461 0.35416666666666669
r5752 n3461 n3462 0.35416666666666669
r5753 n3462 n3463 0.39583333333333331
r5754 n3463 n3464 0.39583333333333331
r5755 n3464 n3465 0.35416666666666669
r5756 n3465 n3466 0.35416666666666669
r5757 n3466 n3467 0.39583333333333331
r5758 n3467 n3468 0.39583333333333331
r5759 n3468 n3469 0.35416666666666669
r5760 n3469 n3470 0.35416666666666669
r5761 n3470 n3471 0.39583333333333331
r5762 n3471 n3472 0.39583333333333331
r5763 n3472 n3473 0.35416666666666669
r5764 n3473 n3474 0.35416666666666669
r5765 n3474 n3475 0.39583333333333331
r5766 n3475 n3476 0.39583333333333331
r5767 n3476 n3477 0.35416666666666669
r5768 n3477 n3478 0.35416666666666669
r5769 n3478 n3479 0.39583333333333331
r5770 n3479 n3480 0.39583333333333331
r5771 n3480 n3481 0.35416666666666669
r5772 n3481 n3482 0.35416666666666669
r5773 n3482 n3483 0.14583333333333334
r5774 n3377 n3484 0.050000000000000003
r5775 n3378 n3485 0.25
r5776 n3484 n3485 0.375
r5777 n3379 n3486 0.015625
r5778 n3485 n3486 1.0625
r5779 n3380 n3487 0.25
r5780 n3486 n3487 1.0625
r5781 n3381 n3488 0.013888888888888888
r5782 n3487 n3488 1.1875
r5783 n3382 n3489 0.25
r5784 n3488 n3489 1.1875
r5785 n3383 n3490 0.038461538461538464
r5786 n3489 n3490 0.46875
r5787 n3384 n3491 0.041666666666666664
r5788 n3490 n3491 0.78125
r5789 n3385 n3492 0.071428571428571425
r5790 n3491 n3492 0.59375
r5791 n3386 n3493 0.25
r5792 n3492 n3493 0.28125
r5793 n3387 n3494 0.125
r5794 n3493 n3494 0.1875
r5795 n3388 n3495 0.055555555555555552
r5796 n3494 n3495 0.40625
r5797 n3389 n3496 0.023809523809523808
r5798 n3495 n3496 0.9375
r5799 n3390 n3497 0.25
r5800 n3496 n3497 0.71875
r5801 n3391 n3498 0.25
r5802 n3497 n3498 0.125
r5803 n3392 n3499 0.055555555555555552
r5804 n3498 n3499 0.34375
r5805 n3393 n3500 0.041666666666666664
r5806 n3499 n3500 0.65625
r5807 n3394 n3501 0.055555555555555552
r5808 n3500 n3501 0.65625
r5809 n3395 n3502 0.25
r5810 n3501 n3502 0.34375
r5811 n3396 n3503 0.25
r5812 n3502 n3503 0.125
r5813 n3397 n3504 0.023809523809523808
r5814 n3503 n3504 0.71875
r5815 n3398 n3505 0.033333333333333333
r5816 n3504 n3505 1.125
r5817 n3399 n3506 0.25
r5818 n3505 n3506 0.53125
r5819 n3400 n3507 0.015625
r5820 n3506 n3507 1.0625
r5821 n3401 n3508 0.25
r5822 n3507 n3508 1.0625
r5823 n3402 n3509 0.041666666666666664
r5824 n3508 n3509 0.4375
r5825 n3403 n3510 0.050000000000000003
r5826 n3404 n3511 0.25
r5827 n3510 n3511 0.375
r5828 n3405 n3512 0.015625
r5829 n3511 n3512 1.0625
r5830 n3406 n3513 0.25
r5831 n3512 n3513 1.0625
r5832 n3407 n3514 0.013888888888888888
r5833 n3513 n3514 1.1875
r5834 n3408 n3515 0.25
r5835 n3514 n3515 1.1875
r5836 n3409 n3516 0.015625
r5837 n3515 n3516 1.0625
r5838 n3410 n3517 0.25
r5839 n3516 n3517 1.0625
r5840 n3411 n3518 0.013888888888888888
r5841 n3517 n3518 1.1875
r5842 n3412 n3519 0.25
r5843 n3518 n3519 1.1875
r5844 n3413 n3520 0.015625
r5845 n3519 n3520 1.0625
r5846 n3414 n3521 0.25
r5847 n3520 n3521 1.0625
r5848 n3415 n3522 0.013888888888888888
r5849 n3521 n3522 1.1875
r5850 n3416 n3523 0.25
r5851 n3522 n3523 1.1875
r5852 n3417 n3524 0.015625
r5853 n3523 n3524 1.0625
r5854 n3418 n3525 0.25
r5855 n3524 n3525 1.0625
r5856 n3419 n3526 0.013888888888888888
r5857 n3525 n3526 1.1875
r5858 n3420 n3527 0.25
r5859 n3526 n3527 1.1875
r5860 n3421 n3528 0.015625
r5861 n3527 n3528 1.0625
r5862 n3422 n3529 0.25
r5863 n3528 n3529 1.0625
r5864 n3423 n3530 0.013888888888888888
r5865 n3529 n3530 1.1875
r5866 n3424 n3531 0.25
r5867 n3530 n3531 1.1875
r5868 n3425 n3532 0.015625
r5869 n3531 n3532 1.0625
r5870 n3426 n3533 0.25
r5871 n3532 n3533 1.0625
r5872 n3427 n3534 0.013888888888888888
r5873 n3533 n3534 1.1875
r5874 n3428 n3535 0.25
r5875 n3534 n3535 1.1875
r5876 n3429 n3536 0.015625
r5877 n3535 n3536 1.0625
r5878 n3430 n3537 0.25
r5879 n3536 n3537 1.0625
r5880 n3431 n3538 0.013888888888888888
r5881 n3537 n3538 1.1875
r5882 n3432 n3539 0.25
r5883 n3538 n3539 1.1875
r5884 n3433 n3540 0.015625
r5885 n3539 n3540 1.0625
r5886 n3434 n3541 0.25
r5887 n3540 n3541 1.0625
r5888 n3435 n3542 0.033333333333333333
r5889 n3541 n3542 0.53125
r5890 n3436 n3543 0.041666666666666664
r5891 n3542 n3543 0.84375
r5892 n3437 n3544 0.055555555555555552
r5893 n3543 n3544 0.65625
r5894 n3438 n3545 0.25
r5895 n3544 n3545 0.34375
r5896 n3439 n3546 0.25
r5897 n3545 n3546 0.125
r5898 n3440 n3547 0.0625
r5899 n3546 n3547 0.3125
r5900 n3441 n3548 0.022727272727272728
r5901 n3547 n3548 0.9375
r5902 n3442 n3549 0.5
r5903 n3548 n3549 0.71875
r5904 n3443 n3550 0.5
r5905 n3549 n3550 0.0625
r5906 n3444 n3551 0.5
r5907 n3550 n3551 0.0625
r5908 n3445 n3552 0.050000000000000003
r5909 n3551 n3552 0.34375
r5910 n3446 n3553 0.041666666666666664
r5911 n3552 n3553 0.6875
r5912 n3447 n3554 0.0625
r5913 n3553 n3554 0.625
r5914 n3448 n3555 0.25
r5915 n3554 n3555 0.3125
r5916 n3449 n3556 0.16666666666666666
r5917 n3555 n3556 0.15625
r5918 n3450 n3557 0.25
r5919 n3556 n3557 0.15625
r5920 n3451 n3558 0.083333333333333329
r5921 n3557 n3558 0.25
r5922 n3452 n3559 0.041666666666666664
r5923 n3558 n3559 0.5625
r5924 n3453 n3560 0.035714285714285712
r5925 n3559 n3560 0.8125
r5926 n3454 n3561 0.25
r5927 n3560 n3561 0.5
r5928 n3455 n3562 0.013888888888888888
r5929 n3561 n3562 1.1875
r5930 n3456 n3563 0.25
r5931 n3562 n3563 1.1875
r5932 n3457 n3564 0.015625
r5933 n3563 n3564 1.0625
r5934 n3458 n3565 0.25
r5935 n3564 n3565 1.0625
r5936 n3459 n3566 0.013888888888888888
r5937 n3565 n3566 1.1875
r5938 n3460 n3567 0.25
r5939 n3566 n3567 1.1875
r5940 n3461 n3568 0.015625
r5941 n3567 n3568 1.0625
r5942 n3462 n3569 0.25
r5943 n3568 n3569 1.0625
r5944 n3463 n3570 0.013888888888888888
r5945 n3569 n3570 1.1875
r5946 n3464 n3571 0.25
r5947 n3570 n3571 1.1875
r5948 n3465 n3572 0.015625
r5949 n3571 n3572 1.0625
r5950 n3466 n3573 0.25
r5951 n3572 n3573 1.0625
r5952 n3467 n3574 0.013888888888888888
r5953 n3573 n3574 1.1875
r5954 n3468 n3575 0.25
r5955 n3574 n3575 1.1875
r5956 n3469 n3576 0.015625
r5957 n3575 n3576 1.0625
r5958 n3470 n3577 0.25
r5959 n3576 n3577 1.0625
r5960 n3471 n3578 0.013888888888888888
r5961 n3577 n3578 1.1875
r5962 n3472 n3579 0.25
r5963 n3578 n3579 1.1875
r5964 n3473 n3580 0.015625
r5965 n3579 n3580 1.0625
r5966 n3474 n3581 0.25
r5967 n3580 n3581 1.0625
r5968 n3475 n3582 0.013888888888888888
r5969 n3581 n3582 1.1875
r5970 n3476 n3583 0.25
r5971 n3582 n3583 1.1875
r5972 n3477 n3584 0.015625
r5973 n3583 n3584 1.0625
r5974 n3478 n3585 0.25
r5975 n3584 n3585 1.0625
r5976 n3479 n3586 0.013888888888888888
r5977 n3585 n3586 1.1875
r5978 n3480 n3587 0.25
r5979 n3586 n3587 1.1875
r5980 n3481 n3588 0.015625
r5981 n3587 n3588 1.0625
r5982 n3482 n3589 0.25
r5983 n3588 n3589 1.0625
r5984 n3483 n3590 0.041666666666666664
r5985 n3589 n3590 0.4375
r5986 n3484 n3591 0.043749999999999997
r5987 n3485 n3592 0.21875
r5988 n3591 n3592 0.14999999999999999
r5989 n3486 n3593 0.013671875
r5990 n3592 n3593 0.42499999999999999
r5991 n3487 n3594 0.21875
r5992 n3593 n3594 0.42499999999999999
r5993 n3488 n3595 0.012152777777777778
r5994 n3594 n3595 0.47499999999999998
r5995 n3489 n3596 0.21875
r5996 n3595 n3596 0.47499999999999998
r5997 n3490 n3597 0.033653846153846152
r5998 n3596 n3597 0.1875
r5999 n3491 n3598 0.036458333333333336
r6000 n3597 n3598 0.3125
r6001 n3492 n3599 0.0625
r6002 n3598 n3599 0.23749999999999999
r6003 n3493 n3600 0.21875
r6004 n3599 n3600 0.1125
r6005 n3494 n3601 0.109375
r6006 n3600 n3601 0.074999999999999997
r6007 n3495 n3602 0.048611111111111112
r6008 n3601 n3602 0.16250000000000001
r6009 n3496 n3603 0.020833333333333332
r6010 n3602 n3603 0.375
r6011 n3497 n3604 0.21875
r6012 n3603 n3604 0.28749999999999998
r6013 n3498 n3605 0.21875
r6014 n3604 n3605 0.050000000000000003
r6015 n3499 n3606 0.048611111111111112
r6016 n3605 n3606 0.13750000000000001
r6017 n3500 n3607 0.036458333333333336
r6018 n3606 n3607 0.26250000000000001
r6019 n3501 n3608 0.048611111111111112
r6020 n3607 n3608 0.26250000000000001
r6021 n3502 n3609 0.21875
r6022 n3608 n3609 0.13750000000000001
r6023 n3503 n3610 0.21875
r6024 n3609 n3610 0.050000000000000003
r6025 n3504 n3611 0.020833333333333332
r6026 n3610 n3611 0.28749999999999998
r6027 n3505 n3612 0.029166666666666667
r6028 n3611 n3612 0.45000000000000001
r6029 n3506 n3613 0.21875
r6030 n3612 n3613 0.21249999999999999
r6031 n3507 n3614 0.013671875
r6032 n3613 n3614 0.42499999999999999
r6033 n3508 n3615 0.21875
r6034 n3614 n3615 0.42499999999999999
r6035 n3509 n3616 0.036458333333333336
r6036 n3615 n3616 0.17499999999999999
r6037 n3510 n3617 0.043749999999999997
r6038 n3511 n3618 0.21875
r6039 n3617 n3618 0.14999999999999999
r6040 n3512 n3619 0.013671875
r6041 n3618 n3619 0.42499999999999999
r6042 n3513 n3620 0.21875
r6043 n3619 n3620 0.42499999999999999
r6044 n3514 n3621 0.012152777777777778
r6045 n3620 n3621 0.47499999999999998
r6046 n3515 n3622 0.21875
r6047 n3621 n3622 0.47499999999999998
r6048 n3516 n3623 0.013671875
r6049 n3622 n3623 0.42499999999999999
r6050 n3517 n3624 0.21875
r6051 n3623 n3624 0.42499999999999999
r6052 n3518 n3625 0.012152777777777778
r6053 n3624 n3625 0.47499999999999998
r6054 n3519 n3626 0.21875
r6055 n3625 n3626 0.47499999999999998
r6056 n3520 n3627 0.013671875
r6057 n3626 n3627 0.42499999999999999
r6058 n3521 n3628 0.21875
r6059 n3627 n3628 0.42499999999999999
r6060 n3522 n3629 0.012152777777777778
r6061 n3628 n3629 0.47499999999999998
r6062 n3523 n3630 0.21875
r6063 n3629 n3630 0.47499999999999998
r6064 n3524 n3631 0.013671875
r6065 n3630 n3631 0.42499999999999999
r6066 n3525 n3632 0.21875
r6067 n3631 n3632 0.42499999999999999
r6068 n3526 n3633 0.012152777777777778
r6069 n3632 n3633 0.47499999999999998
r6070 n3527 n3634 0.21875
r6071 n3633 n3634 0.47499999999999998
r6072 n3528 n3635 0.013671875
r6073 n3634 n3635 0.42499999999999999
r6074 n3529 n3636 0.21875
r6075 n3635 n3636 0.42499999999999999
r6076 n3530 n3637 0.012152777777777778
r6077 n3636 n3637 0.47499999999999998
r6078 n3531 n3638 0.21875
r6079 n3637 n3638 0.47499999999999998
r6080 n3532 n3639 0.013671875
r6081 n3638 n3639 0.42499999999999999
r6082 n3533 n3640 0.21875
r6083 n3639 n3640 0.42499999999999999
r6084 n3534 n3641 0.012152777777777778
r6085 n3640 n3641 0.47499999999999998
r6086 n3535 n3642 0.21875
r6087 n3641 n3642 0.47499999999999998
r6088 n3536 n3643 0.013671875
r6089 n3642 n3643 0.42499999999999999
r6090 n3537 n3644 0.21875
r6091 n3643 n3644 0.42499999999999999
r6092 n3538 n3645 0.012152777777777778
r6093 n3644 n3645 0.47499999999999998
r6094 n3539 n3646 0.21875
r6095 n3645 n3646 0.47499999999999998
r6096 n3540 n3647 0.013671875
r6097 n3646 n3647 0.42499999999999999
r6098 n3541 n3648 0.21875
r6099 n3647 n3648 0.42499999999999999
r6100 n3542 n3649 0.029166666666666667
r6101 n3648 n3649 0.21249999999999999
r6102 n3543 n3650 0.036458333333333336
r6103 n3649 n3650 0.33750000000000002
r6104 n3544 n3651 0.048611111111111112
r6105 n3650 n3651 0.26250000000000001
r6106 n3545 n3652 0.21875
r6107 n3651 n3652 0.13750000000000001
r6108 n3546 n3653 0.21875
r6109 n3652 n3653 0.050000000000000003
r6110 n3547 n3654 0.0546875
r6111 n3653 n3654 0.125
r6112 n3548 n3655 0.019886363636363636
r6113 n3654 n3655 0.375
r6114 n3549 n3656 0.4375
r6115 n3655 n3656 0.28749999999999998
r6116 n3550 n3657 0.4375
r6117 n3656 n3657 0.025000000000000001
r6118 n3551 n3658 0.4375
r6119 n3657 n3658 0.025000000000000001
r6120 n3552 n3659 0.043749999999999997
r6121 n3658 n3659 0.13750000000000001
r6122 n3553 n3660 0.036458333333333336
r6123 n3659 n3660 0.27500000000000002
r6124 n3554 n3661 0.0546875
r6125 n3660 n3661 0.25
r6126 n3555 n3662 0.21875
r6127 n3661 n3662 0.125
r6128 n3556 n3663 0.14583333333333334
r6129 n3662 n3663 0.0625
r6130 n3557 n3664 0.21875
r6131 n3663 n3664 0.0625
r6132 n3558 n3665 0.072916666666666671
r6133 n3664 n3665 0.10000000000000001
r6134 n3559 n3666 0.036458333333333336
r6135 n3665 n3666 0.22500000000000001
r6136 n3560 n3667 0.03125
r6137 n3666 n3667 0.32500000000000001
r6138 n3561 n3668 0.21875
r6139 n3667 n3668 0.20000000000000001
r6140 n3562 n3669 0.012152777777777778
r6141 n3668 n3669 0.47499999999999998
r6142 n3563 n3670 0.21875
r6143 n3669 n3670 0.47499999999999998
r6144 n3564 n3671 0.013671875
r6145 n3670 n3671 0.42499999999999999
r6146 n3565 n3672 0.21875
r6147 n3671 n3672 0.42499999999999999
r6148 n3566 n3673 0.012152777777777778
r6149 n3672 n3673 0.47499999999999998
r6150 n3567 n3674 0.21875
r6151 n3673 n3674 0.47499999999999998
r6152 n3568 n3675 0.013671875
r6153 n3674 n3675 0.42499999999999999
r6154 n3569 n3676 0.21875
r6155 n3675 n3676 0.42499999999999999
r6156 n3570 n3677 0.012152777777777778
r6157 n3676 n3677 0.47499999999999998
r6158 n3571 n3678 0.21875
r6159 n3677 n3678 0.47499999999999998
r6160 n3572 n3679 0.013671875
r6161 n3678 n3679 0.42499999999999999
r6162 n3573 n3680 0.21875
r6163 n3679 n3680 0.42499999999999999
r6164 n3574 n3681 0.012152777777777778
r6165 n3680 n3681 0.47499999999999998
r6166 n3575 n3682 0.21875
r6167 n3681 n3682 0.47499999999999998
r6168 n3576 n3683 0.013671875
r6169 n3682 n3683 0.42499999999999999
r6170 n3577 n3684 0.21875
r6171 n3683 n3684 0.42499999999999999
r6172 n3578 n3685 0.012152777777777778
r6173 n3684 n3685 0.47499999999999998
r6174 n3579 n3686 0.21875
r6175 n3685 n3686 0.47499999999999998
r6176 n3580 n3687 0.013671875
r6177 n3686 n3687 0.42499999999999999
r6178 n3581 n3688 0.21875
r6179 n3687 n3688 0.42499999999999999
r6180 n3582 n3689 0.012152777777777778
r6181 n3688 n3689 0.47499999999999998
r6182 n3583 n3690 0.21875
r6183 n3689 n3690 0.47499999999999998
r6184 n3584 n3691 0.013671875
r6185 n3690 n3691 0.42499999999999999
r6186 n3585 n3692 0.21875
r6187 n3691 n3692 0.42499999999999999
r6188 n3586 n3693 0.012152777777777778
r6189 n3692 n3693 0.47499999999999998
r6190 n3587 n3694 0.21875
r6191 n3693 n3694 0.47499999999999998
r6192 n3588 n3695 0.013671875
r6193 n3694 n3695 0.42499999999999999
r6194 n3589 n3696 0.21875
r6195 n3695 n3696 0.42499999999999999
r6196 n3590 n3697 0.036458333333333336
r6197 n3696 n3697 0.17499999999999999
r6198 n3591 n3698 0.125
r6199 n3592 n3699 0.625
r6200 n3698 n3699 0.050000000000000003
r6201 n3593 n3700 0.0390625
r6202 n3699 n3700 0.14166666666666666
r6203 n3594 n3701 0.625
r6204 n3700 n3701 0.14166666666666666
r6205 n3595 n3702 0.034722222222222224
r6206 n3701 n3702 0.15833333333333333
r6207 n3596 n3703 0.625
r6208 n3702 n3703 0.15833333333333333
r6209 n3597 n3704 0.096153846153846159
r6210 n3703 n3704 0.0625
r6211 n3598 n3705 0.10416666666666667
r6212 n3704 n3705 0.10416666666666667
r6213 n3599 n3706 0.17857142857142858
r6214 n3705 n3706 0.079166666666666663
r6215 n3600 n3707 0.625
r6216 n3706 n3707 0.037499999999999999
r6217 n3601 n3708 0.3125
r6218 n3707 n3708 0.025000000000000001
r6219 n3602 n3709 0.1388888888888889
r6220 n3708 n3709 0.054166666666666669
r6221 n3603 n3710 0.059523809523809521
r6222 n3709 n3710 0.125
r6223 n3604 n3711 0.625
r6224 n3710 n3711 0.09583333333333334
r6225 n3605 n3712 0.625
r6226 n3711 n3712 0.016666666666666666
r6227 n3606 n3713 0.1388888888888889
r6228 n3712 n3713 0.04583333333333333
r6229 n3607 n3714 0.10416666666666667
r6230 n3713 n3714 0.087499999999999994
r6231 n3608 n3715 0.1388888888888889
r6232 n3714 n3715 0.087499999999999994
r6233 n3609 n3716 0.625
r6234 n3715 n3716 0.04583333333333333
r6235 n3610 n3717 0.625
r6236 n3716 n3717 0.016666666666666666
r6237 n3611 n3718 0.059523809523809521
r6238 n3717 n3718 0.09583333333333334
r6239 n3612 n3719 0.083333333333333329
r6240 n3718 n3719 0.14999999999999999
r6241 n3613 n3720 0.625
r6242 n3719 n3720 0.070833333333333331
r6243 n3614 n3721 0.0390625
r6244 n3720 n3721 0.14166666666666666
r6245 n3615 n3722 0.625
r6246 n3721 n3722 0.14166666666666666
r6247 n3616 n3723 0.10416666666666667
r6248 n3722 n3723 0.058333333333333334
r6249 n3617 n3724 0.125
r6250 n3618 n3725 0.625
r6251 n3724 n3725 0.050000000000000003
r6252 n3619 n3726 0.0390625
r6253 n3725 n3726 0.14166666666666666
r6254 n3620 n3727 0.625
r6255 n3726 n3727 0.14166666666666666
r6256 n3621 n3728 0.034722222222222224
r6257 n3727 n3728 0.15833333333333333
r6258 n3622 n3729 0.625
r6259 n3728 n3729 0.15833333333333333
r6260 n3623 n3730 0.0390625
r6261 n3729 n3730 0.14166666666666666
r6262 n3624 n3731 0.625
r6263 n3730 n3731 0.14166666666666666
r6264 n3625 n3732 0.034722222222222224
r6265 n3731 n3732 0.15833333333333333
r6266 n3626 n3733 0.625
r6267 n3732 n3733 0.15833333333333333
r6268 n3627 n3734 0.0390625
r6269 n3733 n3734 0.14166666666666666
r6270 n3628 n3735 0.625
r6271 n3734 n3735 0.14166666666666666
r6272 n3629 n3736 0.034722222222222224
r6273 n3735 n3736 0.15833333333333333
r6274 n3630 n3737 0.625
r6275 n3736 n3737 0.15833333333333333
r6276 n3631 n3738 0.0390625
r6277 n3737 n3738 0.14166666666666666
r6278 n3632 n3739 0.625
r6279 n3738 n3739 0.14166666666666666
r6280 n3633 n3740 0.034722222222222224
r6281 n3739 n3740 0.15833333333333333
r6282 n3634 n3741 0.625
r6283 n3740 n3741 0.15833333333333333
r6284 n3635 n3742 0.0390625
r6285 n3741 n3742 0.14166666666666666
r6286 n3636 n3743 0.625
r6287 n3742 n3743 0.14166666666666666
r6288 n3637 n3744 0.034722222222222224
r6289 n3743 n3744 0.15833333333333333
r6290 n3638 n3745 0.625
r6291 n3744 n3745 0.15833333333333333
r6292 n3639 n3746 0.0390625
r6293 n3745 n3746 0.14166666666666666
r6294 n3640 n3747 0.625
r6295 n3746 n3747 0.14166666666666666
r6296 n3641 n3748 0.034722222222222224
r6297 n3747 n3748 0.15833333333333333
r6298 n3642 n3749 0.625
r6299 n3748 n3749 0.15833333333333333
r6300 n3643 n3750 0.0390625
r6301 n3749 n3750 0.14166666666666666
r6302 n3644 n3751 0.625
r6303 n3750 n3751 0.14166666666666666
r6304 n3645 n3752 0.034722222222222224
r6305 n3751 n3752 0.15833333333333333
r6306 n3646 n3753 0.625
r6307 n3752 n3753 0.15833333333333333
r6308 n3647 n3754 0.0390625
r6309 n3753 n3754 0.14166666666666666
r6310 n3648 n3755 0.625
r6311 n3754 n3755 0.14166666666666666
r6312 n3649 n3756 0.083333333333333329
r6313 n3755 n3756 0.070833333333333331
r6314 n3650 n3757 0.10416666666666667
r6315 n3756 n3757 0.1125
r6316 n3651 n3758 0.1388888888888889
r6317 n3757 n3758 0.087499999999999994
r6318 n3652 n3759 0.625
r6319 n3758 n3759 0.04583333333333333
r6320 n3653 n3760 0.625
r6321 n3759 n3760 0.016666666666666666
r6322 n3654 n3761 0.15625
r6323 n3760 n3761 0.041666666666666664
r6324 n3655 n3762 0.056818181818181816
r6325 n3761 n3762 0.125
r6326 n3656 n3763 1.25
r6327 n3762 n3763 0.09583333333333334
r6328 n3657 n3764 1.25
r6329 n3763 n3764 0.0083333333333333332
r6330 n3658 n3765 1.25
r6331 n3764 n3765 0.0083333333333333332
r6332 n3659 n3766 0.125
r6333 n3765 n3766 0.04583333333333333
r6334 n3660 n3767 0.10416666666666667
r6335 n3766 n3767 0.09166666666666666
r6336 n3661 n3768 0.15625
r6337 n3767 n3768 0.083333333333333329
r6338 n3662 n3769 0.625
r6339 n3768 n3769 0.041666666666666664
r6340 n3663 n3770 0.41666666666666669
r6341 n3769 n3770 0.020833333333333332
r6342 n3664 n3771 0.625
r6343 n3770 n3771 0.020833333333333332
r6344 n3665 n3772 0.20833333333333334
r6345 n3771 n3772 0.033333333333333333
r6346 n3666 n3773 0.10416666666666667
r6347 n3772 n3773 0.074999999999999997
r6348 n3667 n3774 0.089285714285714288
r6349 n3773 n3774 0.10833333333333334
r6350 n3668 n3775 0.625
r6351 n3774 n3775 0.066666666666666666
r6352 n3669 n3776 0.034722222222222224
r6353 n3775 n3776 0.15833333333333333
r6354 n3670 n3777 0.625
r6355 n3776 n3777 0.15833333333333333
r6356 n3671 n3778 0.0390625
r6357 n3777 n3778 0.14166666666666666
r6358 n3672 n3779 0.625
r6359 n3778 n3779 0.14166666666666666
r6360 n3673 n3780 0.034722222222222224
r6361 n3779 n3780 0.15833333333333333
r6362 n3674 n3781 0.625
r6363 n3780 n3781 0.15833333333333333
r6364 n3675 n3782 0.0390625
r6365 n3781 n3782 0.14166666666666666
r6366 n3676 n3783 0.625
r6367 n3782 n3783 0.14166666666666666
r6368 n3677 n3784 0.034722222222222224
r6369 n3783 n3784 0.15833333333333333
r6370 n3678 n3785 0.625
r6371 n3784 n3785 0.15833333333333333
r6372 n3679 n3786 0.0390625
r6373 n3785 n3786 0.14166666666666666
r6374 n3680 n3787 0.625
r6375 n3786 n3787 0.14166666666666666
r6376 n3681 n3788 0.034722222222222224
r6377 n3787 n3788 0.15833333333333333
r6378 n3682 n3789 0.625
r6379 n3788 n3789 0.15833333333333333
r6380 n3683 n3790 0.0390625
r6381 n3789 n3790 0.14166666666666666
r6382 n3684 n3791 0.625
r6383 n3790 n3791 0.14166666666666666
r6384 n3685 n3792 0.034722222222222224
r6385 n3791 n3792 0.15833333333333333
r6386 n3686 n3793 0.625
r6387 n3792 n3793 0.15833333333333333
r6388 n3687 n3794 0.0390625
r6389 n3793 n3794 0.14166666666666666
r6390 n3688 n3795 0.625
r6391 n3794 n3795 0.14166666666666666
r6392 n3689 n3796 0.034722222222222224
r6393 n3795 n3796 0.15833333333333333
r6394 n3690 n3797 0.625
r6395 n3796 n3797 0.15833333333333333
r6396 n3691 n3798 0.0390625
r6397 n3797 n3798 0.14166666666666666
r6398 n3692 n3799 0.625
r6399 n3798 n3799 0.14166666666666666
r6400 n3693 n3800 0.034722222222222224
r6401 n3799 n3800 0.15833333333333333
r6402 n3694 n3801 0.625
r6403 n3800 n3801 0.15833333333333333
r6404 n3695 n3802 0.0390625
r6405 n3801 n3802 0.14166666666666666
r6406 n3696 n3803 0.625
r6407 n3802 n3803 0.14166666666666666
r6408 n3697 n3804 0.10416666666666667
r6409 n3803 n3804 0.058333333333333334
r6410 n3698 n3805 0.1125
r6411 n3699 n3806 0.5625
r6412 n3805 n3806 0.25
r6413 n3700 n3807 0.03515625
r6414 n3806 n3807 0.70833333333333337
r6415 n3701 n3808 0.5625
r6416 n3807 n3808 0.70833333333333337
r6417 n3702 n3809 0.03125
r6418 n3808 n3809 0.79166666666666663
r6419 n3703 n3810 0.5625
r6420 n3809 n3810 0.79166666666666663
r6421 n3704 n3811 0.086538461538461536
r6422 n3810 n3811 0.3125
r6423 n3705 n3812 0.09375
r6424 n3811 n3812 0.52083333333333337
r6425 n3706 n3813 0.16071428571428573
r6426 n3812 n3813 0.39583333333333331
r6427 n3707 n3814 0.5625
r6428 n3813 n3814 0.1875
r6429 n3708 n3815 0.28125
r6430 n3814 n3815 0.125
r6431 n3709 n3816 0.125
r6432 n3815 n3816 0.27083333333333331
r6433 n3710 n3817 0.053571428571428568
r6434 n3816 n3817 0.625
r6435 n3711 n3818 0.5625
r6436 n3817 n3818 0.47916666666666669
r6437 n3712 n3819 0.5625
r6438 n3818 n3819 0.083333333333333329
r6439 n3713 n3820 0.125
r6440 n3819 n3820 0.22916666666666666
r6441 n3714 n3821 0.09375
r6442 n3820 n3821 0.4375
r6443 n3715 n3822 0.125
r6444 n3821 n3822 0.4375
r6445 n3716 n3823 0.5625
r6446 n3822 n3823 0.22916666666666666
r6447 n3717 n3824 0.5625
r6448 n3823 n3824 0.083333333333333329
r6449 n3718 n3825 0.053571428571428568
r6450 n3824 n3825 0.47916666666666669
r6451 n3719 n3826 0.074999999999999997
r6452 n3825 n3826 0.75
r6453 n3720 n3827 0.5625
r6454 n3826 n3827 0.35416666666666669
r6455 n3721 n3828 0.03515625
r6456 n3827 n3828 0.70833333333333337
r6457 n3722 n3829 0.5625
r6458 n3828 n3829 0.70833333333333337
r6459 n3723 n3830 0.09375
r6460 n3829 n3830 0.29166666666666669
r6461 n3724 n3831 0.1125
r6462 n3725 n3832 0.5625
r6463 n3831 n3832 0.25
r6464 n3726 n3833 0.03515625
r6465 n3832 n3833 0.70833333333333337
r6466 n3727 n3834 0.5625
r6467 n3833 n3834 0.70833333333333337
r6468 n3728 n3835 0.03125
r6469 n3834 n3835 0.79166666666666663
r6470 n3729 n3836 0.5625
r6471 n3835 n3836 0.79166666666666663
r6472 n3730 n3837 0.03515625
r6473 n3836 n3837 0.70833333333333337
r6474 n3731 n3838 0.5625
r6475 n3837 n3838 0.70833333333333337
r6476 n3732 n3839 0.03125
r6477 n3838 n3839 0.79166666666666663
r6478 n3733 n3840 0.5625
r6479 n3839 n3840 0.79166666666666663
r6480 n3734 n3841 0.03515625
r6481 n3840 n3841 0.70833333333333337
r6482 n3735 n3842 0.5625
r6483 n3841 n3842 0.70833333333333337
r6484 n3736 n3843 0.03125
r6485 n3842 n3843 0.79166666666666663
r6486 n3737 n3844 0.5625
r6487 n3843 n3844 0.79166666666666663
r6488 n3738 n3845 0.03515625
r6489 n3844 n3845 0.70833333333333337
r6490 n3739 n3846 0.5625
r6491 n3845 n3846 0.70833333333333337
r6492 n3740 n3847 0.03125
r6493 n3846 n3847 0.79166666666666663
r6494 n3741 n3848 0.5625
r6495 n3847 n3848 0.79166666666666663
r6496 n3742 n3849 0.03515625
r6497 n3848 n3849 0.70833333333333337
r6498 n3743 n3850 0.5625
r6499 n3849 n3850 0.70833333333333337
r6500 n3744 n3851 0.03125
r6501 n3850 n3851 0.79166666666666663
r6502 n3745 n3852 0.5625
r6503 n3851 n3852 0.79166666666666663
r6504 n3746 n3853 0.03515625
r6505 n3852 n3853 0.70833333333333337
r6506 n3747 n3854 0.5625
r6507 n3853 n3854 0.70833333333333337
r6508 n3748 n3855 0.03125
r6509 n3854 n3855 0.79166666666666663
r6510 n3749 n3856 0.5625
r6511 n3855 n3856 0.79166666666666663
r6512 n3750 n3857 0.03515625
r6513 n3856 n3857 0.70833333333333337
r6514 n3751 n3858 0.5625
r6515 n3857 n3858 0.70833333333333337
r6516 n3752 n3859 0.03125
r6517 n3858 n3859 0.79166666666666663
r6518 n3753 n3860 0.5625
r6519 n3859 n3860 0.79166666666666663
r6520 n3754 n3861 0.03515625
r6521 n3860 n3861 0.70833333333333337
r6522 n3755 n3862 0.5625
r6523 n3861 n3862 0.70833333333333337
r6524 n3756 n3863 0.074999999999999997
r6525 n3862 n3863 0.35416666666666669
r6526 n3757 n3864 0.09375
r6527 n3863 n3864 0.5625
r6528 n3758 n3865 0.125
r6529 n3864 n3865 0.4375
r6530 n3759 n3866 0.5625
r6531 n3865 n3866 0.22916666666666666
r6532 n3760 n3867 0.5625
r6533 n3866 n3867 0.083333333333333329
r6534 n3761 n3868 0.140625
r6535 n3867 n3868 0.20833333333333334
r6536 n3762 n3869 0.05113636363636364
r6537 n3868 n3869 0.625
r6538 n3763 n3870 1.125
r6539 n3869 n3870 0.47916666666666669
r6540 n3764 n3871 1.125
r6541 n3870 n3871 0.041666666666666664
r6542 n3765 n3872 1.125
r6543 n3871 n3872 0.041666666666666664
r6544 n3766 n3873 0.1125
r6545 n3872 n3873 0.22916666666666666
r6546 n3767 n3874 0.09375
r6547 n3873 n3874 0.45833333333333331
r6548 n3768 n3875 0.140625
r6549 n3874 n3875 0.41666666666666669
r6550 n3769 n3876 0.5625
r6551 n3875 n3876 0.20833333333333334
r6552 n3770 n3877 0.375
r6553 n3876 n3877 0.10416666666666667
r6554 n3771 n3878 0.5625
r6555 n3877 n3878 0.10416666666666667
r6556 n3772 n3879 0.1875
r6557 n3878 n3879 0.16666666666666666
r6558 n3773 n3880 0.09375
r6559 n3879 n3880 0.375
r6560 n3774 n3881 0.080357142857142863
r6561 n3880 n3881 0.54166666666666663
r6562 n3775 n3882 0.5625
r6563 n3881 n3882 0.33333333333333331
r6564 n3776 n3883 0.03125
r6565 n3882 n3883 0.79166666666666663
r6566 n3777 n3884 0.5625
r6567 n3883 n3884 0.79166666666666663
r6568 n3778 n3885 0.03515625
r6569 n3884 n3885 0.70833333333333337
r6570 n3779 n3886 0.5625
r6571 n3885 n3886 0.70833333333333337
r6572 n3780 n3887 0.03125
r6573 n3886 n3887 0.79166666666666663
r6574 n3781 n3888 0.5625
r6575 n3887 n3888 0.79166666666666663
r6576 n3782 n3889 0.03515625
r6577 n3888 n3889 0.70833333333333337
r6578 n3783 n3890 0.5625
r6579 n3889 n3890 0.70833333333333337
r6580 n3784 n3891 0.03125
r6581 n3890 n3891 0.79166666666666663
r6582 n3785 n3892 0.5625
r6583 n3891 n3892 0.79166666666666663
r6584 n3786 n3893 0.03515625
r6585 n3892 n3893 0.70833333333333337
r6586 n3787 n3894 0.5625
r6587 n3893 n3894 0.70833333333333337
r6588 n3788 n3895 0.03125
r6589 n3894 n3895 0.79166666666666663
r6590 n3789 n3896 0.5625
r6591 n3895 n3896 0.79166666666666663
r6592 n3790 n3897 0.03515625
r6593 n3896 n3897 0.70833333333333337
r6594 n3791 n3898 0.5625
r6595 n3897 n3898 0.70833333333333337
r6596 n3792 n3899 0.03125
r6597 n3898 n3899 0.79166666666666663
r6598 n3793 n3900 0.5625
r6599 n3899 n3900 0.79166666666666663
r6600 n3794 n3901 0.03515625
r6601 n3900 n3901 0.70833333333333337
r6602 n3795 n3902 0.5625
r6603 n3901 n3902 0.70833333333333337
r6604 n3796 n3903 0.03125
r6605 n3902 n3903 0.79166666666666663
r6606 n3797 n3904 0.5625
r6607 n3903 n3904 0.79166666666666663
r6608 n3798 n3905 0.03515625
r6609 n3904 n3905 0.70833333333333337
r6610 n3799 n3906 0.5625
r6611 n3905 n3906 0.70833333333333337
r6612 n3800 n3907 0.03125
r6613 n3906 n3907 0.79166666666666663
r6614 n3801 n3908 0.5625
r6615 n3907 n3908 0.79166666666666663
r6616 n3802 n3909 0.03515625
r6617 n3908 n3909 0.70833333333333337
r6618 n3803 n3910 0.5625
r6619 n3909 n3910 0.70833333333333337
r6620 n3804 n3911 0.09375
r6621 n3910 n3911 0.29166666666666669
r6622 n3805 n3912 0.043749999999999997
r6623 n3806 n3913 0.21875
r6624 n3912 n3913 0.1875
r6625 n3807 n3914 0.013671875
r6626 n3913 n3914 0.53125
r6627 n3808 n3915 0.21875
r6628 n3914 n3915 0.53125
r6629 n3809 n3916 0.012152777777777778
r6630 n3915 n3916 0.59375
r6631 n3810 n3917 0.21875
r6632 n3916 n3917 0.59375
r6633 n3811 n3918 0.033653846153846152
r6634 n3917 n3918 0.234375
r6635 n3812 n3919 0.036458333333333336
r6636 n3918 n3919 0.390625
r6637 n3813 n3920 0.0625
r6638 n3919 n3920 0.296875
r6639 n3814 n3921 0.21875
r6640 n3920 n3921 0.140625
r6641 n3815 n3922 0.109375
r6642 n3921 n3922 0.09375
r6643 n3816 n3923 0.048611111111111112
r6644 n3922 n3923 0.203125
r6645 n3817 n3924 0.020833333333333332
r6646 n3923 n3924 0.46875
r6647 n3818 n3925 0.21875
r6648 n3924 n3925 0.359375
r6649 n3819 n3926 0.21875
r6650 n3925 n3926 0.0625
r6651 n3820 n3927 0.048611111111111112
r6652 n3926 n3927 0.171875
r6653 n3821 n3928 0.036458333333333336
r6654 n3927 n3928 0.328125
r6655 n3822 n3929 0.048611111111111112
r6656 n3928 n3929 0.328125
r6657 n3823 n3930 0.21875
r6658 n3929 n3930 0.171875
r6659 n3824 n3931 0.21875
r6660 n3930 n3931 0.0625
r6661 n3825 n3932 0.020833333333333332
r6662 n3931 n3932 0.359375
r6663 n3826 n3933 0.029166666666666667
r6664 n3932 n3933 0.5625
r6665 n3827 n3934 0.21875
r6666 n3933 n3934 0.265625
r6667 n3828 n3935 0.013671875
r6668 n3934 n3935 0.53125
r6669 n3829 n3936 0.21875
r6670 n3935 n3936 0.53125
r6671 n3830 n3937 0.036458333333333336
r6672 n3936 n3937 0.21875
r6673 n3938 n3939 0.09375
r6674 n3939 n3940 0.078125
r6675 n3940 n3941 0.15625
r6676 n3941 n3942 0.46875
r6677 n3942 n3943 0.375
r6678 n3943 n3944 0.078125
r6679 n3944 n3945 0.09375
r6680 n3831 n3946 0.043749999999999997
r6681 n3832 n3947 0.21875
r6682 n3946 n3947 0.1875
r6683 n3833 n3948 0.013671875
r6684 n3947 n3948 0.53125
r6685 n3834 n3949 0.21875
r6686 n3948 n3949 0.53125
r6687 n3835 n3950 0.012152777777777778
r6688 n3949 n3950 0.59375
r6689 n3836 n3951 0.21875
r6690 n3950 n3951 0.59375
r6691 n3837 n3952 0.013671875
r6692 n3951 n3952 0.53125
r6693 n3838 n3953 0.21875
r6694 n3952 n3953 0.53125
r6695 n3839 n3954 0.012152777777777778
r6696 n3953 n3954 0.59375
r6697 n3840 n3955 0.21875
r6698 n3954 n3955 0.59375
r6699 n3841 n3956 0.013671875
r6700 n3955 n3956 0.53125
r6701 n3842 n3957 0.21875
r6702 n3956 n3957 0.53125
r6703 n3843 n3958 0.012152777777777778
r6704 n3957 n3958 0.59375
r6705 n3844 n3959 0.21875
r6706 n3958 n3959 0.59375
r6707 n3845 n3960 0.013671875
r6708 n3959 n3960 0.53125
r6709 n3846 n3961 0.21875
r6710 n3960 n3961 0.53125
r6711 n3847 n3962 0.012152777777777778
r6712 n3961 n3962 0.59375
r6713 n3848 n3963 0.21875
r6714 n3962 n3963 0.59375
r6715 n3849 n3964 0.013671875
r6716 n3963 n3964 0.53125
r6717 n3850 n3965 0.21875
r6718 n3964 n3965 0.53125
r6719 n3851 n3966 0.012152777777777778
r6720 n3965 n3966 0.59375
r6721 n3852 n3967 0.21875
r6722 n3966 n3967 0.59375
r6723 n3853 n3968 0.013671875
r6724 n3967 n3968 0.53125
r6725 n3854 n3969 0.21875
r6726 n3968 n3969 0.53125
r6727 n3855 n3970 0.012152777777777778
r6728 n3969 n3970 0.59375
r6729 n3856 n3971 0.21875
r6730 n3970 n3971 0.59375
r6731 n3857 n3972 0.013671875
r6732 n3971 n3972 0.53125
r6733 n3858 n3973 0.21875
r6734 n3972 n3973 0.53125
r6735 n3859 n3974 0.012152777777777778
r6736 n3973 n3974 0.59375
r6737 n3860 n3975 0.21875
r6738 n3974 n3975 0.59375
r6739 n3861 n3976 0.013671875
r6740 n3975 n3976 0.53125
r6741 n3862 n3977 0.21875
r6742 n3976 n3977 0.53125
r6743 n3863 n3978 0.029166666666666667
r6744 n3977 n3978 0.265625
r6745 n3864 n3979 0.036458333333333336
r6746 n3978 n3979 0.421875
r6747 n3865 n3980 0.048611111111111112
r6748 n3979 n3980 0.328125
r6749 n3866 n3981 0.21875
r6750 n3980 n3981 0.171875
r6751 n3867 n3982 0.21875
r6752 n3981 n3982 0.0625
r6753 n3868 n3983 0.0546875
r6754 n3982 n3983 0.15625
r6755 n3869 n3984 0.019886363636363636
r6756 n3983 n3984 0.46875
r6757 n3870 n3985 0.4375
r6758 n3984 n3985 0.359375
r6759 n3871 n3986 0.4375
r6760 n3985 n3986 0.03125
r6761 n3872 n3987 0.4375
r6762 n3986 n3987 0.03125
r6763 n3873 n3988 0.043749999999999997
r6764 n3987 n3988 0.171875
r6765 n3874 n3989 0.036458333333333336
r6766 n3988 n3989 0.34375
r6767 n3875 n3990 0.0546875
r6768 n3989 n3990 0.3125
r6769 n3876 n3991 0.21875
r6770 n3990 n3991 0.15625
r6771 n3877 n3992 0.14583333333333334
r6772 n3991 n3992 0.078125
r6773 n3878 n3993 0.21875
r6774 n3992 n3993 0.078125
r6775 n3879 n3994 0.072916666666666671
r6776 n3993 n3994 0.125
r6777 n3880 n3995 0.036458333333333336
r6778 n3994 n3995 0.28125
r6779 n3881 n3996 0.03125
r6780 n3995 n3996 0.40625
r6781 n3882 n3997 0.21875
r6782 n3996 n3997 0.25
r6783 n3883 n3998 0.012152777777777778
r6784 n3997 n3998 0.59375
r6785 n3884 n3999 0.21875
r6786 n3998 n3999 0.59375
r6787 n3885 n4000 0.013671875
r6788 n3999 n4000 0.53125
r6789 n3886 n4001 0.21875
r6790 n4000 n4001 0.53125
r6791 n3887 n4002 0.012152777777777778
r6792 n4001 n4002 0.59375
r6793 n3888 n4003 0.21875
r6794 n4002 n4003 0.59375
r6795 n3889 n4004 0.013671875
r6796 n4003 n4004 0.53125
r6797 n3890 n4005 0.21875
r6798 n4004 n4005 0.53125
r6799 n3891 n4006 0.012152777777777778
r6800 n4005 n4006 0.59375
r6801 n3892 n4007 0.21875
r6802 n4006 n4007 0.59375
r6803 n3893 n4008 0.013671875
r6804 n4007 n4008 0.53125
r6805 n3894 n4009 0.21875
r6806 n4008 n4009 0.53125
r6807 n3895 n4010 0.012152777777777778
r6808 n4009 n4010 0.59375
r6809 n3896 n4011 0.21875
r6810 n4010 n4011 0.59375
r6811 n3897 n4012 0.013671875
r6812 n4011 n4012 0.53125
r6813 n3898 n4013 0.21875
r6814 n4012 n4013 0.53125
r6815 n3899 n4014 0.012152777777777778
r6816 n4013 n4014 0.59375
r6817 n3900 n4015 0.21875
r6818 n4014 n4015 0.59375
r6819 n3901 n4016 0.013671875
r6820 n4015 n4016 0.53125
r6821 n3902 n4017 0.21875
r6822 n4016 n4017 0.53125
r6823 n3903 n4018 0.012152777777777778
r6824 n4017 n4018 0.59375
r6825 n3904 n4019 0.21875
r6826 n4018 n4019 0.59375
r6827 n3905 n4020 0.013671875
r6828 n4019 n4020 0.53125
r6829 n3906 n4021 0.21875
r6830 n4020 n4021 0.53125
r6831 n3907 n4022 0.012152777777777778
r6832 n4021 n4022 0.59375
r6833 n3908 n4023 0.21875
r6834 n4022 n4023 0.59375
r6835 n3909 n4024 0.013671875
r6836 n4023 n4024 0.53125
r6837 n3910 n4025 0.21875
r6838 n4024 n4025 0.53125
r6839 n3911 n4026 0.036458333333333336
r6840 n4025 n4026 0.21875
r6841 n4027 n4028 0.09375
r6842 n4028 n4029 0.078125
r6843 n4029 n4030 0.203125
r6844 n4030 n4031 0.46875
r6845 n4031 n4032 0.328125
r6846 n4032 n4033 0.078125
r6847 n4033 n4034 0.09375
r6848 n3912 n4035 0.043749999999999997
r6849 n3913 n4036 0.21875
r6850 n4035 n4036 0.25
r6851 n3914 n4037 0.013671875
r6852 n4036 n4037 0.70833333333333337
r6853 n3915 n4038 0.21875
r6854 n4037 n4038 0.70833333333333337
r6855 n3916 n4039 0.012152777777777778
r6856 n4038 n4039 0.79166666666666663
r6857 n3917 n4040 0.21875
r6858 n4039 n4040 0.79166666666666663
r6859 n3918 n4041 0.033653846153846152
r6860 n4040 n4041 0.3125
r6861 n3919 n4042 0.036458333333333336
r6862 n4041 n4042 0.52083333333333337
r6863 n3920 n4043 0.0625
r6864 n4042 n4043 0.39583333333333331
r6865 n3921 n4044 0.21875
r6866 n4043 n4044 0.1875
r6867 n3922 n4045 0.109375
r6868 n4044 n4045 0.125
r6869 n3923 n4046 0.048611111111111112
r6870 n4045 n4046 0.27083333333333331
r6871 n3924 n4047 0.020833333333333332
r6872 n4046 n4047 0.625
r6873 n3925 n4048 0.21875
r6874 n4047 n4048 0.47916666666666669
r6875 n3926 n4049 0.21875
r6876 n4048 n4049 0.083333333333333329
r6877 n3927 n4050 0.048611111111111112
r6878 n4049 n4050 0.22916666666666666
r6879 n3928 n4051 0.036458333333333336
r6880 n4050 n4051 0.4375
r6881 n3929 n4052 0.048611111111111112
r6882 n4051 n4052 0.4375
r6883 n3930 n4053 0.21875
r6884 n4052 n4053 0.22916666666666666
r6885 n3931 n4054 0.21875
r6886 n4053 n4054 0.083333333333333329
r6887 n3932 n4055 0.020833333333333332
r6888 n4054 n4055 0.47916666666666669
r6889 n3933 n4056 0.029166666666666667
r6890 n4055 n4056 0.75
r6891 n3934 n4057 0.21875
r6892 n4056 n4057 0.35416666666666669
r6893 n3935 n4058 0.013671875
r6894 n4057 n4058 0.70833333333333337
r6895 n3936 n4059 0.21875
r6896 n4058 n4059 0.70833333333333337
r6897 n3937 n4060 0.036458333333333336
r6898 n4059 n4060 0.29166666666666669
r6899 n3938 n4061 0.14583333333333334
r6900 n3939 n4062 0.14583333333333334
r6901 n4061 n4062 0.125
r6902 n3940 n4063 0.21875
r6903 n4062 n4063 0.10416666666666667
r6904 n3941 n4064 0.0546875
r6905 n4063 n4064 0.20833333333333334
r6906 n3942 n4065 0.019886363636363636
r6907 n4064 n4065 0.625
r6908 n3943 n4066 0.21875
r6909 n4065 n4066 0.5
r6910 n3944 n4067 0.14583333333333334
r6911 n4066 n4067 0.10416666666666667
r6912 n3945 n4068 0.14583333333333334
r6913 n4067 n4068 0.125
r6914 n3946 n4069 0.043749999999999997
r6915 n3947 n4070 0.21875
r6916 n4069 n4070 0.25
r6917 n3948 n4071 0.013671875
r6918 n4070 n4071 0.70833333333333337
r6919 n3949 n4072 0.21875
r6920 n4071 n4072 0.70833333333333337
r6921 n3950 n4073 0.012152777777777778
r6922 n4072 n4073 0.79166666666666663
r6923 n3951 n4074 0.21875
r6924 n4073 n4074 0.79166666666666663
r6925 n3952 n4075 0.013671875
r6926 n4074 n4075 0.70833333333333337
r6927 n3953 n4076 0.21875
r6928 n4075 n4076 0.70833333333333337
r6929 n3954 n4077 0.012152777777777778
r6930 n4076 n4077 0.79166666666666663
r6931 n3955 n4078 0.21875
r6932 n4077 n4078 0.79166666666666663
r6933 n3956 n4079 0.013671875
r6934 n4078 n4079 0.70833333333333337
r6935 n3957 n4080 0.21875
r6936 n4079 n4080 0.70833333333333337
r6937 n3958 n4081 0.012152777777777778
r6938 n4080 n4081 0.79166666666666663
r6939 n3959 n4082 0.21875
r6940 n4081 n4082 0.79166666666666663
r6941 n3960 n4083 0.013671875
r6942 n4082 n4083 0.70833333333333337
r6943 n3961 n4084 0.21875
r6944 n4083 n4084 0.70833333333333337
r6945 n3962 n4085 0.012152777777777778
r6946 n4084 n4085 0.79166666666666663
r6947 n3963 n4086 0.21875
r6948 n4085 n4086 0.79166666666666663
r6949 n3964 n4087 0.013671875
r6950 n4086 n4087 0.70833333333333337
r6951 n3965 n4088 0.21875
r6952 n4087 n4088 0.70833333333333337
r6953 n3966 n4089 0.012152777777777778
r6954 n4088 n4089 0.79166666666666663
r6955 n3967 n4090 0.21875
r6956 n4089 n4090 0.79166666666666663
r6957 n3968 n4091 0.013671875
r6958 n4090 n4091 0.70833333333333337
r6959 n3969 n4092 0.21875
r6960 n4091 n4092 0.70833333333333337
r6961 n3970 n4093 0.012152777777777778
r6962 n4092 n4093 0.79166666666666663
r6963 n3971 n4094 0.21875
r6964 n4093 n4094 0.79166666666666663
r6965 n3972 n4095 0.013671875
r6966 n4094 n4095 0.70833333333333337
r6967 n3973 n4096 0.21875
r6968 n4095 n4096 0.70833333333333337
r6969 n3974 n4097 0.012152777777777778
r6970 n4096 n4097 0.79166666666666663
r6971 n3975 n4098 0.21875
r6972 n4097 n4098 0.79166666666666663
r6973 n3976 n4099 0.013671875
r6974 n4098 n4099 0.70833333333333337
r6975 n3977 n4100 0.21875
r6976 n4099 n4100 0.70833333333333337
r6977 n3978 n4101 0.029166666666666667
r6978 n4100 n4101 0.35416666666666669
r6979 n3979 n4102 0.036458333333333336
r6980 n4101 n4102 0.5625
r6981 n3980 n4103 0.048611111111111112
r6982 n4102 n4103 0.4375
r6983 n3981 n4104 0.21875
r6984 n4103 n4104 0.22916666666666666
r6985 n3982 n4105 0.21875
r6986 n4104 n4105 0.083333333333333329
r6987 n3983 n4106 0.0546875
r6988 n4105 n4106 0.20833333333333334
r6989 n3984 n4107 0.019886363636363636
r6990 n4106 n4107 0.625
r6991 n3985 n4108 0.4375
r6992 n4107 n4108 0.47916666666666669
r6993 n3986 n4109 0.4375
r6994 n4108 n4109 0.041666666666666664
r6995 n3987 n4110 0.4375
r6996 n4109 n4110 0.041666666666666664
r6997 n3988 n4111 0.043749999999999997
r6998 n4110 n4111 0.22916666666666666
r6999 n3989 n4112 0.036458333333333336
r7000 n4111 n4112 0.45833333333333331
r7001 n3990 n4113 0.0546875
r7002 n4112 n4113 0.41666666666666669
r7003 n3991 n4114 0.21875
r7004 n4113 n4114 0.20833333333333334
r7005 n3992 n4115 0.14583333333333334
r7006 n4114 n4115 0.10416666666666667
r7007 n3993 n4116 0.21875
r7008 n4115 n4116 0.10416666666666667
r7009 n3994 n4117 0.072916666666666671
r7010 n4116 n4117 0.16666666666666666
r7011 n3995 n4118 0.036458333333333336
r7012 n4117 n4118 0.375
r7013 n3996 n4119 0.03125
r7014 n4118 n4119 0.54166666666666663
r7015 n3997 n4120 0.21875
r7016 n4119 n4120 0.33333333333333331
r7017 n3998 n4121 0.012152777777777778
r7018 n4120 n4121 0.79166666666666663
r7019 n3999 n4122 0.21875
r7020 n4121 n4122 0.79166666666666663
r7021 n4000 n4123 0.013671875
r7022 n4122 n4123 0.70833333333333337
r7023 n4001 n4124 0.21875
r7024 n4123 n4124 0.70833333333333337
r7025 n4002 n4125 0.012152777777777778
r7026 n4124 n4125 0.79166666666666663
r7027 n4003 n4126 0.21875
r7028 n4125 n4126 0.79166666666666663
r7029 n4004 n4127 0.013671875
r7030 n4126 n4127 0.70833333333333337
r7031 n4005 n4128 0.21875
r7032 n4127 n4128 0.70833333333333337
r7033 n4006 n4129 0.012152777777777778
r7034 n4128 n4129 0.79166666666666663
r7035 n4007 n4130 0.21875
r7036 n4129 n4130 0.79166666666666663
r7037 n4008 n4131 0.013671875
r7038 n4130 n4131 0.70833333333333337
r7039 n4009 n4132 0.21875
r7040 n4131 n4132 0.70833333333333337
r7041 n4010 n4133 0.012152777777777778
r7042 n4132 n4133 0.79166666666666663
r7043 n4011 n4134 0.21875
r7044 n4133 n4134 0.79166666666666663
r7045 n4012 n4135 0.013671875
r7046 n4134 n4135 0.70833333333333337
r7047 n4013 n4136 0.21875
r7048 n4135 n4136 0.70833333333333337
r7049 n4014 n4137 0.012152777777777778
r7050 n4136 n4137 0.79166666666666663
r7051 n4015 n4138 0.21875
r7052 n4137 n4138 0.79166666666666663
r7053 n4016 n4139 0.013671875
r7054 n4138 n4139 0.70833333333333337
r7055 n4017 n4140 0.21875
r7056 n4139 n4140 0.70833333333333337
r7057 n4018 n4141 0.012152777777777778
r7058 n4140 n4141 0.79166666666666663
r7059 n4019 n4142 0.21875
r7060 n4141 n4142 0.79166666666666663
r7061 n4020 n4143 0.013671875
r7062 n4142 n4143 0.70833333333333337
r7063 n4021 n4144 0.21875
r7064 n4143 n4144 0.70833333333333337
r7065 n4022 n4145 0.012152777777777778
r7066 n4144 n4145 0.79166666666666663
r7067 n4023 n4146 0.21875
r7068 n4145 n4146 0.79166666666666663
r7069 n4024 n4147 0.013671875
r7070 n4146 n4147 0.70833333333333337
r7071 n4025 n4148 0.21875
r7072 n4147 n4148 0.70833333333333337
r7073 n4026 n4149 0.036458333333333336
r7074 n4148 n4149 0.29166666666666669
r7075 n4027 n4150 0.14583333333333334
r7076 n4028 n4151 0.14583333333333334
r7077 n4150 n4151 0.125
r7078 n4029 n4152 0.21875
r7079 n4151 n4152 0.10416666666666667
r7080 n4030 n4153 0.039772727272727272
r7081 n4152 n4153 0.27083333333333331
r7082 n4031 n4154 0.023026315789473683
r7083 n4153 n4154 0.625
r7084 n4032 n4155 0.21875
r7085 n4154 n4155 0.4375
r7086 n4033 n4156 0.14583333333333334
r7087 n4155 n4156 0.10416666666666667
r7088 n4034 n4157 0.14583333333333334
r7089 n4156 n4157 0.125
r7090 n4035 n4158 0.03125
r7091 n4036 n4159 0.15625
r7092 n4158 n4159 0.375
r7093 n4037 n4160 0.009765625
r7094 n4159 n4160 1.0625
r7095 n4038 n4161 0.15625
r7096 n4160 n4161 1.0625
r7097 n4039 n4162 0.0086805555555555559
r7098 n4161 n4162 1.1875
r7099 n4040 n4163 0.15625
r7100 n4162 n4163 1.1875
r7101 n4041 n4164 0.02403846153846154
r7102 n4163 n4164 0.46875
r7103 n4042 n4165 0.026041666666666668
r7104 n4164 n4165 0.78125
r7105 n4043 n4166 0.044642857142857144
r7106 n4165 n4166 0.59375
r7107 n4044 n4167 0.15625
r7108 n4166 n4167 0.28125
r7109 n4045 n4168 0.078125
r7110 n4167 n4168 0.1875
r7111 n4046 n4169 0.034722222222222224
r7112 n4168 n4169 0.40625
r7113 n4047 n4170 0.01488095238095238
r7114 n4169 n4170 0.9375
r7115 n4048 n4171 0.15625
r7116 n4170 n4171 0.71875
r7117 n4049 n4172 0.15625
r7118 n4171 n4172 0.125
r7119 n4050 n4173 0.034722222222222224
r7120 n4172 n4173 0.34375
r7121 n4051 n4174 0.026041666666666668
r7122 n4173 n4174 0.65625
r7123 n4052 n4175 0.034722222222222224
r7124 n4174 n4175 0.65625
r7125 n4053 n4176 0.15625
r7126 n4175 n4176 0.34375
r7127 n4054 n4177 0.15625
r7128 n4176 n4177 0.125
r7129 n4055 n4178 0.01488095238095238
r7130 n4177 n4178 0.71875
r7131 n4056 n4179 0.020833333333333332
r7132 n4178 n4179 1.125
r7133 n4057 n4180 0.15625
r7134 n4179 n4180 0.53125
r7135 n4058 n4181 0.009765625
r7136 n4180 n4181 1.0625
r7137 n4059 n4182 0.15625
r7138 n4181 n4182 1.0625
r7139 n4060 n4183 0.026041666666666668
r7140 n4182 n4183 0.4375
r7141 n4184 n4185 0.53125
r7142 n4061 n4186 0.10416666666666667
r7143 n4185 n4186 0.3125
r7144 n4062 n4187 0.10416666666666667
r7145 n4186 n4187 0.1875
r7146 n4063 n4188 0.15625
r7147 n4187 n4188 0.15625
r7148 n4064 n4189 0.0390625
r7149 n4188 n4189 0.3125
r7150 n4065 n4190 0.014204545454545454
r7151 n4189 n4190 0.9375
r7152 n4066 n4191 0.15625
r7153 n4190 n4191 0.75
r7154 n4067 n4192 0.10416666666666667
r7155 n4191 n4192 0.15625
r7156 n4068 n4193 0.10416666666666667
r7157 n4192 n4193 0.1875
r7158 n4193 n4194 0.21875
r7159 n4194 n4195 0.21875
r7160 n4195 n4196 0.40625
r7161 n4069 n4197 0.03125
r7162 n4070 n4198 0.15625
r7163 n4197 n4198 0.375
r7164 n4071 n4199 0.009765625
r7165 n4198 n4199 1.0625
r7166 n4072 n4200 0.15625
r7167 n4199 n4200 1.0625
r7168 n4073 n4201 0.0086805555555555559
r7169 n4200 n4201 1.1875
r7170 n4074 n4202 0.15625
r7171 n4201 n4202 1.1875
r7172 n4075 n4203 0.009765625
r7173 n4202 n4203 1.0625
r7174 n4076 n4204 0.15625
r7175 n4203 n4204 1.0625
r7176 n4077 n4205 0.0086805555555555559
r7177 n4204 n4205 1.1875
r7178 n4078 n4206 0.15625
r7179 n4205 n4206 1.1875
r7180 n4079 n4207 0.009765625
r7181 n4206 n4207 1.0625
r7182 n4080 n4208 0.15625
r7183 n4207 n4208 1.0625
r7184 n4081 n4209 0.0086805555555555559
r7185 n4208 n4209 1.1875
r7186 n4082 n4210 0.15625
r7187 n4209 n4210 1.1875
r7188 n4083 n4211 0.009765625
r7189 n4210 n4211 1.0625
r7190 n4084 n4212 0.15625
r7191 n4211 n4212 1.0625
r7192 n4085 n4213 0.0086805555555555559
r7193 n4212 n4213 1.1875
r7194 n4086 n4214 0.15625
r7195 n4213 n4214 1.1875
r7196 n4087 n4215 0.009765625
r7197 n4214 n4215 1.0625
r7198 n4088 n4216 0.15625
r7199 n4215 n4216 1.0625
r7200 n4089 n4217 0.0086805555555555559
r7201 n4216 n4217 1.1875
r7202 n4090 n4218 0.15625
r7203 n4217 n4218 1.1875
r7204 n4091 n4219 0.009765625
r7205 n4218 n4219 1.0625
r7206 n4092 n4220 0.15625
r7207 n4219 n4220 1.0625
r7208 n4093 n4221 0.0086805555555555559
r7209 n4220 n4221 1.1875
r7210 n4094 n4222 0.15625
r7211 n4221 n4222 1.1875
r7212 n4095 n4223 0.009765625
r7213 n4222 n4223 1.0625
r7214 n4096 n4224 0.15625
r7215 n4223 n4224 1.0625
r7216 n4097 n4225 0.0086805555555555559
r7217 n4224 n4225 1.1875
r7218 n4098 n4226 0.15625
r7219 n4225 n4226 1.1875
r7220 n4099 n4227 0.009765625
r7221 n4226 n4227 1.0625
r7222 n4100 n4228 0.15625
r7223 n4227 n4228 1.0625
r7224 n4101 n4229 0.020833333333333332
r7225 n4228 n4229 0.53125
r7226 n4102 n4230 0.026041666666666668
r7227 n4229 n4230 0.84375
r7228 n4103 n4231 0.034722222222222224
r7229 n4230 n4231 0.65625
r7230 n4104 n4232 0.15625
r7231 n4231 n4232 0.34375
r7232 n4105 n4233 0.15625
r7233 n4232 n4233 0.125
r7234 n4106 n4234 0.0390625
r7235 n4233 n4234 0.3125
r7236 n4107 n4235 0.014204545454545454
r7237 n4234 n4235 0.9375
r7238 n4108 n4236 0.3125
r7239 n4235 n4236 0.71875
r7240 n4109 n4237 0.3125
r7241 n4236 n4237 0.0625
r7242 n4110 n4238 0.3125
r7243 n4237 n4238 0.0625
r7244 n4111 n4239 0.03125
r7245 n4238 n4239 0.34375
r7246 n4112 n4240 0.026041666666666668
r7247 n4239 n4240 0.6875
r7248 n4113 n4241 0.0390625
r7249 n4240 n4241 0.625
r7250 n4114 n4242 0.15625
r7251 n4241 n4242 0.3125
r7252 n4115 n4243 0.10416666666666667
r7253 n4242 n4243 0.15625
r7254 n4116 n4244 0.15625
r7255 n4243 n4244 0.15625
r7256 n4117 n4245 0.052083333333333336
r7257 n4244 n4245 0.25
r7258 n4118 n4246 0.026041666666666668
r7259 n4245 n4246 0.5625
r7260 n4119 n4247 0.022321428571428572
r7261 n4246 n4247 0.8125
r7262 n4120 n4248 0.15625
r7263 n4247 n4248 0.5
r7264 n4121 n4249 0.0086805555555555559
r7265 n4248 n4249 1.1875
r7266 n4122 n4250 0.15625
r7267 n4249 n4250 1.1875
r7268 n4123 n4251 0.009765625
r7269 n4250 n4251 1.0625
r7270 n4124 n4252 0.15625
r7271 n4251 n4252 1.0625
r7272 n4125 n4253 0.0086805555555555559
r7273 n4252 n4253 1.1875
r7274 n4126 n4254 0.15625
r7275 n4253 n4254 1.1875
r7276 n4127 n4255 0.009765625
r7277 n4254 n4255 1.0625
r7278 n4128 n4256 0.15625
r7279 n4255 n4256 1.0625
r7280 n4129 n4257 0.0086805555555555559
r7281 n4256 n4257 1.1875
r7282 n4130 n4258 0.15625
r7283 n4257 n4258 1.1875
r7284 n4131 n4259 0.009765625
r7285 n4258 n4259 1.0625
r7286 n4132 n4260 0.15625
r7287 n4259 n4260 1.0625
r7288 n4133 n4261 0.0086805555555555559
r7289 n4260 n4261 1.1875
r7290 n4134 n4262 0.15625
r7291 n4261 n4262 1.1875
r7292 n4135 n4263 0.009765625
r7293 n4262 n4263 1.0625
r7294 n4136 n4264 0.15625
r7295 n4263 n4264 1.0625
r7296 n4137 n4265 0.0086805555555555559
r7297 n4264 n4265 1.1875
r7298 n4138 n4266 0.15625
r7299 n4265 n4266 1.1875
r7300 n4139 n4267 0.009765625
r7301 n4266 n4267 1.0625
r7302 n4140 n4268 0.15625
r7303 n4267 n4268 1.0625
r7304 n4141 n4269 0.0086805555555555559
r7305 n4268 n4269 1.1875
r7306 n4142 n4270 0.15625
r7307 n4269 n4270 1.1875
r7308 n4143 n4271 0.009765625
r7309 n4270 n4271 1.0625
r7310 n4144 n4272 0.15625
r7311 n4271 n4272 1.0625
r7312 n4145 n4273 0.0086805555555555559
r7313 n4272 n4273 1.1875
r7314 n4146 n4274 0.15625
r7315 n4273 n4274 1.1875
r7316 n4147 n4275 0.009765625
r7317 n4274 n4275 1.0625
r7318 n4148 n4276 0.15625
r7319 n4275 n4276 1.0625
r7320 n4149 n4277 0.026041666666666668
r7321 n4276 n4277 0.4375
r7322 n4278 n4279 0.53125
r7323 n4150 n4280 0.10416666666666667
r7324 n4279 n4280 0.3125
r7325 n4151 n4281 0.10416666666666667
r7326 n4280 n4281 0.1875
r7327 n4152 n4282 0.15625
r7328 n4281 n4282 0.15625
r7329 n4153 n4283 0.028409090909090908
r7330 n4282 n4283 0.40625
r7331 n4154 n4284 0.016447368421052631
r7332 n4283 n4284 0.9375
r7333 n4155 n4285 0.15625
r7334 n4284 n4285 0.65625
r7335 n4156 n4286 0.10416666666666667
r7336 n4285 n4286 0.15625
r7337 n4157 n4287 0.10416666666666667
r7338 n4286 n4287 0.1875
r7339 n4287 n4288 0.3125
r7340 n4288 n4289 0.53125
r7341 n4158 n4290 0.050000000000000003
r7342 n4159 n4291 0.25
r7343 n4290 n4291 0.125
r7344 n4160 n4292 0.015625
r7345 n4291 n4292 0.35416666666666669
r7346 n4161 n4293 0.25
r7347 n4292 n4293 0.35416666666666669
r7348 n4162 n4294 0.013888888888888888
r7349 n4293 n4294 0.39583333333333331
r7350 n4163 n4295 0.25
r7351 n4294 n4295 0.39583333333333331
r7352 n4164 n4296 0.038461538461538464
r7353 n4295 n4296 0.15625
r7354 n4165 n4297 0.041666666666666664
r7355 n4296 n4297 0.26041666666666669
r7356 n4166 n4298 0.071428571428571425
r7357 n4297 n4298 0.19791666666666666
r7358 n4167 n4299 0.25
r7359 n4298 n4299 0.09375
r7360 n4168 n4300 0.125
r7361 n4299 n4300 0.0625
r7362 n4169 n4301 0.055555555555555552
r7363 n4300 n4301 0.13541666666666666
r7364 n4170 n4302 0.023809523809523808
r7365 n4301 n4302 0.3125
r7366 n4171 n4303 0.25
r7367 n4302 n4303 0.23958333333333334
r7368 n4172 n4304 0.25
r7369 n4303 n4304 0.041666666666666664
r7370 n4173 n4305 0.055555555555555552
r7371 n4304 n4305 0.11458333333333333
r7372 n4174 n4306 0.041666666666666664
r7373 n4305 n4306 0.21875
r7374 n4175 n4307 0.055555555555555552
r7375 n4306 n4307 0.21875
r7376 n4176 n4308 0.25
r7377 n4307 n4308 0.11458333333333333
r7378 n4177 n4309 0.25
r7379 n4308 n4309 0.041666666666666664
r7380 n4178 n4310 0.023809523809523808
r7381 n4309 n4310 0.23958333333333334
r7382 n4179 n4311 0.033333333333333333
r7383 n4310 n4311 0.375
r7384 n4180 n4312 0.25
r7385 n4311 n4312 0.17708333333333334
r7386 n4181 n4313 0.015625
r7387 n4312 n4313 0.35416666666666669
r7388 n4182 n4314 0.25
r7389 n4313 n4314 0.35416666666666669
r7390 n4183 n4315 0.041666666666666664
r7391 n4314 n4315 0.14583333333333334
r7392 n4184 n4316 0.050000000000000003
r7393 n4185 n4317 0.071428571428571425
r7394 n4316 n4317 0.17708333333333334
r7395 n4186 n4318 0.16666666666666666
r7396 n4317 n4318 0.10416666666666667
r7397 n4187 n4319 0.16666666666666666
r7398 n4318 n4319 0.0625
r7399 n4188 n4320 0.25
r7400 n4319 n4320 0.052083333333333336
r7401 n4189 n4321 0.0625
r7402 n4320 n4321 0.10416666666666667
r7403 n4190 n4322 0.022727272727272728
r7404 n4321 n4322 0.3125
r7405 n4191 n4323 0.25
r7406 n4322 n4323 0.25
r7407 n4192 n4324 0.16666666666666666
r7408 n4323 n4324 0.052083333333333336
r7409 n4193 n4325 0.16666666666666666
r7410 n4324 n4325 0.0625
r7411 n4194 n4326 0.125
r7412 n4325 n4326 0.072916666666666671
r7413 n4195 n4327 0.16666666666666666
r7414 n4326 n4327 0.072916666666666671
r7415 n4196 n4328 0.050000000000000003
r7416 n4327 n4328 0.13541666666666666
r7417 n4197 n4329 0.050000000000000003
r7418 n4198 n4330 0.25
r7419 n4329 n4330 0.125
r7420 n4199 n4331 0.015625
r7421 n4330 n4331 0.35416666666666669
r7422 n4200 n4332 0.25
r7423 n4331 n4332 0.35416666666666669
r7424 n4201 n4333 0.013888888888888888
r7425 n4332 n4333 0.39583333333333331
r7426 n4202 n4334 0.25
r7427 n4333 n4334 0.39583333333333331
r7428 n4203 n4335 0.015625
r7429 n4334 n4335 0.35416666666666669
r7430 n4204 n4336 0.25
r7431 n4335 n4336 0.35416666666666669
r7432 n4205 n4337 0.013888888888888888
r7433 n4336 n4337 0.39583333333333331
r7434 n4206 n4338 0.25
r7435 n4337 n4338 0.39583333333333331
r7436 n4207 n4339 0.015625
r7437 n4338 n4339 0.35416666666666669
r7438 n4208 n4340 0.25
r7439 n4339 n4340 0.35416666666666669
r7440 n4209 n4341 0.013888888888888888
r7441 n4340 n4341 0.39583333333333331
r7442 n4210 n4342 0.25
r7443 n4341 n4342 0.39583333333333331
r7444 n4211 n4343 0.015625
r7445 n4342 n4343 0.35416666666666669
r7446 n4212 n4344 0.25
r7447 n4343 n4344 0.35416666666666669
r7448 n4213 n4345 0.013888888888888888
r7449 n4344 n4345 0.39583333333333331
r7450 n4214 n4346 0.25
r7451 n4345 n4346 0.39583333333333331
r7452 n4215 n4347 0.015625
r7453 n4346 n4347 0.35416666666666669
r7454 n4216 n4348 0.25
r7455 n4347 n4348 0.35416666666666669
r7456 n4217 n4349 0.013888888888888888
r7457 n4348 n4349 0.39583333333333331
r7458 n4218 n4350 0.25
r7459 n4349 n4350 0.39583333333333331
r7460 n4219 n4351 0.015625
r7461 n4350 n4351 0.35416666666666669
r7462 n4220 n4352 0.25
r7463 n4351 n4352 0.35416666666666669
r7464 n4221 n4353 0.013888888888888888
r7465 n4352 n4353 0.39583333333333331
r7466 n4222 n4354 0.25
r7467 n4353 n4354 0.39583333333333331
r7468 n4223 n4355 0.015625
r7469 n4354 n4355 0.35416666666666669
r7470 n4224 n4356 0.25
r7471 n4355 n4356 0.35416666666666669
r7472 n4225 n4357 0.013888888888888888
r7473 n4356 n4357 0.39583333333333331
r7474 n4226 n4358 0.25
r7475 n4357 n4358 0.39583333333333331
r7476 n4227 n4359 0.015625
r7477 n4358 n4359 0.35416666666666669
r7478 n4228 n4360 0.25
r7479 n4359 n4360 0.35416666666666669
r7480 n4229 n4361 0.033333333333333333
r7481 n4360 n4361 0.17708333333333334
r7482 n4230 n4362 0.041666666666666664
r7483 n4361 n4362 0.28125
r7484 n4231 n4363 0.055555555555555552
r7485 n4362 n4363 0.21875
r7486 n4232 n4364 0.25
r7487 n4363 n4364 0.11458333333333333
r7488 n4233 n4365 0.25
r7489 n4364 n4365 0.041666666666666664
r7490 n4234 n4366 0.0625
r7491 n4365 n4366 0.10416666666666667
r7492 n4235 n4367 0.022727272727272728
r7493 n4366 n4367 0.3125
r7494 n4236 n4368 0.5
r7495 n4367 n4368 0.23958333333333334
r7496 n4237 n4369 0.5
r7497 n4368 n4369 0.020833333333333332
r7498 n4238 n4370 0.5
r7499 n4369 n4370 0.020833333333333332
r7500 n4239 n4371 0.050000000000000003
r7501 n4370 n4371 0.11458333333333333
r7502 n4240 n4372 0.041666666666666664
r7503 n4371 n4372 0.22916666666666666
r7504 n4241 n4373 0.0625
r7505 n4372 n4373 0.20833333333333334
r7506 n4242 n4374 0.25
r7507 n4373 n4374 0.10416666666666667
r7508 n4243 n4375 0.16666666666666666
r7509 n4374 n4375 0.052083333333333336
r7510 n4244 n4376 0.25
r7511 n4375 n4376 0.052083333333333336
r7512 n4245 n4377 0.083333333333333329
r7513 n4376 n4377 0.083333333333333329
r7514 n4246 n4378 0.041666666666666664
r7515 n4377 n4378 0.1875
r7516 n4247 n4379 0.035714285714285712
r7517 n4378 n4379 0.27083333333333331
r7518 n4248 n4380 0.25
r7519 n4379 n4380 0.16666666666666666
r7520 n4249 n4381 0.013888888888888888
r7521 n4380 n4381 0.39583333333333331
r7522 n4250 n4382 0.25
r7523 n4381 n4382 0.39583333333333331
r7524 n4251 n4383 0.015625
r7525 n4382 n4383 0.35416666666666669
r7526 n4252 n4384 0.25
r7527 n4383 n4384 0.35416666666666669
r7528 n4253 n4385 0.013888888888888888
r7529 n4384 n4385 0.39583333333333331
r7530 n4254 n4386 0.25
r7531 n4385 n4386 0.39583333333333331
r7532 n4255 n4387 0.015625
r7533 n4386 n4387 0.35416666666666669
r7534 n4256 n4388 0.25
r7535 n4387 n4388 0.35416666666666669
r7536 n4257 n4389 0.013888888888888888
r7537 n4388 n4389 0.39583333333333331
r7538 n4258 n4390 0.25
r7539 n4389 n4390 0.39583333333333331
r7540 n4259 n4391 0.015625
r7541 n4390 n4391 0.35416666666666669
r7542 n4260 n4392 0.25
r7543 n4391 n4392 0.35416666666666669
r7544 n4261 n4393 0.013888888888888888
r7545 n4392 n4393 0.39583333333333331
r7546 n4262 n4394 0.25
r7547 n4393 n4394 0.39583333333333331
r7548 n4263 n4395 0.015625
r7549 n4394 n4395 0.35416666666666669
r7550 n4264 n4396 0.25
r7551 n4395 n4396 0.35416666666666669
r7552 n4265 n4397 0.013888888888888888
r7553 n4396 n4397 0.39583333333333331
r7554 n4266 n4398 0.25
r7555 n4397 n4398 0.39583333333333331
r7556 n4267 n4399 0.015625
r7557 n4398 n4399 0.35416666666666669
r7558 n4268 n4400 0.25
r7559 n4399 n4400 0.35416666666666669
r7560 n4269 n4401 0.013888888888888888
r7561 n4400 n4401 0.39583333333333331
r7562 n4270 n4402 0.25
r7563 n4401 n4402 0.39583333333333331
r7564 n4271 n4403 0.015625
r7565 n4402 n4403 0.35416666666666669
r7566 n4272 n4404 0.25
r7567 n4403 n4404 0.35416666666666669
r7568 n4273 n4405 0.013888888888888888
r7569 n4404 n4405 0.39583333333333331
r7570 n4274 n4406 0.25
r7571 n4405 n4406 0.39583333333333331
r7572 n4275 n4407 0.015625
r7573 n4406 n4407 0.35416666666666669
r7574 n4276 n4408 0.25
r7575 n4407 n4408 0.35416666666666669
r7576 n4277 n4409 0.041666666666666664
r7577 n4408 n4409 0.14583333333333334
r7578 n4278 n4410 0.050000000000000003
r7579 n4279 n4411 0.071428571428571425
r7580 n4410 n4411 0.17708333333333334
r7581 n4280 n4412 0.16666666666666666
r7582 n4411 n4412 0.10416666666666667
r7583 n4281 n4413 0.16666666666666666
r7584 n4412 n4413 0.0625
r7585 n4282 n4414 0.25
r7586 n4413 n4414 0.052083333333333336
r7587 n4283 n4415 0.045454545454545456
r7588 n4414 n4415 0.13541666666666666
r7589 n4284 n4416 0.026315789473684209
r7590 n4415 n4416 0.3125
r7591 n4285 n4417 0.25
r7592 n4416 n4417 0.21875
r7593 n4286 n4418 0.16666666666666666
r7594 n4417 n4418 0.052083333333333336
r7595 n4287 n4419 0.16666666666666666
r7596 n4418 n4419 0.0625
r7597 n4288 n4420 0.071428571428571425
r7598 n4419 n4420 0.10416666666666667
r7599 n4289 n4421 0.050000000000000003
r7600 n4420 n4421 0.17708333333333334
r7601 n4297 n4422 0.041666666666666664
r7602 n4298 n4423 0.071428571428571425
r7603 n4422 n4423 0.59375
r7604 n4299 n4424 0.25
r7605 n4423 n4424 0.28125
r7606 n4300 n4425 0.125
r7607 n4424 n4425 0.1875
r7608 n4301 n4426 0.055555555555555552
r7609 n4425 n4426 0.40625
r7610 n4302 n4427 0.023809523809523808
r7611 n4426 n4427 0.9375
r7612 n4303 n4428 0.25
r7613 n4427 n4428 0.71875
r7614 n4304 n4429 0.25
r7615 n4428 n4429 0.125
r7616 n4305 n4430 0.055555555555555552
r7617 n4429 n4430 0.34375
r7618 n4306 n4431 0.041666666666666664
r7619 n4430 n4431 0.65625
r7620 n4316 n4432 0.050000000000000003
r7621 n4317 n4433 0.071428571428571425
r7622 n4432 n4433 0.53125
r7623 n4318 n4434 0.16666666666666666
r7624 n4433 n4434 0.3125
r7625 n4319 n4435 0.16666666666666666
r7626 n4434 n4435 0.1875
r7627 n4320 n4436 0.25
r7628 n4435 n4436 0.15625
r7629 n4321 n4437 0.0625
r7630 n4436 n4437 0.3125
r7631 n4322 n4438 0.022727272727272728
r7632 n4437 n4438 0.9375
r7633 n4323 n4439 0.25
r7634 n4438 n4439 0.75
r7635 n4324 n4440 0.16666666666666666
r7636 n4439 n4440 0.15625
r7637 n4325 n4441 0.16666666666666666
r7638 n4440 n4441 0.1875
r7639 n4326 n4442 0.125
r7640 n4441 n4442 0.21875
r7641 n4327 n4443 0.16666666666666666
r7642 n4442 n4443 0.21875
r7643 n4328 n4444 0.050000000000000003
r7644 n4443 n4444 0.40625
r7645 n4362 n4445 0.041666666666666664
r7646 n4363 n4446 0.055555555555555552
r7647 n4445 n4446 0.65625
r7648 n4364 n4447 0.25
r7649 n4446 n4447 0.34375
r7650 n4365 n4448 0.25
r7651 n4447 n4448 0.125
r7652 n4366 n4449 0.0625
r7653 n4448 n4449 0.3125
r7654 n4367 n4450 0.022727272727272728
r7655 n4449 n4450 0.9375
r7656 n4368 n4451 0.5
r7657 n4450 n4451 0.71875
r7658 n4369 n4452 0.5
r7659 n4451 n4452 0.0625
r7660 n4370 n4453 0.5
r7661 n4452 n4453 0.0625
r7662 n4371 n4454 0.050000000000000003
r7663 n4453 n4454 0.34375
r7664 n4372 n4455 0.041666666666666664
r7665 n4454 n4455 0.6875
r7666 n4410 n4456 0.050000000000000003
r7667 n4411 n4457 0.071428571428571425
r7668 n4456 n4457 0.53125
r7669 n4412 n4458 0.16666666666666666
r7670 n4457 n4458 0.3125
r7671 n4413 n4459 0.16666666666666666
r7672 n4458 n4459 0.1875
r7673 n4414 n4460 0.25
r7674 n4459 n4460 0.15625
r7675 n4415 n4461 0.045454545454545456
r7676 n4460 n4461 0.40625
r7677 n4416 n4462 0.026315789473684209
r7678 n4461 n4462 0.9375
r7679 n4417 n4463 0.25
r7680 n4462 n4463 0.65625
r7681 n4418 n4464 0.16666666666666666
r7682 n4463 n4464 0.15625
r7683 n4419 n4465 0.16666666666666666
r7684 n4464 n4465 0.1875
r7685 n4420 n4466 0.071428571428571425
r7686 n4465 n4466 0.3125
r7687 n4421 n4467 0.050000000000000003
r7688 n4466 n4467 0.53125
r7689 n4422 n4468 0.026041666666666668
r7690 n4423 n4469 0.044642857142857144
r7691 n4468 n4469 0.39583333333333331
r7692 n4424 n4470 0.15625
r7693 n4469 n4470 0.1875
r7694 n4425 n4471 0.078125
r7695 n4470 n4471 0.125
r7696 n4426 n4472 0.034722222222222224
r7697 n4471 n4472 0.27083333333333331
r7698 n4427 n4473 0.01488095238095238
r7699 n4472 n4473 0.625
r7700 n4428 n4474 0.15625
r7701 n4473 n4474 0.47916666666666669
r7702 n4429 n4475 0.15625
r7703 n4474 n4475 0.083333333333333329
r7704 n4430 n4476 0.034722222222222224
r7705 n4475 n4476 0.22916666666666666
r7706 n4431 n4477 0.026041666666666668
r7707 n4476 n4477 0.4375
r7708 n4432 n4478 0.03125
r7709 n4433 n4479 0.044642857142857144
r7710 n4478 n4479 0.35416666666666669
r7711 n4434 n4480 0.10416666666666667
r7712 n4479 n4480 0.20833333333333334
r7713 n4435 n4481 0.10416666666666667
r7714 n4480 n4481 0.125
r7715 n4436 n4482 0.15625
r7716 n4481 n4482 0.10416666666666667
r7717 n4437 n4483 0.0390625
r7718 n4482 n4483 0.20833333333333334
r7719 n4438 n4484 0.014204545454545454
r7720 n4483 n4484 0.625
r7721 n4439 n4485 0.15625
r7722 n4484 n4485 0.5
r7723 n4440 n4486 0.10416666666666667
r7724 n4485 n4486 0.10416666666666667
r7725 n4441 n4487 0.10416666666666667
r7726 n4486 n4487 0.125
r7727 n4442 n4488 0.078125
r7728 n4487 n4488 0.14583333333333334
r7729 n4443 n4489 0.10416666666666667
r7730 n4488 n4489 0.14583333333333334
r7731 n4444 n4490 0.03125
r7732 n4489 n4490 0.27083333333333331
r7733 n4445 n4491 0.026041666666666668
r7734 n4446 n4492 0.034722222222222224
r7735 n4491 n4492 0.4375
r7736 n4447 n4493 0.15625
r7737 n4492 n4493 0.22916666666666666
r7738 n4448 n4494 0.15625
r7739 n4493 n4494 0.083333333333333329
r7740 n4449 n4495 0.0390625
r7741 n4494 n4495 0.20833333333333334
r7742 n4450 n4496 0.014204545454545454
r7743 n4495 n4496 0.625
r7744 n4451 n4497 0.3125
r7745 n4496 n4497 0.47916666666666669
r7746 n4452 n4498 0.3125
r7747 n4497 n4498 0.041666666666666664
r7748 n4453 n4499 0.3125
r7749 n4498 n4499 0.041666666666666664
r7750 n4454 n4500 0.03125
r7751 n4499 n4500 0.22916666666666666
r7752 n4455 n4501 0.026041666666666668
r7753 n4500 n4501 0.45833333333333331
r7754 n4456 n4502 0.03125
r7755 n4457 n4503 0.044642857142857144
r7756 n4502 n4503 0.35416666666666669
r7757 n4458 n4504 0.10416666666666667
r7758 n4503 n4504 0.20833333333333334
r7759 n4459 n4505 0.10416666666666667
r7760 n4504 n4505 0.125
r7761 n4460 n4506 0.15625
r7762 n4505 n4506 0.10416666666666667
r7763 n4461 n4507 0.028409090909090908
r7764 n4506 n4507 0.27083333333333331
r7765 n4462 n4508 0.016447368421052631
r7766 n4507 n4508 0.625
r7767 n4463 n4509 0.15625
r7768 n4508 n4509 0.4375
r7769 n4464 n4510 0.10416666666666667
r7770 n4509 n4510 0.10416666666666667
r7771 n4465 n4511 0.10416666666666667
r7772 n4510 n4511 0.125
r7773 n4466 n4512 0.044642857142857144
r7774 n4511 n4512 0.20833333333333334
r7775 n4467 n4513 0.03125
r7776 n4512 n4513 0.35416666666666669
r7777 n4468 n4514 0.026041666666666668
r7778 n4469 n4515 0.044642857142857144
r7779 n4514 n4515 0.59375
r7780 n4470 n4516 0.15625
r7781 n4515 n4516 0.28125
r7782 n4471 n4517 0.078125
r7783 n4516 n4517 0.1875
r7784 n4472 n4518 0.034722222222222224
r7785 n4517 n4518 0.40625
r7786 n4473 n4519 0.01488095238095238
r7787 n4518 n4519 0.9375
r7788 n4474 n4520 0.15625
r7789 n4519 n4520 0.71875
r7790 n4475 n4521 0.15625
r7791 n4520 n4521 0.125
r7792 n4476 n4522 0.034722222222222224
r7793 n4521 n4522 0.34375
r7794 n4477 n4523 0.026041666666666668
r7795 n4522 n4523 0.65625
r7796 n4478 n4524 0.03125
r7797 n4479 n4525 0.044642857142857144
r7798 n4524 n4525 0.53125
r7799 n4480 n4526 0.10416666666666667
r7800 n4525 n4526 0.3125
r7801 n4481 n4527 0.10416666666666667
r7802 n4526 n4527 0.1875
r7803 n4482 n4528 0.15625
r7804 n4527 n4528 0.15625
r7805 n4483 n4529 0.0390625
r7806 n4528 n4529 0.3125
r7807 n4484 n4530 0.014204545454545454
r7808 n4529 n4530 0.9375
r7809 n4485 n4531 0.15625
r7810 n4530 n4531 0.75
r7811 n4486 n4532 0.10416666666666667
r7812 n4531 n4532 0.15625
r7813 n4487 n4533 0.10416666666666667
r7814 n4532 n4533 0.1875
r7815 n4488 n4534 0.078125
r7816 n4533 n4534 0.21875
r7817 n4489 n4535 0.10416666666666667
r7818 n4534 n4535 0.21875
r7819 n4490 n4536 0.03125
r7820 n4535 n4536 0.40625
r7821 n4491 n4537 0.026041666666666668
r7822 n4492 n4538 0.034722222222222224
r7823 n4537 n4538 0.65625
r7824 n4493 n4539 0.15625
r7825 n4538 n4539 0.34375
r7826 n4494 n4540 0.15625
r7827 n4539 n4540 0.125
r7828 n4495 n4541 0.0390625
r7829 n4540 n4541 0.3125
r7830 n4496 n4542 0.014204545454545454
r7831 n4541 n4542 0.9375
r7832 n4497 n4543 0.3125
r7833 n4542 n4543 0.71875
r7834 n4498 n4544 0.3125
r7835 n4543 n4544 0.0625
r7836 n4499 n4545 0.3125
r7837 n4544 n4545 0.0625
r7838 n4500 n4546 0.03125
r7839 n4545 n4546 0.34375
r7840 n4501 n4547 0.026041666666666668
r7841 n4546 n4547 0.6875
r7842 n4502 n4548 0.03125
r7843 n4503 n4549 0.044642857142857144
r7844 n4548 n4549 0.53125
r7845 n4504 n4550 0.10416666666666667
r7846 n4549 n4550 0.3125
r7847 n4505 n4551 0.10416666666666667
r7848 n4550 n4551 0.1875
r7849 n4506 n4552 0.15625
r7850 n4551 n4552 0.15625
r7851 n4507 n4553 0.028409090909090908
r7852 n4552 n4553 0.40625
r7853 n4508 n4554 0.016447368421052631
r7854 n4553 n4554 0.9375
r7855 n4509 n4555 0.15625
r7856 n4554 n4555 0.65625
r7857 n4510 n4556 0.10416666666666667
r7858 n4555 n4556 0.15625
r7859 n4511 n4557 0.10416666666666667
r7860 n4556 n4557 0.1875
r7861 n4512 n4558 0.044642857142857144
r7862 n4557 n4558 0.3125
r7863 n4513 n4559 0.03125
r7864 n4558 n4559 0.53125
r7865 n4524 n4560 0.20000000000000001
r7866 n4525 n4561 0.2857142857142857
r7867 n4560 n4561 0.035416666666666666
r7868 n4526 n4562 0.66666666666666663
r7869 n4561 n4562 0.020833333333333332
r7870 n4527 n4563 0.66666666666666663
r7871 n4562 n4563 0.012500000000000001
r7872 n4528 n4564 1
r7873 n4563 n4564 0.010416666666666666
r7874 n4529 n4565 0.25
r7875 n4564 n4565 0.020833333333333332
r7876 n4530 n4566 0.090909090909090912
r7877 n4565 n4566 0.0625
r7878 n4531 n4567 1
r7879 n4566 n4567 0.050000000000000003
r7880 n4532 n4568 0.66666666666666663
r7881 n4567 n4568 0.010416666666666666
r7882 n4533 n4569 0.66666666666666663
r7883 n4568 n4569 0.012500000000000001
r7884 n4534 n4570 0.5
r7885 n4569 n4570 0.014583333333333334
r7886 n4535 n4571 0.66666666666666663
r7887 n4570 n4571 0.014583333333333334
r7888 n4536 n4572 0.20000000000000001
r7889 n4571 n4572 0.027083333333333334
r7890 n4548 n4573 0.20000000000000001
r7891 n4549 n4574 0.2857142857142857
r7892 n4573 n4574 0.035416666666666666
r7893 n4550 n4575 0.66666666666666663
r7894 n4574 n4575 0.020833333333333332
r7895 n4551 n4576 0.66666666666666663
r7896 n4575 n4576 0.012500000000000001
r7897 n4552 n4577 1
r7898 n4576 n4577 0.010416666666666666
r7899 n4553 n4578 0.18181818181818182
r7900 n4577 n4578 0.027083333333333334
r7901 n4554 n4579 0.10526315789473684
r7902 n4578 n4579 0.0625
r7903 n4555 n4580 1
r7904 n4579 n4580 0.043749999999999997
r7905 n4556 n4581 0.66666666666666663
r7906 n4580 n4581 0.010416666666666666
r7907 n4557 n4582 0.66666666666666663
r7908 n4581 n4582 0.012500000000000001
r7909 n4558 n4583 0.2857142857142857
r7910 n4582 n4583 0.020833333333333332
r7911 n4559 n4584 0.20000000000000001
r7912 n4583 n4584 0.035416666666666666
r7913 n4585 n4586 0.59375
r7914 n4586 n4587 0.28125
r7915 n4587 n4588 0.1875
r7916 n4588 n4589 0.40625
r7917 n4589 n4590 0.9375
r7918 n4590 n4591 0.71875
r7919 n4591 n4592 0.125
r7920 n4592 n4593 0.34375
r7921 n4593 n4594 0.65625
r7922 n4560 n4595 0.20000000000000001
r7923 n4561 n4596 0.2857142857142857
r7924 n4595 n4596 0.53125
r7925 n4562 n4597 0.66666666666666663
r7926 n4596 n4597 0.3125
r7927 n4563 n4598 0.66666666666666663
r7928 n4597 n4598 0.1875
r7929 n4564 n4599 1
r7930 n4598 n4599 0.15625
r7931 n4565 n4600 0.25
r7932 n4599 n4600 0.3125
r7933 n4566 n4601 0.090909090909090912
r7934 n4600 n4601 0.9375
r7935 n4567 n4602 1
r7936 n4601 n4602 0.75
r7937 n4568 n4603 0.66666666666666663
r7938 n4602 n4603 0.15625
r7939 n4569 n4604 0.66666666666666663
r7940 n4603 n4604 0.1875
r7941 n4570 n4605 0.5
r7942 n4604 n4605 0.21875
r7943 n4571 n4606 0.66666666666666663
r7944 n4605 n4606 0.21875
r7945 n4572 n4607 0.20000000000000001
r7946 n4606 n4607 0.40625
r7947 n4608 n4609 0.65625
r7948 n4609 n4610 0.34375
r7949 n4610 n4611 0.125
r7950 n4611 n4612 0.3125
r7951 n4612 n4613 0.9375
r7952 n4613 n4614 0.71875
r7953 n4614 n4615 0.0625
r7954 n4615 n4616 0.0625
r7955 n4616 n4617 0.34375
r7956 n4617 n4618 0.6875
r7957 n4573 n4619 0.20000000000000001
r7958 n4574 n4620 0.2857142857142857
r7959 n4619 n4620 0.53125
r7960 n4575 n4621 0.66666666666666663
r7961 n4620 n4621 0.3125
r7962 n4576 n4622 0.66666666666666663
r7963 n4621 n4622 0.1875
r7964 n4577 n4623 1
r7965 n4622 n4623 0.15625
r7966 n4578 n4624 0.18181818181818182
r7967 n4623 n4624 0.40625
r7968 n4579 n4625 0.10526315789473684
r7969 n4624 n4625 0.9375
r7970 n4580 n4626 1
r7971 n4625 n4626 0.65625
r7972 n4581 n4627 0.66666666666666663
r7973 n4626 n4627 0.15625
r7974 n4582 n4628 0.66666666666666663
r7975 n4627 n4628 0.1875
r7976 n4583 n4629 0.2857142857142857
r7977 n4628 n4629 0.3125
r7978 n4584 n4630 0.20000000000000001
r7979 n4629 n4630 0.53125
r7980 n4585 n4631 0.026041666666666668
r7981 n4586 n4632 0.044642857142857144
r7982 n4631 n4632 0.39583333333333331
r7983 n4587 n4633 0.15625
r7984 n4632 n4633 0.1875
r7985 n4588 n4634 0.078125
r7986 n4633 n4634 0.125
r7987 n4589 n4635 0.034722222222222224
r7988 n4634 n4635 0.27083333333333331
r7989 n4590 n4636 0.01488095238095238
r7990 n4635 n4636 0.625
r7991 n4591 n4637 0.15625
r7992 n4636 n4637 0.47916666666666669
r7993 n4592 n4638 0.15625
r7994 n4637 n4638 0.083333333333333329
r7995 n4593 n4639 0.034722222222222224
r7996 n4638 n4639 0.22916666666666666
r7997 n4594 n4640 0.026041666666666668
r7998 n4639 n4640 0.4375
r7999 n4595 n4641 0.03125
r8000 n4596 n4642 0.044642857142857144
r8001 n4641 n4642 0.35416666666666669
r8002 n4597 n4643 0.10416666666666667
r8003 n4642 n4643 0.20833333333333334
r8004 n4598 n4644 0.10416666666666667
r8005 n4643 n4644 0.125
r8006 n4599 n4645 0.15625
r8007 n4644 n4645 0.10416666666666667
r8008 n4600 n4646 0.0390625
r8009 n4645 n4646 0.20833333333333334
r8010 n4601 n4647 0.014204545454545454
r8011 n4646 n4647 0.625
r8012 n4602 n4648 0.15625
r8013 n4647 n4648 0.5
r8014 n4603 n4649 0.10416666666666667
r8015 n4648 n4649 0.10416666666666667
r8016 n4604 n4650 0.10416666666666667
r8017 n4649 n4650 0.125
r8018 n4605 n4651 0.078125
r8019 n4650 n4651 0.14583333333333334
r8020 n4606 n4652 0.10416666666666667
r8021 n4651 n4652 0.14583333333333334
r8022 n4607 n4653 0.03125
r8023 n4652 n4653 0.27083333333333331
r8024 n4608 n4654 0.026041666666666668
r8025 n4609 n4655 0.034722222222222224
r8026 n4654 n4655 0.4375
r8027 n4610 n4656 0.15625
r8028 n4655 n4656 0.22916666666666666
r8029 n4611 n4657 0.15625
r8030 n4656 n4657 0.083333333333333329
r8031 n4612 n4658 0.0390625
r8032 n4657 n4658 0.20833333333333334
r8033 n4613 n4659 0.014204545454545454
r8034 n4658 n4659 0.625
r8035 n4614 n4660 0.3125
r8036 n4659 n4660 0.47916666666666669
r8037 n4615 n4661 0.3125
r8038 n4660 n4661 0.041666666666666664
r8039 n4616 n4662 0.3125
r8040 n4661 n4662 0.041666666666666664
r8041 n4617 n4663 0.03125
r8042 n4662 n4663 0.22916666666666666
r8043 n4618 n4664 0.026041666666666668
r8044 n4663 n4664 0.45833333333333331
r8045 n4619 n4665 0.03125
r8046 n4620 n4666 0.044642857142857144
r8047 n4665 n4666 0.35416666666666669
r8048 n4621 n4667 0.10416666666666667
r8049 n4666 n4667 0.20833333333333334
r8050 n4622 n4668 0.10416666666666667
r8051 n4667 n4668 0.125
r8052 n4623 n4669 0.15625
r8053 n4668 n4669 0.10416666666666667
r8054 n4624 n4670 0.028409090909090908
r8055 n4669 n4670 0.27083333333333331
r8056 n4625 n4671 0.016447368421052631
r8057 n4670 n4671 0.625
r8058 n4626 n4672 0.15625
r8059 n4671 n4672 0.4375
r8060 n4627 n4673 0.10416666666666667
r8061 n4672 n4673 0.10416666666666667
r8062 n4628 n4674 0.10416666666666667
r8063 n4673 n4674 0.125
r8064 n4629 n4675 0.044642857142857144
r8065 n4674 n4675 0.20833333333333334
r8066 n4630 n4676 0.03125
r8067 n4675 n4676 0.35416666666666669
r8068 n4631 n4677 0.026041666666666668
r8069 n4632 n4678 0.044642857142857144
r8070 n4677 n4678 0.59375
r8071 n4633 n4679 0.15625
r8072 n4678 n4679 0.28125
r8073 n4634 n4680 0.078125
r8074 n4679 n4680 0.1875
r8075 n4635 n4681 0.034722222222222224
r8076 n4680 n4681 0.40625
r8077 n4636 n4682 0.01488095238095238
r8078 n4681 n4682 0.9375
r8079 n4637 n4683 0.15625
r8080 n4682 n4683 0.71875
r8081 n4638 n4684 0.15625
r8082 n4683 n4684 0.125
r8083 n4639 n4685 0.034722222222222224
r8084 n4684 n4685 0.34375
r8085 n4640 n4686 0.026041666666666668
r8086 n4685 n4686 0.65625
r8087 n4641 n4687 0.03125
r8088 n4642 n4688 0.044642857142857144
r8089 n4687 n4688 0.53125
r8090 n4643 n4689 0.10416666666666667
r8091 n4688 n4689 0.3125
r8092 n4644 n4690 0.10416666666666667
r8093 n4689 n4690 0.1875
r8094 n4645 n4691 0.15625
r8095 n4690 n4691 0.15625
r8096 n4646 n4692 0.0390625
r8097 n4691 n4692 0.3125
r8098 n4647 n4693 0.014204545454545454
r8099 n4692 n4693 0.9375
r8100 n4648 n4694 0.15625
r8101 n4693 n4694 0.75
r8102 n4649 n4695 0.10416666666666667
r8103 n4694 n4695 0.15625
r8104 n4650 n4696 0.10416666666666667
r8105 n4695 n4696 0.1875
r8106 n4651 n4697 0.078125
r8107 n4696 n4697 0.21875
r8108 n4652 n4698 0.10416666666666667
r8109 n4697 n4698 0.21875
r8110 n4653 n4699 0.03125
r8111 n4698 n4699 0.40625
r8112 n4654 n4700 0.026041666666666668
r8113 n4655 n4701 0.034722222222222224
r8114 n4700 n4701 0.65625
r8115 n4656 n4702 0.15625
r8116 n4701 n4702 0.34375
r8117 n4657 n4703 0.15625
r8118 n4702 n4703 0.125
r8119 n4658 n4704 0.0390625
r8120 n4703 n4704 0.3125
r8121 n4659 n4705 0.014204545454545454
r8122 n4704 n4705 0.9375
r8123 n4660 n4706 0.3125
r8124 n4705 n4706 0.71875
r8125 n4661 n4707 0.3125
r8126 n4706 n4707 0.0625
r8127 n4662 n4708 0.3125
r8128 n4707 n4708 0.0625
r8129 n4663 n4709 0.03125
r8130 n4708 n4709 0.34375
r8131 n4664 n4710 0.026041666666666668
r8132 n4709 n4710 0.6875
r8133 n4665 n4711 0.03125
r8134 n4666 n4712 0.044642857142857144
r8135 n4711 n4712 0.53125
r8136 n4667 n4713 0.10416666666666667
r8137 n4712 n4713 0.3125
r8138 n4668 n4714 0.10416666666666667
r8139 n4713 n4714 0.1875
r8140 n4669 n4715 0.15625
r8141 n4714 n4715 0.15625
r8142 n4670 n4716 0.028409090909090908
r8143 n4715 n4716 0.40625
r8144 n4671 n4717 0.016447368421052631
r8145 n4716 n4717 0.9375
r8146 n4672 n4718 0.15625
r8147 n4717 n4718 0.65625
r8148 n4673 n4719 0.10416666666666667
r8149 n4718 n4719 0.15625
r8150 n4674 n4720 0.10416666666666667
r8151 n4719 n4720 0.1875
r8152 n4675 n4721 0.044642857142857144
r8153 n4720 n4721 0.3125
r8154 n4676 n4722 0.03125
r8155 n4721 n4722 0.53125
r8156 n4723 n4724 0.125
r8157 n4724 n4725 0.35416666666666669
r8158 n4725 n4726 0.35416666666666669
r8159 n4726 n4727 0.39583333333333331
r8160 n4727 n4728 0.39583333333333331
r8161 n4728 n4729 0.15625
r8162 n4677 n4730 0.041666666666666664
r8163 n4729 n4730 0.26041666666666669
r8164 n4678 n4731 0.071428571428571425
r8165 n4730 n4731 0.19791666666666666
r8166 n4679 n4732 0.25
r8167 n4731 n4732 0.09375
r8168 n4680 n4733 0.125
r8169 n4732 n4733 0.0625
r8170 n4681 n4734 0.055555555555555552
r8171 n4733 n4734 0.13541666666666666
r8172 n4682 n4735 0.023809523809523808
r8173 n4734 n4735 0.3125
r8174 n4683 n4736 0.25
r8175 n4735 n4736 0.23958333333333334
r8176 n4684 n4737 0.25
r8177 n4736 n4737 0.041666666666666664
r8178 n4685 n4738 0.055555555555555552
r8179 n4737 n4738 0.11458333333333333
r8180 n4686 n4739 0.041666666666666664
r8181 n4738 n4739 0.21875
r8182 n4739 n4740 0.21875
r8183 n4740 n4741 0.11458333333333333
r8184 n4741 n4742 0.041666666666666664
r8185 n4742 n4743 0.23958333333333334
r8186 n4743 n4744 0.375
r8187 n4744 n4745 0.17708333333333334
r8188 n4745 n4746 0.35416666666666669
r8189 n4746 n4747 0.35416666666666669
r8190 n4747 n4748 0.14583333333333334
r8191 n4687 n4749 0.050000000000000003
r8192 n4688 n4750 0.071428571428571425
r8193 n4749 n4750 0.17708333333333334
r8194 n4689 n4751 0.16666666666666666
r8195 n4750 n4751 0.10416666666666667
r8196 n4690 n4752 0.16666666666666666
r8197 n4751 n4752 0.0625
r8198 n4691 n4753 0.25
r8199 n4752 n4753 0.052083333333333336
r8200 n4692 n4754 0.0625
r8201 n4753 n4754 0.10416666666666667
r8202 n4693 n4755 0.022727272727272728
r8203 n4754 n4755 0.3125
r8204 n4694 n4756 0.25
r8205 n4755 n4756 0.25
r8206 n4695 n4757 0.16666666666666666
r8207 n4756 n4757 0.052083333333333336
r8208 n4696 n4758 0.16666666666666666
r8209 n4757 n4758 0.0625
r8210 n4697 n4759 0.125
r8211 n4758 n4759 0.072916666666666671
r8212 n4698 n4760 0.16666666666666666
r8213 n4759 n4760 0.072916666666666671
r8214 n4699 n4761 0.050000000000000003
r8215 n4760 n4761 0.13541666666666666
r8216 n4762 n4763 0.125
r8217 n4763 n4764 0.35416666666666669
r8218 n4764 n4765 0.35416666666666669
r8219 n4765 n4766 0.39583333333333331
r8220 n4766 n4767 0.39583333333333331
r8221 n4767 n4768 0.35416666666666669
r8222 n4768 n4769 0.35416666666666669
r8223 n4769 n4770 0.39583333333333331
r8224 n4770 n4771 0.39583333333333331
r8225 n4771 n4772 0.35416666666666669
r8226 n4772 n4773 0.35416666666666669
r8227 n4773 n4774 0.39583333333333331
r8228 n4774 n4775 0.39583333333333331
r8229 n4775 n4776 0.35416666666666669
r8230 n4776 n4777 0.35416666666666669
r8231 n4777 n4778 0.39583333333333331
r8232 n4778 n4779 0.39583333333333331
r8233 n4779 n4780 0.35416666666666669
r8234 n4780 n4781 0.35416666666666669
r8235 n4781 n4782 0.39583333333333331
r8236 n4782 n4783 0.39583333333333331
r8237 n4783 n4784 0.35416666666666669
r8238 n4784 n4785 0.35416666666666669
r8239 n4785 n4786 0.39583333333333331
r8240 n4786 n4787 0.39583333333333331
r8241 n4787 n4788 0.35416666666666669
r8242 n4788 n4789 0.35416666666666669
r8243 n4789 n4790 0.39583333333333331
r8244 n4790 n4791 0.39583333333333331
r8245 n4791 n4792 0.35416666666666669
r8246 n4792 n4793 0.35416666666666669
r8247 n4793 n4794 0.17708333333333334
r8248 n4700 n4795 0.041666666666666664
r8249 n4794 n4795 0.28125
r8250 n4701 n4796 0.055555555555555552
r8251 n4795 n4796 0.21875
r8252 n4702 n4797 0.25
r8253 n4796 n4797 0.11458333333333333
r8254 n4703 n4798 0.25
r8255 n4797 n4798 0.041666666666666664
r8256 n4704 n4799 0.0625
r8257 n4798 n4799 0.10416666666666667
r8258 n4705 n4800 0.022727272727272728
r8259 n4799 n4800 0.3125
r8260 n4706 n4801 0.5
r8261 n4800 n4801 0.23958333333333334
r8262 n4707 n4802 0.5
r8263 n4801 n4802 0.020833333333333332
r8264 n4708 n4803 0.5
r8265 n4802 n4803 0.020833333333333332
r8266 n4709 n4804 0.050000000000000003
r8267 n4803 n4804 0.11458333333333333
r8268 n4710 n4805 0.041666666666666664
r8269 n4804 n4805 0.22916666666666666
r8270 n4805 n4806 0.20833333333333334
r8271 n4806 n4807 0.10416666666666667
r8272 n4807 n4808 0.052083333333333336
r8273 n4808 n4809 0.052083333333333336
r8274 n4809 n4810 0.083333333333333329
r8275 n4810 n4811 0.1875
r8276 n4811 n4812 0.27083333333333331
r8277 n4812 n4813 0.16666666666666666
r8278 n4813 n4814 0.39583333333333331
r8279 n4814 n4815 0.39583333333333331
r8280 n4815 n4816 0.35416666666666669
r8281 n4816 n4817 0.35416666666666669
r8282 n4817 n4818 0.39583333333333331
r8283 n4818 n4819 0.39583333333333331
r8284 n4819 n4820 0.35416666666666669
r8285 n4820 n4821 0.35416666666666669
r8286 n4821 n4822 0.39583333333333331
r8287 n4822 n4823 0.39583333333333331
r8288 n4823 n4824 0.35416666666666669
r8289 n4824 n4825 0.35416666666666669
r8290 n4825 n4826 0.39583333333333331
r8291 n4826 n4827 0.39583333333333331
r8292 n4827 n4828 0.35416666666666669
r8293 n4828 n4829 0.35416666666666669
r8294 n4829 n4830 0.39583333333333331
r8295 n4830 n4831 0.39583333333333331
r8296 n4831 n4832 0.35416666666666669
r8297 n4832 n4833 0.35416666666666669
r8298 n4833 n4834 0.39583333333333331
r8299 n4834 n4835 0.39583333333333331
r8300 n4835 n4836 0.35416666666666669
r8301 n4836 n4837 0.35416666666666669
r8302 n4837 n4838 0.39583333333333331
r8303 n4838 n4839 0.39583333333333331
r8304 n4839 n4840 0.35416666666666669
r8305 n4840 n4841 0.35416666666666669
r8306 n4841 n4842 0.14583333333333334
r8307 n4711 n4843 0.050000000000000003
r8308 n4712 n4844 0.071428571428571425
r8309 n4843 n4844 0.17708333333333334
r8310 n4713 n4845 0.16666666666666666
r8311 n4844 n4845 0.10416666666666667
r8312 n4714 n4846 0.16666666666666666
r8313 n4845 n4846 0.0625
r8314 n4715 n4847 0.25
r8315 n4846 n4847 0.052083333333333336
r8316 n4716 n4848 0.045454545454545456
r8317 n4847 n4848 0.13541666666666666
r8318 n4717 n4849 0.026315789473684209
r8319 n4848 n4849 0.3125
r8320 n4718 n4850 0.25
r8321 n4849 n4850 0.21875
r8322 n4719 n4851 0.16666666666666666
r8323 n4850 n4851 0.052083333333333336
r8324 n4720 n4852 0.16666666666666666
r8325 n4851 n4852 0.0625
r8326 n4721 n4853 0.071428571428571425
r8327 n4852 n4853 0.10416666666666667
r8328 n4722 n4854 0.050000000000000003
r8329 n4853 n4854 0.17708333333333334
r8330 n4723 n4855 0.050000000000000003
r8331 n4724 n4856 0.25
r8332 n4855 n4856 0.375
r8333 n4725 n4857 0.015625
r8334 n4856 n4857 1.0625
r8335 n4726 n4858 0.25
r8336 n4857 n4858 1.0625
r8337 n4727 n4859 0.013888888888888888
r8338 n4858 n4859 1.1875
r8339 n4728 n4860 0.25
r8340 n4859 n4860 1.1875
r8341 n4729 n4861 0.038461538461538464
r8342 n4860 n4861 0.46875
r8343 n4730 n4862 0.041666666666666664
r8344 n4861 n4862 0.78125
r8345 n4731 n4863 0.071428571428571425
r8346 n4862 n4863 0.59375
r8347 n4732 n4864 0.25
r8348 n4863 n4864 0.28125
r8349 n4733 n4865 0.125
r8350 n4864 n4865 0.1875
r8351 n4734 n4866 0.055555555555555552
r8352 n4865 n4866 0.40625
r8353 n4735 n4867 0.023809523809523808
r8354 n4866 n4867 0.9375
r8355 n4736 n4868 0.25
r8356 n4867 n4868 0.71875
r8357 n4737 n4869 0.25
r8358 n4868 n4869 0.125
r8359 n4738 n4870 0.055555555555555552
r8360 n4869 n4870 0.34375
r8361 n4739 n4871 0.041666666666666664
r8362 n4870 n4871 0.65625
r8363 n4740 n4872 0.055555555555555552
r8364 n4871 n4872 0.65625
r8365 n4741 n4873 0.25
r8366 n4872 n4873 0.34375
r8367 n4742 n4874 0.25
r8368 n4873 n4874 0.125
r8369 n4743 n4875 0.023809523809523808
r8370 n4874 n4875 0.71875
r8371 n4744 n4876 0.033333333333333333
r8372 n4875 n4876 1.125
r8373 n4745 n4877 0.25
r8374 n4876 n4877 0.53125
r8375 n4746 n4878 0.015625
r8376 n4877 n4878 1.0625
r8377 n4747 n4879 0.25
r8378 n4878 n4879 1.0625
r8379 n4748 n4880 0.041666666666666664
r8380 n4879 n4880 0.4375
r8381 n4749 n4881 0.050000000000000003
r8382 n4750 n4882 0.071428571428571425
r8383 n4881 n4882 0.53125
r8384 n4751 n4883 0.16666666666666666
r8385 n4882 n4883 0.3125
r8386 n4752 n4884 0.16666666666666666
r8387 n4883 n4884 0.1875
r8388 n4753 n4885 0.25
r8389 n4884 n4885 0.15625
r8390 n4754 n4886 0.0625
r8391 n4885 n4886 0.3125
r8392 n4755 n4887 0.022727272727272728
r8393 n4886 n4887 0.9375
r8394 n4756 n4888 0.25
r8395 n4887 n4888 0.75
r8396 n4757 n4889 0.16666666666666666
r8397 n4888 n4889 0.15625
r8398 n4758 n4890 0.16666666666666666
r8399 n4889 n4890 0.1875
r8400 n4759 n4891 0.125
r8401 n4890 n4891 0.21875
r8402 n4760 n4892 0.16666666666666666
r8403 n4891 n4892 0.21875
r8404 n4761 n4893 0.050000000000000003
r8405 n4892 n4893 0.40625
r8406 n4762 n4894 0.050000000000000003
r8407 n4763 n4895 0.25
r8408 n4894 n4895 0.375
r8409 n4764 n4896 0.015625
r8410 n4895 n4896 1.0625
r8411 n4765 n4897 0.25
r8412 n4896 n4897 1.0625
r8413 n4766 n4898 0.013888888888888888
r8414 n4897 n4898 1.1875
r8415 n4767 n4899 0.25
r8416 n4898 n4899 1.1875
r8417 n4768 n4900 0.015625
r8418 n4899 n4900 1.0625
r8419 n4769 n4901 0.25
r8420 n4900 n4901 1.0625
r8421 n4770 n4902 0.013888888888888888
r8422 n4901 n4902 1.1875
r8423 n4771 n4903 0.25
r8424 n4902 n4903 1.1875
r8425 n4772 n4904 0.015625
r8426 n4903 n4904 1.0625
r8427 n4773 n4905 0.25
r8428 n4904 n4905 1.0625
r8429 n4774 n4906 0.013888888888888888
r8430 n4905 n4906 1.1875
r8431 n4775 n4907 0.25
r8432 n4906 n4907 1.1875
r8433 n4776 n4908 0.015625
r8434 n4907 n4908 1.0625
r8435 n4777 n4909 0.25
r8436 n4908 n4909 1.0625
r8437 n4778 n4910 0.013888888888888888
r8438 n4909 n4910 1.1875
r8439 n4779 n4911 0.25
r8440 n4910 n4911 1.1875
r8441 n4780 n4912 0.015625
r8442 n4911 n4912 1.0625
r8443 n4781 n4913 0.25
r8444 n4912 n4913 1.0625
r8445 n4782 n4914 0.013888888888888888
r8446 n4913 n4914 1.1875
r8447 n4783 n4915 0.25
r8448 n4914 n4915 1.1875
r8449 n4784 n4916 0.015625
r8450 n4915 n4916 1.0625
r8451 n4785 n4917 0.25
r8452 n4916 n4917 1.0625
r8453 n4786 n4918 0.013888888888888888
r8454 n4917 n4918 1.1875
r8455 n4787 n4919 0.25
r8456 n4918 n4919 1.1875
r8457 n4788 n4920 0.015625
r8458 n4919 n4920 1.0625
r8459 n4789 n4921 0.25
r8460 n4920 n4921 1.0625
r8461 n4790 n4922 0.013888888888888888
r8462 n4921 n4922 1.1875
r8463 n4791 n4923 0.25
r8464 n4922 n4923 1.1875
r8465 n4792 n4924 0.015625
r8466 n4923 n4924 1.0625
r8467 n4793 n4925 0.25
r8468 n4924 n4925 1.0625
r8469 n4794 n4926 0.033333333333333333
r8470 n4925 n4926 0.53125
r8471 n4795 n4927 0.041666666666666664
r8472 n4926 n4927 0.84375
r8473 n4796 n4928 0.055555555555555552
r8474 n4927 n4928 0.65625
r8475 n4797 n4929 0.25
r8476 n4928 n4929 0.34375
r8477 n4798 n4930 0.25
r8478 n4929 n4930 0.125
r8479 n4799 n4931 0.0625
r8480 n4930 n4931 0.3125
r8481 n4800 n4932 0.022727272727272728
r8482 n4931 n4932 0.9375
r8483 n4801 n4933 0.5
r8484 n4932 n4933 0.71875
r8485 n4802 n4934 0.5
r8486 n4933 n4934 0.0625
r8487 n4803 n4935 0.5
r8488 n4934 n4935 0.0625
r8489 n4804 n4936 0.050000000000000003
r8490 n4935 n4936 0.34375
r8491 n4805 n4937 0.041666666666666664
r8492 n4936 n4937 0.6875
r8493 n4806 n4938 0.0625
r8494 n4937 n4938 0.625
r8495 n4807 n4939 0.25
r8496 n4938 n4939 0.3125
r8497 n4808 n4940 0.16666666666666666
r8498 n4939 n4940 0.15625
r8499 n4809 n4941 0.25
r8500 n4940 n4941 0.15625
r8501 n4810 n4942 0.083333333333333329
r8502 n4941 n4942 0.25
r8503 n4811 n4943 0.041666666666666664
r8504 n4942 n4943 0.5625
r8505 n4812 n4944 0.035714285714285712
r8506 n4943 n4944 0.8125
r8507 n4813 n4945 0.25
r8508 n4944 n4945 0.5
r8509 n4814 n4946 0.013888888888888888
r8510 n4945 n4946 1.1875
r8511 n4815 n4947 0.25
r8512 n4946 n4947 1.1875
r8513 n4816 n4948 0.015625
r8514 n4947 n4948 1.0625
r8515 n4817 n4949 0.25
r8516 n4948 n4949 1.0625
r8517 n4818 n4950 0.013888888888888888
r8518 n4949 n4950 1.1875
r8519 n4819 n4951 0.25
r8520 n4950 n4951 1.1875
r8521 n4820 n4952 0.015625
r8522 n4951 n4952 1.0625
r8523 n4821 n4953 0.25
r8524 n4952 n4953 1.0625
r8525 n4822 n4954 0.013888888888888888
r8526 n4953 n4954 1.1875
r8527 n4823 n4955 0.25
r8528 n4954 n4955 1.1875
r8529 n4824 n4956 0.015625
r8530 n4955 n4956 1.0625
r8531 n4825 n4957 0.25
r8532 n4956 n4957 1.0625
r8533 n4826 n4958 0.013888888888888888
r8534 n4957 n4958 1.1875
r8535 n4827 n4959 0.25
r8536 n4958 n4959 1.1875
r8537 n4828 n4960 0.015625
r8538 n4959 n4960 1.0625
r8539 n4829 n4961 0.25
r8540 n4960 n4961 1.0625
r8541 n4830 n4962 0.013888888888888888
r8542 n4961 n4962 1.1875
r8543 n4831 n4963 0.25
r8544 n4962 n4963 1.1875
r8545 n4832 n4964 0.015625
r8546 n4963 n4964 1.0625
r8547 n4833 n4965 0.25
r8548 n4964 n4965 1.0625
r8549 n4834 n4966 0.013888888888888888
r8550 n4965 n4966 1.1875
r8551 n4835 n4967 0.25
r8552 n4966 n4967 1.1875
r8553 n4836 n4968 0.015625
r8554 n4967 n4968 1.0625
r8555 n4837 n4969 0.25
r8556 n4968 n4969 1.0625
r8557 n4838 n4970 0.013888888888888888
r8558 n4969 n4970 1.1875
r8559 n4839 n4971 0.25
r8560 n4970 n4971 1.1875
r8561 n4840 n4972 0.015625
r8562 n4971 n4972 1.0625
r8563 n4841 n4973 0.25
r8564 n4972 n4973 1.0625
r8565 n4842 n4974 0.041666666666666664
r8566 n4973 n4974 0.4375
r8567 n4843 n4975 0.050000000000000003
r8568 n4844 n4976 0.071428571428571425
r8569 n4975 n4976 0.53125
r8570 n4845 n4977 0.16666666666666666
r8571 n4976 n4977 0.3125
r8572 n4846 n4978 0.16666666666666666
r8573 n4977 n4978 0.1875
r8574 n4847 n4979 0.25
r8575 n4978 n4979 0.15625
r8576 n4848 n4980 0.045454545454545456
r8577 n4979 n4980 0.40625
r8578 n4849 n4981 0.026315789473684209
r8579 n4980 n4981 0.9375
r8580 n4850 n4982 0.25
r8581 n4981 n4982 0.65625
r8582 n4851 n4983 0.16666666666666666
r8583 n4982 n4983 0.15625
r8584 n4852 n4984 0.16666666666666666
r8585 n4983 n4984 0.1875
r8586 n4853 n4985 0.071428571428571425
r8587 n4984 n4985 0.3125
r8588 n4854 n4986 0.050000000000000003
r8589 n4985 n4986 0.53125
r8590 n4855 n4987 0.03125
r8591 n4856 n4988 0.15625
r8592 n4987 n4988 0.25
r8593 n4857 n4989 0.009765625
r8594 n4988 n4989 0.70833333333333337
r8595 n4858 n4990 0.15625
r8596 n4989 n4990 0.70833333333333337
r8597 n4859 n4991 0.0086805555555555559
r8598 n4990 n4991 0.79166666666666663
r8599 n4860 n4992 0.15625
r8600 n4991 n4992 0.79166666666666663
r8601 n4861 n4993 0.02403846153846154
r8602 n4992 n4993 0.3125
r8603 n4862 n4994 0.026041666666666668
r8604 n4993 n4994 0.52083333333333337
r8605 n4863 n4995 0.044642857142857144
r8606 n4994 n4995 0.39583333333333331
r8607 n4864 n4996 0.15625
r8608 n4995 n4996 0.1875
r8609 n4865 n4997 0.078125
r8610 n4996 n4997 0.125
r8611 n4866 n4998 0.034722222222222224
r8612 n4997 n4998 0.27083333333333331
r8613 n4867 n4999 0.01488095238095238
r8614 n4998 n4999 0.625
r8615 n4868 n5000 0.15625
r8616 n4999 n5000 0.47916666666666669
r8617 n4869 n5001 0.15625
r8618 n5000 n5001 0.083333333333333329
r8619 n4870 n5002 0.034722222222222224
r8620 n5001 n5002 0.22916666666666666
r8621 n4871 n5003 0.026041666666666668
r8622 n5002 n5003 0.4375
r8623 n4872 n5004 0.034722222222222224
r8624 n5003 n5004 0.4375
r8625 n4873 n5005 0.15625
r8626 n5004 n5005 0.22916666666666666
r8627 n4874 n5006 0.15625
r8628 n5005 n5006 0.083333333333333329
r8629 n4875 n5007 0.01488095238095238
r8630 n5006 n5007 0.47916666666666669
r8631 n4876 n5008 0.020833333333333332
r8632 n5007 n5008 0.75
r8633 n4877 n5009 0.15625
r8634 n5008 n5009 0.35416666666666669
r8635 n4878 n5010 0.009765625
r8636 n5009 n5010 0.70833333333333337
r8637 n4879 n5011 0.15625
r8638 n5010 n5011 0.70833333333333337
r8639 n4880 n5012 0.026041666666666668
r8640 n5011 n5012 0.29166666666666669
r8641 n4883 n5013 0.10416666666666667
r8642 n4884 n5014 0.10416666666666667
r8643 n5013 n5014 0.125
r8644 n4885 n5015 0.15625
r8645 n5014 n5015 0.10416666666666667
r8646 n4886 n5016 0.0390625
r8647 n5015 n5016 0.20833333333333334
r8648 n4887 n5017 0.014204545454545454
r8649 n5016 n5017 0.625
r8650 n4888 n5018 0.15625
r8651 n5017 n5018 0.5
r8652 n4889 n5019 0.10416666666666667
r8653 n5018 n5019 0.10416666666666667
r8654 n4890 n5020 0.10416666666666667
r8655 n5019 n5020 0.125
r8656 n4894 n5021 0.03125
r8657 n4895 n5022 0.15625
r8658 n5021 n5022 0.25
r8659 n4896 n5023 0.009765625
r8660 n5022 n5023 0.70833333333333337
r8661 n4897 n5024 0.15625
r8662 n5023 n5024 0.70833333333333337
r8663 n4898 n5025 0.0086805555555555559
r8664 n5024 n5025 0.79166666666666663
r8665 n4899 n5026 0.15625
r8666 n5025 n5026 0.79166666666666663
r8667 n4900 n5027 0.009765625
r8668 n5026 n5027 0.70833333333333337
r8669 n4901 n5028 0.15625
r8670 n5027 n5028 0.70833333333333337
r8671 n4902 n5029 0.0086805555555555559
r8672 n5028 n5029 0.79166666666666663
r8673 n4903 n5030 0.15625
r8674 n5029 n5030 0.79166666666666663
r8675 n4904 n5031 0.009765625
r8676 n5030 n5031 0.70833333333333337
r8677 n4905 n5032 0.15625
r8678 n5031 n5032 0.70833333333333337
r8679 n4906 n5033 0.0086805555555555559
r8680 n5032 n5033 0.79166666666666663
r8681 n4907 n5034 0.15625
r8682 n5033 n5034 0.79166666666666663
r8683 n4908 n5035 0.009765625
r8684 n5034 n5035 0.70833333333333337
r8685 n4909 n5036 0.15625
r8686 n5035 n5036 0.70833333333333337
r8687 n4910 n5037 0.0086805555555555559
r8688 n5036 n5037 0.79166666666666663
r8689 n4911 n5038 0.15625
r8690 n5037 n5038 0.79166666666666663
r8691 n4912 n5039 0.009765625
r8692 n5038 n5039 0.70833333333333337
r8693 n4913 n5040 0.15625
r8694 n5039 n5040 0.70833333333333337
r8695 n4914 n5041 0.0086805555555555559
r8696 n5040 n5041 0.79166666666666663
r8697 n4915 n5042 0.15625
r8698 n5041 n5042 0.79166666666666663
r8699 n4916 n5043 0.009765625
r8700 n5042 n5043 0.70833333333333337
r8701 n4917 n5044 0.15625
r8702 n5043 n5044 0.70833333333333337
r8703 n4918 n5045 0.0086805555555555559
r8704 n5044 n5045 0.79166666666666663
r8705 n4919 n5046 0.15625
r8706 n5045 n5046 0.79166666666666663
r8707 n4920 n5047 0.009765625
r8708 n5046 n5047 0.70833333333333337
r8709 n4921 n5048 0.15625
r8710 n5047 n5048 0.70833333333333337
r8711 n4922 n5049 0.0086805555555555559
r8712 n5048 n5049 0.79166666666666663
r8713 n4923 n5050 0.15625
r8714 n5049 n5050 0.79166666666666663
r8715 n4924 n5051 0.009765625
r8716 n5050 n5051 0.70833333333333337
r8717 n4925 n5052 0.15625
r8718 n5051 n5052 0.70833333333333337
r8719 n4926 n5053 0.020833333333333332
r8720 n5052 n5053 0.35416666666666669
r8721 n4927 n5054 0.026041666666666668
r8722 n5053 n5054 0.5625
r8723 n4928 n5055 0.034722222222222224
r8724 n5054 n5055 0.4375
r8725 n4929 n5056 0.15625
r8726 n5055 n5056 0.22916666666666666
r8727 n4930 n5057 0.15625
r8728 n5056 n5057 0.083333333333333329
r8729 n4931 n5058 0.0390625
r8730 n5057 n5058 0.20833333333333334
r8731 n4932 n5059 0.014204545454545454
r8732 n5058 n5059 0.625
r8733 n4933 n5060 0.3125
r8734 n5059 n5060 0.47916666666666669
r8735 n4934 n5061 0.3125
r8736 n5060 n5061 0.041666666666666664
r8737 n4935 n5062 0.3125
r8738 n5061 n5062 0.041666666666666664
r8739 n4936 n5063 0.03125
r8740 n5062 n5063 0.22916666666666666
r8741 n4937 n5064 0.026041666666666668
r8742 n5063 n5064 0.45833333333333331
r8743 n4938 n5065 0.0390625
r8744 n5064 n5065 0.41666666666666669
r8745 n4939 n5066 0.15625
r8746 n5065 n5066 0.20833333333333334
r8747 n4940 n5067 0.10416666666666667
r8748 n5066 n5067 0.10416666666666667
r8749 n4941 n5068 0.15625
r8750 n5067 n5068 0.10416666666666667
r8751 n4942 n5069 0.052083333333333336
r8752 n5068 n5069 0.16666666666666666
r8753 n4943 n5070 0.026041666666666668
r8754 n5069 n5070 0.375
r8755 n4944 n5071 0.022321428571428572
r8756 n5070 n5071 0.54166666666666663
r8757 n4945 n5072 0.15625
r8758 n5071 n5072 0.33333333333333331
r8759 n4946 n5073 0.0086805555555555559
r8760 n5072 n5073 0.79166666666666663
r8761 n4947 n5074 0.15625
r8762 n5073 n5074 0.79166666666666663
r8763 n4948 n5075 0.009765625
r8764 n5074 n5075 0.70833333333333337
r8765 n4949 n5076 0.15625
r8766 n5075 n5076 0.70833333333333337
r8767 n4950 n5077 0.0086805555555555559
r8768 n5076 n5077 0.79166666666666663
r8769 n4951 n5078 0.15625
r8770 n5077 n5078 0.79166666666666663
r8771 n4952 n5079 0.009765625
r8772 n5078 n5079 0.70833333333333337
r8773 n4953 n5080 0.15625
r8774 n5079 n5080 0.70833333333333337
r8775 n4954 n5081 0.0086805555555555559
r8776 n5080 n5081 0.79166666666666663
r8777 n4955 n5082 0.15625
r8778 n5081 n5082 0.79166666666666663
r8779 n4956 n5083 0.009765625
r8780 n5082 n5083 0.70833333333333337
r8781 n4957 n5084 0.15625
r8782 n5083 n5084 0.70833333333333337
r8783 n4958 n5085 0.0086805555555555559
r8784 n5084 n5085 0.79166666666666663
r8785 n4959 n5086 0.15625
r8786 n5085 n5086 0.79166666666666663
r8787 n4960 n5087 0.009765625
r8788 n5086 n5087 0.70833333333333337
r8789 n4961 n5088 0.15625
r8790 n5087 n5088 0.70833333333333337
r8791 n4962 n5089 0.0086805555555555559
r8792 n5088 n5089 0.79166666666666663
r8793 n4963 n5090 0.15625
r8794 n5089 n5090 0.79166666666666663
r8795 n4964 n5091 0.009765625
r8796 n5090 n5091 0.70833333333333337
r8797 n4965 n5092 0.15625
r8798 n5091 n5092 0.70833333333333337
r8799 n4966 n5093 0.0086805555555555559
r8800 n5092 n5093 0.79166666666666663
r8801 n4967 n5094 0.15625
r8802 n5093 n5094 0.79166666666666663
r8803 n4968 n5095 0.009765625
r8804 n5094 n5095 0.70833333333333337
r8805 n4969 n5096 0.15625
r8806 n5095 n5096 0.70833333333333337
r8807 n4970 n5097 0.0086805555555555559
r8808 n5096 n5097 0.79166666666666663
r8809 n4971 n5098 0.15625
r8810 n5097 n5098 0.79166666666666663
r8811 n4972 n5099 0.009765625
r8812 n5098 n5099 0.70833333333333337
r8813 n4973 n5100 0.15625
r8814 n5099 n5100 0.70833333333333337
r8815 n4974 n5101 0.026041666666666668
r8816 n5100 n5101 0.29166666666666669
r8817 n4977 n5102 0.10416666666666667
r8818 n4978 n5103 0.10416666666666667
r8819 n5102 n5103 0.125
r8820 n4979 n5104 0.15625
r8821 n5103 n5104 0.10416666666666667
r8822 n4980 n5105 0.028409090909090908
r8823 n5104 n5105 0.27083333333333331
r8824 n4981 n5106 0.016447368421052631
r8825 n5105 n5106 0.625
r8826 n4982 n5107 0.15625
r8827 n5106 n5107 0.4375
r8828 n4983 n5108 0.10416666666666667
r8829 n5107 n5108 0.10416666666666667
r8830 n4984 n5109 0.10416666666666667
r8831 n5108 n5109 0.125
r8832 n4987 n5110 0.043749999999999997
r8833 n4988 n5111 0.21875
r8834 n5110 n5111 0.1875
r8835 n4989 n5112 0.013671875
r8836 n5111 n5112 0.53125
r8837 n4990 n5113 0.21875
r8838 n5112 n5113 0.53125
r8839 n4991 n5114 0.012152777777777778
r8840 n5113 n5114 0.59375
r8841 n4992 n5115 0.21875
r8842 n5114 n5115 0.59375
r8843 n4993 n5116 0.033653846153846152
r8844 n5115 n5116 0.234375
r8845 n4994 n5117 0.036458333333333336
r8846 n5116 n5117 0.390625
r8847 n4995 n5118 0.0625
r8848 n5117 n5118 0.296875
r8849 n4996 n5119 0.21875
r8850 n5118 n5119 0.140625
r8851 n4997 n5120 0.109375
r8852 n5119 n5120 0.09375
r8853 n4998 n5121 0.048611111111111112
r8854 n5120 n5121 0.203125
r8855 n4999 n5122 0.020833333333333332
r8856 n5121 n5122 0.46875
r8857 n5000 n5123 0.21875
r8858 n5122 n5123 0.359375
r8859 n5001 n5124 0.21875
r8860 n5123 n5124 0.0625
r8861 n5002 n5125 0.048611111111111112
r8862 n5124 n5125 0.171875
r8863 n5003 n5126 0.036458333333333336
r8864 n5125 n5126 0.328125
r8865 n5004 n5127 0.048611111111111112
r8866 n5126 n5127 0.328125
r8867 n5005 n5128 0.21875
r8868 n5127 n5128 0.171875
r8869 n5006 n5129 0.21875
r8870 n5128 n5129 0.0625
r8871 n5007 n5130 0.020833333333333332
r8872 n5129 n5130 0.359375
r8873 n5008 n5131 0.029166666666666667
r8874 n5130 n5131 0.5625
r8875 n5009 n5132 0.21875
r8876 n5131 n5132 0.265625
r8877 n5010 n5133 0.013671875
r8878 n5132 n5133 0.53125
r8879 n5011 n5134 0.21875
r8880 n5133 n5134 0.53125
r8881 n5012 n5135 0.036458333333333336
r8882 n5134 n5135 0.21875
r8883 n5013 n5136 0.14583333333333334
r8884 n5014 n5137 0.14583333333333334
r8885 n5136 n5137 0.09375
r8886 n5015 n5138 0.21875
r8887 n5137 n5138 0.078125
r8888 n5016 n5139 0.0546875
r8889 n5138 n5139 0.15625
r8890 n5017 n5140 0.019886363636363636
r8891 n5139 n5140 0.46875
r8892 n5018 n5141 0.21875
r8893 n5140 n5141 0.375
r8894 n5019 n5142 0.14583333333333334
r8895 n5141 n5142 0.078125
r8896 n5020 n5143 0.14583333333333334
r8897 n5142 n5143 0.09375
r8898 n5021 n5144 0.043749999999999997
r8899 n5022 n5145 0.21875
r8900 n5144 n5145 0.1875
r8901 n5023 n5146 0.013671875
r8902 n5145 n5146 0.53125
r8903 n5024 n5147 0.21875
r8904 n5146 n5147 0.53125
r8905 n5025 n5148 0.012152777777777778
r8906 n5147 n5148 0.59375
r8907 n5026 n5149 0.21875
r8908 n5148 n5149 0.59375
r8909 n5027 n5150 0.013671875
r8910 n5149 n5150 0.53125
r8911 n5028 n5151 0.21875
r8912 n5150 n5151 0.53125
r8913 n5029 n5152 0.012152777777777778
r8914 n5151 n5152 0.59375
r8915 n5030 n5153 0.21875
r8916 n5152 n5153 0.59375
r8917 n5031 n5154 0.013671875
r8918 n5153 n5154 0.53125
r8919 n5032 n5155 0.21875
r8920 n5154 n5155 0.53125
r8921 n5033 n5156 0.012152777777777778
r8922 n5155 n5156 0.59375
r8923 n5034 n5157 0.21875
r8924 n5156 n5157 0.59375
r8925 n5035 n5158 0.013671875
r8926 n5157 n5158 0.53125
r8927 n5036 n5159 0.21875
r8928 n5158 n5159 0.53125
r8929 n5037 n5160 0.012152777777777778
r8930 n5159 n5160 0.59375
r8931 n5038 n5161 0.21875
r8932 n5160 n5161 0.59375
r8933 n5039 n5162 0.013671875
r8934 n5161 n5162 0.53125
r8935 n5040 n5163 0.21875
r8936 n5162 n5163 0.53125
r8937 n5041 n5164 0.012152777777777778
r8938 n5163 n5164 0.59375
r8939 n5042 n5165 0.21875
r8940 n5164 n5165 0.59375
r8941 n5043 n5166 0.013671875
r8942 n5165 n5166 0.53125
r8943 n5044 n5167 0.21875
r8944 n5166 n5167 0.53125
r8945 n5045 n5168 0.012152777777777778
r8946 n5167 n5168 0.59375
r8947 n5046 n5169 0.21875
r8948 n5168 n5169 0.59375
r8949 n5047 n5170 0.013671875
r8950 n5169 n5170 0.53125
r8951 n5048 n5171 0.21875
r8952 n5170 n5171 0.53125
r8953 n5049 n5172 0.012152777777777778
r8954 n5171 n5172 0.59375
r8955 n5050 n5173 0.21875
r8956 n5172 n5173 0.59375
r8957 n5051 n5174 0.013671875
r8958 n5173 n5174 0.53125
r8959 n5052 n5175 0.21875
r8960 n5174 n5175 0.53125
r8961 n5053 n5176 0.029166666666666667
r8962 n5175 n5176 0.265625
r8963 n5054 n5177 0.036458333333333336
r8964 n5176 n5177 0.421875
r8965 n5055 n5178 0.048611111111111112
r8966 n5177 n5178 0.328125
r8967 n5056 n5179 0.21875
r8968 n5178 n5179 0.171875
r8969 n5057 n5180 0.21875
r8970 n5179 n5180 0.0625
r8971 n5058 n5181 0.0546875
r8972 n5180 n5181 0.15625
r8973 n5059 n5182 0.019886363636363636
r8974 n5181 n5182 0.46875
r8975 n5060 n5183 0.4375
r8976 n5182 n5183 0.359375
r8977 n5061 n5184 0.4375
r8978 n5183 n5184 0.03125
r8979 n5062 n5185 0.4375
r8980 n5184 n5185 0.03125
r8981 n5063 n5186 0.043749999999999997
r8982 n5185 n5186 0.171875
r8983 n5064 n5187 0.036458333333333336
r8984 n5186 n5187 0.34375
r8985 n5065 n5188 0.0546875
r8986 n5187 n5188 0.3125
r8987 n5066 n5189 0.21875
r8988 n5188 n5189 0.15625
r8989 n5067 n5190 0.14583333333333334
r8990 n5189 n5190 0.078125
r8991 n5068 n5191 0.21875
r8992 n5190 n5191 0.078125
r8993 n5069 n5192 0.072916666666666671
r8994 n5191 n5192 0.125
r8995 n5070 n5193 0.036458333333333336
r8996 n5192 n5193 0.28125
r8997 n5071 n5194 0.03125
r8998 n5193 n5194 0.40625
r8999 n5072 n5195 0.21875
r9000 n5194 n5195 0.25
r9001 n5073 n5196 0.012152777777777778
r9002 n5195 n5196 0.59375
r9003 n5074 n5197 0.21875
r9004 n5196 n5197 0.59375
r9005 n5075 n5198 0.013671875
r9006 n5197 n5198 0.53125
r9007 n5076 n5199 0.21875
r9008 n5198 n5199 0.53125
r9009 n5077 n5200 0.012152777777777778
r9010 n5199 n5200 0.59375
r9011 n5078 n5201 0.21875
r9012 n5200 n5201 0.59375
r9013 n5079 n5202 0.013671875
r9014 n5201 n5202 0.53125
r9015 n5080 n5203 0.21875
r9016 n5202 n5203 0.53125
r9017 n5081 n5204 0.012152777777777778
r9018 n5203 n5204 0.59375
r9019 n5082 n5205 0.21875
r9020 n5204 n5205 0.59375
r9021 n5083 n5206 0.013671875
r9022 n5205 n5206 0.53125
r9023 n5084 n5207 0.21875
r9024 n5206 n5207 0.53125
r9025 n5085 n5208 0.012152777777777778
r9026 n5207 n5208 0.59375
r9027 n5086 n5209 0.21875
r9028 n5208 n5209 0.59375
r9029 n5087 n5210 0.013671875
r9030 n5209 n5210 0.53125
r9031 n5088 n5211 0.21875
r9032 n5210 n5211 0.53125
r9033 n5089 n5212 0.012152777777777778
r9034 n5211 n5212 0.59375
r9035 n5090 n5213 0.21875
r9036 n5212 n5213 0.59375
r9037 n5091 n5214 0.013671875
r9038 n5213 n5214 0.53125
r9039 n5092 n5215 0.21875
r9040 n5214 n5215 0.53125
r9041 n5093 n5216 0.012152777777777778
r9042 n5215 n5216 0.59375
r9043 n5094 n5217 0.21875
r9044 n5216 n5217 0.59375
r9045 n5095 n5218 0.013671875
r9046 n5217 n5218 0.53125
r9047 n5096 n5219 0.21875
r9048 n5218 n5219 0.53125
r9049 n5097 n5220 0.012152777777777778
r9050 n5219 n5220 0.59375
r9051 n5098 n5221 0.21875
r9052 n5220 n5221 0.59375
r9053 n5099 n5222 0.013671875
r9054 n5221 n5222 0.53125
r9055 n5100 n5223 0.21875
r9056 n5222 n5223 0.53125
r9057 n5101 n5224 0.036458333333333336
r9058 n5223 n5224 0.21875
r9059 n5102 n5225 0.14583333333333334
r9060 n5103 n5226 0.14583333333333334
r9061 n5225 n5226 0.09375
r9062 n5104 n5227 0.21875
r9063 n5226 n5227 0.078125
r9064 n5105 n5228 0.039772727272727272
r9065 n5227 n5228 0.203125
r9066 n5106 n5229 0.023026315789473683
r9067 n5228 n5229 0.46875
r9068 n5107 n5230 0.21875
r9069 n5229 n5230 0.328125
r9070 n5108 n5231 0.14583333333333334
r9071 n5230 n5231 0.078125
r9072 n5109 n5232 0.14583333333333334
r9073 n5231 n5232 0.09375
r9074 n5110 n5233 0.043749999999999997
r9075 n5111 n5234 0.21875
r9076 n5233 n5234 0.25
r9077 n5112 n5235 0.013671875
r9078 n5234 n5235 0.70833333333333337
r9079 n5113 n5236 0.21875
r9080 n5235 n5236 0.70833333333333337
r9081 n5114 n5237 0.012152777777777778
r9082 n5236 n5237 0.79166666666666663
r9083 n5115 n5238 0.21875
r9084 n5237 n5238 0.79166666666666663
r9085 n5116 n5239 0.033653846153846152
r9086 n5238 n5239 0.3125
r9087 n5117 n5240 0.036458333333333336
r9088 n5239 n5240 0.52083333333333337
r9089 n5118 n5241 0.0625
r9090 n5240 n5241 0.39583333333333331
r9091 n5119 n5242 0.21875
r9092 n5241 n5242 0.1875
r9093 n5120 n5243 0.109375
r9094 n5242 n5243 0.125
r9095 n5121 n5244 0.048611111111111112
r9096 n5243 n5244 0.27083333333333331
r9097 n5122 n5245 0.020833333333333332
r9098 n5244 n5245 0.625
r9099 n5123 n5246 0.21875
r9100 n5245 n5246 0.47916666666666669
r9101 n5124 n5247 0.21875
r9102 n5246 n5247 0.083333333333333329
r9103 n5125 n5248 0.048611111111111112
r9104 n5247 n5248 0.22916666666666666
r9105 n5126 n5249 0.036458333333333336
r9106 n5248 n5249 0.4375
r9107 n5127 n5250 0.048611111111111112
r9108 n5249 n5250 0.4375
r9109 n5128 n5251 0.21875
r9110 n5250 n5251 0.22916666666666666
r9111 n5129 n5252 0.21875
r9112 n5251 n5252 0.083333333333333329
r9113 n5130 n5253 0.020833333333333332
r9114 n5252 n5253 0.47916666666666669
r9115 n5131 n5254 0.029166666666666667
r9116 n5253 n5254 0.75
r9117 n5132 n5255 0.21875
r9118 n5254 n5255 0.35416666666666669
r9119 n5133 n5256 0.013671875
r9120 n5255 n5256 0.70833333333333337
r9121 n5134 n5257 0.21875
r9122 n5256 n5257 0.70833333333333337
r9123 n5135 n5258 0.036458333333333336
r9124 n5257 n5258 0.29166666666666669
r9125 n5144 n5259 0.043749999999999997
r9126 n5145 n5260 0.21875
r9127 n5259 n5260 0.25
r9128 n5146 n5261 0.013671875
r9129 n5260 n5261 0.70833333333333337
r9130 n5147 n5262 0.21875
r9131 n5261 n5262 0.70833333333333337
r9132 n5148 n5263 0.012152777777777778
r9133 n5262 n5263 0.79166666666666663
r9134 n5149 n5264 0.21875
r9135 n5263 n5264 0.79166666666666663
r9136 n5150 n5265 0.013671875
r9137 n5264 n5265 0.70833333333333337
r9138 n5151 n5266 0.21875
r9139 n5265 n5266 0.70833333333333337
r9140 n5152 n5267 0.012152777777777778
r9141 n5266 n5267 0.79166666666666663
r9142 n5153 n5268 0.21875
r9143 n5267 n5268 0.79166666666666663
r9144 n5154 n5269 0.013671875
r9145 n5268 n5269 0.70833333333333337
r9146 n5155 n5270 0.21875
r9147 n5269 n5270 0.70833333333333337
r9148 n5156 n5271 0.012152777777777778
r9149 n5270 n5271 0.79166666666666663
r9150 n5157 n5272 0.21875
r9151 n5271 n5272 0.79166666666666663
r9152 n5158 n5273 0.013671875
r9153 n5272 n5273 0.70833333333333337
r9154 n5159 n5274 0.21875
r9155 n5273 n5274 0.70833333333333337
r9156 n5160 n5275 0.012152777777777778
r9157 n5274 n5275 0.79166666666666663
r9158 n5161 n5276 0.21875
r9159 n5275 n5276 0.79166666666666663
r9160 n5162 n5277 0.013671875
r9161 n5276 n5277 0.70833333333333337
r9162 n5163 n5278 0.21875
r9163 n5277 n5278 0.70833333333333337
r9164 n5164 n5279 0.012152777777777778
r9165 n5278 n5279 0.79166666666666663
r9166 n5165 n5280 0.21875
r9167 n5279 n5280 0.79166666666666663
r9168 n5166 n5281 0.013671875
r9169 n5280 n5281 0.70833333333333337
r9170 n5167 n5282 0.21875
r9171 n5281 n5282 0.70833333333333337
r9172 n5168 n5283 0.012152777777777778
r9173 n5282 n5283 0.79166666666666663
r9174 n5169 n5284 0.21875
r9175 n5283 n5284 0.79166666666666663
r9176 n5170 n5285 0.013671875
r9177 n5284 n5285 0.70833333333333337
r9178 n5171 n5286 0.21875
r9179 n5285 n5286 0.70833333333333337
r9180 n5172 n5287 0.012152777777777778
r9181 n5286 n5287 0.79166666666666663
r9182 n5173 n5288 0.21875
r9183 n5287 n5288 0.79166666666666663
r9184 n5174 n5289 0.013671875
r9185 n5288 n5289 0.70833333333333337
r9186 n5175 n5290 0.21875
r9187 n5289 n5290 0.70833333333333337
r9188 n5176 n5291 0.029166666666666667
r9189 n5290 n5291 0.35416666666666669
r9190 n5177 n5292 0.036458333333333336
r9191 n5291 n5292 0.5625
r9192 n5178 n5293 0.048611111111111112
r9193 n5292 n5293 0.4375
r9194 n5179 n5294 0.21875
r9195 n5293 n5294 0.22916666666666666
r9196 n5180 n5295 0.21875
r9197 n5294 n5295 0.083333333333333329
r9198 n5181 n5296 0.0546875
r9199 n5295 n5296 0.20833333333333334
r9200 n5182 n5297 0.019886363636363636
r9201 n5296 n5297 0.625
r9202 n5183 n5298 0.4375
r9203 n5297 n5298 0.47916666666666669
r9204 n5184 n5299 0.4375
r9205 n5298 n5299 0.041666666666666664
r9206 n5185 n5300 0.4375
r9207 n5299 n5300 0.041666666666666664
r9208 n5186 n5301 0.043749999999999997
r9209 n5300 n5301 0.22916666666666666
r9210 n5187 n5302 0.036458333333333336
r9211 n5301 n5302 0.45833333333333331
r9212 n5188 n5303 0.0546875
r9213 n5302 n5303 0.41666666666666669
r9214 n5189 n5304 0.21875
r9215 n5303 n5304 0.20833333333333334
r9216 n5190 n5305 0.14583333333333334
r9217 n5304 n5305 0.10416666666666667
r9218 n5191 n5306 0.21875
r9219 n5305 n5306 0.10416666666666667
r9220 n5192 n5307 0.072916666666666671
r9221 n5306 n5307 0.16666666666666666
r9222 n5193 n5308 0.036458333333333336
r9223 n5307 n5308 0.375
r9224 n5194 n5309 0.03125
r9225 n5308 n5309 0.54166666666666663
r9226 n5195 n5310 0.21875
r9227 n5309 n5310 0.33333333333333331
r9228 n5196 n5311 0.012152777777777778
r9229 n5310 n5311 0.79166666666666663
r9230 n5197 n5312 0.21875
r9231 n5311 n5312 0.79166666666666663
r9232 n5198 n5313 0.013671875
r9233 n5312 n5313 0.70833333333333337
r9234 n5199 n5314 0.21875
r9235 n5313 n5314 0.70833333333333337
r9236 n5200 n5315 0.012152777777777778
r9237 n5314 n5315 0.79166666666666663
r9238 n5201 n5316 0.21875
r9239 n5315 n5316 0.79166666666666663
r9240 n5202 n5317 0.013671875
r9241 n5316 n5317 0.70833333333333337
r9242 n5203 n5318 0.21875
r9243 n5317 n5318 0.70833333333333337
r9244 n5204 n5319 0.012152777777777778
r9245 n5318 n5319 0.79166666666666663
r9246 n5205 n5320 0.21875
r9247 n5319 n5320 0.79166666666666663
r9248 n5206 n5321 0.013671875
r9249 n5320 n5321 0.70833333333333337
r9250 n5207 n5322 0.21875
r9251 n5321 n5322 0.70833333333333337
r9252 n5208 n5323 0.012152777777777778
r9253 n5322 n5323 0.79166666666666663
r9254 n5209 n5324 0.21875
r9255 n5323 n5324 0.79166666666666663
r9256 n5210 n5325 0.013671875
r9257 n5324 n5325 0.70833333333333337
r9258 n5211 n5326 0.21875
r9259 n5325 n5326 0.70833333333333337
r9260 n5212 n5327 0.012152777777777778
r9261 n5326 n5327 0.79166666666666663
r9262 n5213 n5328 0.21875
r9263 n5327 n5328 0.79166666666666663
r9264 n5214 n5329 0.013671875
r9265 n5328 n5329 0.70833333333333337
r9266 n5215 n5330 0.21875
r9267 n5329 n5330 0.70833333333333337
r9268 n5216 n5331 0.012152777777777778
r9269 n5330 n5331 0.79166666666666663
r9270 n5217 n5332 0.21875
r9271 n5331 n5332 0.79166666666666663
r9272 n5218 n5333 0.013671875
r9273 n5332 n5333 0.70833333333333337
r9274 n5219 n5334 0.21875
r9275 n5333 n5334 0.70833333333333337
r9276 n5220 n5335 0.012152777777777778
r9277 n5334 n5335 0.79166666666666663
r9278 n5221 n5336 0.21875
r9279 n5335 n5336 0.79166666666666663
r9280 n5222 n5337 0.013671875
r9281 n5336 n5337 0.70833333333333337
r9282 n5223 n5338 0.21875
r9283 n5337 n5338 0.70833333333333337
r9284 n5224 n5339 0.036458333333333336
r9285 n5338 n5339 0.29166666666666669
r9286 n5233 n5340 0.1125
r9287 n5234 n5341 0.5625
r9288 n5340 n5341 0.050000000000000003
r9289 n5235 n5342 0.03515625
r9290 n5341 n5342 0.14166666666666666
r9291 n5236 n5343 0.5625
r9292 n5342 n5343 0.14166666666666666
r9293 n5237 n5344 0.03125
r9294 n5343 n5344 0.15833333333333333
r9295 n5238 n5345 0.5625
r9296 n5344 n5345 0.15833333333333333
r9297 n5239 n5346 0.086538461538461536
r9298 n5345 n5346 0.0625
r9299 n5240 n5347 0.09375
r9300 n5346 n5347 0.10416666666666667
r9301 n5241 n5348 0.16071428571428573
r9302 n5347 n5348 0.079166666666666663
r9303 n5242 n5349 0.5625
r9304 n5348 n5349 0.037499999999999999
r9305 n5243 n5350 0.28125
r9306 n5349 n5350 0.025000000000000001
r9307 n5244 n5351 0.125
r9308 n5350 n5351 0.054166666666666669
r9309 n5245 n5352 0.053571428571428568
r9310 n5351 n5352 0.125
r9311 n5246 n5353 0.5625
r9312 n5352 n5353 0.09583333333333334
r9313 n5247 n5354 0.5625
r9314 n5353 n5354 0.016666666666666666
r9315 n5248 n5355 0.125
r9316 n5354 n5355 0.04583333333333333
r9317 n5249 n5356 0.09375
r9318 n5355 n5356 0.087499999999999994
r9319 n5250 n5357 0.125
r9320 n5356 n5357 0.087499999999999994
r9321 n5251 n5358 0.5625
r9322 n5357 n5358 0.04583333333333333
r9323 n5252 n5359 0.5625
r9324 n5358 n5359 0.016666666666666666
r9325 n5253 n5360 0.053571428571428568
r9326 n5359 n5360 0.09583333333333334
r9327 n5254 n5361 0.074999999999999997
r9328 n5360 n5361 0.14999999999999999
r9329 n5255 n5362 0.5625
r9330 n5361 n5362 0.070833333333333331
r9331 n5256 n5363 0.03515625
r9332 n5362 n5363 0.14166666666666666
r9333 n5257 n5364 0.5625
r9334 n5363 n5364 0.14166666666666666
r9335 n5258 n5365 0.09375
r9336 n5364 n5365 0.058333333333333334
r9337 n5259 n5366 0.1125
r9338 n5260 n5367 0.5625
r9339 n5366 n5367 0.050000000000000003
r9340 n5261 n5368 0.03515625
r9341 n5367 n5368 0.14166666666666666
r9342 n5262 n5369 0.5625
r9343 n5368 n5369 0.14166666666666666
r9344 n5263 n5370 0.03125
r9345 n5369 n5370 0.15833333333333333
r9346 n5264 n5371 0.5625
r9347 n5370 n5371 0.15833333333333333
r9348 n5265 n5372 0.03515625
r9349 n5371 n5372 0.14166666666666666
r9350 n5266 n5373 0.5625
r9351 n5372 n5373 0.14166666666666666
r9352 n5267 n5374 0.03125
r9353 n5373 n5374 0.15833333333333333
r9354 n5268 n5375 0.5625
r9355 n5374 n5375 0.15833333333333333
r9356 n5269 n5376 0.03515625
r9357 n5375 n5376 0.14166666666666666
r9358 n5270 n5377 0.5625
r9359 n5376 n5377 0.14166666666666666
r9360 n5271 n5378 0.03125
r9361 n5377 n5378 0.15833333333333333
r9362 n5272 n5379 0.5625
r9363 n5378 n5379 0.15833333333333333
r9364 n5273 n5380 0.03515625
r9365 n5379 n5380 0.14166666666666666
r9366 n5274 n5381 0.5625
r9367 n5380 n5381 0.14166666666666666
r9368 n5275 n5382 0.03125
r9369 n5381 n5382 0.15833333333333333
r9370 n5276 n5383 0.5625
r9371 n5382 n5383 0.15833333333333333
r9372 n5277 n5384 0.03515625
r9373 n5383 n5384 0.14166666666666666
r9374 n5278 n5385 0.5625
r9375 n5384 n5385 0.14166666666666666
r9376 n5279 n5386 0.03125
r9377 n5385 n5386 0.15833333333333333
r9378 n5280 n5387 0.5625
r9379 n5386 n5387 0.15833333333333333
r9380 n5281 n5388 0.03515625
r9381 n5387 n5388 0.14166666666666666
r9382 n5282 n5389 0.5625
r9383 n5388 n5389 0.14166666666666666
r9384 n5283 n5390 0.03125
r9385 n5389 n5390 0.15833333333333333
r9386 n5284 n5391 0.5625
r9387 n5390 n5391 0.15833333333333333
r9388 n5285 n5392 0.03515625
r9389 n5391 n5392 0.14166666666666666
r9390 n5286 n5393 0.5625
r9391 n5392 n5393 0.14166666666666666
r9392 n5287 n5394 0.03125
r9393 n5393 n5394 0.15833333333333333
r9394 n5288 n5395 0.5625
r9395 n5394 n5395 0.15833333333333333
r9396 n5289 n5396 0.03515625
r9397 n5395 n5396 0.14166666666666666
r9398 n5290 n5397 0.5625
r9399 n5396 n5397 0.14166666666666666
r9400 n5291 n5398 0.074999999999999997
r9401 n5397 n5398 0.070833333333333331
r9402 n5292 n5399 0.09375
r9403 n5398 n5399 0.1125
r9404 n5293 n5400 0.125
r9405 n5399 n5400 0.087499999999999994
r9406 n5294 n5401 0.5625
r9407 n5400 n5401 0.04583333333333333
r9408 n5295 n5402 0.5625
r9409 n5401 n5402 0.016666666666666666
r9410 n5296 n5403 0.140625
r9411 n5402 n5403 0.041666666666666664
r9412 n5297 n5404 0.05113636363636364
r9413 n5403 n5404 0.125
r9414 n5298 n5405 1.125
r9415 n5404 n5405 0.09583333333333334
r9416 n5299 n5406 1.125
r9417 n5405 n5406 0.0083333333333333332
r9418 n5300 n5407 1.125
r9419 n5406 n5407 0.0083333333333333332
r9420 n5301 n5408 0.1125
r9421 n5407 n5408 0.04583333333333333
r9422 n5302 n5409 0.09375
r9423 n5408 n5409 0.09166666666666666
r9424 n5303 n5410 0.140625
r9425 n5409 n5410 0.083333333333333329
r9426 n5304 n5411 0.5625
r9427 n5410 n5411 0.041666666666666664
r9428 n5305 n5412 0.375
r9429 n5411 n5412 0.020833333333333332
r9430 n5306 n5413 0.5625
r9431 n5412 n5413 0.020833333333333332
r9432 n5307 n5414 0.1875
r9433 n5413 n5414 0.033333333333333333
r9434 n5308 n5415 0.09375
r9435 n5414 n5415 0.074999999999999997
r9436 n5309 n5416 0.080357142857142863
r9437 n5415 n5416 0.10833333333333334
r9438 n5310 n5417 0.5625
r9439 n5416 n5417 0.066666666666666666
r9440 n5311 n5418 0.03125
r9441 n5417 n5418 0.15833333333333333
r9442 n5312 n5419 0.5625
r9443 n5418 n5419 0.15833333333333333
r9444 n5313 n5420 0.03515625
r9445 n5419 n5420 0.14166666666666666
r9446 n5314 n5421 0.5625
r9447 n5420 n5421 0.14166666666666666
r9448 n5315 n5422 0.03125
r9449 n5421 n5422 0.15833333333333333
r9450 n5316 n5423 0.5625
r9451 n5422 n5423 0.15833333333333333
r9452 n5317 n5424 0.03515625
r9453 n5423 n5424 0.14166666666666666
r9454 n5318 n5425 0.5625
r9455 n5424 n5425 0.14166666666666666
r9456 n5319 n5426 0.03125
r9457 n5425 n5426 0.15833333333333333
r9458 n5320 n5427 0.5625
r9459 n5426 n5427 0.15833333333333333
r9460 n5321 n5428 0.03515625
r9461 n5427 n5428 0.14166666666666666
r9462 n5322 n5429 0.5625
r9463 n5428 n5429 0.14166666666666666
r9464 n5323 n5430 0.03125
r9465 n5429 n5430 0.15833333333333333
r9466 n5324 n5431 0.5625
r9467 n5430 n5431 0.15833333333333333
r9468 n5325 n5432 0.03515625
r9469 n5431 n5432 0.14166666666666666
r9470 n5326 n5433 0.5625
r9471 n5432 n5433 0.14166666666666666
r9472 n5327 n5434 0.03125
r9473 n5433 n5434 0.15833333333333333
r9474 n5328 n5435 0.5625
r9475 n5434 n5435 0.15833333333333333
r9476 n5329 n5436 0.03515625
r9477 n5435 n5436 0.14166666666666666
r9478 n5330 n5437 0.5625
r9479 n5436 n5437 0.14166666666666666
r9480 n5331 n5438 0.03125
r9481 n5437 n5438 0.15833333333333333
r9482 n5332 n5439 0.5625
r9483 n5438 n5439 0.15833333333333333
r9484 n5333 n5440 0.03515625
r9485 n5439 n5440 0.14166666666666666
r9486 n5334 n5441 0.5625
r9487 n5440 n5441 0.14166666666666666
r9488 n5335 n5442 0.03125
r9489 n5441 n5442 0.15833333333333333
r9490 n5336 n5443 0.5625
r9491 n5442 n5443 0.15833333333333333
r9492 n5337 n5444 0.03515625
r9493 n5443 n5444 0.14166666666666666
r9494 n5338 n5445 0.5625
r9495 n5444 n5445 0.14166666666666666
r9496 n5339 n5446 0.09375
r9497 n5445 n5446 0.058333333333333334
r9498 n5340 n5447 0.125
r9499 n5341 n5448 0.625
r9500 n5447 n5448 0.14999999999999999
r9501 n5342 n5449 0.0390625
r9502 n5448 n5449 0.42499999999999999
r9503 n5343 n5450 0.625
r9504 n5449 n5450 0.42499999999999999
r9505 n5344 n5451 0.034722222222222224
r9506 n5450 n5451 0.47499999999999998
r9507 n5345 n5452 0.625
r9508 n5451 n5452 0.47499999999999998
r9509 n5346 n5453 0.096153846153846159
r9510 n5452 n5453 0.1875
r9511 n5347 n5454 0.10416666666666667
r9512 n5453 n5454 0.3125
r9513 n5348 n5455 0.17857142857142858
r9514 n5454 n5455 0.23749999999999999
r9515 n5349 n5456 0.625
r9516 n5455 n5456 0.1125
r9517 n5350 n5457 0.3125
r9518 n5456 n5457 0.074999999999999997
r9519 n5351 n5458 0.1388888888888889
r9520 n5457 n5458 0.16250000000000001
r9521 n5352 n5459 0.059523809523809521
r9522 n5458 n5459 0.375
r9523 n5353 n5460 0.625
r9524 n5459 n5460 0.28749999999999998
r9525 n5354 n5461 0.625
r9526 n5460 n5461 0.050000000000000003
r9527 n5355 n5462 0.1388888888888889
r9528 n5461 n5462 0.13750000000000001
r9529 n5356 n5463 0.10416666666666667
r9530 n5462 n5463 0.26250000000000001
r9531 n5357 n5464 0.1388888888888889
r9532 n5463 n5464 0.26250000000000001
r9533 n5358 n5465 0.625
r9534 n5464 n5465 0.13750000000000001
r9535 n5359 n5466 0.625
r9536 n5465 n5466 0.050000000000000003
r9537 n5360 n5467 0.059523809523809521
r9538 n5466 n5467 0.28749999999999998
r9539 n5361 n5468 0.083333333333333329
r9540 n5467 n5468 0.45000000000000001
r9541 n5362 n5469 0.625
r9542 n5468 n5469 0.21249999999999999
r9543 n5363 n5470 0.0390625
r9544 n5469 n5470 0.42499999999999999
r9545 n5364 n5471 0.625
r9546 n5470 n5471 0.42499999999999999
r9547 n5365 n5472 0.10416666666666667
r9548 n5471 n5472 0.17499999999999999
r9549 n5366 n5473 0.125
r9550 n5367 n5474 0.625
r9551 n5473 n5474 0.14999999999999999
r9552 n5368 n5475 0.0390625
r9553 n5474 n5475 0.42499999999999999
r9554 n5369 n5476 0.625
r9555 n5475 n5476 0.42499999999999999
r9556 n5370 n5477 0.034722222222222224
r9557 n5476 n5477 0.47499999999999998
r9558 n5371 n5478 0.625
r9559 n5477 n5478 0.47499999999999998
r9560 n5372 n5479 0.0390625
r9561 n5478 n5479 0.42499999999999999
r9562 n5373 n5480 0.625
r9563 n5479 n5480 0.42499999999999999
r9564 n5374 n5481 0.034722222222222224
r9565 n5480 n5481 0.47499999999999998
r9566 n5375 n5482 0.625
r9567 n5481 n5482 0.47499999999999998
r9568 n5376 n5483 0.0390625
r9569 n5482 n5483 0.42499999999999999
r9570 n5377 n5484 0.625
r9571 n5483 n5484 0.42499999999999999
r9572 n5378 n5485 0.034722222222222224
r9573 n5484 n5485 0.47499999999999998
r9574 n5379 n5486 0.625
r9575 n5485 n5486 0.47499999999999998
r9576 n5380 n5487 0.0390625
r9577 n5486 n5487 0.42499999999999999
r9578 n5381 n5488 0.625
r9579 n5487 n5488 0.42499999999999999
r9580 n5382 n5489 0.034722222222222224
r9581 n5488 n5489 0.47499999999999998
r9582 n5383 n5490 0.625
r9583 n5489 n5490 0.47499999999999998
r9584 n5384 n5491 0.0390625
r9585 n5490 n5491 0.42499999999999999
r9586 n5385 n5492 0.625
r9587 n5491 n5492 0.42499999999999999
r9588 n5386 n5493 0.034722222222222224
r9589 n5492 n5493 0.47499999999999998
r9590 n5387 n5494 0.625
r9591 n5493 n5494 0.47499999999999998
r9592 n5388 n5495 0.0390625
r9593 n5494 n5495 0.42499999999999999
r9594 n5389 n5496 0.625
r9595 n5495 n5496 0.42499999999999999
r9596 n5390 n5497 0.034722222222222224
r9597 n5496 n5497 0.47499999999999998
r9598 n5391 n5498 0.625
r9599 n5497 n5498 0.47499999999999998
r9600 n5392 n5499 0.0390625
r9601 n5498 n5499 0.42499999999999999
r9602 n5393 n5500 0.625
r9603 n5499 n5500 0.42499999999999999
r9604 n5394 n5501 0.034722222222222224
r9605 n5500 n5501 0.47499999999999998
r9606 n5395 n5502 0.625
r9607 n5501 n5502 0.47499999999999998
r9608 n5396 n5503 0.0390625
r9609 n5502 n5503 0.42499999999999999
r9610 n5397 n5504 0.625
r9611 n5503 n5504 0.42499999999999999
r9612 n5398 n5505 0.083333333333333329
r9613 n5504 n5505 0.21249999999999999
r9614 n5399 n5506 0.10416666666666667
r9615 n5505 n5506 0.33750000000000002
r9616 n5400 n5507 0.1388888888888889
r9617 n5506 n5507 0.26250000000000001
r9618 n5401 n5508 0.625
r9619 n5507 n5508 0.13750000000000001
r9620 n5402 n5509 0.625
r9621 n5508 n5509 0.050000000000000003
r9622 n5403 n5510 0.15625
r9623 n5509 n5510 0.125
r9624 n5404 n5511 0.056818181818181816
r9625 n5510 n5511 0.375
r9626 n5405 n5512 1.25
r9627 n5511 n5512 0.28749999999999998
r9628 n5406 n5513 1.25
r9629 n5512 n5513 0.025000000000000001
r9630 n5407 n5514 1.25
r9631 n5513 n5514 0.025000000000000001
r9632 n5408 n5515 0.125
r9633 n5514 n5515 0.13750000000000001
r9634 n5409 n5516 0.10416666666666667
r9635 n5515 n5516 0.27500000000000002
r9636 n5410 n5517 0.15625
r9637 n5516 n5517 0.25
r9638 n5411 n5518 0.625
r9639 n5517 n5518 0.125
r9640 n5412 n5519 0.41666666666666669
r9641 n5518 n5519 0.0625
r9642 n5413 n5520 0.625
r9643 n5519 n5520 0.0625
r9644 n5414 n5521 0.20833333333333334
r9645 n5520 n5521 0.10000000000000001
r9646 n5415 n5522 0.10416666666666667
r9647 n5521 n5522 0.22500000000000001
r9648 n5416 n5523 0.089285714285714288
r9649 n5522 n5523 0.32500000000000001
r9650 n5417 n5524 0.625
r9651 n5523 n5524 0.20000000000000001
r9652 n5418 n5525 0.034722222222222224
r9653 n5524 n5525 0.47499999999999998
r9654 n5419 n5526 0.625
r9655 n5525 n5526 0.47499999999999998
r9656 n5420 n5527 0.0390625
r9657 n5526 n5527 0.42499999999999999
r9658 n5421 n5528 0.625
r9659 n5527 n5528 0.42499999999999999
r9660 n5422 n5529 0.034722222222222224
r9661 n5528 n5529 0.47499999999999998
r9662 n5423 n5530 0.625
r9663 n5529 n5530 0.47499999999999998
r9664 n5424 n5531 0.0390625
r9665 n5530 n5531 0.42499999999999999
r9666 n5425 n5532 0.625
r9667 n5531 n5532 0.42499999999999999
r9668 n5426 n5533 0.034722222222222224
r9669 n5532 n5533 0.47499999999999998
r9670 n5427 n5534 0.625
r9671 n5533 n5534 0.47499999999999998
r9672 n5428 n5535 0.0390625
r9673 n5534 n5535 0.42499999999999999
r9674 n5429 n5536 0.625
r9675 n5535 n5536 0.42499999999999999
r9676 n5430 n5537 0.034722222222222224
r9677 n5536 n5537 0.47499999999999998
r9678 n5431 n5538 0.625
r9679 n5537 n5538 0.47499999999999998
r9680 n5432 n5539 0.0390625
r9681 n5538 n5539 0.42499999999999999
r9682 n5433 n5540 0.625
r9683 n5539 n5540 0.42499999999999999
r9684 n5434 n5541 0.034722222222222224
r9685 n5540 n5541 0.47499999999999998
r9686 n5435 n5542 0.625
r9687 n5541 n5542 0.47499999999999998
r9688 n5436 n5543 0.0390625
r9689 n5542 n5543 0.42499999999999999
r9690 n5437 n5544 0.625
r9691 n5543 n5544 0.42499999999999999
r9692 n5438 n5545 0.034722222222222224
r9693 n5544 n5545 0.47499999999999998
r9694 n5439 n5546 0.625
r9695 n5545 n5546 0.47499999999999998
r9696 n5440 n5547 0.0390625
r9697 n5546 n5547 0.42499999999999999
r9698 n5441 n5548 0.625
r9699 n5547 n5548 0.42499999999999999
r9700 n5442 n5549 0.034722222222222224
r9701 n5548 n5549 0.47499999999999998
r9702 n5443 n5550 0.625
r9703 n5549 n5550 0.47499999999999998
r9704 n5444 n5551 0.0390625
r9705 n5550 n5551 0.42499999999999999
r9706 n5445 n5552 0.625
r9707 n5551 n5552 0.42499999999999999
r9708 n5446 n5553 0.10416666666666667
r9709 n5552 n5553 0.17499999999999999
r9710 n5447 n5554 0.043749999999999997
r9711 n5448 n5555 0.21875
r9712 n5554 n5555 0.375
r9713 n5449 n5556 0.013671875
r9714 n5555 n5556 1.0625
r9715 n5450 n5557 0.21875
r9716 n5556 n5557 1.0625
r9717 n5451 n5558 0.012152777777777778
r9718 n5557 n5558 1.1875
r9719 n5452 n5559 0.21875
r9720 n5558 n5559 1.1875
r9721 n5453 n5560 0.033653846153846152
r9722 n5559 n5560 0.46875
r9723 n5454 n5561 0.036458333333333336
r9724 n5560 n5561 0.78125
r9725 n5455 n5562 0.0625
r9726 n5561 n5562 0.59375
r9727 n5456 n5563 0.21875
r9728 n5562 n5563 0.28125
r9729 n5457 n5564 0.109375
r9730 n5563 n5564 0.1875
r9731 n5458 n5565 0.048611111111111112
r9732 n5564 n5565 0.40625
r9733 n5459 n5566 0.020833333333333332
r9734 n5565 n5566 0.9375
r9735 n5460 n5567 0.21875
r9736 n5566 n5567 0.71875
r9737 n5461 n5568 0.21875
r9738 n5567 n5568 0.125
r9739 n5462 n5569 0.048611111111111112
r9740 n5568 n5569 0.34375
r9741 n5463 n5570 0.036458333333333336
r9742 n5569 n5570 0.65625
r9743 n5464 n5571 0.048611111111111112
r9744 n5570 n5571 0.65625
r9745 n5465 n5572 0.21875
r9746 n5571 n5572 0.34375
r9747 n5466 n5573 0.21875
r9748 n5572 n5573 0.125
r9749 n5467 n5574 0.020833333333333332
r9750 n5573 n5574 0.71875
r9751 n5468 n5575 0.029166666666666667
r9752 n5574 n5575 1.125
r9753 n5469 n5576 0.21875
r9754 n5575 n5576 0.53125
r9755 n5470 n5577 0.013671875
r9756 n5576 n5577 1.0625
r9757 n5471 n5578 0.21875
r9758 n5577 n5578 1.0625
r9759 n5472 n5579 0.036458333333333336
r9760 n5578 n5579 0.4375
r9761 n5473 n5580 0.043749999999999997
r9762 n5474 n5581 0.21875
r9763 n5580 n5581 0.375
r9764 n5475 n5582 0.013671875
r9765 n5581 n5582 1.0625
r9766 n5476 n5583 0.21875
r9767 n5582 n5583 1.0625
r9768 n5477 n5584 0.012152777777777778
r9769 n5583 n5584 1.1875
r9770 n5478 n5585 0.21875
r9771 n5584 n5585 1.1875
r9772 n5479 n5586 0.013671875
r9773 n5585 n5586 1.0625
r9774 n5480 n5587 0.21875
r9775 n5586 n5587 1.0625
r9776 n5481 n5588 0.012152777777777778
r9777 n5587 n5588 1.1875
r9778 n5482 n5589 0.21875
r9779 n5588 n5589 1.1875
r9780 n5483 n5590 0.013671875
r9781 n5589 n5590 1.0625
r9782 n5484 n5591 0.21875
r9783 n5590 n5591 1.0625
r9784 n5485 n5592 0.012152777777777778
r9785 n5591 n5592 1.1875
r9786 n5486 n5593 0.21875
r9787 n5592 n5593 1.1875
r9788 n5487 n5594 0.013671875
r9789 n5593 n5594 1.0625
r9790 n5488 n5595 0.21875
r9791 n5594 n5595 1.0625
r9792 n5489 n5596 0.012152777777777778
r9793 n5595 n5596 1.1875
r9794 n5490 n5597 0.21875
r9795 n5596 n5597 1.1875
r9796 n5491 n5598 0.013671875
r9797 n5597 n5598 1.0625
r9798 n5492 n5599 0.21875
r9799 n5598 n5599 1.0625
r9800 n5493 n5600 0.012152777777777778
r9801 n5599 n5600 1.1875
r9802 n5494 n5601 0.21875
r9803 n5600 n5601 1.1875
r9804 n5495 n5602 0.013671875
r9805 n5601 n5602 1.0625
r9806 n5496 n5603 0.21875
r9807 n5602 n5603 1.0625
r9808 n5497 n5604 0.012152777777777778
r9809 n5603 n5604 1.1875
r9810 n5498 n5605 0.21875
r9811 n5604 n5605 1.1875
r9812 n5499 n5606 0.013671875
r9813 n5605 n5606 1.0625
r9814 n5500 n5607 0.21875
r9815 n5606 n5607 1.0625
r9816 n5501 n5608 0.012152777777777778
r9817 n5607 n5608 1.1875
r9818 n5502 n5609 0.21875
r9819 n5608 n5609 1.1875
r9820 n5503 n5610 0.013671875
r9821 n5609 n5610 1.0625
r9822 n5504 n5611 0.21875
r9823 n5610 n5611 1.0625
r9824 n5505 n5612 0.029166666666666667
r9825 n5611 n5612 0.53125
r9826 n5506 n5613 0.036458333333333336
r9827 n5612 n5613 0.84375
r9828 n5507 n5614 0.048611111111111112
r9829 n5613 n5614 0.65625
r9830 n5508 n5615 0.21875
r9831 n5614 n5615 0.34375
r9832 n5509 n5616 0.21875
r9833 n5615 n5616 0.125
r9834 n5510 n5617 0.0546875
r9835 n5616 n5617 0.3125
r9836 n5511 n5618 0.019886363636363636
r9837 n5617 n5618 0.9375
r9838 n5512 n5619 0.4375
r9839 n5618 n5619 0.71875
r9840 n5513 n5620 0.4375
r9841 n5619 n5620 0.0625
r9842 n5514 n5621 0.4375
r9843 n5620 n5621 0.0625
r9844 n5515 n5622 0.043749999999999997
r9845 n5621 n5622 0.34375
r9846 n5516 n5623 0.036458333333333336
r9847 n5622 n5623 0.6875
r9848 n5517 n5624 0.0546875
r9849 n5623 n5624 0.625
r9850 n5518 n5625 0.21875
r9851 n5624 n5625 0.3125
r9852 n5519 n5626 0.14583333333333334
r9853 n5625 n5626 0.15625
r9854 n5520 n5627 0.21875
r9855 n5626 n5627 0.15625
r9856 n5521 n5628 0.072916666666666671
r9857 n5627 n5628 0.25
r9858 n5522 n5629 0.036458333333333336
r9859 n5628 n5629 0.5625
r9860 n5523 n5630 0.03125
r9861 n5629 n5630 0.8125
r9862 n5524 n5631 0.21875
r9863 n5630 n5631 0.5
r9864 n5525 n5632 0.012152777777777778
r9865 n5631 n5632 1.1875
r9866 n5526 n5633 0.21875
r9867 n5632 n5633 1.1875
r9868 n5527 n5634 0.013671875
r9869 n5633 n5634 1.0625
r9870 n5528 n5635 0.21875
r9871 n5634 n5635 1.0625
r9872 n5529 n5636 0.012152777777777778
r9873 n5635 n5636 1.1875
r9874 n5530 n5637 0.21875
r9875 n5636 n5637 1.1875
r9876 n5531 n5638 0.013671875
r9877 n5637 n5638 1.0625
r9878 n5532 n5639 0.21875
r9879 n5638 n5639 1.0625
r9880 n5533 n5640 0.012152777777777778
r9881 n5639 n5640 1.1875
r9882 n5534 n5641 0.21875
r9883 n5640 n5641 1.1875
r9884 n5535 n5642 0.013671875
r9885 n5641 n5642 1.0625
r9886 n5536 n5643 0.21875
r9887 n5642 n5643 1.0625
r9888 n5537 n5644 0.012152777777777778
r9889 n5643 n5644 1.1875
r9890 n5538 n5645 0.21875
r9891 n5644 n5645 1.1875
r9892 n5539 n5646 0.013671875
r9893 n5645 n5646 1.0625
r9894 n5540 n5647 0.21875
r9895 n5646 n5647 1.0625
r9896 n5541 n5648 0.012152777777777778
r9897 n5647 n5648 1.1875
r9898 n5542 n5649 0.21875
r9899 n5648 n5649 1.1875
r9900 n5543 n5650 0.013671875
r9901 n5649 n5650 1.0625
r9902 n5544 n5651 0.21875
r9903 n5650 n5651 1.0625
r9904 n5545 n5652 0.012152777777777778
r9905 n5651 n5652 1.1875
r9906 n5546 n5653 0.21875
r9907 n5652 n5653 1.1875
r9908 n5547 n5654 0.013671875
r9909 n5653 n5654 1.0625
r9910 n5548 n5655 0.21875
r9911 n5654 n5655 1.0625
r9912 n5549 n5656 0.012152777777777778
r9913 n5655 n5656 1.1875
r9914 n5550 n5657 0.21875
r9915 n5656 n5657 1.1875
r9916 n5551 n5658 0.013671875
r9917 n5657 n5658 1.0625
r9918 n5552 n5659 0.21875
r9919 n5658 n5659 1.0625
r9920 n5553 n5660 0.036458333333333336
r9921 n5659 n5660 0.4375
r9922 n5554 n5661 0.050000000000000003
r9923 n5555 n5662 0.25
r9924 n5661 n5662 0.125
r9925 n5556 n5663 0.015625
r9926 n5662 n5663 0.35416666666666669
r9927 n5557 n5664 0.25
r9928 n5663 n5664 0.35416666666666669
r9929 n5558 n5665 0.013888888888888888
r9930 n5664 n5665 0.39583333333333331
r9931 n5559 n5666 0.25
r9932 n5665 n5666 0.39583333333333331
r9933 n5560 n5667 0.038461538461538464
r9934 n5666 n5667 0.15625
r9935 n5561 n5668 0.041666666666666664
r9936 n5667 n5668 0.26041666666666669
r9937 n5562 n5669 0.071428571428571425
r9938 n5668 n5669 0.19791666666666666
r9939 n5563 n5670 0.25
r9940 n5669 n5670 0.09375
r9941 n5564 n5671 0.125
r9942 n5670 n5671 0.0625
r9943 n5565 n5672 0.055555555555555552
r9944 n5671 n5672 0.13541666666666666
r9945 n5566 n5673 0.023809523809523808
r9946 n5672 n5673 0.3125
r9947 n5567 n5674 0.25
r9948 n5673 n5674 0.23958333333333334
r9949 n5568 n5675 0.25
r9950 n5674 n5675 0.041666666666666664
r9951 n5569 n5676 0.055555555555555552
r9952 n5675 n5676 0.11458333333333333
r9953 n5570 n5677 0.041666666666666664
r9954 n5676 n5677 0.21875
r9955 n5571 n5678 0.055555555555555552
r9956 n5677 n5678 0.21875
r9957 n5572 n5679 0.25
r9958 n5678 n5679 0.11458333333333333
r9959 n5573 n5680 0.25
r9960 n5679 n5680 0.041666666666666664
r9961 n5574 n5681 0.023809523809523808
r9962 n5680 n5681 0.23958333333333334
r9963 n5575 n5682 0.033333333333333333
r9964 n5681 n5682 0.375
r9965 n5576 n5683 0.25
r9966 n5682 n5683 0.17708333333333334
r9967 n5577 n5684 0.015625
r9968 n5683 n5684 0.35416666666666669
r9969 n5578 n5685 0.25
r9970 n5684 n5685 0.35416666666666669
r9971 n5579 n5686 0.041666666666666664
r9972 n5685 n5686 0.14583333333333334
r9973 n5580 n5687 0.050000000000000003
r9974 n5581 n5688 0.25
r9975 n5687 n5688 0.125
r9976 n5582 n5689 0.015625
r9977 n5688 n5689 0.35416666666666669
r9978 n5583 n5690 0.25
r9979 n5689 n5690 0.35416666666666669
r9980 n5584 n5691 0.013888888888888888
r9981 n5690 n5691 0.39583333333333331
r9982 n5585 n5692 0.25
r9983 n5691 n5692 0.39583333333333331
r9984 n5586 n5693 0.015625
r9985 n5692 n5693 0.35416666666666669
r9986 n5587 n5694 0.25
r9987 n5693 n5694 0.35416666666666669
r9988 n5588 n5695 0.013888888888888888
r9989 n5694 n5695 0.39583333333333331
r9990 n5589 n5696 0.25
r9991 n5695 n5696 0.39583333333333331
r9992 n5590 n5697 0.015625
r9993 n5696 n5697 0.35416666666666669
r9994 n5591 n5698 0.25
r9995 n5697 n5698 0.35416666666666669
r9996 n5592 n5699 0.013888888888888888
r9997 n5698 n5699 0.39583333333333331
r9998 n5593 n5700 0.25
r9999 n5699 n5700 0.39583333333333331
r10000 n5594 n5701 0.015625
r10001 n5700 n5701 0.35416666666666669
r10002 n5595 n5702 0.25
r10003 n5701 n5702 0.35416666666666669
r10004 n5596 n5703 0.013888888888888888
r10005 n5702 n5703 0.39583333333333331
r10006 n5597 n5704 0.25
r10007 n5703 n5704 0.39583333333333331
r10008 n5598 n5705 0.015625
r10009 n5704 n5705 0.35416666666666669
r10010 n5599 n5706 0.25
r10011 n5705 n5706 0.35416666666666669
r10012 n5600 n5707 0.013888888888888888
r10013 n5706 n5707 0.39583333333333331
r10014 n5601 n5708 0.25
r10015 n5707 n5708 0.39583333333333331
r10016 n5602 n5709 0.015625
r10017 n5708 n5709 0.35416666666666669
r10018 n5603 n5710 0.25
r10019 n5709 n5710 0.35416666666666669
r10020 n5604 n5711 0.013888888888888888
r10021 n5710 n5711 0.39583333333333331
r10022 n5605 n5712 0.25
r10023 n5711 n5712 0.39583333333333331
r10024 n5606 n5713 0.015625
r10025 n5712 n5713 0.35416666666666669
r10026 n5607 n5714 0.25
r10027 n5713 n5714 0.35416666666666669
r10028 n5608 n5715 0.013888888888888888
r10029 n5714 n5715 0.39583333333333331
r10030 n5609 n5716 0.25
r10031 n5715 n5716 0.39583333333333331
r10032 n5610 n5717 0.015625
r10033 n5716 n5717 0.35416666666666669
r10034 n5611 n5718 0.25
r10035 n5717 n5718 0.35416666666666669
r10036 n5612 n5719 0.033333333333333333
r10037 n5718 n5719 0.17708333333333334
r10038 n5613 n5720 0.041666666666666664
r10039 n5719 n5720 0.28125
r10040 n5614 n5721 0.055555555555555552
r10041 n5720 n5721 0.21875
r10042 n5615 n5722 0.25
r10043 n5721 n5722 0.11458333333333333
r10044 n5616 n5723 0.25
r10045 n5722 n5723 0.041666666666666664
r10046 n5617 n5724 0.0625
r10047 n5723 n5724 0.10416666666666667
r10048 n5618 n5725 0.022727272727272728
r10049 n5724 n5725 0.3125
r10050 n5619 n5726 0.5
r10051 n5725 n5726 0.23958333333333334
r10052 n5620 n5727 0.5
r10053 n5726 n5727 0.020833333333333332
r10054 n5621 n5728 0.5
r10055 n5727 n5728 0.020833333333333332
r10056 n5622 n5729 0.050000000000000003
r10057 n5728 n5729 0.11458333333333333
r10058 n5623 n5730 0.041666666666666664
r10059 n5729 n5730 0.22916666666666666
r10060 n5624 n5731 0.0625
r10061 n5730 n5731 0.20833333333333334
r10062 n5625 n5732 0.25
r10063 n5731 n5732 0.10416666666666667
r10064 n5626 n5733 0.16666666666666666
r10065 n5732 n5733 0.052083333333333336
r10066 n5627 n5734 0.25
r10067 n5733 n5734 0.052083333333333336
r10068 n5628 n5735 0.083333333333333329
r10069 n5734 n5735 0.083333333333333329
r10070 n5629 n5736 0.041666666666666664
r10071 n5735 n5736 0.1875
r10072 n5630 n5737 0.035714285714285712
r10073 n5736 n5737 0.27083333333333331
r10074 n5631 n5738 0.25
r10075 n5737 n5738 0.16666666666666666
r10076 n5632 n5739 0.013888888888888888
r10077 n5738 n5739 0.39583333333333331
r10078 n5633 n5740 0.25
r10079 n5739 n5740 0.39583333333333331
r10080 n5634 n5741 0.015625
r10081 n5740 n5741 0.35416666666666669
r10082 n5635 n5742 0.25
r10083 n5741 n5742 0.35416666666666669
r10084 n5636 n5743 0.013888888888888888
r10085 n5742 n5743 0.39583333333333331
r10086 n5637 n5744 0.25
r10087 n5743 n5744 0.39583333333333331
r10088 n5638 n5745 0.015625
r10089 n5744 n5745 0.35416666666666669
r10090 n5639 n5746 0.25
r10091 n5745 n5746 0.35416666666666669
r10092 n5640 n5747 0.013888888888888888
r10093 n5746 n5747 0.39583333333333331
r10094 n5641 n5748 0.25
r10095 n5747 n5748 0.39583333333333331
r10096 n5642 n5749 0.015625
r10097 n5748 n5749 0.35416666666666669
r10098 n5643 n5750 0.25
r10099 n5749 n5750 0.35416666666666669
r10100 n5644 n5751 0.013888888888888888
r10101 n5750 n5751 0.39583333333333331
r10102 n5645 n5752 0.25
r10103 n5751 n5752 0.39583333333333331
r10104 n5646 n5753 0.015625
r10105 n5752 n5753 0.35416666666666669
r10106 n5647 n5754 0.25
r10107 n5753 n5754 0.35416666666666669
r10108 n5648 n5755 0.013888888888888888
r10109 n5754 n5755 0.39583333333333331
r10110 n5649 n5756 0.25
r10111 n5755 n5756 0.39583333333333331
r10112 n5650 n5757 0.015625
r10113 n5756 n5757 0.35416666666666669
r10114 n5651 n5758 0.25
r10115 n5757 n5758 0.35416666666666669
r10116 n5652 n5759 0.013888888888888888
r10117 n5758 n5759 0.39583333333333331
r10118 n5653 n5760 0.25
r10119 n5759 n5760 0.39583333333333331
r10120 n5654 n5761 0.015625
r10121 n5760 n5761 0.35416666666666669
r10122 n5655 n5762 0.25
r10123 n5761 n5762 0.35416666666666669
r10124 n5656 n5763 0.013888888888888888
r10125 n5762 n5763 0.39583333333333331
r10126 n5657 n5764 0.25
r10127 n5763 n5764 0.39583333333333331
r10128 n5658 n5765 0.015625
r10129 n5764 n5765 0.35416666666666669
r10130 n5659 n5766 0.25
r10131 n5765 n5766 0.35416666666666669
r10132 n5660 n5767 0.041666666666666664
r10133 n5766 n5767 0.14583333333333334
r10134 n5668 n5768 0.067708333333333329
r10135 n5669 n5769 0.11607142857142858
r10136 n5768 n5769 0.16964285714285715
r10137 n5670 n5770 0.40625
r10138 n5769 n5770 0.080357142857142863
r10139 n5671 n5771 0.203125
r10140 n5770 n5771 0.053571428571428568
r10141 n5672 n5772 0.090277777777777776
r10142 n5771 n5772 0.11607142857142858
r10143 n5673 n5773 0.038690476190476192
r10144 n5772 n5773 0.26785714285714285
r10145 n5674 n5774 0.40625
r10146 n5773 n5774 0.20535714285714285
r10147 n5675 n5775 0.40625
r10148 n5774 n5775 0.035714285714285712
r10149 n5676 n5776 0.090277777777777776
r10150 n5775 n5776 0.098214285714285712
r10151 n5677 n5777 0.067708333333333329
r10152 n5776 n5777 0.1875
r10153 n5720 n5778 0.067708333333333329
r10154 n5721 n5779 0.090277777777777776
r10155 n5778 n5779 0.1875
r10156 n5722 n5780 0.40625
r10157 n5779 n5780 0.098214285714285712
r10158 n5723 n5781 0.40625
r10159 n5780 n5781 0.035714285714285712
r10160 n5724 n5782 0.1015625
r10161 n5781 n5782 0.089285714285714288
r10162 n5725 n5783 0.036931818181818184
r10163 n5782 n5783 0.26785714285714285
r10164 n5726 n5784 0.8125
r10165 n5783 n5784 0.20535714285714285
r10166 n5727 n5785 0.8125
r10167 n5784 n5785 0.017857142857142856
r10168 n5728 n5786 0.8125
r10169 n5785 n5786 0.017857142857142856
r10170 n5729 n5787 0.081250000000000003
r10171 n5786 n5787 0.098214285714285712
r10172 n5730 n5788 0.067708333333333329
r10173 n5787 n5788 0.19642857142857142
r10174 n5789 n5790 0.015277777777777777
r10175 n5790 n5791 0.013888888888888888
r10176 n5791 n5792 0.044444444444444446
r10177 n5792 n5793 0.034722222222222224
r10178 n5793 n5794 0.044444444444444446
r10179 n5794 n5795 0.044444444444444446
r10180 n5795 n5796 0.034722222222222224
r10181 n5796 n5797 0.044444444444444446
r10182 n5797 n5798 0.013888888888888888
r10183 n5798 n5799 0.015277777777777777
r10184 n5800 n5801 0.027777777777777776
r10185 n5801 n5802 0.04583333333333333
r10186 n5802 n5803 0.034722222222222224
r10187 n5803 n5804 0.044444444444444446
r10188 n5804 n5805 0.044444444444444446
r10189 n5805 n5806 0.034722222222222224
r10190 n5806 n5807 0.04583333333333333
r10191 n5807 n5808 0.027777777777777776
r10192 n5789 n5809 0.46875
r10193 n5790 n5810 4.6875
r10194 n5809 n5810 0.022916666666666665
r10195 n5791 n5811 0.52083333333333337
r10196 n5810 n5811 0.020833333333333332
r10197 n5792 n5812 0.20380434782608695
r10198 n5811 n5812 0.066666666666666666
r10199 n5793 n5813 2.34375
r10200 n5812 n5813 0.052083333333333336
r10201 n5794 n5814 0.15625
r10202 n5813 n5814 0.066666666666666666
r10203 n5795 n5815 2.34375
r10204 n5814 n5815 0.066666666666666666
r10205 n5796 n5816 0.20380434782608695
r10206 n5815 n5816 0.052083333333333336
r10207 n5797 n5817 0.52083333333333337
r10208 n5816 n5817 0.066666666666666666
r10209 n5798 n5818 4.6875
r10210 n5817 n5818 0.020833333333333332
r10211 n5799 n5819 0.46875
r10212 n5818 n5819 0.022916666666666665
r10213 n5800 n5820 0.46875
r10214 n5801 n5821 0.46875
r10215 n5820 n5821 0.041666666666666664
r10216 n5802 n5822 0.20380434782608695
r10217 n5821 n5822 0.068750000000000006
r10218 n5803 n5823 2.34375
r10219 n5822 n5823 0.052083333333333336
r10220 n5804 n5824 0.15625
r10221 n5823 n5824 0.066666666666666666
r10222 n5805 n5825 2.34375
r10223 n5824 n5825 0.066666666666666666
r10224 n5806 n5826 0.20380434782608695
r10225 n5825 n5826 0.052083333333333336
r10226 n5807 n5827 0.46875
r10227 n5826 n5827 0.068750000000000006
r10228 n5808 n5828 0.46875
r10229 n5827 n5828 0.041666666666666664
r10230 n5809 n5829 0.34375
r10231 n5810 n5830 3.4375
r10232 n5829 n5830 0.0275
r10233 n5811 n5831 0.38194444444444442
r10234 n5830 n5831 0.025000000000000001
r10235 n5812 n5832 0.14945652173913043
r10236 n5831 n5832 0.080000000000000002
r10237 n5813 n5833 1.71875
r10238 n5832 n5833 0.0625
r10239 n5814 n5834 0.11458333333333333
r10240 n5833 n5834 0.080000000000000002
r10241 n5815 n5835 1.71875
r10242 n5834 n5835 0.080000000000000002
r10243 n5816 n5836 0.14945652173913043
r10244 n5835 n5836 0.0625
r10245 n5817 n5837 0.38194444444444442
r10246 n5836 n5837 0.080000000000000002
r10247 n5818 n5838 3.4375
r10248 n5837 n5838 0.025000000000000001
r10249 n5819 n5839 0.34375
r10250 n5838 n5839 0.0275
r10251 n5820 n5840 0.34375
r10252 n5821 n5841 0.34375
r10253 n5840 n5841 0.050000000000000003
r10254 n5822 n5842 0.14945652173913043
r10255 n5841 n5842 0.082500000000000004
r10256 n5823 n5843 1.71875
r10257 n5842 n5843 0.0625
r10258 n5824 n5844 0.11458333333333333
r10259 n5843 n5844 0.080000000000000002
r10260 n5825 n5845 1.71875
r10261 n5844 n5845 0.080000000000000002
r10262 n5826 n5846 0.14945652173913043
r10263 n5845 n5846 0.0625
r10264 n5827 n5847 0.34375
r10265 n5846 n5847 0.082500000000000004
r10266 n5828 n5848 0.34375
r10267 n5847 n5848 0.050000000000000003
r10268 n5829 n5849 0.28125
r10269 n5830 n5850 2.8125
r10270 n5849 n5850 0.034375000000000003
r10271 n5831 n5851 0.3125
r10272 n5850 n5851 0.03125
r10273 n5832 n5852 0.12228260869565218
r10274 n5851 n5852 0.10000000000000001
r10275 n5833 n5853 1.40625
r10276 n5852 n5853 0.078125
r10277 n5834 n5854 0.09375
r10278 n5853 n5854 0.10000000000000001
r10279 n5835 n5855 1.40625
r10280 n5854 n5855 0.10000000000000001
r10281 n5836 n5856 0.12228260869565218
r10282 n5855 n5856 0.078125
r10283 n5837 n5857 0.3125
r10284 n5856 n5857 0.10000000000000001
r10285 n5838 n5858 2.8125
r10286 n5857 n5858 0.03125
r10287 n5839 n5859 0.28125
r10288 n5858 n5859 0.034375000000000003
r10289 n5840 n5860 0.28125
r10290 n5841 n5861 0.28125
r10291 n5860 n5861 0.0625
r10292 n5842 n5862 0.12228260869565218
r10293 n5861 n5862 0.10312499999999999
r10294 n5843 n5863 1.40625
r10295 n5862 n5863 0.078125
r10296 n5844 n5864 0.09375
r10297 n5863 n5864 0.10000000000000001
r10298 n5845 n5865 1.40625
r10299 n5864 n5865 0.10000000000000001
r10300 n5846 n5866 0.12228260869565218
r10301 n5865 n5866 0.078125
r10302 n5847 n5867 0.28125
r10303 n5866 n5867 0.10312499999999999
r10304 n5848 n5868 0.28125
r10305 n5867 n5868 0.0625
r10306 n5850 n5869 3.4375
r10307 n5851 n5870 0.38194444444444442
r10308 n5869 n5870 0.017857142857142856
r10309 n5852 n5871 0.14945652173913043
r10310 n5870 n5871 0.057142857142857141
r10311 n5853 n5872 1.71875
r10312 n5871 n5872 0.044642857142857144
r10313 n5854 n5873 0.11458333333333333
r10314 n5872 n5873 0.057142857142857141
r10315 n5855 n5874 1.71875
r10316 n5873 n5874 0.057142857142857141
r10317 n5856 n5875 0.14945652173913043
r10318 n5874 n5875 0.044642857142857144
r10319 n5857 n5876 0.38194444444444442
r10320 n5875 n5876 0.057142857142857141
r10321 n5858 n5877 3.4375
r10322 n5876 n5877 0.017857142857142856
r10323 n5861 n5878 0.34375
r10324 n5862 n5879 0.14945652173913043
r10325 n5878 n5879 0.058928571428571427
r10326 n5863 n5880 1.71875
r10327 n5879 n5880 0.044642857142857144
r10328 n5864 n5881 0.11458333333333333
r10329 n5880 n5881 0.057142857142857141
r10330 n5865 n5882 1.71875
r10331 n5881 n5882 0.057142857142857141
r10332 n5866 n5883 0.14945652173913043
r10333 n5882 n5883 0.044642857142857144
r10334 n5867 n5884 0.34375
r10335 n5883 n5884 0.058928571428571427
r10336 n5869 n5885 4.375
r10337 n5870 n5886 0.4861111111111111
r10338 n5885 n5886 0.017857142857142856
r10339 n5871 n5887 0.19021739130434784
r10340 n5886 n5887 0.057142857142857141
r10341 n5872 n5888 2.1875
r10342 n5887 n5888 0.044642857142857144
r10343 n5873 n5889 0.14583333333333334
r10344 n5888 n5889 0.057142857142857141
r10345 n5874 n5890 2.1875
r10346 n5889 n5890 0.057142857142857141
r10347 n5875 n5891 0.19021739130434784
r10348 n5890 n5891 0.044642857142857144
r10349 n5876 n5892 0.4861111111111111
r10350 n5891 n5892 0.057142857142857141
r10351 n5877 n5893 4.375
r10352 n5892 n5893 0.017857142857142856
r10353 n5878 n5894 0.4375
r10354 n5879 n5895 0.19021739130434784
r10355 n5894 n5895 0.058928571428571427
r10356 n5880 n5896 2.1875
r10357 n5895 n5896 0.044642857142857144
r10358 n5881 n5897 0.14583333333333334
r10359 n5896 n5897 0.057142857142857141
r10360 n5882 n5898 2.1875
r10361 n5897 n5898 0.057142857142857141
r10362 n5883 n5899 0.19021739130434784
r10363 n5898 n5899 0.044642857142857144
r10364 n5884 n5900 0.4375
r10365 n5899 n5900 0.058928571428571427
r10366 n5885 n5901 4.0625
r10367 n5886 n5902 0.4513888888888889
r10368 n5901 n5902 0.020833333333333332
r10369 n5887 n5903 0.1766304347826087
r10370 n5902 n5903 0.066666666666666666
r10371 n5888 n5904 2.03125
r10372 n5903 n5904 0.052083333333333336
r10373 n5889 n5905 0.13541666666666666
r10374 n5904 n5905 0.066666666666666666
r10375 n5890 n5906 2.03125
r10376 n5905 n5906 0.066666666666666666
r10377 n5891 n5907 0.1766304347826087
r10378 n5906 n5907 0.052083333333333336
r10379 n5892 n5908 0.4513888888888889
r10380 n5907 n5908 0.066666666666666666
r10381 n5893 n5909 4.0625
r10382 n5908 n5909 0.020833333333333332
r10383 n5894 n5910 0.40625
r10384 n5895 n5911 0.1766304347826087
r10385 n5910 n5911 0.068750000000000006
r10386 n5896 n5912 2.03125
r10387 n5911 n5912 0.052083333333333336
r10388 n5897 n5913 0.13541666666666666
r10389 n5912 n5913 0.066666666666666666
r10390 n5898 n5914 2.03125
r10391 n5913 n5914 0.066666666666666666
r10392 n5899 n5915 0.1766304347826087
r10393 n5914 n5915 0.052083333333333336
r10394 n5900 n5916 0.40625
r10395 n5915 n5916 0.068750000000000006
r10396 n5901 n5917 3.75
r10397 n5902 n5918 0.41666666666666669
r10398 n5917 n5918 0.020833333333333332
r10399 n5903 n5919 0.16304347826086957
r10400 n5918 n5919 0.066666666666666666
r10401 n5904 n5920 1.875
r10402 n5919 n5920 0.052083333333333336
r10403 n5905 n5921 0.125
r10404 n5920 n5921 0.066666666666666666
r10405 n5906 n5922 1.875
r10406 n5921 n5922 0.066666666666666666
r10407 n5907 n5923 0.16304347826086957
r10408 n5922 n5923 0.052083333333333336
r10409 n5908 n5924 0.41666666666666669
r10410 n5923 n5924 0.066666666666666666
r10411 n5909 n5925 3.75
r10412 n5924 n5925 0.020833333333333332
r10413 n5910 n5926 0.375
r10414 n5911 n5927 0.16304347826086957
r10415 n5926 n5927 0.068750000000000006
r10416 n5912 n5928 1.875
r10417 n5927 n5928 0.052083333333333336
r10418 n5913 n5929 0.125
r10419 n5928 n5929 0.066666666666666666
r10420 n5914 n5930 1.875
r10421 n5929 n5930 0.066666666666666666
r10422 n5915 n5931 0.16304347826086957
r10423 n5930 n5931 0.052083333333333336
r10424 n5916 n5932 0.375
r10425 n5931 n5932 0.068750000000000006
r10426 n5917 n5933 4.125
r10427 n5918 n5934 0.45833333333333331
r10428 n5933 n5934 0.017361111111111112
r10429 n5919 n5935 0.17934782608695651
r10430 n5934 n5935 0.055555555555555552
r10431 n5920 n5936 2.0625
r10432 n5935 n5936 0.043402777777777776
r10433 n5921 n5937 0.13750000000000001
r10434 n5936 n5937 0.055555555555555552
r10435 n5922 n5938 2.0625
r10436 n5937 n5938 0.055555555555555552
r10437 n5923 n5939 0.17934782608695651
r10438 n5938 n5939 0.043402777777777776
r10439 n5924 n5940 0.45833333333333331
r10440 n5939 n5940 0.055555555555555552
r10441 n5925 n5941 4.125
r10442 n5940 n5941 0.017361111111111112
r10443 n5926 n5942 0.41249999999999998
r10444 n5927 n5943 0.17934782608695651
r10445 n5942 n5943 0.057291666666666664
r10446 n5928 n5944 2.0625
r10447 n5943 n5944 0.043402777777777776
r10448 n5929 n5945 0.13750000000000001
r10449 n5944 n5945 0.055555555555555552
r10450 n5930 n5946 2.0625
r10451 n5945 n5946 0.055555555555555552
r10452 n5931 n5947 0.17934782608695651
r10453 n5946 n5947 0.043402777777777776
r10454 n5932 n5948 0.41249999999999998
r10455 n5947 n5948 0.057291666666666664
r10456 n5933 n5949 4.5
r10457 n5934 n5950 0.5
r10458 n5949 n5950 0.017361111111111112
r10459 n5935 n5951 0.19565217391304349
r10460 n5950 n5951 0.055555555555555552
r10461 n5936 n5952 2.25
r10462 n5951 n5952 0.043402777777777776
r10463 n5937 n5953 0.14999999999999999
r10464 n5952 n5953 0.055555555555555552
r10465 n5938 n5954 2.25
r10466 n5953 n5954 0.055555555555555552
r10467 n5939 n5955 0.19565217391304349
r10468 n5954 n5955 0.043402777777777776
r10469 n5940 n5956 0.5
r10470 n5955 n5956 0.055555555555555552
r10471 n5941 n5957 4.5
r10472 n5956 n5957 0.017361111111111112
r10473 n5942 n5958 0.45000000000000001
r10474 n5943 n5959 0.19565217391304349
r10475 n5958 n5959 0.057291666666666664
r10476 n5944 n5960 2.25
r10477 n5959 n5960 0.043402777777777776
r10478 n5945 n5961 0.14999999999999999
r10479 n5960 n5961 0.055555555555555552
r10480 n5946 n5962 2.25
r10481 n5961 n5962 0.055555555555555552
r10482 n5947 n5963 0.19565217391304349
r10483 n5962 n5963 0.043402777777777776
r10484 n5948 n5964 0.45000000000000001
r10485 n5963 n5964 0.057291666666666664
r10486 n5949 n5965 4
r10487 n5950 n5966 0.44444444444444442
r10488 n5965 n5966 0.022321428571428572
r10489 n5951 n5967 0.17391304347826086
r10490 n5966 n5967 0.071428571428571425
r10491 n5952 n5968 2
r10492 n5967 n5968 0.055803571428571432
r10493 n5953 n5969 0.13333333333333333
r10494 n5968 n5969 0.071428571428571425
r10495 n5954 n5970 2
r10496 n5969 n5970 0.071428571428571425
r10497 n5955 n5971 0.17391304347826086
r10498 n5970 n5971 0.055803571428571432
r10499 n5956 n5972 0.44444444444444442
r10500 n5971 n5972 0.071428571428571425
r10501 n5957 n5973 4
r10502 n5972 n5973 0.022321428571428572
r10503 n5974 n5975 0.024553571428571428
r10504 n5975 n5976 0.0089285714285714281
r10505 n5976 n5977 0.022321428571428572
r10506 n5977 n5978 0.066964285714285712
r10507 n5978 n5979 0.051339285714285712
r10508 n5979 n5980 0.004464285714285714
r10509 n5980 n5981 0.004464285714285714
r10510 n5981 n5982 0.024553571428571428
r10511 n5982 n5983 0.049107142857142856
r10512 n5983 n5984 0.044642857142857144
r10513 n5984 n5985 0.022321428571428572
r10514 n5985 n5986 0.011160714285714286
r10515 n5986 n5987 0.011160714285714286
r10516 n5987 n5988 0.017857142857142856
r10517 n5988 n5989 0.040178571428571432
r10518 n5989 n5990 0.058035714285714288
r10519 n5990 n5991 0.035714285714285712
r10520 n5991 n5992 0.084821428571428575
r10521 n5992 n5993 0.084821428571428575
r10522 n5993 n5994 0.075892857142857137
r10523 n5994 n5995 0.075892857142857137
r10524 n5995 n5996 0.084821428571428575
r10525 n5996 n5997 0.084821428571428575
r10526 n5997 n5998 0.075892857142857137
r10527 n5998 n5999 0.075892857142857137
r10528 n5999 n6000 0.084821428571428575
r10529 n6000 n6001 0.084821428571428575
r10530 n6001 n6002 0.075892857142857137
r10531 n6002 n6003 0.075892857142857137
r10532 n6003 n6004 0.084821428571428575
r10533 n6004 n6005 0.084821428571428575
r10534 n6005 n6006 0.075892857142857137
r10535 n6006 n6007 0.075892857142857137
r10536 n6007 n6008 0.084821428571428575
r10537 n6008 n6009 0.084821428571428575
r10538 n6009 n6010 0.075892857142857137
r10539 n6010 n6011 0.075892857142857137
r10540 n6011 n6012 0.084821428571428575
r10541 n6012 n6013 0.084821428571428575
r10542 n6013 n6014 0.075892857142857137
r10543 n6014 n6015 0.075892857142857137
r10544 n6015 n6016 0.084821428571428575
r10545 n6016 n6017 0.084821428571428575
r10546 n6017 n6018 0.075892857142857137
r10547 n6018 n6019 0.075892857142857137
r10548 n6019 n6020 0.03125
r10549 n6020 n6021 0.035714285714285712
r10550 n6021 n6022 0.053571428571428568
r10551 n6022 n6023 0.12053571428571429
r10552 n6023 n6024 0.080357142857142863
r10553 n6024 n6025 0.026785714285714284
r10554 n6025 n6026 0.037946428571428568
r10555 n6026 n6027 0.022321428571428572
r10556 n6027 n6028 0.013392857142857142
r10557 n6028 n6029 0.011160714285714286
r10558 n6029 n6030 0.029017857142857144
r10559 n6030 n6031 0.066964285714285712
r10560 n6031 n6032 0.046875
r10561 n6032 n6033 0.011160714285714286
r10562 n6033 n6034 0.013392857142857142
r10563 n6034 n6035 0.022321428571428572
r10564 n6035 n6036 0.037946428571428568
r10565 n6036 n6037 0.13169642857142858
r10566 n6037 n6038 0.18526785714285715
r10567 n6038 n6039 0.18705357142857143
r10568 n6039 n6040 0.22187499999999999
r10569 n6040 n6041 0.22187499999999999
r10570 n6041 n6042 0.22232142857142856
r10571 n6042 n6043 0.13348214285714285
r10572 n5958 n6044 0.40000000000000002
r10573 n6043 n6044 0.044642857142857144
r10574 n5959 n6045 0.17391304347826086
r10575 n6044 n6045 0.073660714285714288
r10576 n5960 n6046 2
r10577 n6045 n6046 0.055803571428571432
r10578 n5961 n6047 0.13333333333333333
r10579 n6046 n6047 0.071428571428571425
r10580 n5962 n6048 2
r10581 n6047 n6048 0.071428571428571425
r10582 n5963 n6049 0.17391304347826086
r10583 n6048 n6049 0.055803571428571432
r10584 n5964 n6050 0.40000000000000002
r10585 n6049 n6050 0.073660714285714288
r10586 n5965 n6051 3.5
r10587 n5966 n6052 0.3888888888888889
r10588 n6051 n6052 0.022321428571428572
r10589 n5967 n6053 0.15217391304347827
r10590 n6052 n6053 0.071428571428571425
r10591 n5968 n6054 1.75
r10592 n6053 n6054 0.055803571428571432
r10593 n5969 n6055 0.11666666666666667
r10594 n6054 n6055 0.071428571428571425
r10595 n5970 n6056 1.75
r10596 n6055 n6056 0.071428571428571425
r10597 n5971 n6057 0.15217391304347827
r10598 n6056 n6057 0.055803571428571432
r10599 n5972 n6058 0.3888888888888889
r10600 n6057 n6058 0.071428571428571425
r10601 n5973 n6059 3.5
r10602 n6058 n6059 0.022321428571428572
r10603 n5974 n6060 0.3888888888888889
r10604 n5975 n6061 1.75
r10605 n6060 n6061 0.024553571428571428
r10606 n5976 n6062 1.75
r10607 n6061 n6062 0.0089285714285714281
r10608 n5977 n6063 0.4375
r10609 n6062 n6063 0.022321428571428572
r10610 n5978 n6064 0.15909090909090909
r10611 n6063 n6064 0.066964285714285712
r10612 n5979 n6065 3.5
r10613 n6064 n6065 0.051339285714285712
r10614 n5980 n6066 3.5
r10615 n6065 n6066 0.004464285714285714
r10616 n5981 n6067 3.5
r10617 n6066 n6067 0.004464285714285714
r10618 n5982 n6068 0.34999999999999998
r10619 n6067 n6068 0.024553571428571428
r10620 n5983 n6069 0.29166666666666669
r10621 n6068 n6069 0.049107142857142856
r10622 n5984 n6070 0.4375
r10623 n6069 n6070 0.044642857142857144
r10624 n5985 n6071 1.75
r10625 n6070 n6071 0.022321428571428572
r10626 n5986 n6072 1.1666666666666667
r10627 n6071 n6072 0.011160714285714286
r10628 n5987 n6073 1.75
r10629 n6072 n6073 0.011160714285714286
r10630 n5988 n6074 0.58333333333333337
r10631 n6073 n6074 0.017857142857142856
r10632 n5989 n6075 0.29166666666666669
r10633 n6074 n6075 0.040178571428571432
r10634 n5990 n6076 0.25
r10635 n6075 n6076 0.058035714285714288
r10636 n5991 n6077 1.75
r10637 n6076 n6077 0.035714285714285712
r10638 n5992 n6078 0.097222222222222224
r10639 n6077 n6078 0.084821428571428575
r10640 n5993 n6079 1.75
r10641 n6078 n6079 0.084821428571428575
r10642 n5994 n6080 0.109375
r10643 n6079 n6080 0.075892857142857137
r10644 n5995 n6081 1.75
r10645 n6080 n6081 0.075892857142857137
r10646 n5996 n6082 0.097222222222222224
r10647 n6081 n6082 0.084821428571428575
r10648 n5997 n6083 1.75
r10649 n6082 n6083 0.084821428571428575
r10650 n5998 n6084 0.109375
r10651 n6083 n6084 0.075892857142857137
r10652 n5999 n6085 1.75
r10653 n6084 n6085 0.075892857142857137
r10654 n6000 n6086 0.097222222222222224
r10655 n6085 n6086 0.084821428571428575
r10656 n6001 n6087 1.75
r10657 n6086 n6087 0.084821428571428575
r10658 n6002 n6088 0.109375
r10659 n6087 n6088 0.075892857142857137
r10660 n6003 n6089 1.75
r10661 n6088 n6089 0.075892857142857137
r10662 n6004 n6090 0.097222222222222224
r10663 n6089 n6090 0.084821428571428575
r10664 n6005 n6091 1.75
r10665 n6090 n6091 0.084821428571428575
r10666 n6006 n6092 0.109375
r10667 n6091 n6092 0.075892857142857137
r10668 n6007 n6093 1.75
r10669 n6092 n6093 0.075892857142857137
r10670 n6008 n6094 0.097222222222222224
r10671 n6093 n6094 0.084821428571428575
r10672 n6009 n6095 1.75
r10673 n6094 n6095 0.084821428571428575
r10674 n6010 n6096 0.109375
r10675 n6095 n6096 0.075892857142857137
r10676 n6011 n6097 1.75
r10677 n6096 n6097 0.075892857142857137
r10678 n6012 n6098 0.097222222222222224
r10679 n6097 n6098 0.084821428571428575
r10680 n6013 n6099 1.75
r10681 n6098 n6099 0.084821428571428575
r10682 n6014 n6100 0.109375
r10683 n6099 n6100 0.075892857142857137
r10684 n6015 n6101 1.75
r10685 n6100 n6101 0.075892857142857137
r10686 n6016 n6102 0.097222222222222224
r10687 n6101 n6102 0.084821428571428575
r10688 n6017 n6103 1.75
r10689 n6102 n6103 0.084821428571428575
r10690 n6018 n6104 0.109375
r10691 n6103 n6104 0.075892857142857137
r10692 n6019 n6105 1.75
r10693 n6104 n6105 0.075892857142857137
r10694 n6020 n6106 0.29166666666666669
r10695 n6105 n6106 0.03125
r10696 n6021 n6107 0.875
r10697 n6106 n6107 0.035714285714285712
r10698 n6022 n6108 0.17499999999999999
r10699 n6107 n6108 0.053571428571428568
r10700 n6023 n6109 0.10294117647058823
r10701 n6108 n6109 0.12053571428571429
r10702 n6024 n6110 1.75
r10703 n6109 n6110 0.080357142857142863
r10704 n6025 n6111 0.34999999999999998
r10705 n6110 n6111 0.026785714285714284
r10706 n6026 n6112 0.5
r10707 n6111 n6112 0.037946428571428568
r10708 n6027 n6113 1.1666666666666667
r10709 n6112 n6113 0.022321428571428572
r10710 n6028 n6114 1.1666666666666667
r10711 n6113 n6114 0.013392857142857142
r10712 n6029 n6115 1.75
r10713 n6114 n6115 0.011160714285714286
r10714 n6030 n6116 0.31818181818181818
r10715 n6115 n6116 0.029017857142857144
r10716 n6031 n6117 0.18421052631578946
r10717 n6116 n6117 0.066964285714285712
r10718 n6032 n6118 1.75
r10719 n6117 n6118 0.046875
r10720 n6033 n6119 1.1666666666666667
r10721 n6118 n6119 0.011160714285714286
r10722 n6034 n6120 1.1666666666666667
r10723 n6119 n6120 0.013392857142857142
r10724 n6035 n6121 0.5
r10725 n6120 n6121 0.022321428571428572
r10726 n6036 n6122 0.34999999999999998
r10727 n6121 n6122 0.037946428571428568
r10728 n6037 n6123 0.071428571428571425
r10729 n6122 n6123 0.13169642857142858
r10730 n6038 n6124 0.10294117647058823
r10731 n6123 n6124 0.18526785714285715
r10732 n6039 n6125 0.070281124497991967
r10733 n6124 n6125 0.18705357142857143
r10734 n6040 n6126 0.070564516129032265
r10735 n6125 n6126 0.22187499999999999
r10736 n6041 n6127 0.070281124497991967
r10737 n6126 n6127 0.22187499999999999
r10738 n6042 n6128 0.070281124497991967
r10739 n6127 n6128 0.22232142857142856
r10740 n6043 n6129 0.34999999999999998
r10741 n6128 n6129 0.13348214285714285
r10742 n6044 n6130 0.34999999999999998
r10743 n6129 n6130 0.044642857142857144
r10744 n6045 n6131 0.15217391304347827
r10745 n6130 n6131 0.073660714285714288
r10746 n6046 n6132 1.75
r10747 n6131 n6132 0.055803571428571432
r10748 n6047 n6133 0.11666666666666667
r10749 n6132 n6133 0.071428571428571425
r10750 n6048 n6134 1.75
r10751 n6133 n6134 0.071428571428571425
r10752 n6049 n6135 0.15217391304347827
r10753 n6134 n6135 0.055803571428571432
r10754 n6050 n6136 0.34999999999999998
r10755 n6135 n6136 0.073660714285714288
r10756 n6051 n6137 4.625
r10757 n6052 n6138 0.51388888888888884
r10758 n6137 n6138 0.01358695652173913
r10759 n6053 n6139 0.20108695652173914
r10760 n6138 n6139 0.043478260869565216
r10761 n6054 n6140 2.3125
r10762 n6139 n6140 0.033967391304347824
r10763 n6055 n6141 0.15416666666666667
r10764 n6140 n6141 0.043478260869565216
r10765 n6056 n6142 2.3125
r10766 n6141 n6142 0.043478260869565216
r10767 n6057 n6143 0.20108695652173914
r10768 n6142 n6143 0.033967391304347824
r10769 n6058 n6144 0.51388888888888884
r10770 n6143 n6144 0.043478260869565216
r10771 n6059 n6145 4.625
r10772 n6144 n6145 0.01358695652173913
r10773 n6060 n6146 0.51388888888888884
r10774 n6061 n6147 2.3125
r10775 n6146 n6147 0.014945652173913044
r10776 n6062 n6148 2.3125
r10777 n6147 n6148 0.005434782608695652
r10778 n6063 n6149 0.578125
r10779 n6148 n6149 0.01358695652173913
r10780 n6064 n6150 0.21022727272727273
r10781 n6149 n6150 0.040760869565217392
r10782 n6065 n6151 4.625
r10783 n6150 n6151 0.03125
r10784 n6066 n6152 4.625
r10785 n6151 n6152 0.002717391304347826
r10786 n6067 n6153 4.625
r10787 n6152 n6153 0.002717391304347826
r10788 n6068 n6154 0.46250000000000002
r10789 n6153 n6154 0.014945652173913044
r10790 n6069 n6155 0.38541666666666669
r10791 n6154 n6155 0.029891304347826088
r10792 n6070 n6156 0.578125
r10793 n6155 n6156 0.02717391304347826
r10794 n6071 n6157 2.3125
r10795 n6156 n6157 0.01358695652173913
r10796 n6072 n6158 1.5416666666666667
r10797 n6157 n6158 0.006793478260869565
r10798 n6073 n6159 2.3125
r10799 n6158 n6159 0.006793478260869565
r10800 n6074 n6160 0.77083333333333337
r10801 n6159 n6160 0.010869565217391304
r10802 n6130 n6161 0.46250000000000002
r10803 n6131 n6162 0.20108695652173914
r10804 n6161 n6162 0.044836956521739128
r10805 n6132 n6163 2.3125
r10806 n6162 n6163 0.033967391304347824
r10807 n6133 n6164 0.15416666666666667
r10808 n6163 n6164 0.043478260869565216
r10809 n6134 n6165 2.3125
r10810 n6164 n6165 0.043478260869565216
r10811 n6135 n6166 0.20108695652173914
r10812 n6165 n6166 0.033967391304347824
r10813 n6136 n6167 0.46250000000000002
r10814 n6166 n6167 0.044836956521739128
r10815 n6137 n6168 3
r10816 n6138 n6169 0.33333333333333331
r10817 n6168 n6169 0.3125
r10818 n6139 n6170 0.13043478260869565
r10819 n6169 n6170 1
r10820 n6140 n6171 1.5
r10821 n6170 n6171 0.78125
r10822 n6141 n6172 0.10000000000000001
r10823 n6171 n6172 1
r10824 n6142 n6173 1.5
r10825 n6172 n6173 1
r10826 n6143 n6174 0.13043478260869565
r10827 n6173 n6174 0.78125
r10828 n6144 n6175 0.33333333333333331
r10829 n6174 n6175 1
r10830 n6145 n6176 3
r10831 n6175 n6176 0.3125
r10832 n6177 n6178 0.71875
r10833 n6178 n6179 0.125
r10834 n6179 n6180 0.34375
r10835 n6180 n6181 0.65625
r10836 n6181 n6182 0.65625
r10837 n6182 n6183 0.34375
r10838 n6183 n6184 0.125
r10839 n6184 n6185 0.71875
r10840 n6146 n6186 0.33333333333333331
r10841 n6147 n6187 1.5
r10842 n6186 n6187 0.34375
r10843 n6148 n6188 1.5
r10844 n6187 n6188 0.125
r10845 n6149 n6189 0.375
r10846 n6188 n6189 0.3125
r10847 n6150 n6190 0.13636363636363635
r10848 n6189 n6190 0.9375
r10849 n6151 n6191 3
r10850 n6190 n6191 0.71875
r10851 n6152 n6192 3
r10852 n6191 n6192 0.0625
r10853 n6153 n6193 3
r10854 n6192 n6193 0.0625
r10855 n6154 n6194 0.29999999999999999
r10856 n6193 n6194 0.34375
r10857 n6155 n6195 0.25
r10858 n6194 n6195 0.6875
r10859 n6156 n6196 0.375
r10860 n6195 n6196 0.625
r10861 n6157 n6197 1.5
r10862 n6196 n6197 0.3125
r10863 n6158 n6198 1
r10864 n6197 n6198 0.15625
r10865 n6159 n6199 1.5
r10866 n6198 n6199 0.15625
r10867 n6160 n6200 0.5
r10868 n6199 n6200 0.25
r10869 n6200 n6201 0.5625
r10870 n6161 n6202 0.29999999999999999
r10871 n6162 n6203 0.13043478260869565
r10872 n6202 n6203 1.03125
r10873 n6163 n6204 1.5
r10874 n6203 n6204 0.78125
r10875 n6164 n6205 0.10000000000000001
r10876 n6204 n6205 1
r10877 n6165 n6206 1.5
r10878 n6205 n6206 1
r10879 n6166 n6207 0.13043478260869565
r10880 n6206 n6207 0.78125
r10881 n6167 n6208 0.29999999999999999
r10882 n6207 n6208 1.03125
r10883 n6168 n6209 0.8125
r10884 n6169 n6210 0.090277777777777776
r10885 n6209 n6210 0.056818181818181816
r10886 n6170 n6211 0.035326086956521736
r10887 n6210 n6211 0.18181818181818182
r10888 n6171 n6212 0.40625
r10889 n6211 n6212 0.14204545454545456
r10890 n6172 n6213 0.027083333333333334
r10891 n6212 n6213 0.18181818181818182
r10892 n6173 n6214 0.40625
r10893 n6213 n6214 0.18181818181818182
r10894 n6174 n6215 0.035326086956521736
r10895 n6214 n6215 0.14204545454545456
r10896 n6175 n6216 0.090277777777777776
r10897 n6215 n6216 0.18181818181818182
r10898 n6176 n6217 0.8125
r10899 n6216 n6217 0.056818181818181816
r10900 n6217 n6218 0.0625
r10901 n6218 n6219 0.27272727272727271
r10902 n6219 n6220 0.43181818181818182
r10903 n6220 n6221 0.43181818181818182
r10904 n6221 n6222 0.43181818181818182
r10905 n6222 n6223 0.40909090909090912
r10906 n6223 n6224 0.36931818181818182
r10907 n6224 n6225 0.35227272727272729
r10908 n6225 n6226 0.36931818181818182
r10909 n6226 n6227 0.32954545454545453
r10910 n6227 n6228 0.15909090909090909
r10911 n6228 n6229 0.079545454545454544
r10912 n6229 n6230 0.068181818181818177
r10913 n6230 n6231 0.19318181818181818
r10914 n6231 n6232 0.19318181818181818
r10915 n6232 n6233 0.21590909090909091
r10916 n6233 n6234 0.21590909090909091
r10917 n6234 n6235 0.085227272727272721
r10918 n6235 n6236 0.14204545454545456
r10919 n6236 n6237 0.10795454545454546
r10920 n6237 n6238 0.05113636363636364
r10921 n6238 n6239 0.034090909090909088
r10922 n6239 n6240 0.073863636363636367
r10923 n6177 n6241 0.038690476190476192
r10924 n6240 n6241 0.17045454545454544
r10925 n6178 n6242 0.40625
r10926 n6241 n6242 0.13068181818181818
r10927 n6179 n6243 0.40625
r10928 n6242 n6243 0.022727272727272728
r10929 n6180 n6244 0.090277777777777776
r10930 n6243 n6244 0.0625
r10931 n6181 n6245 0.067708333333333329
r10932 n6244 n6245 0.11931818181818182
r10933 n6182 n6246 0.090277777777777776
r10934 n6245 n6246 0.11931818181818182
r10935 n6183 n6247 0.40625
r10936 n6246 n6247 0.0625
r10937 n6184 n6248 0.40625
r10938 n6247 n6248 0.022727272727272728
r10939 n6185 n6249 0.038690476190476192
r10940 n6248 n6249 0.13068181818181818
r10941 n6186 n6250 0.090277777777777776
r10942 n6187 n6251 0.40625
r10943 n6250 n6251 0.0625
r10944 n6188 n6252 0.40625
r10945 n6251 n6252 0.022727272727272728
r10946 n6189 n6253 0.1015625
r10947 n6252 n6253 0.056818181818181816
r10948 n6190 n6254 0.036931818181818184
r10949 n6253 n6254 0.17045454545454544
r10950 n6191 n6255 0.8125
r10951 n6254 n6255 0.13068181818181818
r10952 n6192 n6256 0.8125
r10953 n6255 n6256 0.011363636363636364
r10954 n6193 n6257 0.8125
r10955 n6256 n6257 0.011363636363636364
r10956 n6194 n6258 0.081250000000000003
r10957 n6257 n6258 0.0625
r10958 n6195 n6259 0.067708333333333329
r10959 n6258 n6259 0.125
r10960 n6196 n6260 0.1015625
r10961 n6259 n6260 0.11363636363636363
r10962 n6197 n6261 0.40625
r10963 n6260 n6261 0.056818181818181816
r10964 n6198 n6262 0.27083333333333331
r10965 n6261 n6262 0.028409090909090908
r10966 n6199 n6263 0.40625
r10967 n6262 n6263 0.028409090909090908
r10968 n6200 n6264 0.13541666666666666
r10969 n6263 n6264 0.045454545454545456
r10970 n6201 n6265 0.067708333333333329
r10971 n6264 n6265 0.10227272727272728
r10972 n6202 n6266 0.081250000000000003
r10973 n6203 n6267 0.035326086956521736
r10974 n6266 n6267 0.1875
r10975 n6204 n6268 0.40625
r10976 n6267 n6268 0.14204545454545456
r10977 n6205 n6269 0.027083333333333334
r10978 n6268 n6269 0.18181818181818182
r10979 n6206 n6270 0.40625
r10980 n6269 n6270 0.18181818181818182
r10981 n6207 n6271 0.035326086956521736
r10982 n6270 n6271 0.14204545454545456
r10983 n6208 n6272 0.081250000000000003
r10984 n6271 n6272 0.1875
r10985 n6209 n6273 0.8125
r10986 n6210 n6274 0.090277777777777776
r10987 n6273 n6274 0.3125
r10988 n6211 n6275 0.035326086956521736
r10989 n6274 n6275 1
r10990 n6212 n6276 0.40625
r10991 n6275 n6276 0.78125
r10992 n6213 n6277 0.027083333333333334
r10993 n6276 n6277 1
r10994 n6214 n6278 0.40625
r10995 n6277 n6278 1
r10996 n6215 n6279 0.035326086956521736
r10997 n6278 n6279 0.78125
r10998 n6216 n6280 0.090277777777777776
r10999 n6279 n6280 1
r11000 n6217 n6281 0.8125
r11001 n6280 n6281 0.3125
r11002 n6218 n6282 0.081250000000000003
r11003 n6281 n6282 0.34375
r11004 n6219 n6283 0.021381578947368422
r11005 n6282 n6283 1.5
r11006 n6220 n6284 0.021381578947368422
r11007 n6283 n6284 2.375
r11008 n6221 n6285 0.021381578947368422
r11009 n6284 n6285 2.375
r11010 n6222 n6286 0.021381578947368422
r11011 n6285 n6286 2.375
r11012 n6223 n6287 0.02389705882352941
r11013 n6286 n6287 2.25
r11014 n6224 n6288 0.02620967741935484
r11015 n6287 n6288 2.03125
r11016 n6225 n6289 0.02620967741935484
r11017 n6288 n6289 1.9375
r11018 n6226 n6290 0.02389705882352941
r11019 n6289 n6290 2.03125
r11020 n6227 n6291 0.033854166666666664
r11021 n6290 n6291 1.8125
r11022 n6228 n6292 0.203125
r11023 n6291 n6292 0.875
r11024 n6229 n6293 0.081250000000000003
r11025 n6292 n6293 0.4375
r11026 n6230 n6294 0.40625
r11027 n6293 n6294 0.375
r11028 n6231 n6295 0.025390625
r11029 n6294 n6295 1.0625
r11030 n6232 n6296 0.40625
r11031 n6295 n6296 1.0625
r11032 n6233 n6297 0.022569444444444444
r11033 n6296 n6297 1.1875
r11034 n6234 n6298 0.40625
r11035 n6297 n6298 1.1875
r11036 n6235 n6299 0.0625
r11037 n6298 n6299 0.46875
r11038 n6236 n6300 0.067708333333333329
r11039 n6299 n6300 0.78125
r11040 n6237 n6301 0.11607142857142858
r11041 n6300 n6301 0.59375
r11042 n6238 n6302 0.40625
r11043 n6301 n6302 0.28125
r11044 n6239 n6303 0.203125
r11045 n6302 n6303 0.1875
r11046 n6240 n6304 0.090277777777777776
r11047 n6303 n6304 0.40625
r11048 n6241 n6305 0.038690476190476192
r11049 n6304 n6305 0.9375
r11050 n6242 n6306 0.40625
r11051 n6305 n6306 0.71875
r11052 n6243 n6307 0.40625
r11053 n6306 n6307 0.125
r11054 n6244 n6308 0.090277777777777776
r11055 n6307 n6308 0.34375
r11056 n6245 n6309 0.067708333333333329
r11057 n6308 n6309 0.65625
r11058 n6246 n6310 0.090277777777777776
r11059 n6309 n6310 0.65625
r11060 n6247 n6311 0.40625
r11061 n6310 n6311 0.34375
r11062 n6248 n6312 0.40625
r11063 n6311 n6312 0.125
r11064 n6249 n6313 0.038690476190476192
r11065 n6312 n6313 0.71875
r11066 n6250 n6314 0.090277777777777776
r11067 n6251 n6315 0.40625
r11068 n6314 n6315 0.34375
r11069 n6252 n6316 0.40625
r11070 n6315 n6316 0.125
r11071 n6253 n6317 0.1015625
r11072 n6316 n6317 0.3125
r11073 n6254 n6318 0.036931818181818184
r11074 n6317 n6318 0.9375
r11075 n6255 n6319 0.8125
r11076 n6318 n6319 0.71875
r11077 n6256 n6320 0.8125
r11078 n6319 n6320 0.0625
r11079 n6257 n6321 0.8125
r11080 n6320 n6321 0.0625
r11081 n6258 n6322 0.081250000000000003
r11082 n6321 n6322 0.34375
r11083 n6259 n6323 0.067708333333333329
r11084 n6322 n6323 0.6875
r11085 n6260 n6324 0.1015625
r11086 n6323 n6324 0.625
r11087 n6261 n6325 0.40625
r11088 n6324 n6325 0.3125
r11089 n6262 n6326 0.27083333333333331
r11090 n6325 n6326 0.15625
r11091 n6263 n6327 0.40625
r11092 n6326 n6327 0.15625
r11093 n6264 n6328 0.13541666666666666
r11094 n6327 n6328 0.25
r11095 n6265 n6329 0.067708333333333329
r11096 n6328 n6329 0.5625
r11097 n6266 n6330 0.081250000000000003
r11098 n6267 n6331 0.035326086956521736
r11099 n6330 n6331 1.03125
r11100 n6268 n6332 0.40625
r11101 n6331 n6332 0.78125
r11102 n6269 n6333 0.027083333333333334
r11103 n6332 n6333 1
r11104 n6270 n6334 0.40625
r11105 n6333 n6334 1
r11106 n6271 n6335 0.035326086956521736
r11107 n6334 n6335 0.78125
r11108 n6272 n6336 0.081250000000000003
r11109 n6335 n6336 1.03125
r11110 n6273 n6337 2
r11111 n6274 n6338 0.22222222222222221
r11112 n6337 n6338 0.020833333333333332
r11113 n6275 n6339 0.086956521739130432
r11114 n6338 n6339 0.066666666666666666
r11115 n6276 n6340 1
r11116 n6339 n6340 0.052083333333333336
r11117 n6277 n6341 0.066666666666666666
r11118 n6340 n6341 0.066666666666666666
r11119 n6278 n6342 1
r11120 n6341 n6342 0.066666666666666666
r11121 n6279 n6343 0.086956521739130432
r11122 n6342 n6343 0.052083333333333336
r11123 n6280 n6344 0.22222222222222221
r11124 n6343 n6344 0.066666666666666666
r11125 n6281 n6345 2
r11126 n6344 n6345 0.020833333333333332
r11127 n6282 n6346 0.20000000000000001
r11128 n6345 n6346 0.022916666666666665
r11129 n6283 n6347 0.052631578947368418
r11130 n6346 n6347 0.10000000000000001
r11131 n6284 n6348 0.052631578947368418
r11132 n6347 n6348 0.15833333333333333
r11133 n6285 n6349 0.052631578947368418
r11134 n6348 n6349 0.15833333333333333
r11135 n6286 n6350 0.052631578947368418
r11136 n6349 n6350 0.15833333333333333
r11137 n6287 n6351 0.058823529411764705
r11138 n6350 n6351 0.14999999999999999
r11139 n6288 n6352 0.064516129032258063
r11140 n6351 n6352 0.13541666666666666
r11141 n6289 n6353 0.064516129032258063
r11142 n6352 n6353 0.12916666666666668
r11143 n6290 n6354 0.058823529411764705
r11144 n6353 n6354 0.13541666666666666
r11145 n6291 n6355 0.083333333333333329
r11146 n6354 n6355 0.12083333333333333
r11147 n6292 n6356 0.5
r11148 n6355 n6356 0.058333333333333334
r11149 n6293 n6357 0.20000000000000001
r11150 n6356 n6357 0.029166666666666667
r11151 n6294 n6358 1
r11152 n6357 n6358 0.025000000000000001
r11153 n6295 n6359 0.0625
r11154 n6358 n6359 0.070833333333333331
r11155 n6296 n6360 1
r11156 n6359 n6360 0.070833333333333331
r11157 n6297 n6361 0.055555555555555552
r11158 n6360 n6361 0.079166666666666663
r11159 n6298 n6362 1
r11160 n6361 n6362 0.079166666666666663
r11161 n6299 n6363 0.15384615384615385
r11162 n6362 n6363 0.03125
r11163 n6300 n6364 0.16666666666666666
r11164 n6363 n6364 0.052083333333333336
r11165 n6301 n6365 0.2857142857142857
r11166 n6364 n6365 0.039583333333333331
r11167 n6302 n6366 1
r11168 n6365 n6366 0.018749999999999999
r11169 n6303 n6367 0.5
r11170 n6366 n6367 0.012500000000000001
r11171 n6304 n6368 0.22222222222222221
r11172 n6367 n6368 0.027083333333333334
r11173 n6305 n6369 0.095238095238095233
r11174 n6368 n6369 0.0625
r11175 n6306 n6370 1
r11176 n6369 n6370 0.04791666666666667
r11177 n6307 n6371 1
r11178 n6370 n6371 0.0083333333333333332
r11179 n6308 n6372 0.22222222222222221
r11180 n6371 n6372 0.022916666666666665
r11181 n6309 n6373 0.16666666666666666
r11182 n6372 n6373 0.043749999999999997
r11183 n6310 n6374 0.22222222222222221
r11184 n6373 n6374 0.043749999999999997
r11185 n6311 n6375 1
r11186 n6374 n6375 0.022916666666666665
r11187 n6312 n6376 1
r11188 n6375 n6376 0.0083333333333333332
r11189 n6313 n6377 0.095238095238095233
r11190 n6376 n6377 0.04791666666666667
r11191 n6314 n6378 0.22222222222222221
r11192 n6315 n6379 1
r11193 n6378 n6379 0.022916666666666665
r11194 n6316 n6380 1
r11195 n6379 n6380 0.0083333333333333332
r11196 n6317 n6381 0.25
r11197 n6380 n6381 0.020833333333333332
r11198 n6318 n6382 0.090909090909090912
r11199 n6381 n6382 0.0625
r11200 n6319 n6383 2
r11201 n6382 n6383 0.04791666666666667
r11202 n6320 n6384 2
r11203 n6383 n6384 0.0041666666666666666
r11204 n6321 n6385 2
r11205 n6384 n6385 0.0041666666666666666
r11206 n6322 n6386 0.20000000000000001
r11207 n6385 n6386 0.022916666666666665
r11208 n6323 n6387 0.16666666666666666
r11209 n6386 n6387 0.04583333333333333
r11210 n6324 n6388 0.25
r11211 n6387 n6388 0.041666666666666664
r11212 n6325 n6389 1
r11213 n6388 n6389 0.020833333333333332
r11214 n6326 n6390 0.66666666666666663
r11215 n6389 n6390 0.010416666666666666
r11216 n6327 n6391 1
r11217 n6390 n6391 0.010416666666666666
r11218 n6328 n6392 0.33333333333333331
r11219 n6391 n6392 0.016666666666666666
r11220 n6329 n6393 0.16666666666666666
r11221 n6392 n6393 0.037499999999999999
r11222 n6330 n6394 0.20000000000000001
r11223 n6331 n6395 0.086956521739130432
r11224 n6394 n6395 0.068750000000000006
r11225 n6332 n6396 1
r11226 n6395 n6396 0.052083333333333336
r11227 n6333 n6397 0.066666666666666666
r11228 n6396 n6397 0.066666666666666666
r11229 n6334 n6398 1
r11230 n6397 n6398 0.066666666666666666
r11231 n6335 n6399 0.086956521739130432
r11232 n6398 n6399 0.052083333333333336
r11233 n6336 n6400 0.20000000000000001
r11234 n6399 n6400 0.068750000000000006
r11235 n6337 n6401 2
r11236 n6338 n6402 0.22222222222222221
r11237 n6401 n6402 0.3125
r11238 n6339 n6403 0.086956521739130432
r11239 n6402 n6403 1
r11240 n6340 n6404 1
r11241 n6403 n6404 0.78125
r11242 n6341 n6405 0.066666666666666666
r11243 n6404 n6405 1
r11244 n6342 n6406 1
r11245 n6405 n6406 1
r11246 n6343 n6407 0.086956521739130432
r11247 n6406 n6407 0.78125
r11248 n6344 n6408 0.22222222222222221
r11249 n6407 n6408 1
r11250 n6345 n6409 2
r11251 n6408 n6409 0.3125
r11252 n6346 n6410 0.20000000000000001
r11253 n6409 n6410 0.34375
r11254 n6347 n6411 0.052631578947368418
r11255 n6410 n6411 1.5
r11256 n6348 n6412 0.052631578947368418
r11257 n6411 n6412 2.375
r11258 n6349 n6413 0.052631578947368418
r11259 n6412 n6413 2.375
r11260 n6350 n6414 0.052631578947368418
r11261 n6413 n6414 2.375
r11262 n6351 n6415 0.058823529411764705
r11263 n6414 n6415 2.25
r11264 n6352 n6416 0.064516129032258063
r11265 n6415 n6416 2.03125
r11266 n6353 n6417 0.064516129032258063
r11267 n6416 n6417 1.9375
r11268 n6354 n6418 0.058823529411764705
r11269 n6417 n6418 2.03125
r11270 n6355 n6419 0.083333333333333329
r11271 n6418 n6419 1.8125
r11272 n6356 n6420 0.5
r11273 n6419 n6420 0.875
r11274 n6357 n6421 0.20000000000000001
r11275 n6420 n6421 0.4375
r11276 n6358 n6422 1
r11277 n6421 n6422 0.375
r11278 n6359 n6423 0.0625
r11279 n6422 n6423 1.0625
r11280 n6360 n6424 1
r11281 n6423 n6424 1.0625
r11282 n6361 n6425 0.055555555555555552
r11283 n6424 n6425 1.1875
r11284 n6362 n6426 1
r11285 n6425 n6426 1.1875
r11286 n6363 n6427 0.15384615384615385
r11287 n6426 n6427 0.46875
r11288 n6364 n6428 0.16666666666666666
r11289 n6427 n6428 0.78125
r11290 n6365 n6429 0.2857142857142857
r11291 n6428 n6429 0.59375
r11292 n6366 n6430 1
r11293 n6429 n6430 0.28125
r11294 n6367 n6431 0.5
r11295 n6430 n6431 0.1875
r11296 n6368 n6432 0.22222222222222221
r11297 n6431 n6432 0.40625
r11298 n6369 n6433 0.095238095238095233
r11299 n6432 n6433 0.9375
r11300 n6370 n6434 1
r11301 n6433 n6434 0.71875
r11302 n6371 n6435 1
r11303 n6434 n6435 0.125
r11304 n6372 n6436 0.22222222222222221
r11305 n6435 n6436 0.34375
r11306 n6373 n6437 0.16666666666666666
r11307 n6436 n6437 0.65625
r11308 n6374 n6438 0.22222222222222221
r11309 n6437 n6438 0.65625
r11310 n6375 n6439 1
r11311 n6438 n6439 0.34375
r11312 n6376 n6440 1
r11313 n6439 n6440 0.125
r11314 n6377 n6441 0.095238095238095233
r11315 n6440 n6441 0.71875
r11316 n6378 n6442 0.22222222222222221
r11317 n6379 n6443 1
r11318 n6442 n6443 0.34375
r11319 n6380 n6444 1
r11320 n6443 n6444 0.125
r11321 n6381 n6445 0.25
r11322 n6444 n6445 0.3125
r11323 n6382 n6446 0.090909090909090912
r11324 n6445 n6446 0.9375
r11325 n6383 n6447 2
r11326 n6446 n6447 0.71875
r11327 n6384 n6448 2
r11328 n6447 n6448 0.0625
r11329 n6385 n6449 2
r11330 n6448 n6449 0.0625
r11331 n6386 n6450 0.20000000000000001
r11332 n6449 n6450 0.34375
r11333 n6387 n6451 0.16666666666666666
r11334 n6450 n6451 0.6875
r11335 n6388 n6452 0.25
r11336 n6451 n6452 0.625
r11337 n6389 n6453 1
r11338 n6452 n6453 0.3125
r11339 n6390 n6454 0.66666666666666663
r11340 n6453 n6454 0.15625
r11341 n6391 n6455 1
r11342 n6454 n6455 0.15625
r11343 n6392 n6456 0.33333333333333331
r11344 n6455 n6456 0.25
r11345 n6393 n6457 0.16666666666666666
r11346 n6456 n6457 0.5625
r11347 n6394 n6458 0.20000000000000001
r11348 n6395 n6459 0.086956521739130432
r11349 n6458 n6459 1.03125
r11350 n6396 n6460 1
r11351 n6459 n6460 0.78125
r11352 n6397 n6461 0.066666666666666666
r11353 n6460 n6461 1
r11354 n6398 n6462 1
r11355 n6461 n6462 1
r11356 n6399 n6463 0.086956521739130432
r11357 n6462 n6463 0.78125
r11358 n6400 n6464 0.20000000000000001
r11359 n6463 n6464 1.03125
r11360 n6401 n6465 0.8125
r11361 n6402 n6466 0.090277777777777776
r11362 n6465 n6466 0.056818181818181816
r11363 n6403 n6467 0.035326086956521736
r11364 n6466 n6467 0.18181818181818182
r11365 n6404 n6468 0.40625
r11366 n6467 n6468 0.14204545454545456
r11367 n6405 n6469 0.027083333333333334
r11368 n6468 n6469 0.18181818181818182
r11369 n6406 n6470 0.40625
r11370 n6469 n6470 0.18181818181818182
r11371 n6407 n6471 0.035326086956521736
r11372 n6470 n6471 0.14204545454545456
r11373 n6408 n6472 0.090277777777777776
r11374 n6471 n6472 0.18181818181818182
r11375 n6409 n6473 0.8125
r11376 n6472 n6473 0.056818181818181816
r11377 n6410 n6474 0.081250000000000003
r11378 n6473 n6474 0.0625
r11379 n6411 n6475 0.021381578947368422
r11380 n6474 n6475 0.27272727272727271
r11381 n6412 n6476 0.021381578947368422
r11382 n6475 n6476 0.43181818181818182
r11383 n6413 n6477 0.021381578947368422
r11384 n6476 n6477 0.43181818181818182
r11385 n6414 n6478 0.021381578947368422
r11386 n6477 n6478 0.43181818181818182
r11387 n6415 n6479 0.02389705882352941
r11388 n6478 n6479 0.40909090909090912
r11389 n6416 n6480 0.02620967741935484
r11390 n6479 n6480 0.36931818181818182
r11391 n6417 n6481 0.02620967741935484
r11392 n6480 n6481 0.35227272727272729
r11393 n6418 n6482 0.02389705882352941
r11394 n6481 n6482 0.36931818181818182
r11395 n6419 n6483 0.033854166666666664
r11396 n6482 n6483 0.32954545454545453
r11397 n6420 n6484 0.203125
r11398 n6483 n6484 0.15909090909090909
r11399 n6421 n6485 0.081250000000000003
r11400 n6484 n6485 0.079545454545454544
r11401 n6422 n6486 0.40625
r11402 n6485 n6486 0.068181818181818177
r11403 n6423 n6487 0.025390625
r11404 n6486 n6487 0.19318181818181818
r11405 n6424 n6488 0.40625
r11406 n6487 n6488 0.19318181818181818
r11407 n6425 n6489 0.022569444444444444
r11408 n6488 n6489 0.21590909090909091
r11409 n6426 n6490 0.40625
r11410 n6489 n6490 0.21590909090909091
r11411 n6427 n6491 0.0625
r11412 n6490 n6491 0.085227272727272721
r11413 n6428 n6492 0.067708333333333329
r11414 n6491 n6492 0.14204545454545456
r11415 n6429 n6493 0.11607142857142858
r11416 n6492 n6493 0.10795454545454546
r11417 n6430 n6494 0.40625
r11418 n6493 n6494 0.05113636363636364
r11419 n6431 n6495 0.203125
r11420 n6494 n6495 0.034090909090909088
r11421 n6432 n6496 0.090277777777777776
r11422 n6495 n6496 0.073863636363636367
r11423 n6433 n6497 0.038690476190476192
r11424 n6496 n6497 0.17045454545454544
r11425 n6434 n6498 0.40625
r11426 n6497 n6498 0.13068181818181818
r11427 n6435 n6499 0.40625
r11428 n6498 n6499 0.022727272727272728
r11429 n6436 n6500 0.090277777777777776
r11430 n6499 n6500 0.0625
r11431 n6437 n6501 0.067708333333333329
r11432 n6500 n6501 0.11931818181818182
r11433 n6438 n6502 0.090277777777777776
r11434 n6501 n6502 0.11931818181818182
r11435 n6439 n6503 0.40625
r11436 n6502 n6503 0.0625
r11437 n6440 n6504 0.40625
r11438 n6503 n6504 0.022727272727272728
r11439 n6441 n6505 0.038690476190476192
r11440 n6504 n6505 0.13068181818181818
r11441 n6442 n6506 0.090277777777777776
r11442 n6443 n6507 0.40625
r11443 n6506 n6507 0.0625
r11444 n6444 n6508 0.40625
r11445 n6507 n6508 0.022727272727272728
r11446 n6445 n6509 0.1015625
r11447 n6508 n6509 0.056818181818181816
r11448 n6446 n6510 0.036931818181818184
r11449 n6509 n6510 0.17045454545454544
r11450 n6447 n6511 0.8125
r11451 n6510 n6511 0.13068181818181818
r11452 n6448 n6512 0.8125
r11453 n6511 n6512 0.011363636363636364
r11454 n6449 n6513 0.8125
r11455 n6512 n6513 0.011363636363636364
r11456 n6450 n6514 0.081250000000000003
r11457 n6513 n6514 0.0625
r11458 n6451 n6515 0.067708333333333329
r11459 n6514 n6515 0.125
r11460 n6452 n6516 0.1015625
r11461 n6515 n6516 0.11363636363636363
r11462 n6453 n6517 0.40625
r11463 n6516 n6517 0.056818181818181816
r11464 n6454 n6518 0.27083333333333331
r11465 n6517 n6518 0.028409090909090908
r11466 n6455 n6519 0.40625
r11467 n6518 n6519 0.028409090909090908
r11468 n6456 n6520 0.13541666666666666
r11469 n6519 n6520 0.045454545454545456
r11470 n6457 n6521 0.067708333333333329
r11471 n6520 n6521 0.10227272727272728
r11472 n6458 n6522 0.081250000000000003
r11473 n6459 n6523 0.035326086956521736
r11474 n6522 n6523 0.1875
r11475 n6460 n6524 0.40625
r11476 n6523 n6524 0.14204545454545456
r11477 n6461 n6525 0.027083333333333334
r11478 n6524 n6525 0.18181818181818182
r11479 n6462 n6526 0.40625
r11480 n6525 n6526 0.18181818181818182
r11481 n6463 n6527 0.035326086956521736
r11482 n6526 n6527 0.14204545454545456
r11483 n6464 n6528 0.081250000000000003
r11484 n6527 n6528 0.1875
r11485 n6465 n6529 0.8125
r11486 n6466 n6530 0.090277777777777776
r11487 n6529 n6530 0.3125
r11488 n6467 n6531 0.035326086956521736
r11489 n6530 n6531 1
r11490 n6468 n6532 0.40625
r11491 n6531 n6532 0.78125
r11492 n6469 n6533 0.027083333333333334
r11493 n6532 n6533 1
r11494 n6470 n6534 0.40625
r11495 n6533 n6534 1
r11496 n6471 n6535 0.035326086956521736
r11497 n6534 n6535 0.78125
r11498 n6472 n6536 0.090277777777777776
r11499 n6535 n6536 1
r11500 n6473 n6537 0.8125
r11501 n6536 n6537 0.3125
r11502 n6497 n6538 0.038690476190476192
r11503 n6498 n6539 0.40625
r11504 n6538 n6539 0.71875
r11505 n6499 n6540 0.40625
r11506 n6539 n6540 0.125
r11507 n6500 n6541 0.090277777777777776
r11508 n6540 n6541 0.34375
r11509 n6501 n6542 0.067708333333333329
r11510 n6541 n6542 0.65625
r11511 n6502 n6543 0.090277777777777776
r11512 n6542 n6543 0.65625
r11513 n6503 n6544 0.40625
r11514 n6543 n6544 0.34375
r11515 n6504 n6545 0.40625
r11516 n6544 n6545 0.125
r11517 n6505 n6546 0.038690476190476192
r11518 n6545 n6546 0.71875
r11519 n6506 n6547 0.090277777777777776
r11520 n6507 n6548 0.40625
r11521 n6547 n6548 0.34375
r11522 n6508 n6549 0.40625
r11523 n6548 n6549 0.125
r11524 n6509 n6550 0.1015625
r11525 n6549 n6550 0.3125
r11526 n6510 n6551 0.036931818181818184
r11527 n6550 n6551 0.9375
r11528 n6511 n6552 0.8125
r11529 n6551 n6552 0.71875
r11530 n6512 n6553 0.8125
r11531 n6552 n6553 0.0625
r11532 n6513 n6554 0.8125
r11533 n6553 n6554 0.0625
r11534 n6514 n6555 0.081250000000000003
r11535 n6554 n6555 0.34375
r11536 n6515 n6556 0.067708333333333329
r11537 n6555 n6556 0.6875
r11538 n6516 n6557 0.1015625
r11539 n6556 n6557 0.625
r11540 n6517 n6558 0.40625
r11541 n6557 n6558 0.3125
r11542 n6518 n6559 0.27083333333333331
r11543 n6558 n6559 0.15625
r11544 n6519 n6560 0.40625
r11545 n6559 n6560 0.15625
r11546 n6520 n6561 0.13541666666666666
r11547 n6560 n6561 0.25
r11548 n6521 n6562 0.067708333333333329
r11549 n6561 n6562 0.5625
r11550 n6522 n6563 0.081250000000000003
r11551 n6523 n6564 0.035326086956521736
r11552 n6563 n6564 1.03125
r11553 n6524 n6565 0.40625
r11554 n6564 n6565 0.78125
r11555 n6525 n6566 0.027083333333333334
r11556 n6565 n6566 1
r11557 n6526 n6567 0.40625
r11558 n6566 n6567 1
r11559 n6527 n6568 0.035326086956521736
r11560 n6567 n6568 0.78125
r11561 n6528 n6569 0.081250000000000003
r11562 n6568 n6569 1.03125
r11563 n6529 n6570 2.0625
r11564 n6530 n6571 0.22916666666666666
r11565 n6570 n6571 0.020161290322580645
r11566 n6531 n6572 0.089673913043478257
r11567 n6571 n6572 0.064516129032258063
r11568 n6532 n6573 1.03125
r11569 n6572 n6573 0.05040322580645161
r11570 n6533 n6574 0.068750000000000006
r11571 n6573 n6574 0.064516129032258063
r11572 n6534 n6575 1.03125
r11573 n6574 n6575 0.064516129032258063
r11574 n6535 n6576 0.089673913043478257
r11575 n6575 n6576 0.05040322580645161
r11576 n6536 n6577 0.22916666666666666
r11577 n6576 n6577 0.064516129032258063
r11578 n6537 n6578 2.0625
r11579 n6577 n6578 0.020161290322580645
r11580 n6547 n6579 0.22916666666666666
r11581 n6548 n6580 1.03125
r11582 n6579 n6580 0.022177419354838711
r11583 n6549 n6581 1.03125
r11584 n6580 n6581 0.0080645161290322578
r11585 n6550 n6582 0.2578125
r11586 n6581 n6582 0.020161290322580645
r11587 n6551 n6583 0.09375
r11588 n6582 n6583 0.060483870967741937
r11589 n6552 n6584 2.0625
r11590 n6583 n6584 0.046370967741935484
r11591 n6553 n6585 2.0625
r11592 n6584 n6585 0.0040322580645161289
r11593 n6554 n6586 2.0625
r11594 n6585 n6586 0.0040322580645161289
r11595 n6555 n6587 0.20624999999999999
r11596 n6586 n6587 0.022177419354838711
r11597 n6563 n6588 0.20624999999999999
r11598 n6564 n6589 0.089673913043478257
r11599 n6588 n6589 0.066532258064516125
r11600 n6565 n6590 1.03125
r11601 n6589 n6590 0.05040322580645161
r11602 n6566 n6591 0.068750000000000006
r11603 n6590 n6591 0.064516129032258063
r11604 n6567 n6592 1.03125
r11605 n6591 n6592 0.064516129032258063
r11606 n6568 n6593 0.089673913043478257
r11607 n6592 n6593 0.05040322580645161
r11608 n6569 n6594 0.20624999999999999
r11609 n6593 n6594 0.066532258064516125
r11610 n6570 n6595 3.875
r11611 n6571 n6596 0.43055555555555558
r11612 n6595 n6596 0.020161290322580645
r11613 n6572 n6597 0.16847826086956522
r11614 n6596 n6597 0.064516129032258063
r11615 n6573 n6598 1.9375
r11616 n6597 n6598 0.05040322580645161
r11617 n6574 n6599 0.12916666666666668
r11618 n6598 n6599 0.064516129032258063
r11619 n6575 n6600 1.9375
r11620 n6599 n6600 0.064516129032258063
r11621 n6576 n6601 0.16847826086956522
r11622 n6600 n6601 0.05040322580645161
r11623 n6577 n6602 0.43055555555555558
r11624 n6601 n6602 0.064516129032258063
r11625 n6578 n6603 3.875
r11626 n6602 n6603 0.020161290322580645
r11627 n6579 n6604 0.43055555555555558
r11628 n6580 n6605 1.9375
r11629 n6604 n6605 0.022177419354838711
r11630 n6581 n6606 1.9375
r11631 n6605 n6606 0.0080645161290322578
r11632 n6582 n6607 0.484375
r11633 n6606 n6607 0.020161290322580645
r11634 n6583 n6608 0.17613636363636365
r11635 n6607 n6608 0.060483870967741937
r11636 n6584 n6609 3.875
r11637 n6608 n6609 0.046370967741935484
r11638 n6585 n6610 3.875
r11639 n6609 n6610 0.0040322580645161289
r11640 n6586 n6611 3.875
r11641 n6610 n6611 0.0040322580645161289
r11642 n6587 n6612 0.38750000000000001
r11643 n6611 n6612 0.022177419354838711
r11644 n6588 n6613 0.38750000000000001
r11645 n6589 n6614 0.16847826086956522
r11646 n6613 n6614 0.066532258064516125
r11647 n6590 n6615 1.9375
r11648 n6614 n6615 0.05040322580645161
r11649 n6591 n6616 0.12916666666666668
r11650 n6615 n6616 0.064516129032258063
r11651 n6592 n6617 1.9375
r11652 n6616 n6617 0.064516129032258063
r11653 n6593 n6618 0.16847826086956522
r11654 n6617 n6618 0.05040322580645161
r11655 n6594 n6619 0.38750000000000001
r11656 n6618 n6619 0.066532258064516125
r11657 n6595 n6620 2.8125
r11658 n6596 n6621 0.3125
r11659 n6620 n6621 0.044642857142857144
r11660 n6597 n6622 0.12228260869565218
r11661 n6621 n6622 0.14285714285714285
r11662 n6598 n6623 1.40625
r11663 n6622 n6623 0.11160714285714286
r11664 n6599 n6624 0.09375
r11665 n6623 n6624 0.14285714285714285
r11666 n6600 n6625 1.40625
r11667 n6624 n6625 0.14285714285714285
r11668 n6601 n6626 0.12228260869565218
r11669 n6625 n6626 0.11160714285714286
r11670 n6602 n6627 0.3125
r11671 n6626 n6627 0.14285714285714285
r11672 n6603 n6628 2.8125
r11673 n6627 n6628 0.044642857142857144
r11674 n6604 n6629 0.3125
r11675 n6605 n6630 1.40625
r11676 n6629 n6630 0.049107142857142856
r11677 n6606 n6631 1.40625
r11678 n6630 n6631 0.017857142857142856
r11679 n6607 n6632 0.3515625
r11680 n6631 n6632 0.044642857142857144
r11681 n6608 n6633 0.12784090909090909
r11682 n6632 n6633 0.13392857142857142
r11683 n6609 n6634 2.8125
r11684 n6633 n6634 0.10267857142857142
r11685 n6610 n6635 2.8125
r11686 n6634 n6635 0.0089285714285714281
r11687 n6611 n6636 2.8125
r11688 n6635 n6636 0.0089285714285714281
r11689 n6612 n6637 0.28125
r11690 n6636 n6637 0.049107142857142856
r11691 n6613 n6638 0.28125
r11692 n6614 n6639 0.12228260869565218
r11693 n6638 n6639 0.14732142857142858
r11694 n6615 n6640 1.40625
r11695 n6639 n6640 0.11160714285714286
r11696 n6616 n6641 0.09375
r11697 n6640 n6641 0.14285714285714285
r11698 n6617 n6642 1.40625
r11699 n6641 n6642 0.14285714285714285
r11700 n6618 n6643 0.12228260869565218
r11701 n6642 n6643 0.11160714285714286
r11702 n6619 n6644 0.28125
r11703 n6643 n6644 0.14732142857142858
r11704 n6620 n6645 1
r11705 n6621 n6646 0.1111111111111111
r11706 n6645 n6646 0.3125
r11707 n6622 n6647 0.043478260869565216
r11708 n6646 n6647 1
r11709 n6623 n6648 0.5
r11710 n6647 n6648 0.78125
r11711 n6624 n6649 0.033333333333333333
r11712 n6648 n6649 1
r11713 n6625 n6650 0.5
r11714 n6649 n6650 1
r11715 n6626 n6651 0.043478260869565216
r11716 n6650 n6651 0.78125
r11717 n6627 n6652 0.1111111111111111
r11718 n6651 n6652 1
r11719 n6628 n6653 1
r11720 n6652 n6653 0.3125
r11721 n6654 n6655 0.59375
r11722 n6655 n6656 0.28125
r11723 n6656 n6657 0.1875
r11724 n6657 n6658 0.40625
r11725 n6658 n6659 0.9375
r11726 n6659 n6660 0.71875
r11727 n6660 n6661 0.125
r11728 n6661 n6662 0.34375
r11729 n6662 n6663 0.65625
r11730 n6629 n6665 0.1111111111111111
r11731 n6664 n6665 0.65625
r11732 n6630 n6666 0.5
r11733 n6665 n6666 0.34375
r11734 n6631 n6667 0.5
r11735 n6666 n6667 0.125
r11736 n6632 n6668 0.125
r11737 n6667 n6668 0.3125
r11738 n6633 n6669 0.045454545454545456
r11739 n6668 n6669 0.9375
r11740 n6634 n6670 1
r11741 n6669 n6670 0.71875
r11742 n6635 n6671 1
r11743 n6670 n6671 0.0625
r11744 n6636 n6672 1
r11745 n6671 n6672 0.0625
r11746 n6637 n6673 0.10000000000000001
r11747 n6672 n6673 0.34375
r11748 n6673 n6674 0.6875
r11749 n6638 n6675 0.10000000000000001
r11750 n6639 n6676 0.043478260869565216
r11751 n6675 n6676 1.03125
r11752 n6640 n6677 0.5
r11753 n6676 n6677 0.78125
r11754 n6641 n6678 0.033333333333333333
r11755 n6677 n6678 1
r11756 n6642 n6679 0.5
r11757 n6678 n6679 1
r11758 n6643 n6680 0.043478260869565216
r11759 n6679 n6680 0.78125
r11760 n6644 n6681 0.10000000000000001
r11761 n6680 n6681 1.03125
r11762 n6645 n6682 0.4375
r11763 n6646 n6683 0.048611111111111112
r11764 n6682 n6683 0.125
r11765 n6647 n6684 0.019021739130434784
r11766 n6683 n6684 0.40000000000000002
r11767 n6648 n6685 0.21875
r11768 n6684 n6685 0.3125
r11769 n6649 n6686 0.014583333333333334
r11770 n6685 n6686 0.40000000000000002
r11771 n6650 n6687 0.21875
r11772 n6686 n6687 0.40000000000000002
r11773 n6651 n6688 0.019021739130434784
r11774 n6687 n6688 0.3125
r11775 n6652 n6689 0.048611111111111112
r11776 n6688 n6689 0.40000000000000002
r11777 n6653 n6690 0.4375
r11778 n6689 n6690 0.125
r11779 n6690 n6691 0.13750000000000001
r11780 n6691 n6692 0.59999999999999998
r11781 n6692 n6693 0.94999999999999996
r11782 n6693 n6694 0.94999999999999996
r11783 n6694 n6695 0.94999999999999996
r11784 n6695 n6696 0.90000000000000002
r11785 n6696 n6697 0.8125
r11786 n6697 n6698 0.77500000000000002
r11787 n6698 n6699 0.8125
r11788 n6699 n6700 0.72499999999999998
r11789 n6700 n6701 0.34999999999999998
r11790 n6701 n6702 0.17499999999999999
r11791 n6702 n6703 0.14999999999999999
r11792 n6703 n6704 0.42499999999999999
r11793 n6704 n6705 0.42499999999999999
r11794 n6705 n6706 0.47499999999999998
r11795 n6706 n6707 0.47499999999999998
r11796 n6707 n6708 0.1875
r11797 n6654 n6709 0.036458333333333336
r11798 n6708 n6709 0.3125
r11799 n6655 n6710 0.0625
r11800 n6709 n6710 0.23749999999999999
r11801 n6656 n6711 0.21875
r11802 n6710 n6711 0.1125
r11803 n6657 n6712 0.109375
r11804 n6711 n6712 0.074999999999999997
r11805 n6658 n6713 0.048611111111111112
r11806 n6712 n6713 0.16250000000000001
r11807 n6659 n6714 0.020833333333333332
r11808 n6713 n6714 0.375
r11809 n6660 n6715 0.21875
r11810 n6714 n6715 0.28749999999999998
r11811 n6661 n6716 0.21875
r11812 n6715 n6716 0.050000000000000003
r11813 n6662 n6717 0.048611111111111112
r11814 n6716 n6717 0.13750000000000001
r11815 n6663 n6718 0.036458333333333336
r11816 n6717 n6718 0.26250000000000001
r11817 n6664 n6719 0.036458333333333336
r11818 n6665 n6720 0.048611111111111112
r11819 n6719 n6720 0.26250000000000001
r11820 n6666 n6721 0.21875
r11821 n6720 n6721 0.13750000000000001
r11822 n6667 n6722 0.21875
r11823 n6721 n6722 0.050000000000000003
r11824 n6668 n6723 0.0546875
r11825 n6722 n6723 0.125
r11826 n6669 n6724 0.019886363636363636
r11827 n6723 n6724 0.375
r11828 n6670 n6725 0.4375
r11829 n6724 n6725 0.28749999999999998
r11830 n6671 n6726 0.4375
r11831 n6725 n6726 0.025000000000000001
r11832 n6672 n6727 0.4375
r11833 n6726 n6727 0.025000000000000001
r11834 n6673 n6728 0.043749999999999997
r11835 n6727 n6728 0.13750000000000001
r11836 n6674 n6729 0.036458333333333336
r11837 n6728 n6729 0.27500000000000002
r11838 n6675 n6730 0.043749999999999997
r11839 n6676 n6731 0.019021739130434784
r11840 n6730 n6731 0.41249999999999998
r11841 n6677 n6732 0.21875
r11842 n6731 n6732 0.3125
r11843 n6678 n6733 0.014583333333333334
r11844 n6732 n6733 0.40000000000000002
r11845 n6679 n6734 0.21875
r11846 n6733 n6734 0.40000000000000002
r11847 n6680 n6735 0.019021739130434784
r11848 n6734 n6735 0.3125
r11849 n6681 n6736 0.043749999999999997
r11850 n6735 n6736 0.41249999999999998
r11851 n6682 n6737 0.6875
r11852 n6683 n6738 0.076388888888888895
r11853 n6737 n6738 0.10416666666666667
r11854 n6684 n6739 0.029891304347826088
r11855 n6738 n6739 0.33333333333333331
r11856 n6685 n6740 0.34375
r11857 n6739 n6740 0.26041666666666669
r11858 n6686 n6741 0.022916666666666665
r11859 n6740 n6741 0.33333333333333331
r11860 n6687 n6742 0.34375
r11861 n6741 n6742 0.33333333333333331
r11862 n6688 n6743 0.029891304347826088
r11863 n6742 n6743 0.26041666666666669
r11864 n6689 n6744 0.076388888888888895
r11865 n6743 n6744 0.33333333333333331
r11866 n6690 n6745 0.6875
r11867 n6744 n6745 0.10416666666666667
r11868 n6691 n6746 0.068750000000000006
r11869 n6745 n6746 0.11458333333333333
r11870 n6692 n6747 0.018092105263157895
r11871 n6746 n6747 0.5
r11872 n6693 n6748 0.018092105263157895
r11873 n6747 n6748 0.79166666666666663
r11874 n6694 n6749 0.018092105263157895
r11875 n6748 n6749 0.79166666666666663
r11876 n6695 n6750 0.018092105263157895
r11877 n6749 n6750 0.79166666666666663
r11878 n6696 n6751 0.020220588235294119
r11879 n6750 n6751 0.75
r11880 n6697 n6752 0.022177419354838711
r11881 n6751 n6752 0.67708333333333337
r11882 n6698 n6753 0.022177419354838711
r11883 n6752 n6753 0.64583333333333337
r11884 n6699 n6754 0.020220588235294119
r11885 n6753 n6754 0.67708333333333337
r11886 n6700 n6755 0.028645833333333332
r11887 n6754 n6755 0.60416666666666663
r11888 n6701 n6756 0.171875
r11889 n6755 n6756 0.29166666666666669
r11890 n6702 n6757 0.068750000000000006
r11891 n6756 n6757 0.14583333333333334
r11892 n6703 n6758 0.34375
r11893 n6757 n6758 0.125
r11894 n6704 n6759 0.021484375
r11895 n6758 n6759 0.35416666666666669
r11896 n6705 n6760 0.34375
r11897 n6759 n6760 0.35416666666666669
r11898 n6706 n6761 0.019097222222222224
r11899 n6760 n6761 0.39583333333333331
r11900 n6707 n6762 0.34375
r11901 n6761 n6762 0.39583333333333331
r11902 n6708 n6763 0.052884615384615384
r11903 n6762 n6763 0.15625
r11904 n6709 n6764 0.057291666666666664
r11905 n6763 n6764 0.26041666666666669
r11906 n6710 n6765 0.098214285714285712
r11907 n6764 n6765 0.19791666666666666
r11908 n6711 n6766 0.34375
r11909 n6765 n6766 0.09375
r11910 n6712 n6767 0.171875
r11911 n6766 n6767 0.0625
r11912 n6713 n6768 0.076388888888888895
r11913 n6767 n6768 0.13541666666666666
r11914 n6714 n6769 0.03273809523809524
r11915 n6768 n6769 0.3125
r11916 n6715 n6770 0.34375
r11917 n6769 n6770 0.23958333333333334
r11918 n6716 n6771 0.34375
r11919 n6770 n6771 0.041666666666666664
r11920 n6717 n6772 0.076388888888888895
r11921 n6771 n6772 0.11458333333333333
r11922 n6718 n6773 0.057291666666666664
r11923 n6772 n6773 0.21875
r11924 n6719 n6774 0.057291666666666664
r11925 n6720 n6775 0.076388888888888895
r11926 n6774 n6775 0.21875
r11927 n6721 n6776 0.34375
r11928 n6775 n6776 0.11458333333333333
r11929 n6722 n6777 0.34375
r11930 n6776 n6777 0.041666666666666664
r11931 n6723 n6778 0.0859375
r11932 n6777 n6778 0.10416666666666667
r11933 n6724 n6779 0.03125
r11934 n6778 n6779 0.3125
r11935 n6725 n6780 0.6875
r11936 n6779 n6780 0.23958333333333334
r11937 n6726 n6781 0.6875
r11938 n6780 n6781 0.020833333333333332
r11939 n6727 n6782 0.6875
r11940 n6781 n6782 0.020833333333333332
r11941 n6728 n6783 0.068750000000000006
r11942 n6782 n6783 0.11458333333333333
r11943 n6729 n6784 0.057291666666666664
r11944 n6783 n6784 0.22916666666666666
r11945 n6730 n6785 0.068750000000000006
r11946 n6731 n6786 0.029891304347826088
r11947 n6785 n6786 0.34375
r11948 n6732 n6787 0.34375
r11949 n6786 n6787 0.26041666666666669
r11950 n6733 n6788 0.022916666666666665
r11951 n6787 n6788 0.33333333333333331
r11952 n6734 n6789 0.34375
r11953 n6788 n6789 0.33333333333333331
r11954 n6735 n6790 0.029891304347826088
r11955 n6789 n6790 0.26041666666666669
r11956 n6736 n6791 0.068750000000000006
r11957 n6790 n6791 0.34375
r11958 n6737 n6792 0.5
r11959 n6738 n6793 0.055555555555555552
r11960 n6792 n6793 0.3125
r11961 n6739 n6794 0.021739130434782608
r11962 n6793 n6794 1
r11963 n6740 n6795 0.25
r11964 n6794 n6795 0.78125
r11965 n6741 n6796 0.016666666666666666
r11966 n6795 n6796 1
r11967 n6742 n6797 0.25
r11968 n6796 n6797 1
r11969 n6743 n6798 0.021739130434782608
r11970 n6797 n6798 0.78125
r11971 n6744 n6799 0.055555555555555552
r11972 n6798 n6799 1
r11973 n6745 n6800 0.5
r11974 n6799 n6800 0.3125
r11975 n6746 n6801 0.050000000000000003
r11976 n6800 n6801 0.34375
r11977 n6747 n6802 0.013157894736842105
r11978 n6801 n6802 1.5
r11979 n6748 n6803 0.013157894736842105
r11980 n6802 n6803 2.375
r11981 n6749 n6804 0.013157894736842105
r11982 n6803 n6804 2.375
r11983 n6750 n6805 0.013157894736842105
r11984 n6804 n6805 2.375
r11985 n6751 n6806 0.014705882352941176
r11986 n6805 n6806 2.25
r11987 n6752 n6807 0.016129032258064516
r11988 n6806 n6807 2.03125
r11989 n6753 n6808 0.016129032258064516
r11990 n6807 n6808 1.9375
r11991 n6754 n6809 0.014705882352941176
r11992 n6808 n6809 2.03125
r11993 n6755 n6810 0.020833333333333332
r11994 n6809 n6810 1.8125
r11995 n6756 n6811 0.125
r11996 n6810 n6811 0.875
r11997 n6757 n6812 0.050000000000000003
r11998 n6811 n6812 0.4375
r11999 n6758 n6813 0.25
r12000 n6812 n6813 0.375
r12001 n6759 n6814 0.015625
r12002 n6813 n6814 1.0625
r12003 n6760 n6815 0.25
r12004 n6814 n6815 1.0625
r12005 n6761 n6816 0.013888888888888888
r12006 n6815 n6816 1.1875
r12007 n6762 n6817 0.25
r12008 n6816 n6817 1.1875
r12009 n6763 n6818 0.038461538461538464
r12010 n6817 n6818 0.46875
r12011 n6764 n6819 0.041666666666666664
r12012 n6818 n6819 0.78125
r12013 n6765 n6820 0.071428571428571425
r12014 n6819 n6820 0.59375
r12015 n6766 n6821 0.25
r12016 n6820 n6821 0.28125
r12017 n6767 n6822 0.125
r12018 n6821 n6822 0.1875
r12019 n6768 n6823 0.055555555555555552
r12020 n6822 n6823 0.40625
r12021 n6769 n6824 0.023809523809523808
r12022 n6823 n6824 0.9375
r12023 n6770 n6825 0.25
r12024 n6824 n6825 0.71875
r12025 n6771 n6826 0.25
r12026 n6825 n6826 0.125
r12027 n6772 n6827 0.055555555555555552
r12028 n6826 n6827 0.34375
r12029 n6773 n6828 0.041666666666666664
r12030 n6827 n6828 0.65625
r12031 n6774 n6829 0.041666666666666664
r12032 n6775 n6830 0.055555555555555552
r12033 n6829 n6830 0.65625
r12034 n6776 n6831 0.25
r12035 n6830 n6831 0.34375
r12036 n6777 n6832 0.25
r12037 n6831 n6832 0.125
r12038 n6778 n6833 0.0625
r12039 n6832 n6833 0.3125
r12040 n6779 n6834 0.022727272727272728
r12041 n6833 n6834 0.9375
r12042 n6780 n6835 0.5
r12043 n6834 n6835 0.71875
r12044 n6781 n6836 0.5
r12045 n6835 n6836 0.0625
r12046 n6782 n6837 0.5
r12047 n6836 n6837 0.0625
r12048 n6783 n6838 0.050000000000000003
r12049 n6837 n6838 0.34375
r12050 n6784 n6839 0.041666666666666664
r12051 n6838 n6839 0.6875
r12052 n6785 n6840 0.050000000000000003
r12053 n6786 n6841 0.021739130434782608
r12054 n6840 n6841 1.03125
r12055 n6787 n6842 0.25
r12056 n6841 n6842 0.78125
r12057 n6788 n6843 0.016666666666666666
r12058 n6842 n6843 1
r12059 n6789 n6844 0.25
r12060 n6843 n6844 1
r12061 n6790 n6845 0.021739130434782608
r12062 n6844 n6845 0.78125
r12063 n6791 n6846 0.050000000000000003
r12064 n6845 n6846 1.03125
r12065 n6792 n6847 0.4375
r12066 n6793 n6848 0.048611111111111112
r12067 n6847 n6848 0.125
r12068 n6794 n6849 0.019021739130434784
r12069 n6848 n6849 0.40000000000000002
r12070 n6795 n6850 0.21875
r12071 n6849 n6850 0.3125
r12072 n6796 n6851 0.014583333333333334
r12073 n6850 n6851 0.40000000000000002
r12074 n6797 n6852 0.21875
r12075 n6851 n6852 0.40000000000000002
r12076 n6798 n6853 0.019021739130434784
r12077 n6852 n6853 0.3125
r12078 n6799 n6854 0.048611111111111112
r12079 n6853 n6854 0.40000000000000002
r12080 n6800 n6855 0.4375
r12081 n6854 n6855 0.125
r12082 n6801 n6856 0.043749999999999997
r12083 n6855 n6856 0.13750000000000001
r12084 n6802 n6857 0.011513157894736841
r12085 n6856 n6857 0.59999999999999998
r12086 n6803 n6858 0.011513157894736841
r12087 n6857 n6858 0.94999999999999996
r12088 n6804 n6859 0.011513157894736841
r12089 n6858 n6859 0.94999999999999996
r12090 n6805 n6860 0.011513157894736841
r12091 n6859 n6860 0.94999999999999996
r12092 n6806 n6861 0.012867647058823529
r12093 n6860 n6861 0.90000000000000002
r12094 n6807 n6862 0.014112903225806451
r12095 n6861 n6862 0.8125
r12096 n6808 n6863 0.014112903225806451
r12097 n6862 n6863 0.77500000000000002
r12098 n6809 n6864 0.012867647058823529
r12099 n6863 n6864 0.8125
r12100 n6810 n6865 0.018229166666666668
r12101 n6864 n6865 0.72499999999999998
r12102 n6811 n6866 0.109375
r12103 n6865 n6866 0.34999999999999998
r12104 n6812 n6867 0.043749999999999997
r12105 n6866 n6867 0.17499999999999999
r12106 n6813 n6868 0.21875
r12107 n6867 n6868 0.14999999999999999
r12108 n6814 n6869 0.013671875
r12109 n6868 n6869 0.42499999999999999
r12110 n6815 n6870 0.21875
r12111 n6869 n6870 0.42499999999999999
r12112 n6816 n6871 0.012152777777777778
r12113 n6870 n6871 0.47499999999999998
r12114 n6817 n6872 0.21875
r12115 n6871 n6872 0.47499999999999998
r12116 n6818 n6873 0.033653846153846152
r12117 n6872 n6873 0.1875
r12118 n6819 n6874 0.036458333333333336
r12119 n6873 n6874 0.3125
r12120 n6820 n6875 0.0625
r12121 n6874 n6875 0.23749999999999999
r12122 n6821 n6876 0.21875
r12123 n6875 n6876 0.1125
r12124 n6822 n6877 0.109375
r12125 n6876 n6877 0.074999999999999997
r12126 n6823 n6878 0.048611111111111112
r12127 n6877 n6878 0.16250000000000001
r12128 n6824 n6879 0.020833333333333332
r12129 n6878 n6879 0.375
r12130 n6825 n6880 0.21875
r12131 n6879 n6880 0.28749999999999998
r12132 n6826 n6881 0.21875
r12133 n6880 n6881 0.050000000000000003
r12134 n6827 n6882 0.048611111111111112
r12135 n6881 n6882 0.13750000000000001
r12136 n6828 n6883 0.036458333333333336
r12137 n6882 n6883 0.26250000000000001
r12138 n6829 n6884 0.036458333333333336
r12139 n6830 n6885 0.048611111111111112
r12140 n6884 n6885 0.26250000000000001
r12141 n6831 n6886 0.21875
r12142 n6885 n6886 0.13750000000000001
r12143 n6832 n6887 0.21875
r12144 n6886 n6887 0.050000000000000003
r12145 n6833 n6888 0.0546875
r12146 n6887 n6888 0.125
r12147 n6834 n6889 0.019886363636363636
r12148 n6888 n6889 0.375
r12149 n6835 n6890 0.4375
r12150 n6889 n6890 0.28749999999999998
r12151 n6836 n6891 0.4375
r12152 n6890 n6891 0.025000000000000001
r12153 n6837 n6892 0.4375
r12154 n6891 n6892 0.025000000000000001
r12155 n6838 n6893 0.043749999999999997
r12156 n6892 n6893 0.13750000000000001
r12157 n6839 n6894 0.036458333333333336
r12158 n6893 n6894 0.27500000000000002
r12159 n6840 n6895 0.043749999999999997
r12160 n6841 n6896 0.019021739130434784
r12161 n6895 n6896 0.41249999999999998
r12162 n6842 n6897 0.21875
r12163 n6896 n6897 0.3125
r12164 n6843 n6898 0.014583333333333334
r12165 n6897 n6898 0.40000000000000002
r12166 n6844 n6899 0.21875
r12167 n6898 n6899 0.40000000000000002
r12168 n6845 n6900 0.019021739130434784
r12169 n6899 n6900 0.3125
r12170 n6846 n6901 0.043749999999999997
r12171 n6900 n6901 0.41249999999999998
r12172 n6847 n6902 1.25
r12173 n6848 n6903 0.1388888888888889
r12174 n6902 n6903 0.041666666666666664
r12175 n6849 n6904 0.05434782608695652
r12176 n6903 n6904 0.13333333333333333
r12177 n6850 n6905 0.625
r12178 n6904 n6905 0.10416666666666667
r12179 n6851 n6906 0.041666666666666664
r12180 n6905 n6906 0.13333333333333333
r12181 n6852 n6907 0.625
r12182 n6906 n6907 0.13333333333333333
r12183 n6853 n6908 0.05434782608695652
r12184 n6907 n6908 0.10416666666666667
r12185 n6854 n6909 0.1388888888888889
r12186 n6908 n6909 0.13333333333333333
r12187 n6855 n6910 1.25
r12188 n6909 n6910 0.041666666666666664
r12189 n6856 n6911 0.125
r12190 n6910 n6911 0.04583333333333333
r12191 n6857 n6912 0.032894736842105261
r12192 n6911 n6912 0.20000000000000001
r12193 n6858 n6913 0.032894736842105261
r12194 n6912 n6913 0.31666666666666665
r12195 n6859 n6914 0.032894736842105261
r12196 n6913 n6914 0.31666666666666665
r12197 n6860 n6915 0.032894736842105261
r12198 n6914 n6915 0.31666666666666665
r12199 n6861 n6916 0.036764705882352942
r12200 n6915 n6916 0.29999999999999999
r12201 n6862 n6917 0.040322580645161289
r12202 n6916 n6917 0.27083333333333331
r12203 n6863 n6918 0.040322580645161289
r12204 n6917 n6918 0.25833333333333336
r12205 n6864 n6919 0.036764705882352942
r12206 n6918 n6919 0.27083333333333331
r12207 n6865 n6920 0.052083333333333336
r12208 n6919 n6920 0.24166666666666667
r12209 n6866 n6921 0.3125
r12210 n6920 n6921 0.11666666666666667
r12211 n6867 n6922 0.125
r12212 n6921 n6922 0.058333333333333334
r12213 n6868 n6923 0.625
r12214 n6922 n6923 0.050000000000000003
r12215 n6869 n6924 0.0390625
r12216 n6923 n6924 0.14166666666666666
r12217 n6870 n6925 0.625
r12218 n6924 n6925 0.14166666666666666
r12219 n6871 n6926 0.034722222222222224
r12220 n6925 n6926 0.15833333333333333
r12221 n6872 n6927 0.625
r12222 n6926 n6927 0.15833333333333333
r12223 n6873 n6928 0.096153846153846159
r12224 n6927 n6928 0.0625
r12225 n6874 n6929 0.10416666666666667
r12226 n6928 n6929 0.10416666666666667
r12227 n6875 n6930 0.17857142857142858
r12228 n6929 n6930 0.079166666666666663
r12229 n6876 n6931 0.625
r12230 n6930 n6931 0.037499999999999999
r12231 n6877 n6932 0.3125
r12232 n6931 n6932 0.025000000000000001
r12233 n6878 n6933 0.1388888888888889
r12234 n6932 n6933 0.054166666666666669
r12235 n6879 n6934 0.059523809523809521
r12236 n6933 n6934 0.125
r12237 n6880 n6935 0.625
r12238 n6934 n6935 0.09583333333333334
r12239 n6881 n6936 0.625
r12240 n6935 n6936 0.016666666666666666
r12241 n6882 n6937 0.1388888888888889
r12242 n6936 n6937 0.04583333333333333
r12243 n6883 n6938 0.10416666666666667
r12244 n6937 n6938 0.087499999999999994
r12245 n6884 n6939 0.10416666666666667
r12246 n6885 n6940 0.1388888888888889
r12247 n6939 n6940 0.087499999999999994
r12248 n6886 n6941 0.625
r12249 n6940 n6941 0.04583333333333333
r12250 n6887 n6942 0.625
r12251 n6941 n6942 0.016666666666666666
r12252 n6888 n6943 0.15625
r12253 n6942 n6943 0.041666666666666664
r12254 n6889 n6944 0.056818181818181816
r12255 n6943 n6944 0.125
r12256 n6890 n6945 1.25
r12257 n6944 n6945 0.09583333333333334
r12258 n6891 n6946 1.25
r12259 n6945 n6946 0.0083333333333333332
r12260 n6892 n6947 1.25
r12261 n6946 n6947 0.0083333333333333332
r12262 n6893 n6948 0.125
r12263 n6947 n6948 0.04583333333333333
r12264 n6894 n6949 0.10416666666666667
r12265 n6948 n6949 0.09166666666666666
r12266 n6895 n6950 0.125
r12267 n6896 n6951 0.05434782608695652
r12268 n6950 n6951 0.13750000000000001
r12269 n6897 n6952 0.625
r12270 n6951 n6952 0.10416666666666667
r12271 n6898 n6953 0.041666666666666664
r12272 n6952 n6953 0.13333333333333333
r12273 n6899 n6954 0.625
r12274 n6953 n6954 0.13333333333333333
r12275 n6900 n6955 0.05434782608695652
r12276 n6954 n6955 0.10416666666666667
r12277 n6901 n6956 0.125
r12278 n6955 n6956 0.13750000000000001
r12279 n6902 n6957 1.125
r12280 n6903 n6958 0.125
r12281 n6957 n6958 0.20833333333333334
r12282 n6904 n6959 0.048913043478260872
r12283 n6958 n6959 0.66666666666666663
r12284 n6905 n6960 0.5625
r12285 n6959 n6960 0.52083333333333337
r12286 n6906 n6961 0.037499999999999999
r12287 n6960 n6961 0.66666666666666663
r12288 n6907 n6962 0.5625
r12289 n6961 n6962 0.66666666666666663
r12290 n6908 n6963 0.048913043478260872
r12291 n6962 n6963 0.52083333333333337
r12292 n6909 n6964 0.125
r12293 n6963 n6964 0.66666666666666663
r12294 n6910 n6965 1.125
r12295 n6964 n6965 0.20833333333333334
r12296 n6911 n6966 0.1125
r12297 n6965 n6966 0.22916666666666666
r12298 n6912 n6967 0.029605263157894735
r12299 n6966 n6967 1
r12300 n6913 n6968 0.029605263157894735
r12301 n6967 n6968 1.5833333333333333
r12302 n6914 n6969 0.029605263157894735
r12303 n6968 n6969 1.5833333333333333
r12304 n6915 n6970 0.029605263157894735
r12305 n6969 n6970 1.5833333333333333
r12306 n6916 n6971 0.033088235294117647
r12307 n6970 n6971 1.5
r12308 n6917 n6972 0.036290322580645164
r12309 n6971 n6972 1.3541666666666667
r12310 n6918 n6973 0.036290322580645164
r12311 n6972 n6973 1.2916666666666667
r12312 n6919 n6974 0.033088235294117647
r12313 n6973 n6974 1.3541666666666667
r12314 n6920 n6975 0.046875
r12315 n6974 n6975 1.2083333333333333
r12316 n6921 n6976 0.28125
r12317 n6975 n6976 0.58333333333333337
r12318 n6922 n6977 0.1125
r12319 n6976 n6977 0.29166666666666669
r12320 n6923 n6978 0.5625
r12321 n6977 n6978 0.25
r12322 n6924 n6979 0.03515625
r12323 n6978 n6979 0.70833333333333337
r12324 n6925 n6980 0.5625
r12325 n6979 n6980 0.70833333333333337
r12326 n6926 n6981 0.03125
r12327 n6980 n6981 0.79166666666666663
r12328 n6927 n6982 0.5625
r12329 n6981 n6982 0.79166666666666663
r12330 n6928 n6983 0.086538461538461536
r12331 n6982 n6983 0.3125
r12332 n6929 n6984 0.09375
r12333 n6983 n6984 0.52083333333333337
r12334 n6930 n6985 0.16071428571428573
r12335 n6984 n6985 0.39583333333333331
r12336 n6931 n6986 0.5625
r12337 n6985 n6986 0.1875
r12338 n6932 n6987 0.28125
r12339 n6986 n6987 0.125
r12340 n6933 n6988 0.125
r12341 n6987 n6988 0.27083333333333331
r12342 n6934 n6989 0.053571428571428568
r12343 n6988 n6989 0.625
r12344 n6935 n6990 0.5625
r12345 n6989 n6990 0.47916666666666669
r12346 n6936 n6991 0.5625
r12347 n6990 n6991 0.083333333333333329
r12348 n6937 n6992 0.125
r12349 n6991 n6992 0.22916666666666666
r12350 n6938 n6993 0.09375
r12351 n6992 n6993 0.4375
r12352 n6994 n6995 0.35416666666666669
r12353 n6995 n6996 0.20833333333333334
r12354 n6996 n6997 0.125
r12355 n6997 n6998 0.10416666666666667
r12356 n6998 n6999 0.20833333333333334
r12357 n6999 n7000 0.625
r12358 n7000 n7001 0.5
r12359 n7001 n7002 0.10416666666666667
r12360 n7002 n7003 0.125
r12361 n7003 n7004 0.14583333333333334
r12362 n7004 n7005 0.14583333333333334
r12363 n7005 n7006 0.27083333333333331
r12364 n6939 n7007 0.09375
r12365 n6940 n7008 0.125
r12366 n7007 n7008 0.4375
r12367 n6941 n7009 0.5625
r12368 n7008 n7009 0.22916666666666666
r12369 n6942 n7010 0.5625
r12370 n7009 n7010 0.083333333333333329
r12371 n6943 n7011 0.140625
r12372 n7010 n7011 0.20833333333333334
r12373 n6944 n7012 0.05113636363636364
r12374 n7011 n7012 0.625
r12375 n6945 n7013 1.125
r12376 n7012 n7013 0.47916666666666669
r12377 n6946 n7014 1.125
r12378 n7013 n7014 0.041666666666666664
r12379 n6947 n7015 1.125
r12380 n7014 n7015 0.041666666666666664
r12381 n6948 n7016 0.1125
r12382 n7015 n7016 0.22916666666666666
r12383 n6949 n7017 0.09375
r12384 n7016 n7017 0.45833333333333331
r12385 n7018 n7019 0.35416666666666669
r12386 n7019 n7020 0.20833333333333334
r12387 n7020 n7021 0.125
r12388 n7021 n7022 0.10416666666666667
r12389 n7022 n7023 0.27083333333333331
r12390 n7023 n7024 0.625
r12391 n7024 n7025 0.4375
r12392 n7025 n7026 0.10416666666666667
r12393 n7026 n7027 0.125
r12394 n7027 n7028 0.20833333333333334
r12395 n7028 n7029 0.35416666666666669
r12396 n6950 n7030 0.1125
r12397 n6951 n7031 0.048913043478260872
r12398 n7030 n7031 0.6875
r12399 n6952 n7032 0.5625
r12400 n7031 n7032 0.52083333333333337
r12401 n6953 n7033 0.037499999999999999
r12402 n7032 n7033 0.66666666666666663
r12403 n6954 n7034 0.5625
r12404 n7033 n7034 0.66666666666666663
r12405 n6955 n7035 0.048913043478260872
r12406 n7034 n7035 0.52083333333333337
r12407 n6956 n7036 0.1125
r12408 n7035 n7036 0.6875
r12409 n6957 n7037 0.4375
r12410 n6958 n7038 0.048611111111111112
r12411 n7037 n7038 0.15625
r12412 n6959 n7039 0.019021739130434784
r12413 n7038 n7039 0.5
r12414 n6960 n7040 0.21875
r12415 n7039 n7040 0.390625
r12416 n6961 n7041 0.014583333333333334
r12417 n7040 n7041 0.5
r12418 n6962 n7042 0.21875
r12419 n7041 n7042 0.5
r12420 n6963 n7043 0.019021739130434784
r12421 n7042 n7043 0.390625
r12422 n6964 n7044 0.048611111111111112
r12423 n7043 n7044 0.5
r12424 n6965 n7045 0.4375
r12425 n7044 n7045 0.15625
r12426 n6966 n7046 0.043749999999999997
r12427 n7045 n7046 0.171875
r12428 n6967 n7047 0.011513157894736841
r12429 n7046 n7047 0.75
r12430 n6968 n7048 0.011513157894736841
r12431 n7047 n7048 1.1875
r12432 n6969 n7049 0.011513157894736841
r12433 n7048 n7049 1.1875
r12434 n6970 n7050 0.011513157894736841
r12435 n7049 n7050 1.1875
r12436 n6971 n7051 0.012867647058823529
r12437 n7050 n7051 1.125
r12438 n6972 n7052 0.014112903225806451
r12439 n7051 n7052 1.015625
r12440 n6973 n7053 0.014112903225806451
r12441 n7052 n7053 0.96875
r12442 n6974 n7054 0.012867647058823529
r12443 n7053 n7054 1.015625
r12444 n6975 n7055 0.018229166666666668
r12445 n7054 n7055 0.90625
r12446 n6976 n7056 0.109375
r12447 n7055 n7056 0.4375
r12448 n6977 n7057 0.043749999999999997
r12449 n7056 n7057 0.21875
r12450 n6978 n7058 0.21875
r12451 n7057 n7058 0.1875
r12452 n6979 n7059 0.013671875
r12453 n7058 n7059 0.53125
r12454 n6980 n7060 0.21875
r12455 n7059 n7060 0.53125
r12456 n6981 n7061 0.012152777777777778
r12457 n7060 n7061 0.59375
r12458 n6982 n7062 0.21875
r12459 n7061 n7062 0.59375
r12460 n6983 n7063 0.033653846153846152
r12461 n7062 n7063 0.234375
r12462 n6984 n7064 0.036458333333333336
r12463 n7063 n7064 0.390625
r12464 n6985 n7065 0.0625
r12465 n7064 n7065 0.296875
r12466 n6986 n7066 0.21875
r12467 n7065 n7066 0.140625
r12468 n6987 n7067 0.109375
r12469 n7066 n7067 0.09375
r12470 n6988 n7068 0.048611111111111112
r12471 n7067 n7068 0.203125
r12472 n6989 n7069 0.020833333333333332
r12473 n7068 n7069 0.46875
r12474 n6990 n7070 0.21875
r12475 n7069 n7070 0.359375
r12476 n6991 n7071 0.21875
r12477 n7070 n7071 0.0625
r12478 n6992 n7072 0.048611111111111112
r12479 n7071 n7072 0.171875
r12480 n6993 n7073 0.036458333333333336
r12481 n7072 n7073 0.328125
r12482 n6994 n7074 0.043749999999999997
r12483 n6995 n7075 0.0625
r12484 n7074 n7075 0.265625
r12485 n6996 n7076 0.14583333333333334
r12486 n7075 n7076 0.15625
r12487 n6997 n7077 0.14583333333333334
r12488 n7076 n7077 0.09375
r12489 n6998 n7078 0.21875
r12490 n7077 n7078 0.078125
r12491 n6999 n7079 0.0546875
r12492 n7078 n7079 0.15625
r12493 n7000 n7080 0.019886363636363636
r12494 n7079 n7080 0.46875
r12495 n7001 n7081 0.21875
r12496 n7080 n7081 0.375
r12497 n7002 n7082 0.14583333333333334
r12498 n7081 n7082 0.078125
r12499 n7003 n7083 0.14583333333333334
r12500 n7082 n7083 0.09375
r12501 n7004 n7084 0.109375
r12502 n7083 n7084 0.109375
r12503 n7005 n7085 0.14583333333333334
r12504 n7084 n7085 0.109375
r12505 n7006 n7086 0.043749999999999997
r12506 n7085 n7086 0.203125
r12507 n7007 n7087 0.036458333333333336
r12508 n7008 n7088 0.048611111111111112
r12509 n7087 n7088 0.328125
r12510 n7009 n7089 0.21875
r12511 n7088 n7089 0.171875
r12512 n7010 n7090 0.21875
r12513 n7089 n7090 0.0625
r12514 n7011 n7091 0.0546875
r12515 n7090 n7091 0.15625
r12516 n7012 n7092 0.019886363636363636
r12517 n7091 n7092 0.46875
r12518 n7013 n7093 0.4375
r12519 n7092 n7093 0.359375
r12520 n7014 n7094 0.4375
r12521 n7093 n7094 0.03125
r12522 n7015 n7095 0.4375
r12523 n7094 n7095 0.03125
r12524 n7016 n7096 0.043749999999999997
r12525 n7095 n7096 0.171875
r12526 n7017 n7097 0.036458333333333336
r12527 n7096 n7097 0.34375
r12528 n7018 n7098 0.043749999999999997
r12529 n7019 n7099 0.0625
r12530 n7098 n7099 0.265625
r12531 n7020 n7100 0.14583333333333334
r12532 n7099 n7100 0.15625
r12533 n7021 n7101 0.14583333333333334
r12534 n7100 n7101 0.09375
r12535 n7022 n7102 0.21875
r12536 n7101 n7102 0.078125
r12537 n7023 n7103 0.039772727272727272
r12538 n7102 n7103 0.203125
r12539 n7024 n7104 0.023026315789473683
r12540 n7103 n7104 0.46875
r12541 n7025 n7105 0.21875
r12542 n7104 n7105 0.328125
r12543 n7026 n7106 0.14583333333333334
r12544 n7105 n7106 0.078125
r12545 n7027 n7107 0.14583333333333334
r12546 n7106 n7107 0.09375
r12547 n7028 n7108 0.0625
r12548 n7107 n7108 0.15625
r12549 n7029 n7109 0.043749999999999997
r12550 n7108 n7109 0.265625
r12551 n7030 n7110 0.043749999999999997
r12552 n7031 n7111 0.019021739130434784
r12553 n7110 n7111 0.515625
r12554 n7032 n7112 0.21875
r12555 n7111 n7112 0.390625
r12556 n7033 n7113 0.014583333333333334
r12557 n7112 n7113 0.5
r12558 n7034 n7114 0.21875
r12559 n7113 n7114 0.5
r12560 n7035 n7115 0.019021739130434784
r12561 n7114 n7115 0.390625
r12562 n7036 n7116 0.043749999999999997
r12563 n7115 n7116 0.515625
r12564 n7037 n7117 0.4375
r12565 n7038 n7118 0.048611111111111112
r12566 n7117 n7118 0.20833333333333334
r12567 n7039 n7119 0.019021739130434784
r12568 n7118 n7119 0.66666666666666663
r12569 n7040 n7120 0.21875
r12570 n7119 n7120 0.52083333333333337
r12571 n7041 n7121 0.014583333333333334
r12572 n7120 n7121 0.66666666666666663
r12573 n7042 n7122 0.21875
r12574 n7121 n7122 0.66666666666666663
r12575 n7043 n7123 0.019021739130434784
r12576 n7122 n7123 0.52083333333333337
r12577 n7044 n7124 0.048611111111111112
r12578 n7123 n7124 0.66666666666666663
r12579 n7045 n7125 0.4375
r12580 n7124 n7125 0.20833333333333334
r12581 n7046 n7126 0.043749999999999997
r12582 n7125 n7126 0.22916666666666666
r12583 n7047 n7127 0.011513157894736841
r12584 n7126 n7127 1
r12585 n7048 n7128 0.011513157894736841
r12586 n7127 n7128 1.5833333333333333
r12587 n7049 n7129 0.011513157894736841
r12588 n7128 n7129 1.5833333333333333
r12589 n7050 n7130 0.011513157894736841
r12590 n7129 n7130 1.5833333333333333
r12591 n7051 n7131 0.012867647058823529
r12592 n7130 n7131 1.5
r12593 n7052 n7132 0.014112903225806451
r12594 n7131 n7132 1.3541666666666667
r12595 n7053 n7133 0.014112903225806451
r12596 n7132 n7133 1.2916666666666667
r12597 n7054 n7134 0.012867647058823529
r12598 n7133 n7134 1.3541666666666667
r12599 n7055 n7135 0.018229166666666668
r12600 n7134 n7135 1.2083333333333333
r12601 n7056 n7136 0.109375
r12602 n7135 n7136 0.58333333333333337
r12603 n7057 n7137 0.043749999999999997
r12604 n7136 n7137 0.29166666666666669
r12605 n7058 n7138 0.21875
r12606 n7137 n7138 0.25
r12607 n7059 n7139 0.013671875
r12608 n7138 n7139 0.70833333333333337
r12609 n7060 n7140 0.21875
r12610 n7139 n7140 0.70833333333333337
r12611 n7061 n7141 0.012152777777777778
r12612 n7140 n7141 0.79166666666666663
r12613 n7062 n7142 0.21875
r12614 n7141 n7142 0.79166666666666663
r12615 n7063 n7143 0.033653846153846152
r12616 n7142 n7143 0.3125
r12617 n7064 n7144 0.036458333333333336
r12618 n7143 n7144 0.52083333333333337
r12619 n7065 n7145 0.0625
r12620 n7144 n7145 0.39583333333333331
r12621 n7066 n7146 0.21875
r12622 n7145 n7146 0.1875
r12623 n7067 n7147 0.109375
r12624 n7146 n7147 0.125
r12625 n7068 n7148 0.048611111111111112
r12626 n7147 n7148 0.27083333333333331
r12627 n7069 n7149 0.020833333333333332
r12628 n7148 n7149 0.625
r12629 n7070 n7150 0.21875
r12630 n7149 n7150 0.47916666666666669
r12631 n7071 n7151 0.21875
r12632 n7150 n7151 0.083333333333333329
r12633 n7072 n7152 0.048611111111111112
r12634 n7151 n7152 0.22916666666666666
r12635 n7073 n7153 0.036458333333333336
r12636 n7152 n7153 0.4375
r12637 n7074 n7154 0.043749999999999997
r12638 n7075 n7155 0.0625
r12639 n7154 n7155 0.35416666666666669
r12640 n7076 n7156 0.14583333333333334
r12641 n7155 n7156 0.20833333333333334
r12642 n7077 n7157 0.14583333333333334
r12643 n7156 n7157 0.125
r12644 n7078 n7158 0.21875
r12645 n7157 n7158 0.10416666666666667
r12646 n7079 n7159 0.0546875
r12647 n7158 n7159 0.20833333333333334
r12648 n7080 n7160 0.019886363636363636
r12649 n7159 n7160 0.625
r12650 n7081 n7161 0.21875
r12651 n7160 n7161 0.5
r12652 n7082 n7162 0.14583333333333334
r12653 n7161 n7162 0.10416666666666667
r12654 n7083 n7163 0.14583333333333334
r12655 n7162 n7163 0.125
r12656 n7084 n7164 0.109375
r12657 n7163 n7164 0.14583333333333334
r12658 n7085 n7165 0.14583333333333334
r12659 n7164 n7165 0.14583333333333334
r12660 n7086 n7166 0.043749999999999997
r12661 n7165 n7166 0.27083333333333331
r12662 n7087 n7167 0.036458333333333336
r12663 n7088 n7168 0.048611111111111112
r12664 n7167 n7168 0.4375
r12665 n7089 n7169 0.21875
r12666 n7168 n7169 0.22916666666666666
r12667 n7090 n7170 0.21875
r12668 n7169 n7170 0.083333333333333329
r12669 n7091 n7171 0.0546875
r12670 n7170 n7171 0.20833333333333334
r12671 n7092 n7172 0.019886363636363636
r12672 n7171 n7172 0.625
r12673 n7093 n7173 0.4375
r12674 n7172 n7173 0.47916666666666669
r12675 n7094 n7174 0.4375
r12676 n7173 n7174 0.041666666666666664
r12677 n7095 n7175 0.4375
r12678 n7174 n7175 0.041666666666666664
r12679 n7096 n7176 0.043749999999999997
r12680 n7175 n7176 0.22916666666666666
r12681 n7097 n7177 0.036458333333333336
r12682 n7176 n7177 0.45833333333333331
r12683 n7098 n7178 0.043749999999999997
r12684 n7099 n7179 0.0625
r12685 n7178 n7179 0.35416666666666669
r12686 n7100 n7180 0.14583333333333334
r12687 n7179 n7180 0.20833333333333334
r12688 n7101 n7181 0.14583333333333334
r12689 n7180 n7181 0.125
r12690 n7102 n7182 0.21875
r12691 n7181 n7182 0.10416666666666667
r12692 n7103 n7183 0.039772727272727272
r12693 n7182 n7183 0.27083333333333331
r12694 n7104 n7184 0.023026315789473683
r12695 n7183 n7184 0.625
r12696 n7105 n7185 0.21875
r12697 n7184 n7185 0.4375
r12698 n7106 n7186 0.14583333333333334
r12699 n7185 n7186 0.10416666666666667
r12700 n7107 n7187 0.14583333333333334
r12701 n7186 n7187 0.125
r12702 n7108 n7188 0.0625
r12703 n7187 n7188 0.20833333333333334
r12704 n7109 n7189 0.043749999999999997
r12705 n7188 n7189 0.35416666666666669
r12706 n7110 n7190 0.043749999999999997
r12707 n7111 n7191 0.019021739130434784
r12708 n7190 n7191 0.6875
r12709 n7112 n7192 0.21875
r12710 n7191 n7192 0.52083333333333337
r12711 n7113 n7193 0.014583333333333334
r12712 n7192 n7193 0.66666666666666663
r12713 n7114 n7194 0.21875
r12714 n7193 n7194 0.66666666666666663
r12715 n7115 n7195 0.019021739130434784
r12716 n7194 n7195 0.52083333333333337
r12717 n7116 n7196 0.043749999999999997
r12718 n7195 n7196 0.6875
r12719 n7117 n7197 0.3125
r12720 n7118 n7198 0.034722222222222224
r12721 n7197 n7198 0.3125
r12722 n7119 n7199 0.01358695652173913
r12723 n7198 n7199 1
r12724 n7120 n7200 0.15625
r12725 n7199 n7200 0.78125
r12726 n7121 n7201 0.010416666666666666
r12727 n7200 n7201 1
r12728 n7122 n7202 0.15625
r12729 n7201 n7202 1
r12730 n7123 n7203 0.01358695652173913
r12731 n7202 n7203 0.78125
r12732 n7124 n7204 0.034722222222222224
r12733 n7203 n7204 1
r12734 n7125 n7205 0.3125
r12735 n7204 n7205 0.3125
r12736 n7126 n7206 0.03125
r12737 n7205 n7206 0.34375
r12738 n7127 n7207 0.0082236842105263153
r12739 n7206 n7207 1.5
r12740 n7128 n7208 0.0082236842105263153
r12741 n7207 n7208 2.375
r12742 n7129 n7209 0.0082236842105263153
r12743 n7208 n7209 2.375
r12744 n7130 n7210 0.0082236842105263153
r12745 n7209 n7210 2.375
r12746 n7131 n7211 0.0091911764705882356
r12747 n7210 n7211 2.25
r12748 n7132 n7212 0.010080645161290322
r12749 n7211 n7212 2.03125
r12750 n7133 n7213 0.010080645161290322
r12751 n7212 n7213 1.9375
r12752 n7134 n7214 0.0091911764705882356
r12753 n7213 n7214 2.03125
r12754 n7135 n7215 0.013020833333333334
r12755 n7214 n7215 1.8125
r12756 n7136 n7216 0.078125
r12757 n7215 n7216 0.875
r12758 n7137 n7217 0.03125
r12759 n7216 n7217 0.4375
r12760 n7138 n7218 0.15625
r12761 n7217 n7218 0.375
r12762 n7139 n7219 0.009765625
r12763 n7218 n7219 1.0625
r12764 n7140 n7220 0.15625
r12765 n7219 n7220 1.0625
r12766 n7141 n7221 0.0086805555555555559
r12767 n7220 n7221 1.1875
r12768 n7142 n7222 0.15625
r12769 n7221 n7222 1.1875
r12770 n7143 n7223 0.02403846153846154
r12771 n7222 n7223 0.46875
r12772 n7144 n7224 0.026041666666666668
r12773 n7223 n7224 0.78125
r12774 n7145 n7225 0.044642857142857144
r12775 n7224 n7225 0.59375
r12776 n7146 n7226 0.15625
r12777 n7225 n7226 0.28125
r12778 n7147 n7227 0.078125
r12779 n7226 n7227 0.1875
r12780 n7148 n7228 0.034722222222222224
r12781 n7227 n7228 0.40625
r12782 n7149 n7229 0.01488095238095238
r12783 n7228 n7229 0.9375
r12784 n7150 n7230 0.15625
r12785 n7229 n7230 0.71875
r12786 n7151 n7231 0.15625
r12787 n7230 n7231 0.125
r12788 n7152 n7232 0.034722222222222224
r12789 n7231 n7232 0.34375
r12790 n7153 n7233 0.026041666666666668
r12791 n7232 n7233 0.65625
r12792 n7154 n7234 0.03125
r12793 n7155 n7235 0.044642857142857144
r12794 n7234 n7235 0.53125
r12795 n7156 n7236 0.10416666666666667
r12796 n7235 n7236 0.3125
r12797 n7157 n7237 0.10416666666666667
r12798 n7236 n7237 0.1875
r12799 n7158 n7238 0.15625
r12800 n7237 n7238 0.15625
r12801 n7159 n7239 0.0390625
r12802 n7238 n7239 0.3125
r12803 n7160 n7240 0.014204545454545454
r12804 n7239 n7240 0.9375
r12805 n7161 n7241 0.15625
r12806 n7240 n7241 0.75
r12807 n7162 n7242 0.10416666666666667
r12808 n7241 n7242 0.15625
r12809 n7163 n7243 0.10416666666666667
r12810 n7242 n7243 0.1875
r12811 n7164 n7244 0.078125
r12812 n7243 n7244 0.21875
r12813 n7165 n7245 0.10416666666666667
r12814 n7244 n7245 0.21875
r12815 n7166 n7246 0.03125
r12816 n7245 n7246 0.40625
r12817 n7167 n7247 0.026041666666666668
r12818 n7168 n7248 0.034722222222222224
r12819 n7247 n7248 0.65625
r12820 n7169 n7249 0.15625
r12821 n7248 n7249 0.34375
r12822 n7170 n7250 0.15625
r12823 n7249 n7250 0.125
r12824 n7171 n7251 0.0390625
r12825 n7250 n7251 0.3125
r12826 n7172 n7252 0.014204545454545454
r12827 n7251 n7252 0.9375
r12828 n7173 n7253 0.3125
r12829 n7252 n7253 0.71875
r12830 n7174 n7254 0.3125
r12831 n7253 n7254 0.0625
r12832 n7175 n7255 0.3125
r12833 n7254 n7255 0.0625
r12834 n7176 n7256 0.03125
r12835 n7255 n7256 0.34375
r12836 n7177 n7257 0.026041666666666668
r12837 n7256 n7257 0.6875
r12838 n7178 n7258 0.03125
r12839 n7179 n7259 0.044642857142857144
r12840 n7258 n7259 0.53125
r12841 n7180 n7260 0.10416666666666667
r12842 n7259 n7260 0.3125
r12843 n7181 n7261 0.10416666666666667
r12844 n7260 n7261 0.1875
r12845 n7182 n7262 0.15625
r12846 n7261 n7262 0.15625
r12847 n7183 n7263 0.028409090909090908
r12848 n7262 n7263 0.40625
r12849 n7184 n7264 0.016447368421052631
r12850 n7263 n7264 0.9375
r12851 n7185 n7265 0.15625
r12852 n7264 n7265 0.65625
r12853 n7186 n7266 0.10416666666666667
r12854 n7265 n7266 0.15625
r12855 n7187 n7267 0.10416666666666667
r12856 n7266 n7267 0.1875
r12857 n7188 n7268 0.044642857142857144
r12858 n7267 n7268 0.3125
r12859 n7189 n7269 0.03125
r12860 n7268 n7269 0.53125
r12861 n7190 n7270 0.03125
r12862 n7191 n7271 0.01358695652173913
r12863 n7270 n7271 1.03125
r12864 n7192 n7272 0.15625
r12865 n7271 n7272 0.78125
r12866 n7193 n7273 0.010416666666666666
r12867 n7272 n7273 1
r12868 n7194 n7274 0.15625
r12869 n7273 n7274 1
r12870 n7195 n7275 0.01358695652173913
r12871 n7274 n7275 0.78125
r12872 n7196 n7276 0.03125
r12873 n7275 n7276 1.03125
r12874 n7197 n7277 0.5
r12875 n7198 n7278 0.055555555555555552
r12876 n7277 n7278 0.10416666666666667
r12877 n7199 n7279 0.021739130434782608
r12878 n7278 n7279 0.33333333333333331
r12879 n7200 n7280 0.25
r12880 n7279 n7280 0.26041666666666669
r12881 n7201 n7281 0.016666666666666666
r12882 n7280 n7281 0.33333333333333331
r12883 n7202 n7282 0.25
r12884 n7281 n7282 0.33333333333333331
r12885 n7203 n7283 0.021739130434782608
r12886 n7282 n7283 0.26041666666666669
r12887 n7204 n7284 0.055555555555555552
r12888 n7283 n7284 0.33333333333333331
r12889 n7205 n7285 0.5
r12890 n7284 n7285 0.10416666666666667
r12891 n7206 n7286 0.050000000000000003
r12892 n7285 n7286 0.11458333333333333
r12893 n7207 n7287 0.013157894736842105
r12894 n7286 n7287 0.5
r12895 n7208 n7288 0.013157894736842105
r12896 n7287 n7288 0.79166666666666663
r12897 n7209 n7289 0.013157894736842105
r12898 n7288 n7289 0.79166666666666663
r12899 n7210 n7290 0.013157894736842105
r12900 n7289 n7290 0.79166666666666663
r12901 n7211 n7291 0.014705882352941176
r12902 n7290 n7291 0.75
r12903 n7212 n7292 0.016129032258064516
r12904 n7291 n7292 0.67708333333333337
r12905 n7213 n7293 0.016129032258064516
r12906 n7292 n7293 0.64583333333333337
r12907 n7214 n7294 0.014705882352941176
r12908 n7293 n7294 0.67708333333333337
r12909 n7215 n7295 0.020833333333333332
r12910 n7294 n7295 0.60416666666666663
r12911 n7216 n7296 0.125
r12912 n7295 n7296 0.29166666666666669
r12913 n7217 n7297 0.050000000000000003
r12914 n7296 n7297 0.14583333333333334
r12915 n7218 n7298 0.25
r12916 n7297 n7298 0.125
r12917 n7219 n7299 0.015625
r12918 n7298 n7299 0.35416666666666669
r12919 n7220 n7300 0.25
r12920 n7299 n7300 0.35416666666666669
r12921 n7221 n7301 0.013888888888888888
r12922 n7300 n7301 0.39583333333333331
r12923 n7222 n7302 0.25
r12924 n7301 n7302 0.39583333333333331
r12925 n7223 n7303 0.038461538461538464
r12926 n7302 n7303 0.15625
r12927 n7224 n7304 0.041666666666666664
r12928 n7303 n7304 0.26041666666666669
r12929 n7225 n7305 0.071428571428571425
r12930 n7304 n7305 0.19791666666666666
r12931 n7226 n7306 0.25
r12932 n7305 n7306 0.09375
r12933 n7227 n7307 0.125
r12934 n7306 n7307 0.0625
r12935 n7228 n7308 0.055555555555555552
r12936 n7307 n7308 0.13541666666666666
r12937 n7229 n7309 0.023809523809523808
r12938 n7308 n7309 0.3125
r12939 n7230 n7310 0.25
r12940 n7309 n7310 0.23958333333333334
r12941 n7231 n7311 0.25
r12942 n7310 n7311 0.041666666666666664
r12943 n7232 n7312 0.055555555555555552
r12944 n7311 n7312 0.11458333333333333
r12945 n7233 n7313 0.041666666666666664
r12946 n7312 n7313 0.21875
r12947 n7234 n7314 0.050000000000000003
r12948 n7235 n7315 0.071428571428571425
r12949 n7314 n7315 0.17708333333333334
r12950 n7236 n7316 0.16666666666666666
r12951 n7315 n7316 0.10416666666666667
r12952 n7237 n7317 0.16666666666666666
r12953 n7316 n7317 0.0625
r12954 n7238 n7318 0.25
r12955 n7317 n7318 0.052083333333333336
r12956 n7239 n7319 0.0625
r12957 n7318 n7319 0.10416666666666667
r12958 n7240 n7320 0.022727272727272728
r12959 n7319 n7320 0.3125
r12960 n7241 n7321 0.25
r12961 n7320 n7321 0.25
r12962 n7242 n7322 0.16666666666666666
r12963 n7321 n7322 0.052083333333333336
r12964 n7243 n7323 0.16666666666666666
r12965 n7322 n7323 0.0625
r12966 n7244 n7324 0.125
r12967 n7323 n7324 0.072916666666666671
r12968 n7245 n7325 0.16666666666666666
r12969 n7324 n7325 0.072916666666666671
r12970 n7246 n7326 0.050000000000000003
r12971 n7325 n7326 0.13541666666666666
r12972 n7247 n7327 0.041666666666666664
r12973 n7248 n7328 0.055555555555555552
r12974 n7327 n7328 0.21875
r12975 n7249 n7329 0.25
r12976 n7328 n7329 0.11458333333333333
r12977 n7250 n7330 0.25
r12978 n7329 n7330 0.041666666666666664
r12979 n7251 n7331 0.0625
r12980 n7330 n7331 0.10416666666666667
r12981 n7252 n7332 0.022727272727272728
r12982 n7331 n7332 0.3125
r12983 n7253 n7333 0.5
r12984 n7332 n7333 0.23958333333333334
r12985 n7254 n7334 0.5
r12986 n7333 n7334 0.020833333333333332
r12987 n7255 n7335 0.5
r12988 n7334 n7335 0.020833333333333332
r12989 n7256 n7336 0.050000000000000003
r12990 n7335 n7336 0.11458333333333333
r12991 n7257 n7337 0.041666666666666664
r12992 n7336 n7337 0.22916666666666666
r12993 n7258 n7338 0.050000000000000003
r12994 n7259 n7339 0.071428571428571425
r12995 n7338 n7339 0.17708333333333334
r12996 n7260 n7340 0.16666666666666666
r12997 n7339 n7340 0.10416666666666667
r12998 n7261 n7341 0.16666666666666666
r12999 n7340 n7341 0.0625
r13000 n7262 n7342 0.25
r13001 n7341 n7342 0.052083333333333336
r13002 n7263 n7343 0.045454545454545456
r13003 n7342 n7343 0.13541666666666666
r13004 n7264 n7344 0.026315789473684209
r13005 n7343 n7344 0.3125
r13006 n7265 n7345 0.25
r13007 n7344 n7345 0.21875
r13008 n7266 n7346 0.16666666666666666
r13009 n7345 n7346 0.052083333333333336
r13010 n7267 n7347 0.16666666666666666
r13011 n7346 n7347 0.0625
r13012 n7268 n7348 0.071428571428571425
r13013 n7347 n7348 0.10416666666666667
r13014 n7269 n7349 0.050000000000000003
r13015 n7348 n7349 0.17708333333333334
r13016 n7270 n7350 0.050000000000000003
r13017 n7271 n7351 0.021739130434782608
r13018 n7350 n7351 0.34375
r13019 n7272 n7352 0.25
r13020 n7351 n7352 0.26041666666666669
r13021 n7273 n7353 0.016666666666666666
r13022 n7352 n7353 0.33333333333333331
r13023 n7274 n7354 0.25
r13024 n7353 n7354 0.33333333333333331
r13025 n7275 n7355 0.021739130434782608
r13026 n7354 n7355 0.26041666666666669
r13027 n7276 n7356 0.050000000000000003
r13028 n7355 n7356 0.34375
r13029 n7277 n7357 0.5
r13030 n7278 n7358 0.055555555555555552
r13031 n7357 n7358 0.3125
r13032 n7279 n7359 0.021739130434782608
r13033 n7358 n7359 1
r13034 n7280 n7360 0.25
r13035 n7359 n7360 0.78125
r13036 n7281 n7361 0.016666666666666666
r13037 n7360 n7361 1
r13038 n7282 n7362 0.25
r13039 n7361 n7362 1
r13040 n7283 n7363 0.021739130434782608
r13041 n7362 n7363 0.78125
r13042 n7284 n7364 0.055555555555555552
r13043 n7363 n7364 1
r13044 n7285 n7365 0.5
r13045 n7364 n7365 0.3125
r13046 n7286 n7366 0.050000000000000003
r13047 n7365 n7366 0.34375
r13048 n7287 n7367 0.013157894736842105
r13049 n7366 n7367 1.5
r13050 n7288 n7368 0.013157894736842105
r13051 n7367 n7368 2.375
r13052 n7289 n7369 0.013157894736842105
r13053 n7368 n7369 2.375
r13054 n7290 n7370 0.013157894736842105
r13055 n7369 n7370 2.375
r13056 n7291 n7371 0.014705882352941176
r13057 n7370 n7371 2.25
r13058 n7292 n7372 0.016129032258064516
r13059 n7371 n7372 2.03125
r13060 n7293 n7373 0.016129032258064516
r13061 n7372 n7373 1.9375
r13062 n7294 n7374 0.014705882352941176
r13063 n7373 n7374 2.03125
r13064 n7295 n7375 0.020833333333333332
r13065 n7374 n7375 1.8125
r13066 n7296 n7376 0.125
r13067 n7375 n7376 0.875
r13068 n7297 n7377 0.050000000000000003
r13069 n7376 n7377 0.4375
r13070 n7298 n7378 0.25
r13071 n7377 n7378 0.375
r13072 n7299 n7379 0.015625
r13073 n7378 n7379 1.0625
r13074 n7300 n7380 0.25
r13075 n7379 n7380 1.0625
r13076 n7301 n7381 0.013888888888888888
r13077 n7380 n7381 1.1875
r13078 n7302 n7382 0.25
r13079 n7381 n7382 1.1875
r13080 n7303 n7383 0.038461538461538464
r13081 n7382 n7383 0.46875
r13082 n7304 n7384 0.041666666666666664
r13083 n7383 n7384 0.78125
r13084 n7305 n7385 0.071428571428571425
r13085 n7384 n7385 0.59375
r13086 n7306 n7386 0.25
r13087 n7385 n7386 0.28125
r13088 n7307 n7387 0.125
r13089 n7386 n7387 0.1875
r13090 n7308 n7388 0.055555555555555552
r13091 n7387 n7388 0.40625
r13092 n7309 n7389 0.023809523809523808
r13093 n7388 n7389 0.9375
r13094 n7310 n7390 0.25
r13095 n7389 n7390 0.71875
r13096 n7311 n7391 0.25
r13097 n7390 n7391 0.125
r13098 n7312 n7392 0.055555555555555552
r13099 n7391 n7392 0.34375
r13100 n7313 n7393 0.041666666666666664
r13101 n7392 n7393 0.65625
r13102 n7314 n7394 0.050000000000000003
r13103 n7315 n7395 0.071428571428571425
r13104 n7394 n7395 0.53125
r13105 n7316 n7396 0.16666666666666666
r13106 n7395 n7396 0.3125
r13107 n7317 n7397 0.16666666666666666
r13108 n7396 n7397 0.1875
r13109 n7318 n7398 0.25
r13110 n7397 n7398 0.15625
r13111 n7319 n7399 0.0625
r13112 n7398 n7399 0.3125
r13113 n7320 n7400 0.022727272727272728
r13114 n7399 n7400 0.9375
r13115 n7321 n7401 0.25
r13116 n7400 n7401 0.75
r13117 n7322 n7402 0.16666666666666666
r13118 n7401 n7402 0.15625
r13119 n7323 n7403 0.16666666666666666
r13120 n7402 n7403 0.1875
r13121 n7324 n7404 0.125
r13122 n7403 n7404 0.21875
r13123 n7325 n7405 0.16666666666666666
r13124 n7404 n7405 0.21875
r13125 n7326 n7406 0.050000000000000003
r13126 n7405 n7406 0.40625
r13127 n7327 n7407 0.041666666666666664
r13128 n7328 n7408 0.055555555555555552
r13129 n7407 n7408 0.65625
r13130 n7329 n7409 0.25
r13131 n7408 n7409 0.34375
r13132 n7330 n7410 0.25
r13133 n7409 n7410 0.125
r13134 n7331 n7411 0.0625
r13135 n7410 n7411 0.3125
r13136 n7332 n7412 0.022727272727272728
r13137 n7411 n7412 0.9375
r13138 n7333 n7413 0.5
r13139 n7412 n7413 0.71875
r13140 n7334 n7414 0.5
r13141 n7413 n7414 0.0625
r13142 n7335 n7415 0.5
r13143 n7414 n7415 0.0625
r13144 n7336 n7416 0.050000000000000003
r13145 n7415 n7416 0.34375
r13146 n7337 n7417 0.041666666666666664
r13147 n7416 n7417 0.6875
r13148 n7338 n7418 0.050000000000000003
r13149 n7339 n7419 0.071428571428571425
r13150 n7418 n7419 0.53125
r13151 n7340 n7420 0.16666666666666666
r13152 n7419 n7420 0.3125
r13153 n7341 n7421 0.16666666666666666
r13154 n7420 n7421 0.1875
r13155 n7342 n7422 0.25
r13156 n7421 n7422 0.15625
r13157 n7343 n7423 0.045454545454545456
r13158 n7422 n7423 0.40625
r13159 n7344 n7424 0.026315789473684209
r13160 n7423 n7424 0.9375
r13161 n7345 n7425 0.25
r13162 n7424 n7425 0.65625
r13163 n7346 n7426 0.16666666666666666
r13164 n7425 n7426 0.15625
r13165 n7347 n7427 0.16666666666666666
r13166 n7426 n7427 0.1875
r13167 n7348 n7428 0.071428571428571425
r13168 n7427 n7428 0.3125
r13169 n7349 n7429 0.050000000000000003
r13170 n7428 n7429 0.53125
r13171 n7350 n7430 0.050000000000000003
r13172 n7351 n7431 0.021739130434782608
r13173 n7430 n7431 1.03125
r13174 n7352 n7432 0.25
r13175 n7431 n7432 0.78125
r13176 n7353 n7433 0.016666666666666666
r13177 n7432 n7433 1
r13178 n7354 n7434 0.25
r13179 n7433 n7434 1
r13180 n7355 n7435 0.021739130434782608
r13181 n7434 n7435 0.78125
r13182 n7356 n7436 0.050000000000000003
r13183 n7435 n7436 1.03125
r13184 n7357 n7437 0.3125
r13185 n7358 n7438 0.034722222222222224
r13186 n7437 n7438 0.20833333333333334
r13187 n7359 n7439 0.01358695652173913
r13188 n7438 n7439 0.66666666666666663
r13189 n7360 n7440 0.15625
r13190 n7439 n7440 0.52083333333333337
r13191 n7361 n7441 0.010416666666666666
r13192 n7440 n7441 0.66666666666666663
r13193 n7362 n7442 0.15625
r13194 n7441 n7442 0.66666666666666663
r13195 n7363 n7443 0.01358695652173913
r13196 n7442 n7443 0.52083333333333337
r13197 n7364 n7444 0.034722222222222224
r13198 n7443 n7444 0.66666666666666663
r13199 n7365 n7445 0.3125
r13200 n7444 n7445 0.20833333333333334
r13201 n7366 n7446 0.03125
r13202 n7445 n7446 0.22916666666666666
r13203 n7367 n7447 0.0082236842105263153
r13204 n7446 n7447 1
r13205 n7368 n7448 0.0082236842105263153
r13206 n7447 n7448 1.5833333333333333
r13207 n7369 n7449 0.0082236842105263153
r13208 n7448 n7449 1.5833333333333333
r13209 n7370 n7450 0.0082236842105263153
r13210 n7449 n7450 1.5833333333333333
r13211 n7371 n7451 0.0091911764705882356
r13212 n7450 n7451 1.5
r13213 n7372 n7452 0.010080645161290322
r13214 n7451 n7452 1.3541666666666667
r13215 n7373 n7453 0.010080645161290322
r13216 n7452 n7453 1.2916666666666667
r13217 n7374 n7454 0.0091911764705882356
r13218 n7453 n7454 1.3541666666666667
r13219 n7375 n7455 0.013020833333333334
r13220 n7454 n7455 1.2083333333333333
r13221 n7376 n7456 0.078125
r13222 n7455 n7456 0.58333333333333337
r13223 n7377 n7457 0.03125
r13224 n7456 n7457 0.29166666666666669
r13225 n7378 n7458 0.15625
r13226 n7457 n7458 0.25
r13227 n7379 n7459 0.009765625
r13228 n7458 n7459 0.70833333333333337
r13229 n7380 n7460 0.15625
r13230 n7459 n7460 0.70833333333333337
r13231 n7381 n7461 0.0086805555555555559
r13232 n7460 n7461 0.79166666666666663
r13233 n7382 n7462 0.15625
r13234 n7461 n7462 0.79166666666666663
r13235 n7383 n7463 0.02403846153846154
r13236 n7462 n7463 0.3125
r13237 n7384 n7464 0.026041666666666668
r13238 n7463 n7464 0.52083333333333337
r13239 n7385 n7465 0.044642857142857144
r13240 n7464 n7465 0.39583333333333331
r13241 n7386 n7466 0.15625
r13242 n7465 n7466 0.1875
r13243 n7387 n7467 0.078125
r13244 n7466 n7467 0.125
r13245 n7388 n7468 0.034722222222222224
r13246 n7467 n7468 0.27083333333333331
r13247 n7389 n7469 0.01488095238095238
r13248 n7468 n7469 0.625
r13249 n7390 n7470 0.15625
r13250 n7469 n7470 0.47916666666666669
r13251 n7391 n7471 0.15625
r13252 n7470 n7471 0.083333333333333329
r13253 n7392 n7472 0.034722222222222224
r13254 n7471 n7472 0.22916666666666666
r13255 n7393 n7473 0.026041666666666668
r13256 n7472 n7473 0.4375
r13257 n7394 n7474 0.03125
r13258 n7395 n7475 0.044642857142857144
r13259 n7474 n7475 0.35416666666666669
r13260 n7396 n7476 0.10416666666666667
r13261 n7475 n7476 0.20833333333333334
r13262 n7397 n7477 0.10416666666666667
r13263 n7476 n7477 0.125
r13264 n7398 n7478 0.15625
r13265 n7477 n7478 0.10416666666666667
r13266 n7399 n7479 0.0390625
r13267 n7478 n7479 0.20833333333333334
r13268 n7400 n7480 0.014204545454545454
r13269 n7479 n7480 0.625
r13270 n7401 n7481 0.15625
r13271 n7480 n7481 0.5
r13272 n7402 n7482 0.10416666666666667
r13273 n7481 n7482 0.10416666666666667
r13274 n7403 n7483 0.10416666666666667
r13275 n7482 n7483 0.125
r13276 n7404 n7484 0.078125
r13277 n7483 n7484 0.14583333333333334
r13278 n7405 n7485 0.10416666666666667
r13279 n7484 n7485 0.14583333333333334
r13280 n7406 n7486 0.03125
r13281 n7485 n7486 0.27083333333333331
r13282 n7407 n7487 0.026041666666666668
r13283 n7408 n7488 0.034722222222222224
r13284 n7487 n7488 0.4375
r13285 n7409 n7489 0.15625
r13286 n7488 n7489 0.22916666666666666
r13287 n7410 n7490 0.15625
r13288 n7489 n7490 0.083333333333333329
r13289 n7411 n7491 0.0390625
r13290 n7490 n7491 0.20833333333333334
r13291 n7412 n7492 0.014204545454545454
r13292 n7491 n7492 0.625
r13293 n7413 n7493 0.3125
r13294 n7492 n7493 0.47916666666666669
r13295 n7414 n7494 0.3125
r13296 n7493 n7494 0.041666666666666664
r13297 n7415 n7495 0.3125
r13298 n7494 n7495 0.041666666666666664
r13299 n7416 n7496 0.03125
r13300 n7495 n7496 0.22916666666666666
r13301 n7417 n7497 0.026041666666666668
r13302 n7496 n7497 0.45833333333333331
r13303 n7418 n7498 0.03125
r13304 n7419 n7499 0.044642857142857144
r13305 n7498 n7499 0.35416666666666669
r13306 n7420 n7500 0.10416666666666667
r13307 n7499 n7500 0.20833333333333334
r13308 n7421 n7501 0.10416666666666667
r13309 n7500 n7501 0.125
r13310 n7422 n7502 0.15625
r13311 n7501 n7502 0.10416666666666667
r13312 n7423 n7503 0.028409090909090908
r13313 n7502 n7503 0.27083333333333331
r13314 n7424 n7504 0.016447368421052631
r13315 n7503 n7504 0.625
r13316 n7425 n7505 0.15625
r13317 n7504 n7505 0.4375
r13318 n7426 n7506 0.10416666666666667
r13319 n7505 n7506 0.10416666666666667
r13320 n7427 n7507 0.10416666666666667
r13321 n7506 n7507 0.125
r13322 n7428 n7508 0.044642857142857144
r13323 n7507 n7508 0.20833333333333334
r13324 n7429 n7509 0.03125
r13325 n7508 n7509 0.35416666666666669
r13326 n7430 n7510 0.03125
r13327 n7431 n7511 0.01358695652173913
r13328 n7510 n7511 0.6875
r13329 n7432 n7512 0.15625
r13330 n7511 n7512 0.52083333333333337
r13331 n7433 n7513 0.010416666666666666
r13332 n7512 n7513 0.66666666666666663
r13333 n7434 n7514 0.15625
r13334 n7513 n7514 0.66666666666666663
r13335 n7435 n7515 0.01358695652173913
r13336 n7514 n7515 0.52083333333333337
r13337 n7436 n7516 0.03125
r13338 n7515 n7516 0.6875
r13339 n7437 n7517 0.3125
r13340 n7438 n7518 0.034722222222222224
r13341 n7517 n7518 0.3125
r13342 n7439 n7519 0.01358695652173913
r13343 n7518 n7519 1
r13344 n7440 n7520 0.15625
r13345 n7519 n7520 0.78125
r13346 n7441 n7521 0.010416666666666666
r13347 n7520 n7521 1
r13348 n7442 n7522 0.15625
r13349 n7521 n7522 1
r13350 n7443 n7523 0.01358695652173913
r13351 n7522 n7523 0.78125
r13352 n7444 n7524 0.034722222222222224
r13353 n7523 n7524 1
r13354 n7445 n7525 0.3125
r13355 n7524 n7525 0.3125
r13356 n7464 n7526 0.026041666666666668
r13357 n7465 n7527 0.044642857142857144
r13358 n7526 n7527 0.59375
r13359 n7466 n7528 0.15625
r13360 n7527 n7528 0.28125
r13361 n7467 n7529 0.078125
r13362 n7528 n7529 0.1875
r13363 n7468 n7530 0.034722222222222224
r13364 n7529 n7530 0.40625
r13365 n7469 n7531 0.01488095238095238
r13366 n7530 n7531 0.9375
r13367 n7470 n7532 0.15625
r13368 n7531 n7532 0.71875
r13369 n7471 n7533 0.15625
r13370 n7532 n7533 0.125
r13371 n7472 n7534 0.034722222222222224
r13372 n7533 n7534 0.34375
r13373 n7473 n7535 0.026041666666666668
r13374 n7534 n7535 0.65625
r13375 n7474 n7536 0.03125
r13376 n7475 n7537 0.044642857142857144
r13377 n7536 n7537 0.53125
r13378 n7476 n7538 0.10416666666666667
r13379 n7537 n7538 0.3125
r13380 n7477 n7539 0.10416666666666667
r13381 n7538 n7539 0.1875
r13382 n7478 n7540 0.15625
r13383 n7539 n7540 0.15625
r13384 n7479 n7541 0.0390625
r13385 n7540 n7541 0.3125
r13386 n7480 n7542 0.014204545454545454
r13387 n7541 n7542 0.9375
r13388 n7481 n7543 0.15625
r13389 n7542 n7543 0.75
r13390 n7482 n7544 0.10416666666666667
r13391 n7543 n7544 0.15625
r13392 n7483 n7545 0.10416666666666667
r13393 n7544 n7545 0.1875
r13394 n7484 n7546 0.078125
r13395 n7545 n7546 0.21875
r13396 n7485 n7547 0.10416666666666667
r13397 n7546 n7547 0.21875
r13398 n7486 n7548 0.03125
r13399 n7547 n7548 0.40625
r13400 n7487 n7549 0.026041666666666668
r13401 n7488 n7550 0.034722222222222224
r13402 n7549 n7550 0.65625
r13403 n7489 n7551 0.15625
r13404 n7550 n7551 0.34375
r13405 n7490 n7552 0.15625
r13406 n7551 n7552 0.125
r13407 n7491 n7553 0.0390625
r13408 n7552 n7553 0.3125
r13409 n7492 n7554 0.014204545454545454
r13410 n7553 n7554 0.9375
r13411 n7493 n7555 0.3125
r13412 n7554 n7555 0.71875
r13413 n7494 n7556 0.3125
r13414 n7555 n7556 0.0625
r13415 n7495 n7557 0.3125
r13416 n7556 n7557 0.0625
r13417 n7496 n7558 0.03125
r13418 n7557 n7558 0.34375
r13419 n7497 n7559 0.026041666666666668
r13420 n7558 n7559 0.6875
r13421 n7498 n7560 0.03125
r13422 n7499 n7561 0.044642857142857144
r13423 n7560 n7561 0.53125
r13424 n7500 n7562 0.10416666666666667
r13425 n7561 n7562 0.3125
r13426 n7501 n7563 0.10416666666666667
r13427 n7562 n7563 0.1875
r13428 n7502 n7564 0.15625
r13429 n7563 n7564 0.15625
r13430 n7503 n7565 0.028409090909090908
r13431 n7564 n7565 0.40625
r13432 n7504 n7566 0.016447368421052631
r13433 n7565 n7566 0.9375
r13434 n7505 n7567 0.15625
r13435 n7566 n7567 0.65625
r13436 n7506 n7568 0.10416666666666667
r13437 n7567 n7568 0.15625
r13438 n7507 n7569 0.10416666666666667
r13439 n7568 n7569 0.1875
r13440 n7508 n7570 0.044642857142857144
r13441 n7569 n7570 0.3125
r13442 n7509 n7571 0.03125
r13443 n7570 n7571 0.53125
r13444 n7510 n7572 0.03125
r13445 n7511 n7573 0.01358695652173913
r13446 n7572 n7573 1.03125
r13447 n7512 n7574 0.15625
r13448 n7573 n7574 0.78125
r13449 n7513 n7575 0.010416666666666666
r13450 n7574 n7575 1
r13451 n7514 n7576 0.15625
r13452 n7575 n7576 1
r13453 n7515 n7577 0.01358695652173913
r13454 n7576 n7577 0.78125
r13455 n7516 n7578 0.03125
r13456 n7577 n7578 1.03125
r13457 n7517 n7579 2
r13458 n7518 n7580 0.22222222222222221
r13459 n7579 n7580 0.020833333333333332
r13460 n7519 n7581 0.086956521739130432
r13461 n7580 n7581 0.066666666666666666
r13462 n7520 n7582 1
r13463 n7581 n7582 0.052083333333333336
r13464 n7521 n7583 0.066666666666666666
r13465 n7582 n7583 0.066666666666666666
r13466 n7522 n7584 1
r13467 n7583 n7584 0.066666666666666666
r13468 n7523 n7585 0.086956521739130432
r13469 n7584 n7585 0.052083333333333336
r13470 n7524 n7586 0.22222222222222221
r13471 n7585 n7586 0.066666666666666666
r13472 n7525 n7587 2
r13473 n7586 n7587 0.020833333333333332
r13474 n7536 n7588 0.20000000000000001
r13475 n7537 n7589 0.2857142857142857
r13476 n7588 n7589 0.035416666666666666
r13477 n7538 n7590 0.66666666666666663
r13478 n7589 n7590 0.020833333333333332
r13479 n7539 n7591 0.66666666666666663
r13480 n7590 n7591 0.012500000000000001
r13481 n7540 n7592 1
r13482 n7591 n7592 0.010416666666666666
r13483 n7541 n7593 0.25
r13484 n7592 n7593 0.020833333333333332
r13485 n7542 n7594 0.090909090909090912
r13486 n7593 n7594 0.0625
r13487 n7543 n7595 1
r13488 n7594 n7595 0.050000000000000003
r13489 n7544 n7596 0.66666666666666663
r13490 n7595 n7596 0.010416666666666666
r13491 n7545 n7597 0.66666666666666663
r13492 n7596 n7597 0.012500000000000001
r13493 n7546 n7598 0.5
r13494 n7597 n7598 0.014583333333333334
r13495 n7547 n7599 0.66666666666666663
r13496 n7598 n7599 0.014583333333333334
r13497 n7548 n7600 0.20000000000000001
r13498 n7599 n7600 0.027083333333333334
r13499 n7560 n7601 0.20000000000000001
r13500 n7561 n7602 0.2857142857142857
r13501 n7601 n7602 0.035416666666666666
r13502 n7562 n7603 0.66666666666666663
r13503 n7602 n7603 0.020833333333333332
r13504 n7563 n7604 0.66666666666666663
r13505 n7603 n7604 0.012500000000000001
r13506 n7564 n7605 1
r13507 n7604 n7605 0.010416666666666666
r13508 n7565 n7606 0.18181818181818182
r13509 n7605 n7606 0.027083333333333334
r13510 n7566 n7607 0.10526315789473684
r13511 n7606 n7607 0.0625
r13512 n7567 n7608 1
r13513 n7607 n7608 0.043749999999999997
r13514 n7568 n7609 0.66666666666666663
r13515 n7608 n7609 0.010416666666666666
r13516 n7569 n7610 0.66666666666666663
r13517 n7609 n7610 0.012500000000000001
r13518 n7570 n7611 0.2857142857142857
r13519 n7610 n7611 0.020833333333333332
r13520 n7571 n7612 0.20000000000000001
r13521 n7611 n7612 0.035416666666666666
r13522 n7572 n7613 0.20000000000000001
r13523 n7573 n7614 0.086956521739130432
r13524 n7613 n7614 0.068750000000000006
r13525 n7574 n7615 1
r13526 n7614 n7615 0.052083333333333336
r13527 n7575 n7616 0.066666666666666666
r13528 n7615 n7616 0.066666666666666666
r13529 n7576 n7617 1
r13530 n7616 n7617 0.066666666666666666
r13531 n7577 n7618 0.086956521739130432
r13532 n7617 n7618 0.052083333333333336
r13533 n7578 n7619 0.20000000000000001
r13534 n7618 n7619 0.068750000000000006
r13535 n7579 n7620 2
r13536 n7580 n7621 0.22222222222222221
r13537 n7620 n7621 0.3125
r13538 n7581 n7622 0.086956521739130432
r13539 n7621 n7622 1
r13540 n7582 n7623 1
r13541 n7622 n7623 0.78125
r13542 n7583 n7624 0.066666666666666666
r13543 n7623 n7624 1
r13544 n7584 n7625 1
r13545 n7624 n7625 1
r13546 n7585 n7626 0.086956521739130432
r13547 n7625 n7626 0.78125
r13548 n7586 n7627 0.22222222222222221
r13549 n7626 n7627 1
r13550 n7587 n7628 2
r13551 n7627 n7628 0.3125
r13552 n7629 n7630 0.59375
r13553 n7630 n7631 0.28125
r13554 n7631 n7632 0.1875
r13555 n7632 n7633 0.40625
r13556 n7633 n7634 0.9375
r13557 n7634 n7635 0.71875
r13558 n7635 n7636 0.125
r13559 n7636 n7637 0.34375
r13560 n7637 n7638 0.65625
r13561 n7588 n7639 0.20000000000000001
r13562 n7589 n7640 0.2857142857142857
r13563 n7639 n7640 0.53125
r13564 n7590 n7641 0.66666666666666663
r13565 n7640 n7641 0.3125
r13566 n7591 n7642 0.66666666666666663
r13567 n7641 n7642 0.1875
r13568 n7592 n7643 1
r13569 n7642 n7643 0.15625
r13570 n7593 n7644 0.25
r13571 n7643 n7644 0.3125
r13572 n7594 n7645 0.090909090909090912
r13573 n7644 n7645 0.9375
r13574 n7595 n7646 1
r13575 n7645 n7646 0.75
r13576 n7596 n7647 0.66666666666666663
r13577 n7646 n7647 0.15625
r13578 n7597 n7648 0.66666666666666663
r13579 n7647 n7648 0.1875
r13580 n7598 n7649 0.5
r13581 n7648 n7649 0.21875
r13582 n7599 n7650 0.66666666666666663
r13583 n7649 n7650 0.21875
r13584 n7600 n7651 0.20000000000000001
r13585 n7650 n7651 0.40625
r13586 n7652 n7653 0.65625
r13587 n7653 n7654 0.34375
r13588 n7654 n7655 0.125
r13589 n7655 n7656 0.3125
r13590 n7656 n7657 0.9375
r13591 n7657 n7658 0.71875
r13592 n7658 n7659 0.0625
r13593 n7659 n7660 0.0625
r13594 n7660 n7661 0.34375
r13595 n7661 n7662 0.6875
r13596 n7601 n7663 0.20000000000000001
r13597 n7602 n7664 0.2857142857142857
r13598 n7663 n7664 0.53125
r13599 n7603 n7665 0.66666666666666663
r13600 n7664 n7665 0.3125
r13601 n7604 n7666 0.66666666666666663
r13602 n7665 n7666 0.1875
r13603 n7605 n7667 1
r13604 n7666 n7667 0.15625
r13605 n7606 n7668 0.18181818181818182
r13606 n7667 n7668 0.40625
r13607 n7607 n7669 0.10526315789473684
r13608 n7668 n7669 0.9375
r13609 n7608 n7670 1
r13610 n7669 n7670 0.65625
r13611 n7609 n7671 0.66666666666666663
r13612 n7670 n7671 0.15625
r13613 n7610 n7672 0.66666666666666663
r13614 n7671 n7672 0.1875
r13615 n7611 n7673 0.2857142857142857
r13616 n7672 n7673 0.3125
r13617 n7612 n7674 0.20000000000000001
r13618 n7673 n7674 0.53125
r13619 n7613 n7675 0.20000000000000001
r13620 n7614 n7676 0.086956521739130432
r13621 n7675 n7676 1.03125
r13622 n7615 n7677 1
r13623 n7676 n7677 0.78125
r13624 n7616 n7678 0.066666666666666666
r13625 n7677 n7678 1
r13626 n7617 n7679 1
r13627 n7678 n7679 1
r13628 n7618 n7680 0.086956521739130432
r13629 n7679 n7680 0.78125
r13630 n7619 n7681 0.20000000000000001
r13631 n7680 n7681 1.03125
r13632 n7620 n7682 0.3125
r13633 n7621 n7683 0.034722222222222224
r13634 n7682 n7683 0.20833333333333334
r13635 n7622 n7684 0.01358695652173913
r13636 n7683 n7684 0.66666666666666663
r13637 n7623 n7685 0.15625
r13638 n7684 n7685 0.52083333333333337
r13639 n7624 n7686 0.010416666666666666
r13640 n7685 n7686 0.66666666666666663
r13641 n7625 n7687 0.15625
r13642 n7686 n7687 0.66666666666666663
r13643 n7626 n7688 0.01358695652173913
r13644 n7687 n7688 0.52083333333333337
r13645 n7627 n7689 0.034722222222222224
r13646 n7688 n7689 0.66666666666666663
r13647 n7628 n7690 0.3125
r13648 n7689 n7690 0.20833333333333334
r13649 n7629 n7691 0.026041666666666668
r13650 n7630 n7692 0.044642857142857144
r13651 n7691 n7692 0.39583333333333331
r13652 n7631 n7693 0.15625
r13653 n7692 n7693 0.1875
r13654 n7632 n7694 0.078125
r13655 n7693 n7694 0.125
r13656 n7633 n7695 0.034722222222222224
r13657 n7694 n7695 0.27083333333333331
r13658 n7634 n7696 0.01488095238095238
r13659 n7695 n7696 0.625
r13660 n7635 n7697 0.15625
r13661 n7696 n7697 0.47916666666666669
r13662 n7636 n7698 0.15625
r13663 n7697 n7698 0.083333333333333329
r13664 n7637 n7699 0.034722222222222224
r13665 n7698 n7699 0.22916666666666666
r13666 n7638 n7700 0.026041666666666668
r13667 n7699 n7700 0.4375
r13668 n7639 n7701 0.03125
r13669 n7640 n7702 0.044642857142857144
r13670 n7701 n7702 0.35416666666666669
r13671 n7641 n7703 0.10416666666666667
r13672 n7702 n7703 0.20833333333333334
r13673 n7642 n7704 0.10416666666666667
r13674 n7703 n7704 0.125
r13675 n7643 n7705 0.15625
r13676 n7704 n7705 0.10416666666666667
r13677 n7644 n7706 0.0390625
r13678 n7705 n7706 0.20833333333333334
r13679 n7645 n7707 0.014204545454545454
r13680 n7706 n7707 0.625
r13681 n7646 n7708 0.15625
r13682 n7707 n7708 0.5
r13683 n7647 n7709 0.10416666666666667
r13684 n7708 n7709 0.10416666666666667
r13685 n7648 n7710 0.10416666666666667
r13686 n7709 n7710 0.125
r13687 n7649 n7711 0.078125
r13688 n7710 n7711 0.14583333333333334
r13689 n7650 n7712 0.10416666666666667
r13690 n7711 n7712 0.14583333333333334
r13691 n7651 n7713 0.03125
r13692 n7712 n7713 0.27083333333333331
r13693 n7652 n7714 0.026041666666666668
r13694 n7653 n7715 0.034722222222222224
r13695 n7714 n7715 0.4375
r13696 n7654 n7716 0.15625
r13697 n7715 n7716 0.22916666666666666
r13698 n7655 n7717 0.15625
r13699 n7716 n7717 0.083333333333333329
r13700 n7656 n7718 0.0390625
r13701 n7717 n7718 0.20833333333333334
r13702 n7657 n7719 0.014204545454545454
r13703 n7718 n7719 0.625
r13704 n7658 n7720 0.3125
r13705 n7719 n7720 0.47916666666666669
r13706 n7659 n7721 0.3125
r13707 n7720 n7721 0.041666666666666664
r13708 n7660 n7722 0.3125
r13709 n7721 n7722 0.041666666666666664
r13710 n7661 n7723 0.03125
r13711 n7722 n7723 0.22916666666666666
r13712 n7662 n7724 0.026041666666666668
r13713 n7723 n7724 0.45833333333333331
r13714 n7663 n7725 0.03125
r13715 n7664 n7726 0.044642857142857144
r13716 n7725 n7726 0.35416666666666669
r13717 n7665 n7727 0.10416666666666667
r13718 n7726 n7727 0.20833333333333334
r13719 n7666 n7728 0.10416666666666667
r13720 n7727 n7728 0.125
r13721 n7667 n7729 0.15625
r13722 n7728 n7729 0.10416666666666667
r13723 n7668 n7730 0.028409090909090908
r13724 n7729 n7730 0.27083333333333331
r13725 n7669 n7731 0.016447368421052631
r13726 n7730 n7731 0.625
r13727 n7670 n7732 0.15625
r13728 n7731 n7732 0.4375
r13729 n7671 n7733 0.10416666666666667
r13730 n7732 n7733 0.10416666666666667
r13731 n7672 n7734 0.10416666666666667
r13732 n7733 n7734 0.125
r13733 n7673 n7735 0.044642857142857144
r13734 n7734 n7735 0.20833333333333334
r13735 n7674 n7736 0.03125
r13736 n7735 n7736 0.35416666666666669
r13737 n7675 n7737 0.03125
r13738 n7676 n7738 0.01358695652173913
r13739 n7737 n7738 0.6875
r13740 n7677 n7739 0.15625
r13741 n7738 n7739 0.52083333333333337
r13742 n7678 n7740 0.010416666666666666
r13743 n7739 n7740 0.66666666666666663
r13744 n7679 n7741 0.15625
r13745 n7740 n7741 0.66666666666666663
r13746 n7680 n7742 0.01358695652173913
r13747 n7741 n7742 0.52083333333333337
r13748 n7681 n7743 0.03125
r13749 n7742 n7743 0.6875
r13750 n7682 n7744 0.3125
r13751 n7683 n7745 0.034722222222222224
r13752 n7744 n7745 0.3125
r13753 n7684 n7746 0.01358695652173913
r13754 n7745 n7746 1
r13755 n7685 n7747 0.15625
r13756 n7746 n7747 0.78125
r13757 n7686 n7748 0.010416666666666666
r13758 n7747 n7748 1
r13759 n7687 n7749 0.15625
r13760 n7748 n7749 1
r13761 n7688 n7750 0.01358695652173913
r13762 n7749 n7750 0.78125
r13763 n7689 n7751 0.034722222222222224
r13764 n7750 n7751 1
r13765 n7690 n7752 0.3125
r13766 n7751 n7752 0.3125
r13767 n7691 n7753 0.026041666666666668
r13768 n7692 n7754 0.044642857142857144
r13769 n7753 n7754 0.59375
r13770 n7693 n7755 0.15625
r13771 n7754 n7755 0.28125
r13772 n7694 n7756 0.078125
r13773 n7755 n7756 0.1875
r13774 n7695 n7757 0.034722222222222224
r13775 n7756 n7757 0.40625
r13776 n7696 n7758 0.01488095238095238
r13777 n7757 n7758 0.9375
r13778 n7697 n7759 0.15625
r13779 n7758 n7759 0.71875
r13780 n7698 n7760 0.15625
r13781 n7759 n7760 0.125
r13782 n7699 n7761 0.034722222222222224
r13783 n7760 n7761 0.34375
r13784 n7700 n7762 0.026041666666666668
r13785 n7761 n7762 0.65625
r13786 n7701 n7763 0.03125
r13787 n7702 n7764 0.044642857142857144
r13788 n7763 n7764 0.53125
r13789 n7703 n7765 0.10416666666666667
r13790 n7764 n7765 0.3125
r13791 n7704 n7766 0.10416666666666667
r13792 n7765 n7766 0.1875
r13793 n7705 n7767 0.15625
r13794 n7766 n7767 0.15625
r13795 n7706 n7768 0.0390625
r13796 n7767 n7768 0.3125
r13797 n7707 n7769 0.014204545454545454
r13798 n7768 n7769 0.9375
r13799 n7708 n7770 0.15625
r13800 n7769 n7770 0.75
r13801 n7709 n7771 0.10416666666666667
r13802 n7770 n7771 0.15625
r13803 n7710 n7772 0.10416666666666667
r13804 n7771 n7772 0.1875
r13805 n7711 n7773 0.078125
r13806 n7772 n7773 0.21875
r13807 n7712 n7774 0.10416666666666667
r13808 n7773 n7774 0.21875
r13809 n7713 n7775 0.03125
r13810 n7774 n7775 0.40625
r13811 n7714 n7776 0.026041666666666668
r13812 n7715 n7777 0.034722222222222224
r13813 n7776 n7777 0.65625
r13814 n7716 n7778 0.15625
r13815 n7777 n7778 0.34375
r13816 n7717 n7779 0.15625
r13817 n7778 n7779 0.125
r13818 n7718 n7780 0.0390625
r13819 n7779 n7780 0.3125
r13820 n7719 n7781 0.014204545454545454
r13821 n7780 n7781 0.9375
r13822 n7720 n7782 0.3125
r13823 n7781 n7782 0.71875
r13824 n7721 n7783 0.3125
r13825 n7782 n7783 0.0625
r13826 n7722 n7784 0.3125
r13827 n7783 n7784 0.0625
r13828 n7723 n7785 0.03125
r13829 n7784 n7785 0.34375
r13830 n7724 n7786 0.026041666666666668
r13831 n7785 n7786 0.6875
r13832 n7725 n7787 0.03125
r13833 n7726 n7788 0.044642857142857144
r13834 n7787 n7788 0.53125
r13835 n7727 n7789 0.10416666666666667
r13836 n7788 n7789 0.3125
r13837 n7728 n7790 0.10416666666666667
r13838 n7789 n7790 0.1875
r13839 n7729 n7791 0.15625
r13840 n7790 n7791 0.15625
r13841 n7730 n7792 0.028409090909090908
r13842 n7791 n7792 0.40625
r13843 n7731 n7793 0.016447368421052631
r13844 n7792 n7793 0.9375
r13845 n7732 n7794 0.15625
r13846 n7793 n7794 0.65625
r13847 n7733 n7795 0.10416666666666667
r13848 n7794 n7795 0.15625
r13849 n7734 n7796 0.10416666666666667
r13850 n7795 n7796 0.1875
r13851 n7735 n7797 0.044642857142857144
r13852 n7796 n7797 0.3125
r13853 n7736 n7798 0.03125
r13854 n7797 n7798 0.53125
r13855 n7737 n7799 0.03125
r13856 n7738 n7800 0.01358695652173913
r13857 n7799 n7800 1.03125
r13858 n7739 n7801 0.15625
r13859 n7800 n7801 0.78125
r13860 n7740 n7802 0.010416666666666666
r13861 n7801 n7802 1
r13862 n7741 n7803 0.15625
r13863 n7802 n7803 1
r13864 n7742 n7804 0.01358695652173913
r13865 n7803 n7804 0.78125
r13866 n7743 n7805 0.03125
r13867 n7804 n7805 1.03125
r13868 n7744 n7806 0.5
r13869 n7745 n7807 0.055555555555555552
r13870 n7806 n7807 0.10416666666666667
r13871 n7746 n7808 0.021739130434782608
r13872 n7807 n7808 0.33333333333333331
r13873 n7747 n7809 0.25
r13874 n7808 n7809 0.26041666666666669
r13875 n7748 n7810 0.016666666666666666
r13876 n7809 n7810 0.33333333333333331
r13877 n7749 n7811 0.25
r13878 n7810 n7811 0.33333333333333331
r13879 n7750 n7812 0.021739130434782608
r13880 n7811 n7812 0.26041666666666669
r13881 n7751 n7813 0.055555555555555552
r13882 n7812 n7813 0.33333333333333331
r13883 n7752 n7814 0.5
r13884 n7813 n7814 0.10416666666666667
r13885 n7753 n7815 0.041666666666666664
r13886 n7754 n7816 0.071428571428571425
r13887 n7815 n7816 0.19791666666666666
r13888 n7755 n7817 0.25
r13889 n7816 n7817 0.09375
r13890 n7756 n7818 0.125
r13891 n7817 n7818 0.0625
r13892 n7757 n7819 0.055555555555555552
r13893 n7818 n7819 0.13541666666666666
r13894 n7758 n7820 0.023809523809523808
r13895 n7819 n7820 0.3125
r13896 n7759 n7821 0.25
r13897 n7820 n7821 0.23958333333333334
r13898 n7760 n7822 0.25
r13899 n7821 n7822 0.041666666666666664
r13900 n7761 n7823 0.055555555555555552
r13901 n7822 n7823 0.11458333333333333
r13902 n7762 n7824 0.041666666666666664
r13903 n7823 n7824 0.21875
r13904 n7763 n7825 0.050000000000000003
r13905 n7764 n7826 0.071428571428571425
r13906 n7825 n7826 0.17708333333333334
r13907 n7765 n7827 0.16666666666666666
r13908 n7826 n7827 0.10416666666666667
r13909 n7766 n7828 0.16666666666666666
r13910 n7827 n7828 0.0625
r13911 n7767 n7829 0.25
r13912 n7828 n7829 0.052083333333333336
r13913 n7768 n7830 0.0625
r13914 n7829 n7830 0.10416666666666667
r13915 n7769 n7831 0.022727272727272728
r13916 n7830 n7831 0.3125
r13917 n7770 n7832 0.25
r13918 n7831 n7832 0.25
r13919 n7771 n7833 0.16666666666666666
r13920 n7832 n7833 0.052083333333333336
r13921 n7772 n7834 0.16666666666666666
r13922 n7833 n7834 0.0625
r13923 n7773 n7835 0.125
r13924 n7834 n7835 0.072916666666666671
r13925 n7774 n7836 0.16666666666666666
r13926 n7835 n7836 0.072916666666666671
r13927 n7775 n7837 0.050000000000000003
r13928 n7836 n7837 0.13541666666666666
r13929 n7776 n7838 0.041666666666666664
r13930 n7777 n7839 0.055555555555555552
r13931 n7838 n7839 0.21875
r13932 n7778 n7840 0.25
r13933 n7839 n7840 0.11458333333333333
r13934 n7779 n7841 0.25
r13935 n7840 n7841 0.041666666666666664
r13936 n7780 n7842 0.0625
r13937 n7841 n7842 0.10416666666666667
r13938 n7781 n7843 0.022727272727272728
r13939 n7842 n7843 0.3125
r13940 n7782 n7844 0.5
r13941 n7843 n7844 0.23958333333333334
r13942 n7783 n7845 0.5
r13943 n7844 n7845 0.020833333333333332
r13944 n7784 n7846 0.5
r13945 n7845 n7846 0.020833333333333332
r13946 n7785 n7847 0.050000000000000003
r13947 n7846 n7847 0.11458333333333333
r13948 n7786 n7848 0.041666666666666664
r13949 n7847 n7848 0.22916666666666666
r13950 n7787 n7849 0.050000000000000003
r13951 n7788 n7850 0.071428571428571425
r13952 n7849 n7850 0.17708333333333334
r13953 n7789 n7851 0.16666666666666666
r13954 n7850 n7851 0.10416666666666667
r13955 n7790 n7852 0.16666666666666666
r13956 n7851 n7852 0.0625
r13957 n7791 n7853 0.25
r13958 n7852 n7853 0.052083333333333336
r13959 n7792 n7854 0.045454545454545456
r13960 n7853 n7854 0.13541666666666666
r13961 n7793 n7855 0.026315789473684209
r13962 n7854 n7855 0.3125
r13963 n7794 n7856 0.25
r13964 n7855 n7856 0.21875
r13965 n7795 n7857 0.16666666666666666
r13966 n7856 n7857 0.052083333333333336
r13967 n7796 n7858 0.16666666666666666
r13968 n7857 n7858 0.0625
r13969 n7797 n7859 0.071428571428571425
r13970 n7858 n7859 0.10416666666666667
r13971 n7798 n7860 0.050000000000000003
r13972 n7859 n7860 0.17708333333333334
r13973 n7799 n7861 0.050000000000000003
r13974 n7800 n7862 0.021739130434782608
r13975 n7861 n7862 0.34375
r13976 n7801 n7863 0.25
r13977 n7862 n7863 0.26041666666666669
r13978 n7802 n7864 0.016666666666666666
r13979 n7863 n7864 0.33333333333333331
r13980 n7803 n7865 0.25
r13981 n7864 n7865 0.33333333333333331
r13982 n7804 n7866 0.021739130434782608
r13983 n7865 n7866 0.26041666666666669
r13984 n7805 n7867 0.050000000000000003
r13985 n7866 n7867 0.34375
r13986 n7806 n7868 0.5
r13987 n7807 n7869 0.055555555555555552
r13988 n7868 n7869 0.3125
r13989 n7808 n7870 0.021739130434782608
r13990 n7869 n7870 1
r13991 n7809 n7871 0.25
r13992 n7870 n7871 0.78125
r13993 n7810 n7872 0.016666666666666666
r13994 n7871 n7872 1
r13995 n7811 n7873 0.25
r13996 n7872 n7873 1
r13997 n7812 n7874 0.021739130434782608
r13998 n7873 n7874 0.78125
r13999 n7813 n7875 0.055555555555555552
r14000 n7874 n7875 1
r14001 n7814 n7876 0.5
r14002 n7875 n7876 0.3125
r14003 n7815 n7877 0.041666666666666664
r14004 n7816 n7878 0.071428571428571425
r14005 n7877 n7878 0.59375
r14006 n7817 n7879 0.25
r14007 n7878 n7879 0.28125
r14008 n7818 n7880 0.125
r14009 n7879 n7880 0.1875
r14010 n7819 n7881 0.055555555555555552
r14011 n7880 n7881 0.40625
r14012 n7820 n7882 0.023809523809523808
r14013 n7881 n7882 0.9375
r14014 n7821 n7883 0.25
r14015 n7882 n7883 0.71875
r14016 n7822 n7884 0.25
r14017 n7883 n7884 0.125
r14018 n7823 n7885 0.055555555555555552
r14019 n7884 n7885 0.34375
r14020 n7824 n7886 0.041666666666666664
r14021 n7885 n7886 0.65625
r14022 n7825 n7887 0.050000000000000003
r14023 n7826 n7888 0.071428571428571425
r14024 n7887 n7888 0.53125
r14025 n7827 n7889 0.16666666666666666
r14026 n7888 n7889 0.3125
r14027 n7828 n7890 0.16666666666666666
r14028 n7889 n7890 0.1875
r14029 n7829 n7891 0.25
r14030 n7890 n7891 0.15625
r14031 n7830 n7892 0.0625
r14032 n7891 n7892 0.3125
r14033 n7831 n7893 0.022727272727272728
r14034 n7892 n7893 0.9375
r14035 n7832 n7894 0.25
r14036 n7893 n7894 0.75
r14037 n7833 n7895 0.16666666666666666
r14038 n7894 n7895 0.15625
r14039 n7834 n7896 0.16666666666666666
r14040 n7895 n7896 0.1875
r14041 n7835 n7897 0.125
r14042 n7896 n7897 0.21875
r14043 n7836 n7898 0.16666666666666666
r14044 n7897 n7898 0.21875
r14045 n7837 n7899 0.050000000000000003
r14046 n7898 n7899 0.40625
r14047 n7838 n7900 0.041666666666666664
r14048 n7839 n7901 0.055555555555555552
r14049 n7900 n7901 0.65625
r14050 n7840 n7902 0.25
r14051 n7901 n7902 0.34375
r14052 n7841 n7903 0.25
r14053 n7902 n7903 0.125
r14054 n7842 n7904 0.0625
r14055 n7903 n7904 0.3125
r14056 n7843 n7905 0.022727272727272728
r14057 n7904 n7905 0.9375
r14058 n7844 n7906 0.5
r14059 n7905 n7906 0.71875
r14060 n7845 n7907 0.5
r14061 n7906 n7907 0.0625
r14062 n7846 n7908 0.5
r14063 n7907 n7908 0.0625
r14064 n7847 n7909 0.050000000000000003
r14065 n7908 n7909 0.34375
r14066 n7848 n7910 0.041666666666666664
r14067 n7909 n7910 0.6875
r14068 n7849 n7911 0.050000000000000003
r14069 n7850 n7912 0.071428571428571425
r14070 n7911 n7912 0.53125
r14071 n7851 n7913 0.16666666666666666
r14072 n7912 n7913 0.3125
r14073 n7852 n7914 0.16666666666666666
r14074 n7913 n7914 0.1875
r14075 n7853 n7915 0.25
r14076 n7914 n7915 0.15625
r14077 n7854 n7916 0.045454545454545456
r14078 n7915 n7916 0.40625
r14079 n7855 n7917 0.026315789473684209
r14080 n7916 n7917 0.9375
r14081 n7856 n7918 0.25
r14082 n7917 n7918 0.65625
r14083 n7857 n7919 0.16666666666666666
r14084 n7918 n7919 0.15625
r14085 n7858 n7920 0.16666666666666666
r14086 n7919 n7920 0.1875
r14087 n7859 n7921 0.071428571428571425
r14088 n7920 n7921 0.3125
r14089 n7860 n7922 0.050000000000000003
r14090 n7921 n7922 0.53125
r14091 n7861 n7923 0.050000000000000003
r14092 n7862 n7924 0.021739130434782608
r14093 n7923 n7924 1.03125
r14094 n7863 n7925 0.25
r14095 n7924 n7925 0.78125
r14096 n7864 n7926 0.016666666666666666
r14097 n7925 n7926 1
r14098 n7865 n7927 0.25
r14099 n7926 n7927 1
r14100 n7866 n7928 0.021739130434782608
r14101 n7927 n7928 0.78125
r14102 n7867 n7929 0.050000000000000003
r14103 n7928 n7929 1.03125
r14104 n7868 n7930 0.3125
r14105 n7869 n7931 0.034722222222222224
r14106 n7930 n7931 0.20833333333333334
r14107 n7870 n7932 0.01358695652173913
r14108 n7931 n7932 0.66666666666666663
r14109 n7871 n7933 0.15625
r14110 n7932 n7933 0.52083333333333337
r14111 n7872 n7934 0.010416666666666666
r14112 n7933 n7934 0.66666666666666663
r14113 n7873 n7935 0.15625
r14114 n7934 n7935 0.66666666666666663
r14115 n7874 n7936 0.01358695652173913
r14116 n7935 n7936 0.52083333333333337
r14117 n7875 n7937 0.034722222222222224
r14118 n7936 n7937 0.66666666666666663
r14119 n7876 n7938 0.3125
r14120 n7937 n7938 0.20833333333333334
r14121 n7877 n7939 0.026041666666666668
r14122 n7878 n7940 0.044642857142857144
r14123 n7939 n7940 0.39583333333333331
r14124 n7879 n7941 0.15625
r14125 n7940 n7941 0.1875
r14126 n7880 n7942 0.078125
r14127 n7941 n7942 0.125
r14128 n7881 n7943 0.034722222222222224
r14129 n7942 n7943 0.27083333333333331
r14130 n7882 n7944 0.01488095238095238
r14131 n7943 n7944 0.625
r14132 n7883 n7945 0.15625
r14133 n7944 n7945 0.47916666666666669
r14134 n7884 n7946 0.15625
r14135 n7945 n7946 0.083333333333333329
r14136 n7885 n7947 0.034722222222222224
r14137 n7946 n7947 0.22916666666666666
r14138 n7886 n7948 0.026041666666666668
r14139 n7947 n7948 0.4375
r14140 n7887 n7949 0.03125
r14141 n7888 n7950 0.044642857142857144
r14142 n7949 n7950 0.35416666666666669
r14143 n7889 n7951 0.10416666666666667
r14144 n7950 n7951 0.20833333333333334
r14145 n7890 n7952 0.10416666666666667
r14146 n7951 n7952 0.125
r14147 n7891 n7953 0.15625
r14148 n7952 n7953 0.10416666666666667
r14149 n7892 n7954 0.0390625
r14150 n7953 n7954 0.20833333333333334
r14151 n7893 n7955 0.014204545454545454
r14152 n7954 n7955 0.625
r14153 n7894 n7956 0.15625
r14154 n7955 n7956 0.5
r14155 n7895 n7957 0.10416666666666667
r14156 n7956 n7957 0.10416666666666667
r14157 n7896 n7958 0.10416666666666667
r14158 n7957 n7958 0.125
r14159 n7897 n7959 0.078125
r14160 n7958 n7959 0.14583333333333334
r14161 n7898 n7960 0.10416666666666667
r14162 n7959 n7960 0.14583333333333334
r14163 n7899 n7961 0.03125
r14164 n7960 n7961 0.27083333333333331
r14165 n7900 n7962 0.026041666666666668
r14166 n7901 n7963 0.034722222222222224
r14167 n7962 n7963 0.4375
r14168 n7902 n7964 0.15625
r14169 n7963 n7964 0.22916666666666666
r14170 n7903 n7965 0.15625
r14171 n7964 n7965 0.083333333333333329
r14172 n7904 n7966 0.0390625
r14173 n7965 n7966 0.20833333333333334
r14174 n7905 n7967 0.014204545454545454
r14175 n7966 n7967 0.625
r14176 n7906 n7968 0.3125
r14177 n7967 n7968 0.47916666666666669
r14178 n7907 n7969 0.3125
r14179 n7968 n7969 0.041666666666666664
r14180 n7908 n7970 0.3125
r14181 n7969 n7970 0.041666666666666664
r14182 n7909 n7971 0.03125
r14183 n7970 n7971 0.22916666666666666
r14184 n7910 n7972 0.026041666666666668
r14185 n7971 n7972 0.45833333333333331
r14186 n7911 n7973 0.03125
r14187 n7912 n7974 0.044642857142857144
r14188 n7973 n7974 0.35416666666666669
r14189 n7913 n7975 0.10416666666666667
r14190 n7974 n7975 0.20833333333333334
r14191 n7914 n7976 0.10416666666666667
r14192 n7975 n7976 0.125
r14193 n7915 n7977 0.15625
r14194 n7976 n7977 0.10416666666666667
r14195 n7916 n7978 0.028409090909090908
r14196 n7977 n7978 0.27083333333333331
r14197 n7917 n7979 0.016447368421052631
r14198 n7978 n7979 0.625
r14199 n7918 n7980 0.15625
r14200 n7979 n7980 0.4375
r14201 n7919 n7981 0.10416666666666667
r14202 n7980 n7981 0.10416666666666667
r14203 n7920 n7982 0.10416666666666667
r14204 n7981 n7982 0.125
r14205 n7921 n7983 0.044642857142857144
r14206 n7982 n7983 0.20833333333333334
r14207 n7922 n7984 0.03125
r14208 n7983 n7984 0.35416666666666669
r14209 n7923 n7985 0.03125
r14210 n7924 n7986 0.01358695652173913
r14211 n7985 n7986 0.6875
r14212 n7925 n7987 0.15625
r14213 n7986 n7987 0.52083333333333337
r14214 n7926 n7988 0.010416666666666666
r14215 n7987 n7988 0.66666666666666663
r14216 n7927 n7989 0.15625
r14217 n7988 n7989 0.66666666666666663
r14218 n7928 n7990 0.01358695652173913
r14219 n7989 n7990 0.52083333333333337
r14220 n7929 n7991 0.03125
r14221 n7990 n7991 0.6875
r14222 n7930 n7992 0.4375
r14223 n7931 n7993 0.048611111111111112
r14224 n7992 n7993 0.15625
r14225 n7932 n7994 0.019021739130434784
r14226 n7993 n7994 0.5
r14227 n7933 n7995 0.21875
r14228 n7994 n7995 0.390625
r14229 n7934 n7996 0.014583333333333334
r14230 n7995 n7996 0.5
r14231 n7935 n7997 0.21875
r14232 n7996 n7997 0.5
r14233 n7936 n7998 0.019021739130434784
r14234 n7997 n7998 0.390625
r14235 n7937 n7999 0.048611111111111112
r14236 n7998 n7999 0.5
r14237 n7938 n8000 0.4375
r14238 n7999 n8000 0.15625
r14239 n7939 n8001 0.036458333333333336
r14240 n7940 n8002 0.0625
r14241 n8001 n8002 0.296875
r14242 n7941 n8003 0.21875
r14243 n8002 n8003 0.140625
r14244 n7942 n8004 0.109375
r14245 n8003 n8004 0.09375
r14246 n7943 n8005 0.048611111111111112
r14247 n8004 n8005 0.203125
r14248 n7944 n8006 0.020833333333333332
r14249 n8005 n8006 0.46875
r14250 n7945 n8007 0.21875
r14251 n8006 n8007 0.359375
r14252 n7946 n8008 0.21875
r14253 n8007 n8008 0.0625
r14254 n7947 n8009 0.048611111111111112
r14255 n8008 n8009 0.171875
r14256 n7948 n8010 0.036458333333333336
r14257 n8009 n8010 0.328125
r14258 n7949 n8011 0.043749999999999997
r14259 n7950 n8012 0.0625
r14260 n8011 n8012 0.265625
r14261 n7951 n8013 0.14583333333333334
r14262 n8012 n8013 0.15625
r14263 n7952 n8014 0.14583333333333334
r14264 n8013 n8014 0.09375
r14265 n7953 n8015 0.21875
r14266 n8014 n8015 0.078125
r14267 n7954 n8016 0.0546875
r14268 n8015 n8016 0.15625
r14269 n7955 n8017 0.019886363636363636
r14270 n8016 n8017 0.46875
r14271 n7956 n8018 0.21875
r14272 n8017 n8018 0.375
r14273 n7957 n8019 0.14583333333333334
r14274 n8018 n8019 0.078125
r14275 n7958 n8020 0.14583333333333334
r14276 n8019 n8020 0.09375
r14277 n7959 n8021 0.109375
r14278 n8020 n8021 0.109375
r14279 n7960 n8022 0.14583333333333334
r14280 n8021 n8022 0.109375
r14281 n7961 n8023 0.043749999999999997
r14282 n8022 n8023 0.203125
r14283 n7962 n8024 0.036458333333333336
r14284 n7963 n8025 0.048611111111111112
r14285 n8024 n8025 0.328125
r14286 n7964 n8026 0.21875
r14287 n8025 n8026 0.171875
r14288 n7965 n8027 0.21875
r14289 n8026 n8027 0.0625
r14290 n7966 n8028 0.0546875
r14291 n8027 n8028 0.15625
r14292 n7967 n8029 0.019886363636363636
r14293 n8028 n8029 0.46875
r14294 n7968 n8030 0.4375
r14295 n8029 n8030 0.359375
r14296 n7969 n8031 0.4375
r14297 n8030 n8031 0.03125
r14298 n7970 n8032 0.4375
r14299 n8031 n8032 0.03125
r14300 n7971 n8033 0.043749999999999997
r14301 n8032 n8033 0.171875
r14302 n7972 n8034 0.036458333333333336
r14303 n8033 n8034 0.34375
r14304 n7973 n8035 0.043749999999999997
r14305 n7974 n8036 0.0625
r14306 n8035 n8036 0.265625
r14307 n7975 n8037 0.14583333333333334
r14308 n8036 n8037 0.15625
r14309 n7976 n8038 0.14583333333333334
r14310 n8037 n8038 0.09375
r14311 n7977 n8039 0.21875
r14312 n8038 n8039 0.078125
r14313 n7978 n8040 0.039772727272727272
r14314 n8039 n8040 0.203125
r14315 n7979 n8041 0.023026315789473683
r14316 n8040 n8041 0.46875
r14317 n7980 n8042 0.21875
r14318 n8041 n8042 0.328125
r14319 n7981 n8043 0.14583333333333334
r14320 n8042 n8043 0.078125
r14321 n7982 n8044 0.14583333333333334
r14322 n8043 n8044 0.09375
r14323 n7983 n8045 0.0625
r14324 n8044 n8045 0.15625
r14325 n7984 n8046 0.043749999999999997
r14326 n8045 n8046 0.265625
r14327 n7985 n8047 0.043749999999999997
r14328 n7986 n8048 0.019021739130434784
r14329 n8047 n8048 0.515625
r14330 n7987 n8049 0.21875
r14331 n8048 n8049 0.390625
r14332 n7988 n8050 0.014583333333333334
r14333 n8049 n8050 0.5
r14334 n7989 n8051 0.21875
r14335 n8050 n8051 0.5
r14336 n7990 n8052 0.019021739130434784
r14337 n8051 n8052 0.390625
r14338 n7991 n8053 0.043749999999999997
r14339 n8052 n8053 0.515625
r14340 n7992 n8054 0.4375
r14341 n7993 n8055 0.048611111111111112
r14342 n8054 n8055 0.20833333333333334
r14343 n7994 n8056 0.019021739130434784
r14344 n8055 n8056 0.66666666666666663
r14345 n7995 n8057 0.21875
r14346 n8056 n8057 0.52083333333333337
r14347 n7996 n8058 0.014583333333333334
r14348 n8057 n8058 0.66666666666666663
r14349 n7997 n8059 0.21875
r14350 n8058 n8059 0.66666666666666663
r14351 n7998 n8060 0.019021739130434784
r14352 n8059 n8060 0.52083333333333337
r14353 n7999 n8061 0.048611111111111112
r14354 n8060 n8061 0.66666666666666663
r14355 n8000 n8062 0.4375
r14356 n8061 n8062 0.20833333333333334
r14357 n8001 n8063 0.036458333333333336
r14358 n8002 n8064 0.0625
r14359 n8063 n8064 0.39583333333333331
r14360 n8003 n8065 0.21875
r14361 n8064 n8065 0.1875
r14362 n8004 n8066 0.109375
r14363 n8065 n8066 0.125
r14364 n8005 n8067 0.048611111111111112
r14365 n8066 n8067 0.27083333333333331
r14366 n8006 n8068 0.020833333333333332
r14367 n8067 n8068 0.625
r14368 n8007 n8069 0.21875
r14369 n8068 n8069 0.47916666666666669
r14370 n8008 n8070 0.21875
r14371 n8069 n8070 0.083333333333333329
r14372 n8009 n8071 0.048611111111111112
r14373 n8070 n8071 0.22916666666666666
r14374 n8010 n8072 0.036458333333333336
r14375 n8071 n8072 0.4375
r14376 n8011 n8073 0.043749999999999997
r14377 n8012 n8074 0.0625
r14378 n8073 n8074 0.35416666666666669
r14379 n8013 n8075 0.14583333333333334
r14380 n8074 n8075 0.20833333333333334
r14381 n8014 n8076 0.14583333333333334
r14382 n8075 n8076 0.125
r14383 n8015 n8077 0.21875
r14384 n8076 n8077 0.10416666666666667
r14385 n8016 n8078 0.0546875
r14386 n8077 n8078 0.20833333333333334
r14387 n8017 n8079 0.019886363636363636
r14388 n8078 n8079 0.625
r14389 n8018 n8080 0.21875
r14390 n8079 n8080 0.5
r14391 n8019 n8081 0.14583333333333334
r14392 n8080 n8081 0.10416666666666667
r14393 n8020 n8082 0.14583333333333334
r14394 n8081 n8082 0.125
r14395 n8021 n8083 0.109375
r14396 n8082 n8083 0.14583333333333334
r14397 n8022 n8084 0.14583333333333334
r14398 n8083 n8084 0.14583333333333334
r14399 n8023 n8085 0.043749999999999997
r14400 n8084 n8085 0.27083333333333331
r14401 n8024 n8086 0.036458333333333336
r14402 n8025 n8087 0.048611111111111112
r14403 n8086 n8087 0.4375
r14404 n8026 n8088 0.21875
r14405 n8087 n8088 0.22916666666666666
r14406 n8027 n8089 0.21875
r14407 n8088 n8089 0.083333333333333329
r14408 n8028 n8090 0.0546875
r14409 n8089 n8090 0.20833333333333334
r14410 n8029 n8091 0.019886363636363636
r14411 n8090 n8091 0.625
r14412 n8030 n8092 0.4375
r14413 n8091 n8092 0.47916666666666669
r14414 n8031 n8093 0.4375
r14415 n8092 n8093 0.041666666666666664
r14416 n8032 n8094 0.4375
r14417 n8093 n8094 0.041666666666666664
r14418 n8033 n8095 0.043749999999999997
r14419 n8094 n8095 0.22916666666666666
r14420 n8034 n8096 0.036458333333333336
r14421 n8095 n8096 0.45833333333333331
r14422 n8035 n8097 0.043749999999999997
r14423 n8036 n8098 0.0625
r14424 n8097 n8098 0.35416666666666669
r14425 n8037 n8099 0.14583333333333334
r14426 n8098 n8099 0.20833333333333334
r14427 n8038 n8100 0.14583333333333334
r14428 n8099 n8100 0.125
r14429 n8039 n8101 0.21875
r14430 n8100 n8101 0.10416666666666667
r14431 n8040 n8102 0.039772727272727272
r14432 n8101 n8102 0.27083333333333331
r14433 n8041 n8103 0.023026315789473683
r14434 n8102 n8103 0.625
r14435 n8042 n8104 0.21875
r14436 n8103 n8104 0.4375
r14437 n8043 n8105 0.14583333333333334
r14438 n8104 n8105 0.10416666666666667
r14439 n8044 n8106 0.14583333333333334
r14440 n8105 n8106 0.125
r14441 n8045 n8107 0.0625
r14442 n8106 n8107 0.20833333333333334
r14443 n8046 n8108 0.043749999999999997
r14444 n8107 n8108 0.35416666666666669
r14445 n8047 n8109 0.043749999999999997
r14446 n8048 n8110 0.019021739130434784
r14447 n8109 n8110 0.6875
r14448 n8049 n8111 0.21875
r14449 n8110 n8111 0.52083333333333337
r14450 n8050 n8112 0.014583333333333334
r14451 n8111 n8112 0.66666666666666663
r14452 n8051 n8113 0.21875
r14453 n8112 n8113 0.66666666666666663
r14454 n8052 n8114 0.019021739130434784
r14455 n8113 n8114 0.52083333333333337
r14456 n8053 n8115 0.043749999999999997
r14457 n8114 n8115 0.6875
r14458 n8054 n8116 1.125
r14459 n8055 n8117 0.125
r14460 n8116 n8117 0.041666666666666664
r14461 n8056 n8118 0.048913043478260872
r14462 n8117 n8118 0.13333333333333333
r14463 n8057 n8119 0.5625
r14464 n8118 n8119 0.10416666666666667
r14465 n8058 n8120 0.037499999999999999
r14466 n8119 n8120 0.13333333333333333
r14467 n8059 n8121 0.5625
r14468 n8120 n8121 0.13333333333333333
r14469 n8060 n8122 0.048913043478260872
r14470 n8121 n8122 0.10416666666666667
r14471 n8061 n8123 0.125
r14472 n8122 n8123 0.13333333333333333
r14473 n8062 n8124 1.125
r14474 n8123 n8124 0.041666666666666664
r14475 n8063 n8125 0.09375
r14476 n8064 n8126 0.16071428571428573
r14477 n8125 n8126 0.079166666666666663
r14478 n8065 n8127 0.5625
r14479 n8126 n8127 0.037499999999999999
r14480 n8066 n8128 0.28125
r14481 n8127 n8128 0.025000000000000001
r14482 n8067 n8129 0.125
r14483 n8128 n8129 0.054166666666666669
r14484 n8068 n8130 0.053571428571428568
r14485 n8129 n8130 0.125
r14486 n8069 n8131 0.5625
r14487 n8130 n8131 0.09583333333333334
r14488 n8070 n8132 0.5625
r14489 n8131 n8132 0.016666666666666666
r14490 n8071 n8133 0.125
r14491 n8132 n8133 0.04583333333333333
r14492 n8072 n8134 0.09375
r14493 n8133 n8134 0.087499999999999994
r14494 n8086 n8135 0.09375
r14495 n8087 n8136 0.125
r14496 n8135 n8136 0.087499999999999994
r14497 n8088 n8137 0.5625
r14498 n8136 n8137 0.04583333333333333
r14499 n8089 n8138 0.5625
r14500 n8137 n8138 0.016666666666666666
r14501 n8090 n8139 0.140625
r14502 n8138 n8139 0.041666666666666664
r14503 n8091 n8140 0.05113636363636364
r14504 n8139 n8140 0.125
r14505 n8092 n8141 1.125
r14506 n8140 n8141 0.09583333333333334
r14507 n8093 n8142 1.125
r14508 n8141 n8142 0.0083333333333333332
r14509 n8094 n8143 1.125
r14510 n8142 n8143 0.0083333333333333332
r14511 n8095 n8144 0.1125
r14512 n8143 n8144 0.04583333333333333
r14513 n8096 n8145 0.09375
r14514 n8144 n8145 0.09166666666666666
r14515 n8109 n8146 0.1125
r14516 n8110 n8147 0.048913043478260872
r14517 n8146 n8147 0.13750000000000001
r14518 n8111 n8148 0.5625
r14519 n8147 n8148 0.10416666666666667
r14520 n8112 n8149 0.037499999999999999
r14521 n8148 n8149 0.13333333333333333
r14522 n8113 n8150 0.5625
r14523 n8149 n8150 0.13333333333333333
r14524 n8114 n8151 0.048913043478260872
r14525 n8150 n8151 0.10416666666666667
r14526 n8115 n8152 0.1125
r14527 n8151 n8152 0.13750000000000001
r14528 n8116 n8153 1.25
r14529 n8117 n8154 0.1388888888888889
r14530 n8153 n8154 0.125
r14531 n8118 n8155 0.05434782608695652
r14532 n8154 n8155 0.40000000000000002
r14533 n8119 n8156 0.625
r14534 n8155 n8156 0.3125
r14535 n8120 n8157 0.041666666666666664
r14536 n8156 n8157 0.40000000000000002
r14537 n8121 n8158 0.625
r14538 n8157 n8158 0.40000000000000002
r14539 n8122 n8159 0.05434782608695652
r14540 n8158 n8159 0.3125
r14541 n8123 n8160 0.1388888888888889
r14542 n8159 n8160 0.40000000000000002
r14543 n8124 n8161 1.25
r14544 n8160 n8161 0.125
r14545 n8125 n8162 0.10416666666666667
r14546 n8126 n8163 0.17857142857142858
r14547 n8162 n8163 0.23749999999999999
r14548 n8127 n8164 0.625
r14549 n8163 n8164 0.1125
r14550 n8128 n8165 0.3125
r14551 n8164 n8165 0.074999999999999997
r14552 n8129 n8166 0.1388888888888889
r14553 n8165 n8166 0.16250000000000001
r14554 n8130 n8167 0.059523809523809521
r14555 n8166 n8167 0.375
r14556 n8131 n8168 0.625
r14557 n8167 n8168 0.28749999999999998
r14558 n8132 n8169 0.625
r14559 n8168 n8169 0.050000000000000003
r14560 n8133 n8170 0.1388888888888889
r14561 n8169 n8170 0.13750000000000001
r14562 n8134 n8171 0.10416666666666667
r14563 n8170 n8171 0.26250000000000001
r14564 n8135 n8172 0.10416666666666667
r14565 n8136 n8173 0.1388888888888889
r14566 n8172 n8173 0.26250000000000001
r14567 n8137 n8174 0.625
r14568 n8173 n8174 0.13750000000000001
r14569 n8138 n8175 0.625
r14570 n8174 n8175 0.050000000000000003
r14571 n8139 n8176 0.15625
r14572 n8175 n8176 0.125
r14573 n8140 n8177 0.056818181818181816
r14574 n8176 n8177 0.375
r14575 n8141 n8178 1.25
r14576 n8177 n8178 0.28749999999999998
r14577 n8142 n8179 1.25
r14578 n8178 n8179 0.025000000000000001
r14579 n8143 n8180 1.25
r14580 n8179 n8180 0.025000000000000001
r14581 n8144 n8181 0.125
r14582 n8180 n8181 0.13750000000000001
r14583 n8145 n8182 0.10416666666666667
r14584 n8181 n8182 0.27500000000000002
r14585 n8146 n8183 0.125
r14586 n8147 n8184 0.05434782608695652
r14587 n8183 n8184 0.41249999999999998
r14588 n8148 n8185 0.625
r14589 n8184 n8185 0.3125
r14590 n8149 n8186 0.041666666666666664
r14591 n8185 n8186 0.40000000000000002
r14592 n8150 n8187 0.625
r14593 n8186 n8187 0.40000000000000002
r14594 n8151 n8188 0.05434782608695652
r14595 n8187 n8188 0.3125
r14596 n8152 n8189 0.125
r14597 n8188 n8189 0.41249999999999998
r14598 n8153 n8190 0.4375
r14599 n8154 n8191 0.048611111111111112
r14600 n8190 n8191 0.3125
r14601 n8155 n8192 0.019021739130434784
r14602 n8191 n8192 1
r14603 n8156 n8193 0.21875
r14604 n8192 n8193 0.78125
r14605 n8157 n8194 0.014583333333333334
r14606 n8193 n8194 1
r14607 n8158 n8195 0.21875
r14608 n8194 n8195 1
r14609 n8159 n8196 0.019021739130434784
r14610 n8195 n8196 0.78125
r14611 n8160 n8197 0.048611111111111112
r14612 n8196 n8197 1
r14613 n8161 n8198 0.4375
r14614 n8197 n8198 0.3125
r14615 n8162 n8199 0.036458333333333336
r14616 n8163 n8200 0.0625
r14617 n8199 n8200 0.59375
r14618 n8164 n8201 0.21875
r14619 n8200 n8201 0.28125
r14620 n8165 n8202 0.109375
r14621 n8201 n8202 0.1875
r14622 n8166 n8203 0.048611111111111112
r14623 n8202 n8203 0.40625
r14624 n8167 n8204 0.020833333333333332
r14625 n8203 n8204 0.9375
r14626 n8168 n8205 0.21875
r14627 n8204 n8205 0.71875
r14628 n8169 n8206 0.21875
r14629 n8205 n8206 0.125
r14630 n8170 n8207 0.048611111111111112
r14631 n8206 n8207 0.34375
r14632 n8171 n8208 0.036458333333333336
r14633 n8207 n8208 0.65625
r14634 n8172 n8209 0.036458333333333336
r14635 n8173 n8210 0.048611111111111112
r14636 n8209 n8210 0.65625
r14637 n8174 n8211 0.21875
r14638 n8210 n8211 0.34375
r14639 n8175 n8212 0.21875
r14640 n8211 n8212 0.125
r14641 n8176 n8213 0.0546875
r14642 n8212 n8213 0.3125
r14643 n8177 n8214 0.019886363636363636
r14644 n8213 n8214 0.9375
r14645 n8178 n8215 0.4375
r14646 n8214 n8215 0.71875
r14647 n8179 n8216 0.4375
r14648 n8215 n8216 0.0625
r14649 n8180 n8217 0.4375
r14650 n8216 n8217 0.0625
r14651 n8181 n8218 0.043749999999999997
r14652 n8217 n8218 0.34375
r14653 n8182 n8219 0.036458333333333336
r14654 n8218 n8219 0.6875
r14655 n8183 n8220 0.043749999999999997
r14656 n8184 n8221 0.019021739130434784
r14657 n8220 n8221 1.03125
r14658 n8185 n8222 0.21875
r14659 n8221 n8222 0.78125
r14660 n8186 n8223 0.014583333333333334
r14661 n8222 n8223 1
r14662 n8187 n8224 0.21875
r14663 n8223 n8224 1
r14664 n8188 n8225 0.019021739130434784
r14665 n8224 n8225 0.78125
r14666 n8189 n8226 0.043749999999999997
r14667 n8225 n8226 1.03125
r14668 n8190 n8227 0.5
r14669 n8191 n8228 0.055555555555555552
r14670 n8227 n8228 0.10416666666666667
r14671 n8192 n8229 0.021739130434782608
r14672 n8228 n8229 0.33333333333333331
r14673 n8193 n8230 0.25
r14674 n8229 n8230 0.26041666666666669
r14675 n8194 n8231 0.016666666666666666
r14676 n8230 n8231 0.33333333333333331
r14677 n8195 n8232 0.25
r14678 n8231 n8232 0.33333333333333331
r14679 n8196 n8233 0.021739130434782608
r14680 n8232 n8233 0.26041666666666669
r14681 n8197 n8234 0.055555555555555552
r14682 n8233 n8234 0.33333333333333331
r14683 n8198 n8235 0.5
r14684 n8234 n8235 0.10416666666666667
r14685 n8199 n8236 0.041666666666666664
r14686 n8200 n8237 0.071428571428571425
r14687 n8236 n8237 0.19791666666666666
r14688 n8201 n8238 0.25
r14689 n8237 n8238 0.09375
r14690 n8202 n8239 0.125
r14691 n8238 n8239 0.0625
r14692 n8203 n8240 0.055555555555555552
r14693 n8239 n8240 0.13541666666666666
r14694 n8204 n8241 0.023809523809523808
r14695 n8240 n8241 0.3125
r14696 n8205 n8242 0.25
r14697 n8241 n8242 0.23958333333333334
r14698 n8206 n8243 0.25
r14699 n8242 n8243 0.041666666666666664
r14700 n8207 n8244 0.055555555555555552
r14701 n8243 n8244 0.11458333333333333
r14702 n8208 n8245 0.041666666666666664
r14703 n8244 n8245 0.21875
r14704 n8209 n8246 0.041666666666666664
r14705 n8210 n8247 0.055555555555555552
r14706 n8246 n8247 0.21875
r14707 n8211 n8248 0.25
r14708 n8247 n8248 0.11458333333333333
r14709 n8212 n8249 0.25
r14710 n8248 n8249 0.041666666666666664
r14711 n8213 n8250 0.0625
r14712 n8249 n8250 0.10416666666666667
r14713 n8214 n8251 0.022727272727272728
r14714 n8250 n8251 0.3125
r14715 n8215 n8252 0.5
r14716 n8251 n8252 0.23958333333333334
r14717 n8216 n8253 0.5
r14718 n8252 n8253 0.020833333333333332
r14719 n8217 n8254 0.5
r14720 n8253 n8254 0.020833333333333332
r14721 n8218 n8255 0.050000000000000003
r14722 n8254 n8255 0.11458333333333333
r14723 n8219 n8256 0.041666666666666664
r14724 n8255 n8256 0.22916666666666666
r14725 n8220 n8257 0.050000000000000003
r14726 n8221 n8258 0.021739130434782608
r14727 n8257 n8258 0.34375
r14728 n8222 n8259 0.25
r14729 n8258 n8259 0.26041666666666669
r14730 n8223 n8260 0.016666666666666666
r14731 n8259 n8260 0.33333333333333331
r14732 n8224 n8261 0.25
r14733 n8260 n8261 0.33333333333333331
r14734 n8225 n8262 0.021739130434782608
r14735 n8261 n8262 0.26041666666666669
r14736 n8226 n8263 0.050000000000000003
r14737 n8262 n8263 0.34375
r14738 n8227 n8264 0.8125
r14739 n8228 n8265 0.090277777777777776
r14740 n8264 n8265 0.089285714285714288
r14741 n8229 n8266 0.035326086956521736
r14742 n8265 n8266 0.2857142857142857
r14743 n8230 n8267 0.40625
r14744 n8266 n8267 0.22321428571428573
r14745 n8231 n8268 0.027083333333333334
r14746 n8267 n8268 0.2857142857142857
r14747 n8232 n8269 0.40625
r14748 n8268 n8269 0.2857142857142857
r14749 n8233 n8270 0.035326086956521736
r14750 n8269 n8270 0.22321428571428573
r14751 n8234 n8271 0.090277777777777776
r14752 n8270 n8271 0.2857142857142857
r14753 n8235 n8272 0.8125
r14754 n8271 n8272 0.089285714285714288
r14755 n8236 n8273 0.067708333333333329
r14756 n8237 n8274 0.11607142857142858
r14757 n8273 n8274 0.16964285714285715
r14758 n8238 n8275 0.40625
r14759 n8274 n8275 0.080357142857142863
r14760 n8239 n8276 0.203125
r14761 n8275 n8276 0.053571428571428568
r14762 n8240 n8277 0.090277777777777776
r14763 n8276 n8277 0.11607142857142858
r14764 n8241 n8278 0.038690476190476192
r14765 n8277 n8278 0.26785714285714285
r14766 n8242 n8279 0.40625
r14767 n8278 n8279 0.20535714285714285
r14768 n8243 n8280 0.40625
r14769 n8279 n8280 0.035714285714285712
r14770 n8244 n8281 0.090277777777777776
r14771 n8280 n8281 0.098214285714285712
r14772 n8245 n8282 0.067708333333333329
r14773 n8281 n8282 0.1875
r14774 n8246 n8283 0.067708333333333329
r14775 n8247 n8284 0.090277777777777776
r14776 n8283 n8284 0.1875
r14777 n8248 n8285 0.40625
r14778 n8284 n8285 0.098214285714285712
r14779 n8249 n8286 0.40625
r14780 n8285 n8286 0.035714285714285712
r14781 n8250 n8287 0.1015625
r14782 n8286 n8287 0.089285714285714288
r14783 n8251 n8288 0.036931818181818184
r14784 n8287 n8288 0.26785714285714285
r14785 n8252 n8289 0.8125
r14786 n8288 n8289 0.20535714285714285
r14787 n8253 n8290 0.8125
r14788 n8289 n8290 0.017857142857142856
r14789 n8254 n8291 0.8125
r14790 n8290 n8291 0.017857142857142856
r14791 n8255 n8292 0.081250000000000003
r14792 n8291 n8292 0.098214285714285712
r14793 n8256 n8293 0.067708333333333329
r14794 n8292 n8293 0.19642857142857142
r14795 n8257 n8294 0.081250000000000003
r14796 n8258 n8295 0.035326086956521736
r14797 n8294 n8295 0.29464285714285715
r14798 n8259 n8296 0.40625
r14799 n8295 n8296 0.22321428571428573
r14800 n8260 n8297 0.027083333333333334
r14801 n8296 n8297 0.2857142857142857
r14802 n8261 n8298 0.40625
r14803 n8297 n8298 0.2857142857142857
r14804 n8262 n8299 0.035326086956521736
r14805 n8298 n8299 0.22321428571428573
r14806 n8263 n8300 0.081250000000000003
r14807 n8299 n8300 0.29464285714285715
r14808 n8264 n8301 1.3125
r14809 n8265 n8302 0.14583333333333334
r14810 n8301 n8302 0.044642857142857144
r14811 n8266 n8303 0.057065217391304345
r14812 n8302 n8303 0.14285714285714285
r14813 n8267 n8304 0.65625
r14814 n8303 n8304 0.11160714285714286
r14815 n8268 n8305 0.043749999999999997
r14816 n8304 n8305 0.14285714285714285
r14817 n8269 n8306 0.65625
r14818 n8305 n8306 0.14285714285714285
r14819 n8270 n8307 0.057065217391304345
r14820 n8306 n8307 0.11160714285714286
r14821 n8271 n8308 0.14583333333333334
r14822 n8307 n8308 0.14285714285714285
r14823 n8272 n8309 1.3125
r14824 n8308 n8309 0.044642857142857144
r14825 n8274 n8310 0.1875
r14826 n8275 n8311 0.65625
r14827 n8310 n8311 0.040178571428571432
r14828 n8276 n8312 0.328125
r14829 n8311 n8312 0.026785714285714284
r14830 n8277 n8313 0.14583333333333334
r14831 n8312 n8313 0.058035714285714288
r14832 n8278 n8314 0.0625
r14833 n8313 n8314 0.13392857142857142
r14834 n8279 n8315 0.65625
r14835 n8314 n8315 0.10267857142857142
r14836 n8280 n8316 0.65625
r14837 n8315 n8316 0.017857142857142856
r14838 n8281 n8317 0.14583333333333334
r14839 n8316 n8317 0.049107142857142856
r14840 n8284 n8318 0.14583333333333334
r14841 n8285 n8319 0.65625
r14842 n8318 n8319 0.049107142857142856
r14843 n8286 n8320 0.65625
r14844 n8319 n8320 0.017857142857142856
r14845 n8287 n8321 0.1640625
r14846 n8320 n8321 0.044642857142857144
r14847 n8288 n8322 0.059659090909090912
r14848 n8321 n8322 0.13392857142857142
r14849 n8289 n8323 1.3125
r14850 n8322 n8323 0.10267857142857142
r14851 n8290 n8324 1.3125
r14852 n8323 n8324 0.0089285714285714281
r14853 n8291 n8325 1.3125
r14854 n8324 n8325 0.0089285714285714281
r14855 n8292 n8326 0.13125000000000001
r14856 n8325 n8326 0.049107142857142856
r14857 n8294 n8327 0.13125000000000001
r14858 n8295 n8328 0.057065217391304345
r14859 n8327 n8328 0.14732142857142858
r14860 n8296 n8329 0.65625
r14861 n8328 n8329 0.11160714285714286
r14862 n8297 n8330 0.043749999999999997
r14863 n8329 n8330 0.14285714285714285
r14864 n8298 n8331 0.65625
r14865 n8330 n8331 0.14285714285714285
r14866 n8299 n8332 0.057065217391304345
r14867 n8331 n8332 0.11160714285714286
r14868 n8300 n8333 0.13125000000000001
r14869 n8332 n8333 0.14732142857142858
r14870 n8301 n8334 3.2250000000000001
r14871 n8302 n8335 0.35833333333333334
r14872 n8334 n8335 0.016622340425531915
r14873 n8303 n8336 0.14021739130434782
r14874 n8335 n8336 0.053191489361702128
r14875 n8304 n8337 1.6125
r14876 n8336 n8337 0.041555851063829786
r14877 n8305 n8338 0.1075
r14878 n8337 n8338 0.053191489361702128
r14879 n8306 n8339 1.6125
r14880 n8338 n8339 0.053191489361702128
r14881 n8307 n8340 0.14021739130434782
r14882 n8339 n8340 0.041555851063829786
r14883 n8308 n8341 0.35833333333333334
r14884 n8340 n8341 0.053191489361702128
r14885 n8309 n8342 3.2250000000000001
r14886 n8341 n8342 0.016622340425531915
r14887 n8310 n8343 0.46071428571428569
r14888 n8311 n8344 1.6125
r14889 n8343 n8344 0.014960106382978724
r14890 n8312 n8345 0.80625000000000002
r14891 n8344 n8345 0.0099734042553191495
r14892 n8313 n8346 0.35833333333333334
r14893 n8345 n8346 0.021609042553191491
r14894 n8314 n8347 0.15357142857142858
r14895 n8346 n8347 0.049867021276595744
r14896 n8315 n8348 1.6125
r14897 n8347 n8348 0.038231382978723402
r14898 n8316 n8349 1.6125
r14899 n8348 n8349 0.006648936170212766
r14900 n8317 n8350 0.35833333333333334
r14901 n8349 n8350 0.018284574468085107
r14902 n8318 n8351 0.35833333333333334
r14903 n8319 n8352 1.6125
r14904 n8351 n8352 0.018284574468085107
r14905 n8320 n8353 1.6125
r14906 n8352 n8353 0.006648936170212766
r14907 n8321 n8354 0.40312500000000001
r14908 n8353 n8354 0.016622340425531915
r14909 n8322 n8355 0.14659090909090908
r14910 n8354 n8355 0.049867021276595744
r14911 n8323 n8356 3.2250000000000001
r14912 n8355 n8356 0.038231382978723402
r14913 n8324 n8357 3.2250000000000001
r14914 n8356 n8357 0.003324468085106383
r14915 n8325 n8358 3.2250000000000001
r14916 n8357 n8358 0.003324468085106383
r14917 n8326 n8359 0.32250000000000001
r14918 n8358 n8359 0.018284574468085107
r14919 n8327 n8360 0.32250000000000001
r14920 n8328 n8361 0.14021739130434782
r14921 n8360 n8361 0.054853723404255317
r14922 n8329 n8362 1.6125
r14923 n8361 n8362 0.041555851063829786
r14924 n8330 n8363 0.1075
r14925 n8362 n8363 0.053191489361702128
r14926 n8331 n8364 1.6125
r14927 n8363 n8364 0.053191489361702128
r14928 n8332 n8365 0.14021739130434782
r14929 n8364 n8365 0.041555851063829786
r14930 n8333 n8366 0.32250000000000001
r14931 n8365 n8366 0.054853723404255317
r14932 n8334 n8367 4.6875
r14933 n8335 n8368 0.52083333333333337
r14934 n8367 n8368 0.016711229946524065
r14935 n8336 n8369 0.20380434782608695
r14936 n8368 n8369 0.053475935828877004
r14937 n8337 n8370 2.34375
r14938 n8369 n8370 0.041778074866310161
r14939 n8338 n8371 0.15625
r14940 n8370 n8371 0.053475935828877004
r14941 n8339 n8372 2.34375
r14942 n8371 n8372 0.053475935828877004
r14943 n8340 n8373 0.20380434782608695
r14944 n8372 n8373 0.041778074866310161
r14945 n8341 n8374 0.52083333333333337
r14946 n8373 n8374 0.053475935828877004
r14947 n8342 n8375 4.6875
r14948 n8374 n8375 0.016711229946524065
r14949 n8343 n8376 0.6696428571428571
r14950 n8344 n8377 2.34375
r14951 n8376 n8377 0.015040106951871657
r14952 n8345 n8378 1.171875
r14953 n8377 n8378 0.010026737967914439
r14954 n8346 n8379 0.52083333333333337
r14955 n8378 n8379 0.021724598930481284
r14956 n8347 n8380 0.22321428571428573
r14957 n8379 n8380 0.050133689839572192
r14958 n8348 n8381 2.34375
r14959 n8380 n8381 0.038435828877005349
r14960 n8349 n8382 2.34375
r14961 n8381 n8382 0.0066844919786096255
r14962 n8350 n8383 0.52083333333333337
r14963 n8382 n8383 0.018382352941176471
r14964 n8351 n8384 0.52083333333333337
r14965 n8352 n8385 2.34375
r14966 n8384 n8385 0.018382352941176471
r14967 n8353 n8386 2.34375
r14968 n8385 n8386 0.0066844919786096255
r14969 n8354 n8387 0.5859375
r14970 n8386 n8387 0.016711229946524065
r14971 n8355 n8388 0.21306818181818182
r14972 n8387 n8388 0.050133689839572192
r14973 n8356 n8389 4.6875
r14974 n8388 n8389 0.038435828877005349
r14975 n8357 n8390 4.6875
r14976 n8389 n8390 0.0033422459893048127
r14977 n8358 n8391 4.6875
r14978 n8390 n8391 0.0033422459893048127
r14979 n8359 n8392 0.46875
r14980 n8391 n8392 0.018382352941176471
r14981 n8360 n8393 0.46875
r14982 n8361 n8394 0.20380434782608695
r14983 n8393 n8394 0.05514705882352941
r14984 n8362 n8395 2.34375
r14985 n8394 n8395 0.041778074866310161
r14986 n8363 n8396 0.15625
r14987 n8395 n8396 0.053475935828877004
r14988 n8364 n8397 2.34375
r14989 n8396 n8397 0.053475935828877004
r14990 n8365 n8398 0.20380434782608695
r14991 n8397 n8398 0.041778074866310161
r14992 n8366 n8399 0.46875
r14993 n8398 n8399 0.05514705882352941
r14994 n8367 n8400 4.4625000000000004
r14995 n8368 n8401 0.49583333333333335
r14996 n8400 n8401 0.018382352941176471
r14997 n8369 n8402 0.19402173913043477
r14998 n8401 n8402 0.058823529411764705
r14999 n8370 n8403 2.2312500000000002
r15000 n8402 n8403 0.04595588235294118
r15001 n8371 n8404 0.14874999999999999
r15002 n8403 n8404 0.058823529411764705
r15003 n8372 n8405 2.2312500000000002
r15004 n8404 n8405 0.058823529411764705
r15005 n8373 n8406 0.19402173913043477
r15006 n8405 n8406 0.04595588235294118
r15007 n8374 n8407 0.49583333333333335
r15008 n8406 n8407 0.058823529411764705
r15009 n8375 n8408 4.4625000000000004
r15010 n8407 n8408 0.018382352941176471
r15011 n8376 n8409 0.63749999999999996
r15012 n8377 n8410 2.2312500000000002
r15013 n8409 n8410 0.016544117647058824
r15014 n8378 n8411 1.1156250000000001
r15015 n8410 n8411 0.011029411764705883
r15016 n8379 n8412 0.49583333333333335
r15017 n8411 n8412 0.02389705882352941
r15018 n8380 n8413 0.21249999999999999
r15019 n8412 n8413 0.05514705882352941
r15020 n8381 n8414 2.2312500000000002
r15021 n8413 n8414 0.042279411764705885
r15022 n8382 n8415 2.2312500000000002
r15023 n8414 n8415 0.0073529411764705881
r15024 n8383 n8416 0.49583333333333335
r15025 n8415 n8416 0.020220588235294119
r15026 n8384 n8417 0.49583333333333335
r15027 n8385 n8418 2.2312500000000002
r15028 n8417 n8418 0.020220588235294119
r15029 n8386 n8419 2.2312500000000002
r15030 n8418 n8419 0.0073529411764705881
r15031 n8387 n8420 0.55781250000000004
r15032 n8419 n8420 0.018382352941176471
r15033 n8388 n8421 0.2028409090909091
r15034 n8420 n8421 0.05514705882352941
r15035 n8389 n8422 4.4625000000000004
r15036 n8421 n8422 0.042279411764705885
r15037 n8390 n8423 4.4625000000000004
r15038 n8422 n8423 0.0036764705882352941
r15039 n8391 n8424 4.4625000000000004
r15040 n8423 n8424 0.0036764705882352941
r15041 n8392 n8425 0.44624999999999998
r15042 n8424 n8425 0.020220588235294119
r15043 n8393 n8426 0.44624999999999998
r15044 n8394 n8427 0.19402173913043477
r15045 n8426 n8427 0.060661764705882353
r15046 n8395 n8428 2.2312500000000002
r15047 n8427 n8428 0.04595588235294118
r15048 n8396 n8429 0.14874999999999999
r15049 n8428 n8429 0.058823529411764705
r15050 n8397 n8430 2.2312500000000002
r15051 n8429 n8430 0.058823529411764705
r15052 n8398 n8431 0.19402173913043477
r15053 n8430 n8431 0.04595588235294118
r15054 n8399 n8432 0.44624999999999998
r15055 n8431 n8432 0.060661764705882353
r15056 n8400 n8433 4.5999999999999996
r15057 n8401 n8434 0.51111111111111107
r15058 n8433 n8434 0.015782828282828284
r15059 n8402 n8435 0.20000000000000001
r15060 n8434 n8435 0.050505050505050504
r15061 n8403 n8436 2.2999999999999998
r15062 n8435 n8436 0.039457070707070704
r15063 n8404 n8437 0.15333333333333332
r15064 n8436 n8437 0.050505050505050504
r15065 n8405 n8438 2.2999999999999998
r15066 n8437 n8438 0.050505050505050504
r15067 n8406 n8439 0.20000000000000001
r15068 n8438 n8439 0.039457070707070704
r15069 n8407 n8440 0.51111111111111107
r15070 n8439 n8440 0.050505050505050504
r15071 n8408 n8441 4.5999999999999996
r15072 n8440 n8441 0.015782828282828284
r15073 n8409 n8442 0.65714285714285714
r15074 n8410 n8443 2.2999999999999998
r15075 n8442 n8443 0.014204545454545454
r15076 n8411 n8444 1.1499999999999999
r15077 n8443 n8444 0.00946969696969697
r15078 n8412 n8445 0.51111111111111107
r15079 n8444 n8445 0.020517676767676768
r15080 n8413 n8446 0.21904761904761905
r15081 n8445 n8446 0.047348484848484848
r15082 n8414 n8447 2.2999999999999998
r15083 n8446 n8447 0.036300505050505048
r15084 n8415 n8448 2.2999999999999998
r15085 n8447 n8448 0.006313131313131313
r15086 n8416 n8449 0.51111111111111107
r15087 n8448 n8449 0.017361111111111112
r15088 n8417 n8450 0.51111111111111107
r15089 n8418 n8451 2.2999999999999998
r15090 n8450 n8451 0.017361111111111112
r15091 n8419 n8452 2.2999999999999998
r15092 n8451 n8452 0.006313131313131313
r15093 n8420 n8453 0.57499999999999996
r15094 n8452 n8453 0.015782828282828284
r15095 n8421 n8454 0.20909090909090908
r15096 n8453 n8454 0.047348484848484848
r15097 n8422 n8455 4.5999999999999996
r15098 n8454 n8455 0.036300505050505048
r15099 n8423 n8456 4.5999999999999996
r15100 n8455 n8456 0.0031565656565656565
r15101 n8424 n8457 4.5999999999999996
r15102 n8456 n8457 0.0031565656565656565
r15103 n8425 n8458 0.46000000000000002
r15104 n8457 n8458 0.017361111111111112
r15105 n8426 n8459 0.46000000000000002
r15106 n8427 n8460 0.20000000000000001
r15107 n8459 n8460 0.052083333333333336
r15108 n8428 n8461 2.2999999999999998
r15109 n8460 n8461 0.039457070707070704
r15110 n8429 n8462 0.15333333333333332
r15111 n8461 n8462 0.050505050505050504
r15112 n8430 n8463 2.2999999999999998
r15113 n8462 n8463 0.050505050505050504
r15114 n8431 n8464 0.20000000000000001
r15115 n8463 n8464 0.039457070707070704
r15116 n8432 n8465 0.46000000000000002
r15117 n8464 n8465 0.052083333333333336
r15118 n8433 n8466 4.9625000000000004
r15119 n8434 n8467 0.55138888888888893
r15120 n8466 n8467 0.015703517587939697
r15121 n8435 n8468 0.21576086956521739
r15122 n8467 n8468 0.050251256281407038
r15123 n8436 n8469 2.4812500000000002
r15124 n8468 n8469 0.03925879396984925
r15125 n8437 n8470 0.16541666666666666
r15126 n8469 n8470 0.050251256281407038
r15127 n8438 n8471 2.4812500000000002
r15128 n8470 n8471 0.050251256281407038
r15129 n8439 n8472 0.21576086956521739
r15130 n8471 n8472 0.03925879396984925
r15131 n8440 n8473 0.55138888888888893
r15132 n8472 n8473 0.050251256281407038
r15133 n8441 n8474 4.9625000000000004
r15134 n8473 n8474 0.015703517587939697
r15135 n8442 n8475 0.70892857142857146
r15136 n8443 n8476 2.4812500000000002
r15137 n8475 n8476 0.014133165829145729
r15138 n8444 n8477 1.2406250000000001
r15139 n8476 n8477 0.0094221105527638183
r15140 n8445 n8478 0.55138888888888893
r15141 n8477 n8478 0.02041457286432161
r15142 n8446 n8479 0.2363095238095238
r15143 n8478 n8479 0.047110552763819098
r15144 n8447 n8480 2.4812500000000002
r15145 n8479 n8480 0.036118090452261303
r15146 n8448 n8481 2.4812500000000002
r15147 n8480 n8481 0.0062814070351758797
r15148 n8449 n8482 0.55138888888888893
r15149 n8481 n8482 0.017273869346733667
r15150 n8450 n8483 0.55138888888888893
r15151 n8451 n8484 2.4812500000000002
r15152 n8483 n8484 0.017273869346733667
r15153 n8452 n8485 2.4812500000000002
r15154 n8484 n8485 0.0062814070351758797
r15155 n8453 n8486 0.62031250000000004
r15156 n8485 n8486 0.015703517587939697
r15157 n8454 n8487 0.22556818181818181
r15158 n8486 n8487 0.047110552763819098
r15159 n8455 n8488 4.9625000000000004
r15160 n8487 n8488 0.036118090452261303
r15161 n8456 n8489 4.9625000000000004
r15162 n8488 n8489 0.0031407035175879399
r15163 n8457 n8490 4.9625000000000004
r15164 n8489 n8490 0.0031407035175879399
r15165 n8458 n8491 0.49625000000000002
r15166 n8490 n8491 0.017273869346733667
r15167 n8459 n8492 0.49625000000000002
r15168 n8460 n8493 0.21576086956521739
r15169 n8492 n8493 0.051821608040201007
r15170 n8461 n8494 2.4812500000000002
r15171 n8493 n8494 0.03925879396984925
r15172 n8462 n8495 0.16541666666666666
r15173 n8494 n8495 0.050251256281407038
r15174 n8463 n8496 2.4812500000000002
r15175 n8495 n8496 0.050251256281407038
r15176 n8464 n8497 0.21576086956521739
r15177 n8496 n8497 0.03925879396984925
r15178 n8465 n8498 0.49625000000000002
r15179 n8497 n8498 0.051821608040201007
r15180 n8466 n8499 4.9625000000000004
r15181 n8467 n8500 0.55138888888888893
r15182 n8499 n8500 0.015782828282828284
r15183 n8468 n8501 0.21576086956521739
r15184 n8500 n8501 0.050505050505050504
r15185 n8469 n8502 2.4812500000000002
r15186 n8501 n8502 0.039457070707070704
r15187 n8470 n8503 0.16541666666666666
r15188 n8502 n8503 0.050505050505050504
r15189 n8471 n8504 2.4812500000000002
r15190 n8503 n8504 0.050505050505050504
r15191 n8472 n8505 0.21576086956521739
r15192 n8504 n8505 0.039457070707070704
r15193 n8473 n8506 0.55138888888888893
r15194 n8505 n8506 0.050505050505050504
r15195 n8474 n8507 4.9625000000000004
r15196 n8506 n8507 0.015782828282828284
r15197 n8475 n8508 0.70892857142857146
r15198 n8476 n8509 2.4812500000000002
r15199 n8508 n8509 0.014204545454545454
r15200 n8477 n8510 1.2406250000000001
r15201 n8509 n8510 0.00946969696969697
r15202 n8478 n8511 0.55138888888888893
r15203 n8510 n8511 0.020517676767676768
r15204 n8479 n8512 0.2363095238095238
r15205 n8511 n8512 0.047348484848484848
r15206 n8480 n8513 2.4812500000000002
r15207 n8512 n8513 0.036300505050505048
r15208 n8481 n8514 2.4812500000000002
r15209 n8513 n8514 0.006313131313131313
r15210 n8482 n8515 0.55138888888888893
r15211 n8514 n8515 0.017361111111111112
r15212 n8483 n8516 0.55138888888888893
r15213 n8484 n8517 2.4812500000000002
r15214 n8516 n8517 0.017361111111111112
r15215 n8485 n8518 2.4812500000000002
r15216 n8517 n8518 0.006313131313131313
r15217 n8486 n8519 0.62031250000000004
r15218 n8518 n8519 0.015782828282828284
r15219 n8487 n8520 0.22556818181818181
r15220 n8519 n8520 0.047348484848484848
r15221 n8488 n8521 4.9625000000000004
r15222 n8520 n8521 0.036300505050505048
r15223 n8489 n8522 4.9625000000000004
r15224 n8521 n8522 0.0031565656565656565
r15225 n8490 n8523 4.9625000000000004
r15226 n8522 n8523 0.0031565656565656565
r15227 n8491 n8524 0.49625000000000002
r15228 n8523 n8524 0.017361111111111112
r15229 n8492 n8525 0.49625000000000002
r15230 n8493 n8526 0.21576086956521739
r15231 n8525 n8526 0.052083333333333336
r15232 n8494 n8527 2.4812500000000002
r15233 n8526 n8527 0.039457070707070704
r15234 n8495 n8528 0.16541666666666666
r15235 n8527 n8528 0.050505050505050504
r15236 n8496 n8529 2.4812500000000002
r15237 n8528 n8529 0.050505050505050504
r15238 n8497 n8530 0.21576086956521739
r15239 n8529 n8530 0.039457070707070704
r15240 n8498 n8531 0.49625000000000002
r15241 n8530 n8531 0.052083333333333336
r15242 n8499 n8532 4.2249999999999996
r15243 n8500 n8533 0.46944444444444444
r15244 n8532 n8533 0.022321428571428572
r15245 n8501 n8534 0.18369565217391304
r15246 n8533 n8534 0.071428571428571425
r15247 n8502 n8535 2.1124999999999998
r15248 n8534 n8535 0.055803571428571432
r15249 n8503 n8536 0.14083333333333334
r15250 n8535 n8536 0.071428571428571425
r15251 n8504 n8537 2.1124999999999998
r15252 n8536 n8537 0.071428571428571425
r15253 n8505 n8538 0.18369565217391304
r15254 n8537 n8538 0.055803571428571432
r15255 n8506 n8539 0.46944444444444444
r15256 n8538 n8539 0.071428571428571425
r15257 n8507 n8540 4.2249999999999996
r15258 n8539 n8540 0.022321428571428572
r15259 n8508 n8541 0.60357142857142854
r15260 n8509 n8542 2.1124999999999998
r15261 n8541 n8542 0.020089285714285716
r15262 n8510 n8543 1.0562499999999999
r15263 n8542 n8543 0.013392857142857142
r15264 n8511 n8544 0.46944444444444444
r15265 n8543 n8544 0.029017857142857144
r15266 n8512 n8545 0.2011904761904762
r15267 n8544 n8545 0.066964285714285712
r15268 n8513 n8546 2.1124999999999998
r15269 n8545 n8546 0.051339285714285712
r15270 n8514 n8547 2.1124999999999998
r15271 n8546 n8547 0.0089285714285714281
r15272 n8515 n8548 0.46944444444444444
r15273 n8547 n8548 0.024553571428571428
r15274 n8548 n8549 0.046875
r15275 n8549 n8550 0.046875
r15276 n8550 n8551 0.024553571428571428
r15277 n8551 n8552 0.0089285714285714281
r15278 n8552 n8553 0.051339285714285712
r15279 n8553 n8554 0.080357142857142863
r15280 n8554 n8555 0.037946428571428568
r15281 n8555 n8556 0.075892857142857137
r15282 n8556 n8557 0.075892857142857137
r15283 n8557 n8558 0.03125
r15284 n8558 n8559 0.035714285714285712
r15285 n8559 n8560 0.053571428571428568
r15286 n8560 n8561 0.12053571428571429
r15287 n8561 n8562 0.087053571428571425
r15288 n8562 n8563 0.033482142857142856
r15289 n8563 n8564 0.037946428571428568
r15290 n8564 n8565 0.022321428571428572
r15291 n8565 n8566 0.013392857142857142
r15292 n8566 n8567 0.011160714285714286
r15293 n8567 n8568 0.022321428571428572
r15294 n8568 n8569 0.066964285714285712
r15295 n8569 n8570 0.053571428571428568
r15296 n8570 n8571 0.011160714285714286
r15297 n8571 n8572 0.013392857142857142
r15298 n8572 n8573 0.015625
r15299 n8573 n8574 0.015625
r15300 n8574 n8575 0.029017857142857144
r15301 n8575 n8576 0.13169642857142858
r15302 n8576 n8577 0.18526785714285715
r15303 n8577 n8578 0.17053571428571429
r15304 n8578 n8579 0.18973214285714285
r15305 n8579 n8580 0.19017857142857142
r15306 n8580 n8581 0.18973214285714285
r15307 n8581 n8582 0.16160714285714287
r15308 n8582 n8583 0.13392857142857142
r15309 n8583 n8584 0.13392857142857142
r15310 n8584 n8585 0.13392857142857142
r15311 n8585 n8586 0.15625
r15312 n8586 n8587 0.17857142857142858
r15313 n8587 n8588 0.16071428571428573
r15314 n8588 n8589 0.13392857142857142
r15315 n8589 n8590 0.125
r15316 n8590 n8591 0.13392857142857142
r15317 n8591 n8592 0.12946428571428573
r15318 n8592 n8593 0.11607142857142858
r15319 n8593 n8594 0.13392857142857142
r15320 n8594 n8595 0.14285714285714285
r15321 n8595 n8596 0.13392857142857142
r15322 n8596 n8597 0.14285714285714285
r15323 n8597 n8598 0.12946428571428573
r15324 n8598 n8599 0.0625
r15325 n8599 n8600 0.03125
r15326 n8600 n8601 0.026785714285714284
r15327 n8601 n8602 0.075892857142857137
r15328 n8602 n8603 0.075892857142857137
r15329 n8603 n8604 0.084821428571428575
r15330 n8604 n8605 0.084821428571428575
r15331 n8605 n8606 0.075892857142857137
r15332 n8606 n8607 0.075892857142857137
r15333 n8607 n8608 0.084821428571428575
r15334 n8608 n8609 0.084821428571428575
r15335 n8609 n8610 0.075892857142857137
r15336 n8610 n8611 0.075892857142857137
r15337 n8611 n8612 0.084821428571428575
r15338 n8612 n8613 0.084821428571428575
r15339 n8613 n8614 0.075892857142857137
r15340 n8614 n8615 0.075892857142857137
r15341 n8615 n8616 0.084821428571428575
r15342 n8616 n8617 0.084821428571428575
r15343 n8617 n8618 0.075892857142857137
r15344 n8618 n8619 0.075892857142857137
r15345 n8619 n8620 0.084821428571428575
r15346 n8620 n8621 0.084821428571428575
r15347 n8621 n8622 0.075892857142857137
r15348 n8622 n8623 0.075892857142857137
r15349 n8623 n8624 0.084821428571428575
r15350 n8624 n8625 0.084821428571428575
r15351 n8625 n8626 0.075892857142857137
r15352 n8626 n8627 0.075892857142857137
r15353 n8627 n8628 0.084821428571428575
r15354 n8628 n8629 0.084821428571428575
r15355 n8629 n8630 0.075892857142857137
r15356 n8630 n8631 0.075892857142857137
r15357 n8631 n8632 0.037946428571428568
r15358 n8632 n8633 0.060267857142857144
r15359 n8516 n8634 0.46944444444444444
r15360 n8633 n8634 0.046875
r15361 n8517 n8635 2.1124999999999998
r15362 n8634 n8635 0.024553571428571428
r15363 n8518 n8636 2.1124999999999998
r15364 n8635 n8636 0.0089285714285714281
r15365 n8519 n8637 0.52812499999999996
r15366 n8636 n8637 0.022321428571428572
r15367 n8520 n8638 0.19204545454545455
r15368 n8637 n8638 0.066964285714285712
r15369 n8521 n8639 4.2249999999999996
r15370 n8638 n8639 0.051339285714285712
r15371 n8522 n8640 4.2249999999999996
r15372 n8639 n8640 0.004464285714285714
r15373 n8523 n8641 4.2249999999999996
r15374 n8640 n8641 0.004464285714285714
r15375 n8524 n8642 0.42249999999999999
r15376 n8641 n8642 0.024553571428571428
r15377 n8525 n8643 0.42249999999999999
r15378 n8526 n8644 0.18369565217391304
r15379 n8643 n8644 0.073660714285714288
r15380 n8527 n8645 2.1124999999999998
r15381 n8644 n8645 0.055803571428571432
r15382 n8528 n8646 0.14083333333333334
r15383 n8645 n8646 0.071428571428571425
r15384 n8529 n8647 2.1124999999999998
r15385 n8646 n8647 0.071428571428571425
r15386 n8530 n8648 0.18369565217391304
r15387 n8647 n8648 0.055803571428571432
r15388 n8531 n8649 0.42249999999999999
r15389 n8648 n8649 0.073660714285714288
r15390 n8532 n8650 3.5
r15391 n8533 n8651 0.3888888888888889
r15392 n8650 n8651 0.022321428571428572
r15393 n8534 n8652 0.15217391304347827
r15394 n8651 n8652 0.071428571428571425
r15395 n8535 n8653 1.75
r15396 n8652 n8653 0.055803571428571432
r15397 n8536 n8654 0.11666666666666667
r15398 n8653 n8654 0.071428571428571425
r15399 n8537 n8655 1.75
r15400 n8654 n8655 0.071428571428571425
r15401 n8538 n8656 0.15217391304347827
r15402 n8655 n8656 0.055803571428571432
r15403 n8539 n8657 0.3888888888888889
r15404 n8656 n8657 0.071428571428571425
r15405 n8540 n8658 3.5
r15406 n8657 n8658 0.022321428571428572
r15407 n8541 n8659 0.5
r15408 n8542 n8660 1.75
r15409 n8659 n8660 0.020089285714285716
r15410 n8543 n8661 0.875
r15411 n8660 n8661 0.013392857142857142
r15412 n8544 n8662 0.3888888888888889
r15413 n8661 n8662 0.029017857142857144
r15414 n8545 n8663 0.16666666666666666
r15415 n8662 n8663 0.066964285714285712
r15416 n8546 n8664 1.75
r15417 n8663 n8664 0.051339285714285712
r15418 n8547 n8665 1.75
r15419 n8664 n8665 0.0089285714285714281
r15420 n8548 n8666 0.3888888888888889
r15421 n8665 n8666 0.024553571428571428
r15422 n8549 n8667 0.29166666666666669
r15423 n8666 n8667 0.046875
r15424 n8550 n8668 0.3888888888888889
r15425 n8667 n8668 0.046875
r15426 n8551 n8669 1.75
r15427 n8668 n8669 0.024553571428571428
r15428 n8552 n8670 1.75
r15429 n8669 n8670 0.0089285714285714281
r15430 n8553 n8671 0.16666666666666666
r15431 n8670 n8671 0.051339285714285712
r15432 n8554 n8672 0.23333333333333334
r15433 n8671 n8672 0.080357142857142863
r15434 n8555 n8673 1.75
r15435 n8672 n8673 0.037946428571428568
r15436 n8556 n8674 0.109375
r15437 n8673 n8674 0.075892857142857137
r15438 n8557 n8675 1.75
r15439 n8674 n8675 0.075892857142857137
r15440 n8558 n8676 0.29166666666666669
r15441 n8675 n8676 0.03125
r15442 n8559 n8677 0.875
r15443 n8676 n8677 0.035714285714285712
r15444 n8560 n8678 0.17499999999999999
r15445 n8677 n8678 0.053571428571428568
r15446 n8561 n8679 0.10294117647058823
r15447 n8678 n8679 0.12053571428571429
r15448 n8562 n8680 0.69999999999999996
r15449 n8679 n8680 0.087053571428571425
r15450 n8563 n8681 0.34999999999999998
r15451 n8680 n8681 0.033482142857142856
r15452 n8564 n8682 0.5
r15453 n8681 n8682 0.037946428571428568
r15454 n8565 n8683 1.1666666666666667
r15455 n8682 n8683 0.022321428571428572
r15456 n8566 n8684 1.1666666666666667
r15457 n8683 n8684 0.013392857142857142
r15458 n8567 n8685 1.75
r15459 n8684 n8685 0.011160714285714286
r15460 n8568 n8686 0.4375
r15461 n8685 n8686 0.022321428571428572
r15462 n8569 n8687 0.15909090909090909
r15463 n8686 n8687 0.066964285714285712
r15464 n8570 n8688 1.75
r15465 n8687 n8688 0.053571428571428568
r15466 n8571 n8689 1.1666666666666667
r15467 n8688 n8689 0.011160714285714286
r15468 n8572 n8690 1.1666666666666667
r15469 n8689 n8690 0.013392857142857142
r15470 n8573 n8691 0.875
r15471 n8690 n8691 0.015625
r15472 n8574 n8692 1.1666666666666667
r15473 n8691 n8692 0.015625
r15474 n8575 n8693 0.34999999999999998
r15475 n8692 n8693 0.029017857142857144
r15476 n8576 n8694 0.071428571428571425
r15477 n8693 n8694 0.13169642857142858
r15478 n8577 n8695 0.10294117647058823
r15479 n8694 n8695 0.18526785714285715
r15480 n8578 n8696 0.08254716981132075
r15481 n8695 n8696 0.17053571428571429
r15482 n8579 n8697 0.082159624413145546
r15483 n8696 n8697 0.18973214285714285
r15484 n8580 n8698 0.082159624413145546
r15485 n8697 n8698 0.19017857142857142
r15486 n8581 n8699 0.08254716981132075
r15487 n8698 n8699 0.18973214285714285
r15488 n8582 n8700 0.11666666666666667
r15489 n8699 n8700 0.16160714285714287
r15490 n8583 n8701 0.11666666666666667
r15491 n8700 n8701 0.13392857142857142
r15492 n8584 n8702 0.11666666666666667
r15493 n8701 n8702 0.13392857142857142
r15494 n8585 n8703 0.11666666666666667
r15495 n8702 n8703 0.13392857142857142
r15496 n8586 n8704 0.087499999999999994
r15497 n8703 n8704 0.15625
r15498 n8587 n8705 0.087499999999999994
r15499 n8704 n8705 0.17857142857142858
r15500 n8588 n8706 0.109375
r15501 n8705 n8706 0.16071428571428573
r15502 n8589 n8707 0.125
r15503 n8706 n8707 0.13392857142857142
r15504 n8590 n8708 0.125
r15505 n8707 n8708 0.125
r15506 n8591 n8709 0.109375
r15507 n8708 n8709 0.13392857142857142
r15508 n8592 n8710 0.13461538461538461
r15509 n8709 n8710 0.12946428571428573
r15510 n8593 n8711 0.13461538461538461
r15511 n8710 n8711 0.11607142857142858
r15512 n8594 n8712 0.10294117647058823
r15513 n8711 n8712 0.13392857142857142
r15514 n8595 n8713 0.11666666666666667
r15515 n8712 n8713 0.14285714285714285
r15516 n8596 n8714 0.11666666666666667
r15517 n8713 n8714 0.13392857142857142
r15518 n8597 n8715 0.10294117647058823
r15519 n8714 n8715 0.14285714285714285
r15520 n8598 n8716 0.14583333333333334
r15521 n8715 n8716 0.12946428571428573
r15522 n8599 n8717 0.875
r15523 n8716 n8717 0.0625
r15524 n8600 n8718 0.34999999999999998
r15525 n8717 n8718 0.03125
r15526 n8601 n8719 1.75
r15527 n8718 n8719 0.026785714285714284
r15528 n8602 n8720 0.109375
r15529 n8719 n8720 0.075892857142857137
r15530 n8603 n8721 1.75
r15531 n8720 n8721 0.075892857142857137
r15532 n8604 n8722 0.097222222222222224
r15533 n8721 n8722 0.084821428571428575
r15534 n8605 n8723 1.75
r15535 n8722 n8723 0.084821428571428575
r15536 n8606 n8724 0.109375
r15537 n8723 n8724 0.075892857142857137
r15538 n8607 n8725 1.75
r15539 n8724 n8725 0.075892857142857137
r15540 n8608 n8726 0.097222222222222224
r15541 n8725 n8726 0.084821428571428575
r15542 n8609 n8727 1.75
r15543 n8726 n8727 0.084821428571428575
r15544 n8610 n8728 0.109375
r15545 n8727 n8728 0.075892857142857137
r15546 n8611 n8729 1.75
r15547 n8728 n8729 0.075892857142857137
r15548 n8612 n8730 0.097222222222222224
r15549 n8729 n8730 0.084821428571428575
r15550 n8613 n8731 1.75
r15551 n8730 n8731 0.084821428571428575
r15552 n8614 n8732 0.109375
r15553 n8731 n8732 0.075892857142857137
r15554 n8615 n8733 1.75
r15555 n8732 n8733 0.075892857142857137
r15556 n8616 n8734 0.097222222222222224
r15557 n8733 n8734 0.084821428571428575
r15558 n8617 n8735 1.75
r15559 n8734 n8735 0.084821428571428575
r15560 n8618 n8736 0.109375
r15561 n8735 n8736 0.075892857142857137
r15562 n8619 n8737 1.75
r15563 n8736 n8737 0.075892857142857137
r15564 n8620 n8738 0.097222222222222224
r15565 n8737 n8738 0.084821428571428575
r15566 n8621 n8739 1.75
r15567 n8738 n8739 0.084821428571428575
r15568 n8622 n8740 0.109375
r15569 n8739 n8740 0.075892857142857137
r15570 n8623 n8741 1.75
r15571 n8740 n8741 0.075892857142857137
r15572 n8624 n8742 0.097222222222222224
r15573 n8741 n8742 0.084821428571428575
r15574 n8625 n8743 1.75
r15575 n8742 n8743 0.084821428571428575
r15576 n8626 n8744 0.109375
r15577 n8743 n8744 0.075892857142857137
r15578 n8627 n8745 1.75
r15579 n8744 n8745 0.075892857142857137
r15580 n8628 n8746 0.097222222222222224
r15581 n8745 n8746 0.084821428571428575
r15582 n8629 n8747 1.75
r15583 n8746 n8747 0.084821428571428575
r15584 n8630 n8748 0.109375
r15585 n8747 n8748 0.075892857142857137
r15586 n8631 n8749 1.75
r15587 n8748 n8749 0.075892857142857137
r15588 n8632 n8750 0.23333333333333334
r15589 n8749 n8750 0.037946428571428568
r15590 n8633 n8751 0.29166666666666669
r15591 n8750 n8751 0.060267857142857144
r15592 n8634 n8752 0.3888888888888889
r15593 n8751 n8752 0.046875
r15594 n8635 n8753 1.75
r15595 n8752 n8753 0.024553571428571428
r15596 n8636 n8754 1.75
r15597 n8753 n8754 0.0089285714285714281
r15598 n8637 n8755 0.4375
r15599 n8754 n8755 0.022321428571428572
r15600 n8638 n8756 0.15909090909090909
r15601 n8755 n8756 0.066964285714285712
r15602 n8639 n8757 3.5
r15603 n8756 n8757 0.051339285714285712
r15604 n8640 n8758 3.5
r15605 n8757 n8758 0.004464285714285714
r15606 n8641 n8759 3.5
r15607 n8758 n8759 0.004464285714285714
r15608 n8642 n8760 0.34999999999999998
r15609 n8759 n8760 0.024553571428571428
r15610 n8643 n8761 0.34999999999999998
r15611 n8644 n8762 0.15217391304347827
r15612 n8761 n8762 0.073660714285714288
r15613 n8645 n8763 1.75
r15614 n8762 n8763 0.055803571428571432
r15615 n8646 n8764 0.11666666666666667
r15616 n8763 n8764 0.071428571428571425
r15617 n8647 n8765 1.75
r15618 n8764 n8765 0.071428571428571425
r15619 n8648 n8766 0.15217391304347827
r15620 n8765 n8766 0.055803571428571432
r15621 n8649 n8767 0.34999999999999998
r15622 n8766 n8767 0.073660714285714288
r15623 n8650 n8768 4.0875000000000004
r15624 n8651 n8769 0.45416666666666666
r15625 n8768 n8769 0.016711229946524065
r15626 n8652 n8770 0.17771739130434783
r15627 n8769 n8770 0.053475935828877004
r15628 n8653 n8771 2.0437500000000002
r15629 n8770 n8771 0.041778074866310161
r15630 n8654 n8772 0.13625000000000001
r15631 n8771 n8772 0.053475935828877004
r15632 n8655 n8773 2.0437500000000002
r15633 n8772 n8773 0.053475935828877004
r15634 n8656 n8774 0.17771739130434783
r15635 n8773 n8774 0.041778074866310161
r15636 n8657 n8775 0.45416666666666666
r15637 n8774 n8775 0.053475935828877004
r15638 n8658 n8776 4.0875000000000004
r15639 n8775 n8776 0.016711229946524065
r15640 n8707 n8777 0.14598214285714287
r15641 n8708 n8778 0.14598214285714287
r15642 n8777 n8778 0.093582887700534759
r15643 n8761 n8779 0.40875
r15644 n8762 n8780 0.17771739130434783
r15645 n8779 n8780 0.05514705882352941
r15646 n8763 n8781 2.0437500000000002
r15647 n8780 n8781 0.041778074866310161
r15648 n8764 n8782 0.13625000000000001
r15649 n8781 n8782 0.053475935828877004
r15650 n8765 n8783 2.0437500000000002
r15651 n8782 n8783 0.053475935828877004
r15652 n8766 n8784 0.17771739130434783
r15653 n8783 n8784 0.041778074866310161
r15654 n8767 n8785 0.40875
r15655 n8784 n8785 0.05514705882352941
r15656 n8768 n8786 4.6624999999999996
r15657 n8769 n8787 0.5180555555555556
r15658 n8786 n8787 0.016801075268817203
r15659 n8770 n8788 0.20271739130434782
r15660 n8787 n8788 0.053763440860215055
r15661 n8771 n8789 2.3312499999999998
r15662 n8788 n8789 0.042002688172043008
r15663 n8772 n8790 0.15541666666666668
r15664 n8789 n8790 0.053763440860215055
r15665 n8773 n8791 2.3312499999999998
r15666 n8790 n8791 0.053763440860215055
r15667 n8774 n8792 0.20271739130434782
r15668 n8791 n8792 0.042002688172043008
r15669 n8775 n8793 0.5180555555555556
r15670 n8792 n8793 0.053763440860215055
r15671 n8776 n8794 4.6624999999999996
r15672 n8793 n8794 0.016801075268817203
r15673 n8777 n8795 0.16651785714285713
r15674 n8778 n8796 0.16651785714285713
r15675 n8795 n8796 0.094086021505376344
r15676 n8779 n8797 0.46625
r15677 n8780 n8798 0.20271739130434782
r15678 n8797 n8798 0.055443548387096774
r15679 n8781 n8799 2.3312499999999998
r15680 n8798 n8799 0.042002688172043008
r15681 n8782 n8800 0.15541666666666668
r15682 n8799 n8800 0.053763440860215055
r15683 n8783 n8801 2.3312499999999998
r15684 n8800 n8801 0.053763440860215055
r15685 n8784 n8802 0.20271739130434782
r15686 n8801 n8802 0.042002688172043008
r15687 n8785 n8803 0.46625
r15688 n8802 n8803 0.055443548387096774
r15689 n8786 n8804 4.6624999999999996
r15690 n8787 n8805 0.5180555555555556
r15691 n8804 n8805 0.016711229946524065
r15692 n8788 n8806 0.20271739130434782
r15693 n8805 n8806 0.053475935828877004
r15694 n8789 n8807 2.3312499999999998
r15695 n8806 n8807 0.041778074866310161
r15696 n8790 n8808 0.15541666666666668
r15697 n8807 n8808 0.053475935828877004
r15698 n8791 n8809 2.3312499999999998
r15699 n8808 n8809 0.053475935828877004
r15700 n8792 n8810 0.20271739130434782
r15701 n8809 n8810 0.041778074866310161
r15702 n8793 n8811 0.5180555555555556
r15703 n8810 n8811 0.053475935828877004
r15704 n8794 n8812 4.6624999999999996
r15705 n8811 n8812 0.016711229946524065
r15706 n8795 n8813 0.16651785714285713
r15707 n8796 n8814 0.16651785714285713
r15708 n8813 n8814 0.093582887700534759
r15709 n8797 n8815 0.46625
r15710 n8798 n8816 0.20271739130434782
r15711 n8815 n8816 0.05514705882352941
r15712 n8799 n8817 2.3312499999999998
r15713 n8816 n8817 0.041778074866310161
r15714 n8800 n8818 0.15541666666666668
r15715 n8817 n8818 0.053475935828877004
r15716 n8801 n8819 2.3312499999999998
r15717 n8818 n8819 0.053475935828877004
r15718 n8802 n8820 0.20271739130434782
r15719 n8819 n8820 0.041778074866310161
r15720 n8803 n8821 0.46625
r15721 n8820 n8821 0.05514705882352941
r15722 n8804 n8822 4.625
r15723 n8805 n8823 0.51388888888888884
r15724 n8822 n8823 0.017076502732240439
r15725 n8806 n8824 0.20108695652173914
r15726 n8823 n8824 0.054644808743169397
r15727 n8807 n8825 2.3125
r15728 n8824 n8825 0.042691256830601092
r15729 n8808 n8826 0.15416666666666667
r15730 n8825 n8826 0.054644808743169397
r15731 n8809 n8827 2.3125
r15732 n8826 n8827 0.054644808743169397
r15733 n8810 n8828 0.20108695652173914
r15734 n8827 n8828 0.042691256830601092
r15735 n8811 n8829 0.51388888888888884
r15736 n8828 n8829 0.054644808743169397
r15737 n8812 n8830 4.625
r15738 n8829 n8830 0.017076502732240439
r15739 n8813 out 0.16517857142857142
r15740 n8814 out 0.16517857142857142
r15741 n8815 n8835 0.46250000000000002
r15742 n8816 n8836 0.20108695652173914
r15743 n8835 n8836 0.056352459016393443
r15744 n8817 n8837 2.3125
r15745 n8836 n8837 0.042691256830601092
r15746 n8818 n8838 0.15416666666666667
r15747 n8837 n8838 0.054644808743169397
r15748 n8819 n8839 2.3125
r15749 n8838 n8839 0.054644808743169397
r15750 n8820 n8840 0.20108695652173914
r15751 n8839 n8840 0.042691256830601092
r15752 n8821 n8841 0.46250000000000002
r15753 n8840 n8841 0.056352459016393443
r15754 n8822 n8842 4.5875000000000004
r15755 n8823 n8843 0.50972222222222219
r15756 n8842 n8843 0.016983695652173912
r15757 n8824 n8844 0.19945652173913042
r15758 n8843 n8844 0.05434782608695652
r15759 n8825 n8845 2.2937500000000002
r15760 n8844 n8845 0.042459239130434784
r15761 n8826 n8846 0.15291666666666667
r15762 n8845 n8846 0.05434782608695652
r15763 n8827 n8847 2.2937500000000002
r15764 n8846 n8847 0.05434782608695652
r15765 n8828 n8848 0.19945652173913042
r15766 n8847 n8848 0.042459239130434784
r15767 n8829 n8849 0.50972222222222219
r15768 n8848 n8849 0.05434782608695652
r15769 n8830 n8850 4.5875000000000004
r15770 n8849 n8850 0.016983695652173912
r15771 n8835 n8855 0.45874999999999999
r15772 n8836 n8856 0.19945652173913042
r15773 n8855 n8856 0.056046195652173912
r15774 n8837 n8857 2.2937500000000002
r15775 n8856 n8857 0.042459239130434784
r15776 n8838 n8858 0.15291666666666667
r15777 n8857 n8858 0.05434782608695652
r15778 n8839 n8859 2.2937500000000002
r15779 n8858 n8859 0.05434782608695652
r15780 n8840 n8860 0.19945652173913042
r15781 n8859 n8860 0.042459239130434784
r15782 n8841 n8861 0.45874999999999999
r15783 n8860 n8861 0.056046195652173912
r15784 n8842 n8862 4.5875000000000004
r15785 n8843 n8863 0.50972222222222219
r15786 n8862 n8863 0.017076502732240439
r15787 n8844 n8864 0.19945652173913042
r15788 n8863 n8864 0.054644808743169397
r15789 n8845 n8865 2.2937500000000002
r15790 n8864 n8865 0.042691256830601092
r15791 n8846 n8866 0.15291666666666667
r15792 n8865 n8866 0.054644808743169397
r15793 n8847 n8867 2.2937500000000002
r15794 n8866 n8867 0.054644808743169397
r15795 n8848 n8868 0.19945652173913042
r15796 n8867 n8868 0.042691256830601092
r15797 n8849 n8869 0.50972222222222219
r15798 n8868 n8869 0.054644808743169397
r15799 n8850 n8870 4.5875000000000004
r15800 n8869 n8870 0.017076502732240439
r15801 n8855 n8875 0.45874999999999999
r15802 n8856 n8876 0.19945652173913042
r15803 n8875 n8876 0.056352459016393443
r15804 n8857 n8877 2.2937500000000002
r15805 n8876 n8877 0.042691256830601092
r15806 n8858 n8878 0.15291666666666667
r15807 n8877 n8878 0.054644808743169397
r15808 n8859 n8879 2.2937500000000002
r15809 n8878 n8879 0.054644808743169397
r15810 n8860 n8880 0.19945652173913042
r15811 n8879 n8880 0.042691256830601092
r15812 n8861 n8881 0.45874999999999999
r15813 n8880 n8881 0.056352459016393443
r15814 in n8902 0.043083333333333335
r15815 in n8903 0.043083333333333335
r15816 n8902 n8903 0.040285714285714286
r15817 n8902 n8904 0.054833333333333331
r15818 n8903 n8905 0.054833333333333331
r15819 n8904 n8905 0.040285714285714286
r15820 n8906 n8907 0.0078333333333333328
r15821 n8907 n8908 0.0046999999999999993
r15822 n8908 n8909 0.0039166666666666664
r15823 n8909 n8910 0.0078333333333333328
r15824 n8910 n8911 0.0235
r15825 n8911 n8912 0.018799999999999997
r15826 n8912 n8913 0.0039166666666666664
r15827 n8913 n8914 0.0046999999999999993
r15828 n8914 n8915 0.0054833333333333331
r15829 n8915 n8916 0.0054833333333333331
r15830 n8916 n8917 0.010183333333333334
r15831 n8917 n8918 0.04621666666666667
r15832 n8918 n8919 0.065016666666666667
r15833 n8919 n8920 0.059846666666666666
r15834 n8920 n8921 0.066583333333333342
r15835 n8921 n8922 0.066739999999999994
r15836 n8922 n8923 0.066583333333333342
r15837 n8923 n8924 0.056713333333333331
r15838 n8904 n8925 0.050916666666666666
r15839 n8924 n8925 0.047
r15840 n8905 n8926 0.050916666666666666
r15841 n8925 n8926 0.047
r15842 n8926 n8927 0.047
r15843 n8927 n8928 0.054833333333333331
r15844 n8928 n8929 0.062666666666666662
r15845 n8929 n8930 0.056400000000000006
r15846 n8930 n8931 0.047
r15847 n8931 n8932 0.043866666666666665
r15848 n8932 n8933 0.047
r15849 n8933 n8934 0.045433333333333333
r15850 n8934 n8935 0.040733333333333337
r15851 n8935 n8936 0.047
r15852 n8936 n8937 0.050133333333333328
r15853 n8937 n8938 0.047
r15854 n8938 n8939 0.050133333333333328
r15855 n8939 n8940 0.045433333333333333
r15856 n8940 n8941 0.021933333333333332
r15857 n8941 n8942 0.010966666666666666
r15858 n8942 n8943 0.0093999999999999986
r15859 n8943 n8944 0.026633333333333335
r15860 n8944 n8945 0.026633333333333335
r15861 n8945 n8946 0.029766666666666667
r15862 n8946 n8947 0.029766666666666667
r15863 n8947 n8948 0.026633333333333335
r15864 n8948 n8949 0.026633333333333335
r15865 n8949 n8950 0.029766666666666667
r15866 n8950 n8951 0.029766666666666667
r15867 n8951 n8952 0.026633333333333335
r15868 n8952 n8953 0.026633333333333335
r15869 n8953 n8954 0.029766666666666667
r15870 n8954 n8955 0.029766666666666667
r15871 n8955 n8956 0.026633333333333335
r15872 n8956 n8957 0.026633333333333335
r15873 n8957 n8958 0.029766666666666667
r15874 n8958 n8959 0.029766666666666667
r15875 n8959 n8960 0.026633333333333335
r15876 n8960 n8961 0.026633333333333335
r15877 n8961 n8962 0.029766666666666667
r15878 n8962 n8963 0.029766666666666667
r15879 n8963 n8964 0.026633333333333335
r15880 n8964 n8965 0.026633333333333335
r15881 n8965 n8966 0.029766666666666667
r15882 n8966 n8967 0.029766666666666667
r15883 n8967 n8968 0.026633333333333335
r15884 n8968 n8969 0.026633333333333335
r15885 n8969 n8970 0.029766666666666667
r15886 n8970 n8971 0.029766666666666667
r15887 n8971 n8972 0.026633333333333335
r15888 n8972 n8973 0.026633333333333335
r15889 n8973 n8974 0.013316666666666668
r15890 n8974 n8975 0.021149999999999999
r15891 n8975 n8976 0.016449999999999999
r15892 n8976 n8977 0.0086166666666666666
r15893 n8977 n8978 0.003133333333333333
r15894 n8978 n8979 0.0078333333333333328
r15895 n8979 n8980 0.0235
r15896 n8980 n8981 0.018016666666666667
r15897 n8981 n8982 0.0015666666666666665
r15898 n8982 n8983 0.0015666666666666665
r15899 n8983 n8984 0.0086166666666666666
r15900 n8984 n8985 0.017233333333333333
r15901 n8985 n8986 0.015666666666666666
r15902 n8986 n8987 0.0078333333333333328
r15903 n8987 n8988 0.0039166666666666664
r15904 n8988 n8989 0.0039166666666666664
r15905 n8989 n8990 0.006266666666666666
r15906 n8990 n8991 0.014100000000000001
r15907 n8991 n8992 0.020366666666666668
r15908 n8992 n8993 0.012533333333333332
r15909 n8993 n8994 0.029766666666666667
r15910 n8994 n8995 0.029766666666666667
r15911 n8995 n8996 0.026633333333333335
r15912 n8996 n8997 0.026633333333333335
r15913 n8997 n8998 0.029766666666666667
r15914 n8998 n8999 0.029766666666666667
r15915 n8999 n9000 0.026633333333333335
r15916 n9000 n9001 0.026633333333333335
r15917 n9001 n9002 0.029766666666666667
r15918 n9002 n9003 0.029766666666666667
r15919 n9003 n9004 0.026633333333333335
r15920 n9004 n9005 0.026633333333333335
r15921 n9005 n9006 0.029766666666666667
r15922 n9006 n9007 0.029766666666666667
r15923 n9007 n9008 0.026633333333333335
r15924 n9008 n9009 0.026633333333333335
r15925 n9009 n9010 0.029766666666666667
r15926 n9010 n9011 0.029766666666666667
r15927 n9011 n9012 0.026633333333333335
r15928 n9012 n9013 0.026633333333333335
r15929 n9013 n9014 0.029766666666666667
r15930 n9014 n9015 0.029766666666666667
r15931 n9015 n9016 0.026633333333333335
r15932 n9016 n9017 0.026633333333333335
r15933 n9017 n9018 0.029766666666666667
r15934 n9018 n9019 0.029766666666666667
r15935 n9019 n9020 0.026633333333333335
r15936 n9020 n9021 0.026633333333333335
r15937 n9021 n9022 0.010966666666666666
r15938 n9022 n9023 0.012533333333333332
r15939 n9023 n9024 0.018799999999999997
r15940 n9024 n9025 0.042299999999999997
r15941 n9025 n9026 0.028200000000000003
r15942 n9026 n9027 0.0093999999999999986
r15943 n9027 n9028 0.013316666666666668
r15944 n9028 n9029 0.0078333333333333328
r15945 n9029 n9030 0.0046999999999999993
r15946 n9030 n9031 0.0039166666666666664
r15947 n9031 n9032 0.010183333333333334
r15948 n9032 n9033 0.0235
r15949 n9033 n9034 0.016449999999999999
r15950 n9034 n9035 0.0039166666666666664
r15951 n9035 n9036 0.0046999999999999993
r15952 n9036 n9037 0.0078333333333333328
r15953 n8906 n9038 0.20142857142857143
r15954 n8907 n9039 0.46999999999999997
r15955 n9038 n9039 0.0078333333333333328
r15956 n8908 n9040 0.46999999999999997
r15957 n9039 n9040 0.0046999999999999993
r15958 n8909 n9041 0.70499999999999996
r15959 n9040 n9041 0.0039166666666666664
r15960 n8910 n9042 0.17624999999999999
r15961 n9041 n9042 0.0078333333333333328
r15962 n8911 n9043 0.064090909090909087
r15963 n9042 n9043 0.0235
r15964 n8912 n9044 0.70499999999999996
r15965 n9043 n9044 0.018799999999999997
r15966 n8913 n9045 0.46999999999999997
r15967 n9044 n9045 0.0039166666666666664
r15968 n8914 n9046 0.46999999999999997
r15969 n9045 n9046 0.0046999999999999993
r15970 n8915 n9047 0.35249999999999998
r15971 n9046 n9047 0.0054833333333333331
r15972 n8916 n9048 0.46999999999999997
r15973 n9047 n9048 0.0054833333333333331
r15974 n8917 n9049 0.14099999999999999
r15975 n9048 n9049 0.010183333333333334
r15976 n8918 n9050 0.028775510204081631
r15977 n9049 n9050 0.04621666666666667
r15978 n8919 n9051 0.041470588235294113
r15979 n9050 n9051 0.065016666666666667
r15980 n8920 n9052 0.033254716981132075
r15981 n9051 n9052 0.059846666666666666
r15982 n8921 n9053 0.033098591549295772
r15983 n9052 n9053 0.066583333333333342
r15984 n8922 n9054 0.033098591549295772
r15985 n9053 n9054 0.066739999999999994
r15986 n8923 n9055 0.033254716981132075
r15987 n9054 n9055 0.066583333333333342
r15988 n8924 n9056 0.047
r15989 n9055 n9056 0.056713333333333331
r15990 n8925 n9057 0.047
r15991 n9056 n9057 0.047
r15992 n8926 n9058 0.047
r15993 n9057 n9058 0.047
r15994 n8927 n9059 0.047
r15995 n9058 n9059 0.047
r15996 n8928 n9060 0.035249999999999997
r15997 n9059 n9060 0.054833333333333331
r15998 n8929 n9061 0.035249999999999997
r15999 n9060 n9061 0.062666666666666662
r16000 n8930 n9062 0.044062499999999998
r16001 n9061 n9062 0.056400000000000006
r16002 n8931 n9063 0.050357142857142857
r16003 n9062 n9063 0.047
r16004 n8932 n9064 0.050357142857142857
r16005 n9063 n9064 0.043866666666666665
r16006 n8933 n9065 0.044062499999999998
r16007 n9064 n9065 0.047
r16008 n8934 n9066 0.054230769230769228
r16009 n9065 n9066 0.045433333333333333
r16010 n8935 n9067 0.054230769230769228
r16011 n9066 n9067 0.040733333333333337
r16012 n8936 n9068 0.041470588235294113
r16013 n9067 n9068 0.047
r16014 n8937 n9069 0.047
r16015 n9068 n9069 0.050133333333333328
r16016 n8938 n9070 0.047
r16017 n9069 n9070 0.047
r16018 n8939 n9071 0.041470588235294113
r16019 n9070 n9071 0.050133333333333328
r16020 n8940 n9072 0.058749999999999997
r16021 n9071 n9072 0.045433333333333333
r16022 n8941 n9073 0.35249999999999998
r16023 n9072 n9073 0.021933333333333332
r16024 n8942 n9074 0.14099999999999999
r16025 n9073 n9074 0.010966666666666666
r16026 n8943 n9075 0.70499999999999996
r16027 n9074 n9075 0.0093999999999999986
r16028 n8944 n9076 0.044062499999999998
r16029 n9075 n9076 0.026633333333333335
r16030 n8945 n9077 0.70499999999999996
r16031 n9076 n9077 0.026633333333333335
r16032 n8946 n9078 0.039166666666666669
r16033 n9077 n9078 0.029766666666666667
r16034 n8947 n9079 0.70499999999999996
r16035 n9078 n9079 0.029766666666666667
r16036 n8948 n9080 0.044062499999999998
r16037 n9079 n9080 0.026633333333333335
r16038 n8949 n9081 0.70499999999999996
r16039 n9080 n9081 0.026633333333333335
r16040 n8950 n9082 0.039166666666666669
r16041 n9081 n9082 0.029766666666666667
r16042 n8951 n9083 0.70499999999999996
r16043 n9082 n9083 0.029766666666666667
r16044 n8952 n9084 0.044062499999999998
r16045 n9083 n9084 0.026633333333333335
r16046 n8953 n9085 0.70499999999999996
r16047 n9084 n9085 0.026633333333333335
r16048 n8954 n9086 0.039166666666666669
r16049 n9085 n9086 0.029766666666666667
r16050 n8955 n9087 0.70499999999999996
r16051 n9086 n9087 0.029766666666666667
r16052 n8956 n9088 0.044062499999999998
r16053 n9087 n9088 0.026633333333333335
r16054 n8957 n9089 0.70499999999999996
r16055 n9088 n9089 0.026633333333333335
r16056 n8958 n9090 0.039166666666666669
r16057 n9089 n9090 0.029766666666666667
r16058 n8959 n9091 0.70499999999999996
r16059 n9090 n9091 0.029766666666666667
r16060 n8960 n9092 0.044062499999999998
r16061 n9091 n9092 0.026633333333333335
r16062 n8961 n9093 0.70499999999999996
r16063 n9092 n9093 0.026633333333333335
r16064 n8962 n9094 0.039166666666666669
r16065 n9093 n9094 0.029766666666666667
r16066 n8963 n9095 0.70499999999999996
r16067 n9094 n9095 0.029766666666666667
r16068 n8964 n9096 0.044062499999999998
r16069 n9095 n9096 0.026633333333333335
r16070 n8965 n9097 0.70499999999999996
r16071 n9096 n9097 0.026633333333333335
r16072 n8966 n9098 0.039166666666666669
r16073 n9097 n9098 0.029766666666666667
r16074 n8967 n9099 0.70499999999999996
r16075 n9098 n9099 0.029766666666666667
r16076 n8968 n9100 0.044062499999999998
r16077 n9099 n9100 0.026633333333333335
r16078 n8969 n9101 0.70499999999999996
r16079 n9100 n9101 0.026633333333333335
r16080 n8970 n9102 0.039166666666666669
r16081 n9101 n9102 0.029766666666666667
r16082 n8971 n9103 0.70499999999999996
r16083 n9102 n9103 0.029766666666666667
r16084 n8972 n9104 0.044062499999999998
r16085 n9103 n9104 0.026633333333333335
r16086 n8973 n9105 0.70499999999999996
r16087 n9104 n9105 0.026633333333333335
r16088 n8974 n9106 0.094
r16089 n9105 n9106 0.013316666666666668
r16090 n8975 n9107 0.11749999999999999
r16091 n9106 n9107 0.021149999999999999
r16092 n8976 n9108 0.15666666666666668
r16093 n9107 n9108 0.016449999999999999
r16094 n8977 n9109 0.70499999999999996
r16095 n9108 n9109 0.0086166666666666666
r16096 n8978 n9110 0.70499999999999996
r16097 n9109 n9110 0.003133333333333333
r16098 n8979 n9111 0.17624999999999999
r16099 n9110 n9111 0.0078333333333333328
r16100 n8980 n9112 0.064090909090909087
r16101 n9111 n9112 0.0235
r16102 n8981 n9113 1.4099999999999999
r16103 n9112 n9113 0.018016666666666667
r16104 n8982 n9114 1.4099999999999999
r16105 n9113 n9114 0.0015666666666666665
r16106 n8983 n9115 1.4099999999999999
r16107 n9114 n9115 0.0015666666666666665
r16108 n8984 n9116 0.14099999999999999
r16109 n9115 n9116 0.0086166666666666666
r16110 n8985 n9117 0.11749999999999999
r16111 n9116 n9117 0.017233333333333333
r16112 n8986 n9118 0.17624999999999999
r16113 n9117 n9118 0.015666666666666666
r16114 n8987 n9119 0.70499999999999996
r16115 n9118 n9119 0.0078333333333333328
r16116 n8988 n9120 0.46999999999999997
r16117 n9119 n9120 0.0039166666666666664
r16118 n8989 n9121 0.70499999999999996
r16119 n9120 n9121 0.0039166666666666664
r16120 n8990 n9122 0.23499999999999999
r16121 n9121 n9122 0.006266666666666666
r16122 n8991 n9123 0.11749999999999999
r16123 n9122 n9123 0.014100000000000001
r16124 n8992 n9124 0.10071428571428571
r16125 n9123 n9124 0.020366666666666668
r16126 n8993 n9125 0.70499999999999996
r16127 n9124 n9125 0.012533333333333332
r16128 n8994 n9126 0.039166666666666669
r16129 n9125 n9126 0.029766666666666667
r16130 n8995 n9127 0.70499999999999996
r16131 n9126 n9127 0.029766666666666667
r16132 n8996 n9128 0.044062499999999998
r16133 n9127 n9128 0.026633333333333335
r16134 n8997 n9129 0.70499999999999996
r16135 n9128 n9129 0.026633333333333335
r16136 n8998 n9130 0.039166666666666669
r16137 n9129 n9130 0.029766666666666667
r16138 n8999 n9131 0.70499999999999996
r16139 n9130 n9131 0.029766666666666667
r16140 n9000 n9132 0.044062499999999998
r16141 n9131 n9132 0.026633333333333335
r16142 n9001 n9133 0.70499999999999996
r16143 n9132 n9133 0.026633333333333335
r16144 n9002 n9134 0.039166666666666669
r16145 n9133 n9134 0.029766666666666667
r16146 n9003 n9135 0.70499999999999996
r16147 n9134 n9135 0.029766666666666667
r16148 n9004 n9136 0.044062499999999998
r16149 n9135 n9136 0.026633333333333335
r16150 n9005 n9137 0.70499999999999996
r16151 n9136 n9137 0.026633333333333335
r16152 n9006 n9138 0.039166666666666669
r16153 n9137 n9138 0.029766666666666667
r16154 n9007 n9139 0.70499999999999996
r16155 n9138 n9139 0.029766666666666667
r16156 n9008 n9140 0.044062499999999998
r16157 n9139 n9140 0.026633333333333335
r16158 n9009 n9141 0.70499999999999996
r16159 n9140 n9141 0.026633333333333335
r16160 n9010 n9142 0.039166666666666669
r16161 n9141 n9142 0.029766666666666667
r16162 n9011 n9143 0.70499999999999996
r16163 n9142 n9143 0.029766666666666667
r16164 n9012 n9144 0.044062499999999998
r16165 n9143 n9144 0.026633333333333335
r16166 n9013 n9145 0.70499999999999996
r16167 n9144 n9145 0.026633333333333335
r16168 n9014 n9146 0.039166666666666669
r16169 n9145 n9146 0.029766666666666667
r16170 n9015 n9147 0.70499999999999996
r16171 n9146 n9147 0.029766666666666667
r16172 n9016 n9148 0.044062499999999998
r16173 n9147 n9148 0.026633333333333335
r16174 n9017 n9149 0.70499999999999996
r16175 n9148 n9149 0.026633333333333335
r16176 n9018 n9150 0.039166666666666669
r16177 n9149 n9150 0.029766666666666667
r16178 n9019 n9151 0.70499999999999996
r16179 n9150 n9151 0.029766666666666667
r16180 n9020 n9152 0.044062499999999998
r16181 n9151 n9152 0.026633333333333335
r16182 n9021 n9153 0.70499999999999996
r16183 n9152 n9153 0.026633333333333335
r16184 n9022 n9154 0.11749999999999999
r16185 n9153 n9154 0.010966666666666666
r16186 n9023 n9155 0.35249999999999998
r16187 n9154 n9155 0.012533333333333332
r16188 n9024 n9156 0.070499999999999993
r16189 n9155 n9156 0.018799999999999997
r16190 n9025 n9157 0.041470588235294113
r16191 n9156 n9157 0.042299999999999997
r16192 n9026 n9158 0.70499999999999996
r16193 n9157 n9158 0.028200000000000003
r16194 n9027 n9159 0.14099999999999999
r16195 n9158 n9159 0.0093999999999999986
r16196 n9028 n9160 0.20142857142857143
r16197 n9159 n9160 0.013316666666666668
r16198 n9029 n9161 0.46999999999999997
r16199 n9160 n9161 0.0078333333333333328
r16200 n9030 n9162 0.46999999999999997
r16201 n9161 n9162 0.0046999999999999993
r16202 n9031 n9163 0.70499999999999996
r16203 n9162 n9163 0.0039166666666666664
r16204 n9032 n9164 0.12818181818181817
r16205 n9163 n9164 0.010183333333333334
r16206 n9033 n9165 0.074210526315789477
r16207 n9164 n9165 0.0235
r16208 n9034 n9166 0.70499999999999996
r16209 n9165 n9166 0.016449999999999999
r16210 n9035 n9167 0.46999999999999997
r16211 n9166 n9167 0.0039166666666666664
r16212 n9036 n9168 0.46999999999999997
r16213 n9167 n9168 0.0046999999999999993
r16214 n9037 n9169 0.20142857142857143
r16215 n9168 n9169 0.0078333333333333328
r16216 n9038 n9170 0.22157142857142856
r16217 n9039 n9171 0.51700000000000002
r16218 n9170 n9171 0.0065277777777777782
r16219 n9040 n9172 0.51700000000000002
r16220 n9171 n9172 0.0039166666666666664
r16221 n9041 n9173 0.77549999999999997
r16222 n9172 n9173 0.0032638888888888891
r16223 n9042 n9174 0.19387499999999999
r16224 n9173 n9174 0.0065277777777777782
r16225 n9043 n9175 0.070499999999999993
r16226 n9174 n9175 0.019583333333333335
r16227 n9044 n9176 0.77549999999999997
r16228 n9175 n9176 0.015666666666666666
r16229 n9045 n9177 0.51700000000000002
r16230 n9176 n9177 0.0032638888888888891
r16231 n9046 n9178 0.51700000000000002
r16232 n9177 n9178 0.0039166666666666664
r16233 n9047 n9179 0.38774999999999998
r16234 n9178 n9179 0.0045694444444444446
r16235 n9048 n9180 0.51700000000000002
r16236 n9179 n9180 0.0045694444444444446
r16237 n9160 n9181 0.22157142857142856
r16238 n9161 n9182 0.51700000000000002
r16239 n9181 n9182 0.0065277777777777782
r16240 n9162 n9183 0.51700000000000002
r16241 n9182 n9183 0.0039166666666666664
r16242 n9163 n9184 0.77549999999999997
r16243 n9183 n9184 0.0032638888888888891
r16244 n9164 n9185 0.14099999999999999
r16245 n9184 n9185 0.0084861111111111109
r16246 n9165 n9186 0.081631578947368416
r16247 n9185 n9186 0.019583333333333335
r16248 n9166 n9187 0.77549999999999997
r16249 n9186 n9187 0.013708333333333333
r16250 n9167 n9188 0.51700000000000002
r16251 n9187 n9188 0.0032638888888888891
r16252 n9168 n9189 0.51700000000000002
r16253 n9188 n9189 0.0039166666666666664
r16254 n9169 n9190 0.22157142857142856
r16255 n9189 n9190 0.0065277777777777782
r16256 n9170 n9191 0.24171428571428574
r16257 n9171 n9192 0.56400000000000006
r16258 n9191 n9192 0.0065277777777777782
r16259 n9172 n9193 0.56400000000000006
r16260 n9192 n9193 0.0039166666666666664
r16261 n9173 n9194 0.84600000000000009
r16262 n9193 n9194 0.0032638888888888891
r16263 n9174 n9195 0.21150000000000002
r16264 n9194 n9195 0.0065277777777777782
r16265 n9175 n9196 0.076909090909090913
r16266 n9195 n9196 0.019583333333333335
r16267 n9176 n9197 0.84600000000000009
r16268 n9196 n9197 0.015666666666666666
r16269 n9177 n9198 0.56400000000000006
r16270 n9197 n9198 0.0032638888888888891
r16271 n9178 n9199 0.56400000000000006
r16272 n9198 n9199 0.0039166666666666664
r16273 n9179 n9200 0.42300000000000004
r16274 n9199 n9200 0.0045694444444444446
r16275 n9180 n9201 0.56400000000000006
r16276 n9200 n9201 0.0045694444444444446
r16277 n9181 n9202 0.24171428571428574
r16278 n9182 n9203 0.56400000000000006
r16279 n9202 n9203 0.0065277777777777782
r16280 n9183 n9204 0.56400000000000006
r16281 n9203 n9204 0.0039166666666666664
r16282 n9184 n9205 0.84600000000000009
r16283 n9204 n9205 0.0032638888888888891
r16284 n9185 n9206 0.15381818181818183
r16285 n9205 n9206 0.0084861111111111109
r16286 n9186 n9207 0.089052631578947383
r16287 n9206 n9207 0.019583333333333335
r16288 n9187 n9208 0.84600000000000009
r16289 n9207 n9208 0.013708333333333333
r16290 n9188 n9209 0.56400000000000006
r16291 n9208 n9209 0.0032638888888888891
r16292 n9189 n9210 0.56400000000000006
r16293 n9209 n9210 0.0039166666666666664
r16294 n9190 n9211 0.24171428571428574
r16295 n9210 n9211 0.0065277777777777782
r16296 n9191 n9212 0.21485714285714286
r16297 n9192 n9213 0.5013333333333333
r16298 n9212 n9213 0.0083928571428571429
r16299 n9193 n9214 0.5013333333333333
r16300 n9213 n9214 0.0050357142857142857
r16301 n9194 n9215 0.752
r16302 n9214 n9215 0.0041964285714285714
r16303 n9195 n9216 0.188
r16304 n9215 n9216 0.0083928571428571429
r16305 n9196 n9217 0.068363636363636363
r16306 n9216 n9217 0.025178571428571429
r16307 n9197 n9218 0.752
r16308 n9217 n9218 0.020142857142857143
r16309 n9198 n9219 0.5013333333333333
r16310 n9218 n9219 0.0041964285714285714
r16311 n9199 n9220 0.5013333333333333
r16312 n9219 n9220 0.0050357142857142857
r16313 n9200 n9221 0.376
r16314 n9220 n9221 0.005875
r16315 n9201 n9222 0.5013333333333333
r16316 n9221 n9222 0.005875
r16317 n9202 n9223 0.21485714285714286
r16318 n9203 n9224 0.5013333333333333
r16319 n9223 n9224 0.0083928571428571429
r16320 n9204 n9225 0.5013333333333333
r16321 n9224 n9225 0.0050357142857142857
r16322 n9205 n9226 0.752
r16323 n9225 n9226 0.0041964285714285714
r16324 n9206 n9227 0.13672727272727273
r16325 n9226 n9227 0.010910714285714286
r16326 n9207 n9228 0.079157894736842108
r16327 n9227 n9228 0.025178571428571429
r16328 n9208 n9229 0.752
r16329 n9228 n9229 0.017624999999999998
r16330 n9209 n9230 0.5013333333333333
r16331 n9229 n9230 0.0041964285714285714
r16332 n9210 n9231 0.5013333333333333
r16333 n9230 n9231 0.0050357142857142857
r16334 n9211 n9232 0.21485714285714286
r16335 n9231 n9232 0.0083928571428571429
r16336 n9212 n9233 0.188
r16337 n9213 n9234 0.43866666666666665
r16338 n9233 n9234 0.0083928571428571429
r16339 n9214 n9235 0.43866666666666665
r16340 n9234 n9235 0.0050357142857142857
r16341 n9215 n9236 0.65800000000000003
r16342 n9235 n9236 0.0041964285714285714
r16343 n9216 n9237 0.16450000000000001
r16344 n9236 n9237 0.0083928571428571429
r16345 n9217 n9238 0.059818181818181819
r16346 n9237 n9238 0.025178571428571429
r16347 n9218 n9239 0.65800000000000003
r16348 n9238 n9239 0.020142857142857143
r16349 n9219 n9240 0.43866666666666665
r16350 n9239 n9240 0.0041964285714285714
r16351 n9220 n9241 0.43866666666666665
r16352 n9240 n9241 0.0050357142857142857
r16353 n9221 n9242 0.32900000000000001
r16354 n9241 n9242 0.005875
r16355 n9222 n9243 0.43866666666666665
r16356 n9242 n9243 0.005875
r16357 n9223 n9244 0.188
r16358 n9224 n9245 0.43866666666666665
r16359 n9244 n9245 0.0083928571428571429
r16360 n9225 n9246 0.43866666666666665
r16361 n9245 n9246 0.0050357142857142857
r16362 n9226 n9247 0.65800000000000003
r16363 n9246 n9247 0.0041964285714285714
r16364 n9227 n9248 0.11963636363636364
r16365 n9247 n9248 0.010910714285714286
r16366 n9228 n9249 0.069263157894736846
r16367 n9248 n9249 0.025178571428571429
r16368 n9229 n9250 0.65800000000000003
r16369 n9249 n9250 0.017624999999999998
r16370 n9230 n9251 0.43866666666666665
r16371 n9250 n9251 0.0041964285714285714
r16372 n9231 n9252 0.43866666666666665
r16373 n9251 n9252 0.0050357142857142857
r16374 n9232 n9253 0.188
r16375 n9252 n9253 0.0083928571428571429
r16376 n9233 n9254 0.24842857142857144
r16377 n9234 n9255 0.57966666666666666
r16378 n9254 n9255 0.0051086956521739129
r16379 n9235 n9256 0.57966666666666666
r16380 n9255 n9256 0.0030652173913043477
r16381 n9236 n9257 0.86950000000000005
r16382 n9256 n9257 0.0025543478260869564
r16383 n9237 n9258 0.21737500000000001
r16384 n9257 n9258 0.0051086956521739129
r16385 n9238 n9259 0.079045454545454544
r16386 n9258 n9259 0.015326086956521739
r16387 n9239 n9260 0.86950000000000005
r16388 n9259 n9260 0.012260869565217391
r16389 n9240 n9261 0.57966666666666666
r16390 n9260 n9261 0.0025543478260869564
r16391 n9241 n9262 0.57966666666666666
r16392 n9261 n9262 0.0030652173913043477
r16393 n9242 n9263 0.43475000000000003
r16394 n9262 n9263 0.003576086956521739
r16395 n9243 n9264 0.57966666666666666
r16396 n9263 n9264 0.003576086956521739
r16397 n9244 n9265 0.24842857142857144
r16398 n9245 n9266 0.57966666666666666
r16399 n9265 n9266 0.0051086956521739129
r16400 n9246 n9267 0.57966666666666666
r16401 n9266 n9267 0.0030652173913043477
r16402 n9247 n9268 0.86950000000000005
r16403 n9267 n9268 0.0025543478260869564
r16404 n9248 n9269 0.15809090909090909
r16405 n9268 n9269 0.0066413043478260872
r16406 n9249 n9270 0.091526315789473692
r16407 n9269 n9270 0.015326086956521739
r16408 n9250 n9271 0.86950000000000005
r16409 n9270 n9271 0.010728260869565217
r16410 n9251 n9272 0.57966666666666666
r16411 n9271 n9272 0.0025543478260869564
r16412 n9252 n9273 0.57966666666666666
r16413 n9272 n9273 0.0030652173913043477
r16414 n9253 n9274 0.24842857142857144
r16415 n9273 n9274 0.0051086956521739129
r16416 n9254 n9275 0.16114285714285714
r16417 n9255 n9276 0.376
r16418 n9275 n9276 0.11750000000000001
r16419 n9256 n9277 0.376
r16420 n9276 n9277 0.070499999999999993
r16421 n9257 n9278 0.56399999999999995
r16422 n9277 n9278 0.058750000000000004
r16423 n9258 n9279 0.14099999999999999
r16424 n9278 n9279 0.11750000000000001
r16425 n9259 n9280 0.051272727272727268
r16426 n9279 n9280 0.35249999999999998
r16427 n9260 n9281 0.56399999999999995
r16428 n9280 n9281 0.28199999999999997
r16429 n9261 n9282 0.376
r16430 n9281 n9282 0.058750000000000004
r16431 n9262 n9283 0.376
r16432 n9282 n9283 0.070499999999999993
r16433 n9263 n9284 0.28199999999999997
r16434 n9283 n9284 0.082250000000000004
r16435 n9264 n9285 0.376
r16436 n9284 n9285 0.082250000000000004
r16437 n9265 n9286 0.16114285714285714
r16438 n9266 n9287 0.376
r16439 n9286 n9287 0.11750000000000001
r16440 n9267 n9288 0.376
r16441 n9287 n9288 0.070499999999999993
r16442 n9268 n9289 0.56399999999999995
r16443 n9288 n9289 0.058750000000000004
r16444 n9269 n9290 0.10254545454545454
r16445 n9289 n9290 0.15275
r16446 n9270 n9291 0.059368421052631577
r16447 n9290 n9291 0.35249999999999998
r16448 n9271 n9292 0.56399999999999995
r16449 n9291 n9292 0.24674999999999997
r16450 n9272 n9293 0.376
r16451 n9292 n9293 0.058750000000000004
r16452 n9273 n9294 0.376
r16453 n9293 n9294 0.070499999999999993
r16454 n9274 n9295 0.16114285714285714
r16455 n9294 n9295 0.11750000000000001
r16456 n9275 n9296 0.043642857142857143
r16457 n9276 n9297 0.10183333333333335
r16458 n9296 n9297 0.021363636363636366
r16459 n9277 n9298 0.10183333333333335
r16460 n9297 n9298 0.012818181818181817
r16461 n9278 n9299 0.15275
r16462 n9298 n9299 0.010681818181818183
r16463 n9279 n9300 0.038187499999999999
r16464 n9299 n9300 0.021363636363636366
r16465 n9280 n9301 0.013886363636363638
r16466 n9300 n9301 0.064090909090909087
r16467 n9281 n9302 0.15275
r16468 n9301 n9302 0.051272727272727268
r16469 n9282 n9303 0.10183333333333335
r16470 n9302 n9303 0.010681818181818183
r16471 n9283 n9304 0.10183333333333335
r16472 n9303 n9304 0.012818181818181817
r16473 n9284 n9305 0.076374999999999998
r16474 n9304 n9305 0.014954545454545455
r16475 n9285 n9306 0.10183333333333335
r16476 n9305 n9306 0.014954545454545455
r16477 n9286 n9307 0.043642857142857143
r16478 n9287 n9308 0.10183333333333335
r16479 n9307 n9308 0.021363636363636366
r16480 n9288 n9309 0.10183333333333335
r16481 n9308 n9309 0.012818181818181817
r16482 n9289 n9310 0.15275
r16483 n9309 n9310 0.010681818181818183
r16484 n9290 n9311 0.027772727272727275
r16485 n9310 n9311 0.027772727272727275
r16486 n9291 n9312 0.016078947368421054
r16487 n9311 n9312 0.064090909090909087
r16488 n9292 n9313 0.15275
r16489 n9312 n9313 0.044863636363636362
r16490 n9293 n9314 0.10183333333333335
r16491 n9313 n9314 0.010681818181818183
r16492 n9294 n9315 0.10183333333333335
r16493 n9314 n9315 0.012818181818181817
r16494 n9295 n9316 0.043642857142857143
r16495 n9315 n9316 0.021363636363636366
r16496 n9296 n9317 0.043642857142857143
r16497 n9297 n9318 0.10183333333333335
r16498 n9317 n9318 0.11750000000000001
r16499 n9298 n9319 0.10183333333333335
r16500 n9318 n9319 0.070499999999999993
r16501 n9299 n9320 0.15275
r16502 n9319 n9320 0.058750000000000004
r16503 n9300 n9321 0.038187499999999999
r16504 n9320 n9321 0.11750000000000001
r16505 n9301 n9322 0.013886363636363638
r16506 n9321 n9322 0.35249999999999998
r16507 n9302 n9323 0.15275
r16508 n9322 n9323 0.28199999999999997
r16509 n9303 n9324 0.10183333333333335
r16510 n9323 n9324 0.058750000000000004
r16511 n9304 n9325 0.10183333333333335
r16512 n9324 n9325 0.070499999999999993
r16513 n9305 n9326 0.076374999999999998
r16514 n9325 n9326 0.082250000000000004
r16515 n9306 n9327 0.10183333333333335
r16516 n9326 n9327 0.082250000000000004
r16517 n9307 n9328 0.043642857142857143
r16518 n9308 n9329 0.10183333333333335
r16519 n9328 n9329 0.11750000000000001
r16520 n9309 n9330 0.10183333333333335
r16521 n9329 n9330 0.070499999999999993
r16522 n9310 n9331 0.15275
r16523 n9330 n9331 0.058750000000000004
r16524 n9311 n9332 0.027772727272727275
r16525 n9331 n9332 0.15275
r16526 n9312 n9333 0.016078947368421054
r16527 n9332 n9333 0.35249999999999998
r16528 n9313 n9334 0.15275
r16529 n9333 n9334 0.24674999999999997
r16530 n9314 n9335 0.10183333333333335
r16531 n9334 n9335 0.058750000000000004
r16532 n9315 n9336 0.10183333333333335
r16533 n9335 n9336 0.070499999999999993
r16534 n9316 n9337 0.043642857142857143
r16535 n9336 n9337 0.11750000000000001
r16536 n9317 n9338 0.10742857142857143
r16537 n9318 n9339 0.25066666666666665
r16538 n9338 n9339 0.0078333333333333328
r16539 n9319 n9340 0.25066666666666665
r16540 n9339 n9340 0.0046999999999999993
r16541 n9320 n9341 0.376
r16542 n9340 n9341 0.0039166666666666664
r16543 n9321 n9342 0.094
r16544 n9341 n9342 0.0078333333333333328
r16545 n9322 n9343 0.034181818181818181
r16546 n9342 n9343 0.0235
r16547 n9323 n9344 0.376
r16548 n9343 n9344 0.018799999999999997
r16549 n9324 n9345 0.25066666666666665
r16550 n9344 n9345 0.0039166666666666664
r16551 n9325 n9346 0.25066666666666665
r16552 n9345 n9346 0.0046999999999999993
r16553 n9326 n9347 0.188
r16554 n9346 n9347 0.0054833333333333331
r16555 n9327 n9348 0.25066666666666665
r16556 n9347 n9348 0.0054833333333333331
r16557 n9328 n9349 0.10742857142857143
r16558 n9329 n9350 0.25066666666666665
r16559 n9349 n9350 0.0078333333333333328
r16560 n9330 n9351 0.25066666666666665
r16561 n9350 n9351 0.0046999999999999993
r16562 n9331 n9352 0.376
r16563 n9351 n9352 0.0039166666666666664
r16564 n9332 n9353 0.068363636363636363
r16565 n9352 n9353 0.010183333333333334
r16566 n9333 n9354 0.039578947368421054
r16567 n9353 n9354 0.0235
r16568 n9334 n9355 0.376
r16569 n9354 n9355 0.016449999999999999
r16570 n9335 n9356 0.25066666666666665
r16571 n9355 n9356 0.0039166666666666664
r16572 n9336 n9357 0.25066666666666665
r16573 n9356 n9357 0.0046999999999999993
r16574 n9337 n9358 0.10742857142857143
r16575 n9357 n9358 0.0078333333333333328
r16576 n9338 n9359 0.10742857142857143
r16577 n9339 n9360 0.25066666666666665
r16578 n9359 n9360 0.11750000000000001
r16579 n9340 n9361 0.25066666666666665
r16580 n9360 n9361 0.070499999999999993
r16581 n9341 n9362 0.376
r16582 n9361 n9362 0.058750000000000004
r16583 n9342 n9363 0.094
r16584 n9362 n9363 0.11750000000000001
r16585 n9343 n9364 0.034181818181818181
r16586 n9363 n9364 0.35249999999999998
r16587 n9344 n9365 0.376
r16588 n9364 n9365 0.28199999999999997
r16589 n9345 n9366 0.25066666666666665
r16590 n9365 n9366 0.058750000000000004
r16591 n9346 n9367 0.25066666666666665
r16592 n9366 n9367 0.070499999999999993
r16593 n9347 n9368 0.188
r16594 n9367 n9368 0.082250000000000004
r16595 n9348 n9369 0.25066666666666665
r16596 n9368 n9369 0.082250000000000004
r16597 n9349 n9370 0.10742857142857143
r16598 n9350 n9371 0.25066666666666665
r16599 n9370 n9371 0.11750000000000001
r16600 n9351 n9372 0.25066666666666665
r16601 n9371 n9372 0.070499999999999993
r16602 n9352 n9373 0.376
r16603 n9372 n9373 0.058750000000000004
r16604 n9353 n9374 0.068363636363636363
r16605 n9373 n9374 0.15275
r16606 n9354 n9375 0.039578947368421054
r16607 n9374 n9375 0.35249999999999998
r16608 n9355 n9376 0.376
r16609 n9375 n9376 0.24674999999999997
r16610 n9356 n9377 0.25066666666666665
r16611 n9376 n9377 0.058750000000000004
r16612 n9357 n9378 0.25066666666666665
r16613 n9377 n9378 0.070499999999999993
r16614 n9358 n9379 0.10742857142857143
r16615 n9378 n9379 0.11750000000000001
r16616 n9359 n9380 0.043642857142857143
r16617 n9360 n9381 0.10183333333333335
r16618 n9380 n9381 0.021363636363636366
r16619 n9361 n9382 0.10183333333333335
r16620 n9381 n9382 0.012818181818181817
r16621 n9362 n9383 0.15275
r16622 n9382 n9383 0.010681818181818183
r16623 n9363 n9384 0.038187499999999999
r16624 n9383 n9384 0.021363636363636366
r16625 n9364 n9385 0.013886363636363638
r16626 n9384 n9385 0.064090909090909087
r16627 n9365 n9386 0.15275
r16628 n9385 n9386 0.051272727272727268
r16629 n9366 n9387 0.10183333333333335
r16630 n9386 n9387 0.010681818181818183
r16631 n9367 n9388 0.10183333333333335
r16632 n9387 n9388 0.012818181818181817
r16633 n9368 n9389 0.076374999999999998
r16634 n9388 n9389 0.014954545454545455
r16635 n9369 n9390 0.10183333333333335
r16636 n9389 n9390 0.014954545454545455
r16637 n9370 n9391 0.043642857142857143
r16638 n9371 n9392 0.10183333333333335
r16639 n9391 n9392 0.021363636363636366
r16640 n9372 n9393 0.10183333333333335
r16641 n9392 n9393 0.012818181818181817
r16642 n9373 n9394 0.15275
r16643 n9393 n9394 0.010681818181818183
r16644 n9374 n9395 0.027772727272727275
r16645 n9394 n9395 0.027772727272727275
r16646 n9375 n9396 0.016078947368421054
r16647 n9395 n9396 0.064090909090909087
r16648 n9376 n9397 0.15275
r16649 n9396 n9397 0.044863636363636362
r16650 n9377 n9398 0.10183333333333335
r16651 n9397 n9398 0.010681818181818183
r16652 n9378 n9399 0.10183333333333335
r16653 n9398 n9399 0.012818181818181817
r16654 n9379 n9400 0.043642857142857143
r16655 n9399 n9400 0.021363636363636366
r16656 n9380 n9401 0.043642857142857143
r16657 n9381 n9402 0.10183333333333335
r16658 n9401 n9402 0.11750000000000001
r16659 n9382 n9403 0.10183333333333335
r16660 n9402 n9403 0.070499999999999993
r16661 n9383 n9404 0.15275
r16662 n9403 n9404 0.058750000000000004
r16663 n9384 n9405 0.038187499999999999
r16664 n9404 n9405 0.11750000000000001
r16665 n9385 n9406 0.013886363636363638
r16666 n9405 n9406 0.35249999999999998
r16667 n9386 n9407 0.15275
r16668 n9406 n9407 0.28199999999999997
r16669 n9387 n9408 0.10183333333333335
r16670 n9407 n9408 0.058750000000000004
r16671 n9388 n9409 0.10183333333333335
r16672 n9408 n9409 0.070499999999999993
r16673 n9389 n9410 0.076374999999999998
r16674 n9409 n9410 0.082250000000000004
r16675 n9390 n9411 0.10183333333333335
r16676 n9410 n9411 0.082250000000000004
r16677 n9391 n9412 0.043642857142857143
r16678 n9392 n9413 0.10183333333333335
r16679 n9412 n9413 0.11750000000000001
r16680 n9393 n9414 0.10183333333333335
r16681 n9413 n9414 0.070499999999999993
r16682 n9394 n9415 0.15275
r16683 n9414 n9415 0.058750000000000004
r16684 n9395 n9416 0.027772727272727275
r16685 n9415 n9416 0.15275
r16686 n9396 n9417 0.016078947368421054
r16687 n9416 n9417 0.35249999999999998
r16688 n9397 n9418 0.15275
r16689 n9417 n9418 0.24674999999999997
r16690 n9398 n9419 0.10183333333333335
r16691 n9418 n9419 0.058750000000000004
r16692 n9399 n9420 0.10183333333333335
r16693 n9419 n9420 0.070499999999999993
r16694 n9400 n9421 0.043642857142857143
r16695 n9420 n9421 0.11750000000000001
r16696 n9401 n9422 0.11078571428571428
r16697 n9402 n9423 0.25850000000000001
r16698 n9422 n9423 0.0075806451612903227
r16699 n9403 n9424 0.25850000000000001
r16700 n9423 n9424 0.0045483870967741929
r16701 n9404 n9425 0.38774999999999998
r16702 n9424 n9425 0.0037903225806451613
r16703 n9405 n9426 0.096937499999999996
r16704 n9425 n9426 0.0075806451612903227
r16705 n9406 n9427 0.035249999999999997
r16706 n9426 n9427 0.022741935483870965
r16707 n9407 n9428 0.38774999999999998
r16708 n9427 n9428 0.018193548387096772
r16709 n9408 n9429 0.25850000000000001
r16710 n9428 n9429 0.0037903225806451613
r16711 n9409 n9430 0.25850000000000001
r16712 n9429 n9430 0.0045483870967741929
r16713 n9410 n9431 0.19387499999999999
r16714 n9430 n9431 0.0053064516129032258
r16715 n9411 n9432 0.25850000000000001
r16716 n9431 n9432 0.0053064516129032258
r16717 n9412 n9433 0.11078571428571428
r16718 n9413 n9434 0.25850000000000001
r16719 n9433 n9434 0.0075806451612903227
r16720 n9414 n9435 0.25850000000000001
r16721 n9434 n9435 0.0045483870967741929
r16722 n9415 n9436 0.38774999999999998
r16723 n9435 n9436 0.0037903225806451613
r16724 n9416 n9437 0.070499999999999993
r16725 n9436 n9437 0.0098548387096774204
r16726 n9417 n9438 0.040815789473684208
r16727 n9437 n9438 0.022741935483870965
r16728 n9418 n9439 0.38774999999999998
r16729 n9438 n9439 0.015919354838709675
r16730 n9419 n9440 0.25850000000000001
r16731 n9439 n9440 0.0037903225806451613
r16732 n9420 n9441 0.25850000000000001
r16733 n9440 n9441 0.0045483870967741929
r16734 n9421 n9442 0.11078571428571428
r16735 n9441 n9442 0.0075806451612903227
r16736 n9422 n9443 0.20814285714285716
r16737 n9423 n9444 0.48566666666666669
r16738 n9443 n9444 0.0075806451612903227
r16739 n9424 n9445 0.48566666666666669
r16740 n9444 n9445 0.0045483870967741929
r16741 n9425 n9446 0.72850000000000004
r16742 n9445 n9446 0.0037903225806451613
r16743 n9426 n9447 0.18212500000000001
r16744 n9446 n9447 0.0075806451612903227
r16745 n9427 n9448 0.066227272727272732
r16746 n9447 n9448 0.022741935483870965
r16747 n9428 n9449 0.72850000000000004
r16748 n9448 n9449 0.018193548387096772
r16749 n9429 n9450 0.48566666666666669
r16750 n9449 n9450 0.0037903225806451613
r16751 n9430 n9451 0.48566666666666669
r16752 n9450 n9451 0.0045483870967741929
r16753 n9431 n9452 0.36425000000000002
r16754 n9451 n9452 0.0053064516129032258
r16755 n9432 n9453 0.48566666666666669
r16756 n9452 n9453 0.0053064516129032258
r16757 n9433 n9454 0.20814285714285716
r16758 n9434 n9455 0.48566666666666669
r16759 n9454 n9455 0.0075806451612903227
r16760 n9435 n9456 0.48566666666666669
r16761 n9455 n9456 0.0045483870967741929
r16762 n9436 n9457 0.72850000000000004
r16763 n9456 n9457 0.0037903225806451613
r16764 n9437 n9458 0.13245454545454546
r16765 n9457 n9458 0.0098548387096774204
r16766 n9438 n9459 0.076684210526315785
r16767 n9458 n9459 0.022741935483870965
r16768 n9439 n9460 0.72850000000000004
r16769 n9459 n9460 0.015919354838709675
r16770 n9440 n9461 0.48566666666666669
r16771 n9460 n9461 0.0037903225806451613
r16772 n9441 n9462 0.48566666666666669
r16773 n9461 n9462 0.0045483870967741929
r16774 n9442 n9463 0.20814285714285716
r16775 n9462 n9463 0.0075806451612903227
r16776 n9443 n9464 0.15107142857142855
r16777 n9444 n9465 0.35249999999999998
r16778 n9464 n9465 0.016785714285714286
r16779 n9445 n9466 0.35249999999999998
r16780 n9465 n9466 0.010071428571428571
r16781 n9446 n9467 0.52874999999999994
r16782 n9466 n9467 0.0083928571428571429
r16783 n9447 n9468 0.13218749999999999
r16784 n9467 n9468 0.016785714285714286
r16785 n9448 n9469 0.048068181818181815
r16786 n9468 n9469 0.050357142857142857
r16787 n9449 n9470 0.52874999999999994
r16788 n9469 n9470 0.040285714285714286
r16789 n9450 n9471 0.35249999999999998
r16790 n9470 n9471 0.0083928571428571429
r16791 n9451 n9472 0.35249999999999998
r16792 n9471 n9472 0.010071428571428571
r16793 n9452 n9473 0.26437499999999997
r16794 n9472 n9473 0.01175
r16795 n9453 n9474 0.35249999999999998
r16796 n9473 n9474 0.01175
r16797 n9454 n9475 0.15107142857142855
r16798 n9455 n9476 0.35249999999999998
r16799 n9475 n9476 0.016785714285714286
r16800 n9456 n9477 0.35249999999999998
r16801 n9476 n9477 0.010071428571428571
r16802 n9457 n9478 0.52874999999999994
r16803 n9477 n9478 0.0083928571428571429
r16804 n9458 n9479 0.096136363636363631
r16805 n9478 n9479 0.021821428571428571
r16806 n9459 n9480 0.055657894736842101
r16807 n9479 n9480 0.050357142857142857
r16808 n9460 n9481 0.52874999999999994
r16809 n9480 n9481 0.035249999999999997
r16810 n9461 n9482 0.35249999999999998
r16811 n9481 n9482 0.0083928571428571429
r16812 n9462 n9483 0.35249999999999998
r16813 n9482 n9483 0.010071428571428571
r16814 n9463 n9484 0.15107142857142855
r16815 n9483 n9484 0.016785714285714286
r16816 n9464 n9485 0.053714285714285714
r16817 n9465 n9486 0.12533333333333332
r16818 n9485 n9486 0.11750000000000001
r16819 n9466 n9487 0.12533333333333332
r16820 n9486 n9487 0.070499999999999993
r16821 n9467 n9488 0.188
r16822 n9487 n9488 0.058750000000000004
r16823 n9468 n9489 0.047
r16824 n9488 n9489 0.11750000000000001
r16825 n9469 n9490 0.017090909090909091
r16826 n9489 n9490 0.35249999999999998
r16827 n9470 n9491 0.188
r16828 n9490 n9491 0.28199999999999997
r16829 n9471 n9492 0.12533333333333332
r16830 n9491 n9492 0.058750000000000004
r16831 n9472 n9493 0.12533333333333332
r16832 n9492 n9493 0.070499999999999993
r16833 n9473 n9494 0.094
r16834 n9493 n9494 0.082250000000000004
r16835 n9474 n9495 0.12533333333333332
r16836 n9494 n9495 0.082250000000000004
r16837 n9475 n9496 0.053714285714285714
r16838 n9476 n9497 0.12533333333333332
r16839 n9496 n9497 0.11750000000000001
r16840 n9477 n9498 0.12533333333333332
r16841 n9497 n9498 0.070499999999999993
r16842 n9478 n9499 0.188
r16843 n9498 n9499 0.058750000000000004
r16844 n9479 n9500 0.034181818181818181
r16845 n9499 n9500 0.15275
r16846 n9480 n9501 0.019789473684210527
r16847 n9500 n9501 0.35249999999999998
r16848 n9481 n9502 0.188
r16849 n9501 n9502 0.24674999999999997
r16850 n9482 n9503 0.12533333333333332
r16851 n9502 n9503 0.058750000000000004
r16852 n9483 n9504 0.12533333333333332
r16853 n9503 n9504 0.070499999999999993
r16854 n9484 n9505 0.053714285714285714
r16855 n9504 n9505 0.11750000000000001
r16856 n9485 n9506 0.0235
r16857 n9486 n9507 0.054833333333333331
r16858 n9506 n9507 0.047
r16859 n9487 n9508 0.054833333333333331
r16860 n9507 n9508 0.028199999999999999
r16861 n9488 n9509 0.082250000000000004
r16862 n9508 n9509 0.0235
r16863 n9489 n9510 0.020562500000000001
r16864 n9509 n9510 0.047
r16865 n9490 n9511 0.0074772727272727274
r16866 n9510 n9511 0.14099999999999999
r16867 n9491 n9512 0.082250000000000004
r16868 n9511 n9512 0.1128
r16869 n9492 n9513 0.054833333333333331
r16870 n9512 n9513 0.0235
r16871 n9493 n9514 0.054833333333333331
r16872 n9513 n9514 0.028199999999999999
r16873 n9494 n9515 0.041125000000000002
r16874 n9514 n9515 0.032899999999999999
r16875 n9495 n9516 0.054833333333333331
r16876 n9515 n9516 0.032899999999999999
r16877 n9496 n9517 0.0235
r16878 n9497 n9518 0.054833333333333331
r16879 n9517 n9518 0.047
r16880 n9498 n9519 0.054833333333333331
r16881 n9518 n9519 0.028199999999999999
r16882 n9499 n9520 0.082250000000000004
r16883 n9519 n9520 0.0235
r16884 n9500 n9521 0.014954545454545455
r16885 n9520 n9521 0.061100000000000002
r16886 n9501 n9522 0.0086578947368421057
r16887 n9521 n9522 0.14099999999999999
r16888 n9502 n9523 0.082250000000000004
r16889 n9522 n9523 0.098699999999999996
r16890 n9503 n9524 0.054833333333333331
r16891 n9523 n9524 0.0235
r16892 n9504 n9525 0.054833333333333331
r16893 n9524 n9525 0.028199999999999999
r16894 n9505 n9526 0.0235
r16895 n9525 n9526 0.047
r16896 n9506 n9527 0.036928571428571429
r16897 n9507 n9528 0.086166666666666669
r16898 n9527 n9528 0.039166666666666669
r16899 n9508 n9529 0.086166666666666669
r16900 n9528 n9529 0.0235
r16901 n9509 n9530 0.12925
r16902 n9529 n9530 0.019583333333333335
r16903 n9510 n9531 0.032312500000000001
r16904 n9530 n9531 0.039166666666666669
r16905 n9511 n9532 0.01175
r16906 n9531 n9532 0.11749999999999999
r16907 n9512 n9533 0.12925
r16908 n9532 n9533 0.094
r16909 n9513 n9534 0.086166666666666669
r16910 n9533 n9534 0.019583333333333335
r16911 n9514 n9535 0.086166666666666669
r16912 n9534 n9535 0.0235
r16913 n9515 n9536 0.064625000000000002
r16914 n9535 n9536 0.027416666666666666
r16915 n9516 n9537 0.086166666666666669
r16916 n9536 n9537 0.027416666666666666
r16917 n9517 n9538 0.036928571428571429
r16918 n9518 n9539 0.086166666666666669
r16919 n9538 n9539 0.039166666666666669
r16920 n9519 n9540 0.086166666666666669
r16921 n9539 n9540 0.0235
r16922 n9520 n9541 0.12925
r16923 n9540 n9541 0.019583333333333335
r16924 n9521 n9542 0.0235
r16925 n9541 n9542 0.050916666666666673
r16926 n9522 n9543 0.013605263157894737
r16927 n9542 n9543 0.11749999999999999
r16928 n9523 n9544 0.12925
r16929 n9543 n9544 0.08224999999999999
r16930 n9524 n9545 0.086166666666666669
r16931 n9544 n9545 0.019583333333333335
r16932 n9525 n9546 0.086166666666666669
r16933 n9545 n9546 0.0235
r16934 n9526 n9547 0.036928571428571429
r16935 n9546 n9547 0.039166666666666669
r16936 n9527 n9548 0.026857142857142857
r16937 n9528 n9549 0.062666666666666662
r16938 n9548 n9549 0.11750000000000001
r16939 n9529 n9550 0.062666666666666662
r16940 n9549 n9550 0.070499999999999993
r16941 n9530 n9551 0.094
r16942 n9550 n9551 0.058750000000000004
r16943 n9531 n9552 0.0235
r16944 n9551 n9552 0.11750000000000001
r16945 n9532 n9553 0.0085454545454545453
r16946 n9552 n9553 0.35249999999999998
r16947 n9533 n9554 0.094
r16948 n9553 n9554 0.28199999999999997
r16949 n9534 n9555 0.062666666666666662
r16950 n9554 n9555 0.058750000000000004
r16951 n9535 n9556 0.062666666666666662
r16952 n9555 n9556 0.070499999999999993
r16953 n9536 n9557 0.047
r16954 n9556 n9557 0.082250000000000004
r16955 n9537 n9558 0.062666666666666662
r16956 n9557 n9558 0.082250000000000004
r16957 n9538 n9559 0.026857142857142857
r16958 n9539 n9560 0.062666666666666662
r16959 n9559 n9560 0.11750000000000001
r16960 n9540 n9561 0.062666666666666662
r16961 n9560 n9561 0.070499999999999993
r16962 n9541 n9562 0.094
r16963 n9561 n9562 0.058750000000000004
r16964 n9542 n9563 0.017090909090909091
r16965 n9562 n9563 0.15275
r16966 n9543 n9564 0.0098947368421052635
r16967 n9563 n9564 0.35249999999999998
r16968 n9544 n9565 0.094
r16969 n9564 n9565 0.24674999999999997
r16970 n9545 n9566 0.062666666666666662
r16971 n9565 n9566 0.058750000000000004
r16972 n9546 n9567 0.062666666666666662
r16973 n9566 n9567 0.070499999999999993
r16974 n9547 n9568 0.026857142857142857
r16975 n9567 n9568 0.11750000000000001
r16976 n9548 n9569 0.0235
r16977 n9549 n9570 0.054833333333333331
r16978 n9569 n9570 0.047
r16979 n9550 n9571 0.054833333333333331
r16980 n9570 n9571 0.028199999999999999
r16981 n9551 n9572 0.082250000000000004
r16982 n9571 n9572 0.0235
r16983 n9552 n9573 0.020562500000000001
r16984 n9572 n9573 0.047
r16985 n9553 n9574 0.0074772727272727274
r16986 n9573 n9574 0.14099999999999999
r16987 n9554 n9575 0.082250000000000004
r16988 n9574 n9575 0.1128
r16989 n9555 n9576 0.054833333333333331
r16990 n9575 n9576 0.0235
r16991 n9556 n9577 0.054833333333333331
r16992 n9576 n9577 0.028199999999999999
r16993 n9557 n9578 0.041125000000000002
r16994 n9577 n9578 0.032899999999999999
r16995 n9558 n9579 0.054833333333333331
r16996 n9578 n9579 0.032899999999999999
r16997 n9559 n9580 0.0235
r16998 n9560 n9581 0.054833333333333331
r16999 n9580 n9581 0.047
r17000 n9561 n9582 0.054833333333333331
r17001 n9581 n9582 0.028199999999999999
r17002 n9562 n9583 0.082250000000000004
r17003 n9582 n9583 0.0235
r17004 n9563 n9584 0.014954545454545455
r17005 n9583 n9584 0.061100000000000002
r17006 n9564 n9585 0.0086578947368421057
r17007 n9584 n9585 0.14099999999999999
r17008 n9565 n9586 0.082250000000000004
r17009 n9585 n9586 0.098699999999999996
r17010 n9566 n9587 0.054833333333333331
r17011 n9586 n9587 0.0235
r17012 n9567 n9588 0.054833333333333331
r17013 n9587 n9588 0.028199999999999999
r17014 n9568 n9589 0.0235
r17015 n9588 n9589 0.047
r17016 n9569 n9590 0.067142857142857143
r17017 n9570 n9591 0.15666666666666668
r17018 n9590 n9591 0.015666666666666666
r17019 n9571 n9592 0.15666666666666668
r17020 n9591 n9592 0.0093999999999999986
r17021 n9572 n9593 0.23500000000000001
r17022 n9592 n9593 0.0078333333333333328
r17023 n9573 n9594 0.058750000000000004
r17024 n9593 n9594 0.015666666666666666
r17025 n9574 n9595 0.021363636363636366
r17026 n9594 n9595 0.047
r17027 n9575 n9596 0.23500000000000001
r17028 n9595 n9596 0.037599999999999995
r17029 n9576 n9597 0.15666666666666668
r17030 n9596 n9597 0.0078333333333333328
r17031 n9577 n9598 0.15666666666666668
r17032 n9597 n9598 0.0093999999999999986
r17033 n9578 n9599 0.11750000000000001
r17034 n9598 n9599 0.010966666666666666
r17035 n9579 n9600 0.15666666666666668
r17036 n9599 n9600 0.010966666666666666
r17037 n9580 n9601 0.067142857142857143
r17038 n9581 n9602 0.15666666666666668
r17039 n9601 n9602 0.015666666666666666
r17040 n9582 n9603 0.15666666666666668
r17041 n9602 n9603 0.0093999999999999986
r17042 n9583 n9604 0.23500000000000001
r17043 n9603 n9604 0.0078333333333333328
r17044 n9584 n9605 0.042727272727272732
r17045 n9604 n9605 0.020366666666666668
r17046 n9585 n9606 0.024736842105263158
r17047 n9605 n9606 0.047
r17048 n9586 n9607 0.23500000000000001
r17049 n9606 n9607 0.032899999999999999
r17050 n9587 n9608 0.15666666666666668
r17051 n9607 n9608 0.0078333333333333328
r17052 n9588 n9609 0.15666666666666668
r17053 n9608 n9609 0.0093999999999999986
r17054 n9589 n9610 0.067142857142857143
r17055 n9609 n9610 0.015666666666666666
r17056 n9590 n9612 0.060428571428571436
r17057 n9611 n9612 0.13316666666666668
r17058 n9591 n9613 0.14100000000000001
r17059 n9612 n9613 0.078333333333333338
r17060 n9592 n9614 0.14100000000000001
r17061 n9613 n9614 0.047
r17062 n9593 n9615 0.21150000000000002
r17063 n9614 n9615 0.039166666666666669
r17064 n9594 n9616 0.052875000000000005
r17065 n9615 n9616 0.078333333333333338
r17066 n9595 n9617 0.019227272727272728
r17067 n9616 n9617 0.23499999999999999
r17068 n9596 n9618 0.21150000000000002
r17069 n9617 n9618 0.188
r17070 n9597 n9619 0.14100000000000001
r17071 n9618 n9619 0.039166666666666669
r17072 n9598 n9620 0.14100000000000001
r17073 n9619 n9620 0.047
r17074 n9599 n9621 0.10575000000000001
r17075 n9620 n9621 0.054833333333333331
r17076 n9600 n9622 0.14100000000000001
r17077 n9621 n9622 0.054833333333333331
r17078 n9622 n9623 0.10183333333333335
r17079 n9601 n9625 0.060428571428571436
r17080 n9624 n9625 0.13316666666666668
r17081 n9602 n9626 0.14100000000000001
r17082 n9625 n9626 0.078333333333333338
r17083 n9603 n9627 0.14100000000000001
r17084 n9626 n9627 0.047
r17085 n9604 n9628 0.21150000000000002
r17086 n9627 n9628 0.039166666666666669
r17087 n9605 n9629 0.038454545454545457
r17088 n9628 n9629 0.10183333333333335
r17089 n9606 n9630 0.022263157894736846
r17090 n9629 n9630 0.23499999999999999
r17091 n9607 n9631 0.21150000000000002
r17092 n9630 n9631 0.16449999999999998
r17093 n9608 n9632 0.14100000000000001
r17094 n9631 n9632 0.039166666666666669
r17095 n9609 n9633 0.14100000000000001
r17096 n9632 n9633 0.047
r17097 n9610 n9634 0.060428571428571436
r17098 n9633 n9634 0.078333333333333338
r17099 n9634 n9635 0.13316666666666668
r17100 n9611 n9636 0.016449999999999999
r17101 n9612 n9637 0.0235
r17102 n9636 n9637 0.099875000000000005
r17103 n9613 n9638 0.054833333333333331
r17104 n9637 n9638 0.058750000000000004
r17105 n9614 n9639 0.054833333333333331
r17106 n9638 n9639 0.035249999999999997
r17107 n9615 n9640 0.082250000000000004
r17108 n9639 n9640 0.029375000000000002
r17109 n9616 n9641 0.020562500000000001
r17110 n9640 n9641 0.058750000000000004
r17111 n9617 n9642 0.0074772727272727274
r17112 n9641 n9642 0.17624999999999999
r17113 n9618 n9643 0.082250000000000004
r17114 n9642 n9643 0.14099999999999999
r17115 n9619 n9644 0.054833333333333331
r17116 n9643 n9644 0.029375000000000002
r17117 n9620 n9645 0.054833333333333331
r17118 n9644 n9645 0.035249999999999997
r17119 n9621 n9646 0.041125000000000002
r17120 n9645 n9646 0.041125000000000002
r17121 n9622 n9647 0.054833333333333331
r17122 n9646 n9647 0.041125000000000002
r17123 n9623 n9648 0.016449999999999999
r17124 n9647 n9648 0.076374999999999998
r17125 n9624 n9649 0.016449999999999999
r17126 n9625 n9650 0.0235
r17127 n9649 n9650 0.099875000000000005
r17128 n9626 n9651 0.054833333333333331
r17129 n9650 n9651 0.058750000000000004
r17130 n9627 n9652 0.054833333333333331
r17131 n9651 n9652 0.035249999999999997
r17132 n9628 n9653 0.082250000000000004
r17133 n9652 n9653 0.029375000000000002
r17134 n9629 n9654 0.014954545454545455
r17135 n9653 n9654 0.076374999999999998
r17136 n9630 n9655 0.0086578947368421057
r17137 n9654 n9655 0.17624999999999999
r17138 n9631 n9656 0.082250000000000004
r17139 n9655 n9656 0.12337499999999998
r17140 n9632 n9657 0.054833333333333331
r17141 n9656 n9657 0.029375000000000002
r17142 n9633 n9658 0.054833333333333331
r17143 n9657 n9658 0.035249999999999997
r17144 n9634 n9659 0.0235
r17145 n9658 n9659 0.058750000000000004
r17146 n9635 n9660 0.016449999999999999
r17147 n9659 n9660 0.099875000000000005
r17148 n9636 n9661 0.016449999999999999
r17149 n9637 n9662 0.0235
r17150 n9661 n9662 0.13316666666666668
r17151 n9638 n9663 0.054833333333333331
r17152 n9662 n9663 0.078333333333333338
r17153 n9639 n9664 0.054833333333333331
r17154 n9663 n9664 0.047
r17155 n9640 n9665 0.082250000000000004
r17156 n9664 n9665 0.039166666666666669
r17157 n9641 n9666 0.020562500000000001
r17158 n9665 n9666 0.078333333333333338
r17159 n9642 n9667 0.0074772727272727274
r17160 n9666 n9667 0.23499999999999999
r17161 n9643 n9668 0.082250000000000004
r17162 n9667 n9668 0.188
r17163 n9644 n9669 0.054833333333333331
r17164 n9668 n9669 0.039166666666666669
r17165 n9645 n9670 0.054833333333333331
r17166 n9669 n9670 0.047
r17167 n9646 n9671 0.041125000000000002
r17168 n9670 n9671 0.054833333333333331
r17169 n9647 n9672 0.054833333333333331
r17170 n9671 n9672 0.054833333333333331
r17171 n9648 n9673 0.016449999999999999
r17172 n9672 n9673 0.10183333333333335
r17173 n9649 n9674 0.016449999999999999
r17174 n9650 n9675 0.0235
r17175 n9674 n9675 0.13316666666666668
r17176 n9651 n9676 0.054833333333333331
r17177 n9675 n9676 0.078333333333333338
r17178 n9652 n9677 0.054833333333333331
r17179 n9676 n9677 0.047
r17180 n9653 n9678 0.082250000000000004
r17181 n9677 n9678 0.039166666666666669
r17182 n9654 n9679 0.014954545454545455
r17183 n9678 n9679 0.10183333333333335
r17184 n9655 n9680 0.0086578947368421057
r17185 n9679 n9680 0.23499999999999999
r17186 n9656 n9681 0.082250000000000004
r17187 n9680 n9681 0.16449999999999998
r17188 n9657 n9682 0.054833333333333331
r17189 n9681 n9682 0.039166666666666669
r17190 n9658 n9683 0.054833333333333331
r17191 n9682 n9683 0.047
r17192 n9659 n9684 0.0235
r17193 n9683 n9684 0.078333333333333338
r17194 n9660 n9685 0.016449999999999999
r17195 n9684 n9685 0.13316666666666668
r17196 n9661 n9686 0.01175
r17197 n9662 n9687 0.016785714285714286
r17198 n9686 n9687 0.19975000000000001
r17199 n9663 n9688 0.039166666666666669
r17200 n9687 n9688 0.11750000000000001
r17201 n9664 n9689 0.039166666666666669
r17202 n9688 n9689 0.070499999999999993
r17203 n9665 n9690 0.058750000000000004
r17204 n9689 n9690 0.058750000000000004
r17205 n9666 n9691 0.014687500000000001
r17206 n9690 n9691 0.11750000000000001
r17207 n9667 n9692 0.0053409090909090915
r17208 n9691 n9692 0.35249999999999998
r17209 n9668 n9693 0.058750000000000004
r17210 n9692 n9693 0.28199999999999997
r17211 n9669 n9694 0.039166666666666669
r17212 n9693 n9694 0.058750000000000004
r17213 n9670 n9695 0.039166666666666669
r17214 n9694 n9695 0.070499999999999993
r17215 n9671 n9696 0.029375000000000002
r17216 n9695 n9696 0.082250000000000004
r17217 n9672 n9697 0.039166666666666669
r17218 n9696 n9697 0.082250000000000004
r17219 n9673 n9698 0.01175
r17220 n9697 n9698 0.15275
r17221 n9674 n9699 0.01175
r17222 n9675 n9700 0.016785714285714286
r17223 n9699 n9700 0.19975000000000001
r17224 n9676 n9701 0.039166666666666669
r17225 n9700 n9701 0.11750000000000001
r17226 n9677 n9702 0.039166666666666669
r17227 n9701 n9702 0.070499999999999993
r17228 n9678 n9703 0.058750000000000004
r17229 n9702 n9703 0.058750000000000004
r17230 n9679 n9704 0.010681818181818183
r17231 n9703 n9704 0.15275
r17232 n9680 n9705 0.0061842105263157894
r17233 n9704 n9705 0.35249999999999998
r17234 n9681 n9706 0.058750000000000004
r17235 n9705 n9706 0.24674999999999997
r17236 n9682 n9707 0.039166666666666669
r17237 n9706 n9707 0.058750000000000004
r17238 n9683 n9708 0.039166666666666669
r17239 n9707 n9708 0.070499999999999993
r17240 n9684 n9709 0.016785714285714286
r17241 n9708 n9709 0.11750000000000001
r17242 n9685 n9710 0.01175
r17243 n9709 n9710 0.19975000000000001
r17244 n9686 n9711 0.018799999999999997
r17245 n9687 n9712 0.026857142857142857
r17246 n9711 n9712 0.066583333333333342
r17247 n9688 n9713 0.062666666666666662
r17248 n9712 n9713 0.039166666666666669
r17249 n9689 n9714 0.062666666666666662
r17250 n9713 n9714 0.0235
r17251 n9690 n9715 0.094
r17252 n9714 n9715 0.019583333333333335
r17253 n9691 n9716 0.0235
r17254 n9715 n9716 0.039166666666666669
r17255 n9692 n9717 0.0085454545454545453
r17256 n9716 n9717 0.11749999999999999
r17257 n9693 n9718 0.094
r17258 n9717 n9718 0.094
r17259 n9694 n9719 0.062666666666666662
r17260 n9718 n9719 0.019583333333333335
r17261 n9695 n9720 0.062666666666666662
r17262 n9719 n9720 0.0235
r17263 n9696 n9721 0.047
r17264 n9720 n9721 0.027416666666666666
r17265 n9697 n9722 0.062666666666666662
r17266 n9721 n9722 0.027416666666666666
r17267 n9698 n9723 0.018799999999999997
r17268 n9722 n9723 0.050916666666666673
r17269 n9699 n9724 0.018799999999999997
r17270 n9700 n9725 0.026857142857142857
r17271 n9724 n9725 0.066583333333333342
r17272 n9701 n9726 0.062666666666666662
r17273 n9725 n9726 0.039166666666666669
r17274 n9702 n9727 0.062666666666666662
r17275 n9726 n9727 0.0235
r17276 n9703 n9728 0.094
r17277 n9727 n9728 0.019583333333333335
r17278 n9704 n9729 0.017090909090909091
r17279 n9728 n9729 0.050916666666666673
r17280 n9705 n9730 0.0098947368421052635
r17281 n9729 n9730 0.11749999999999999
r17282 n9706 n9731 0.094
r17283 n9730 n9731 0.08224999999999999
r17284 n9707 n9732 0.062666666666666662
r17285 n9731 n9732 0.019583333333333335
r17286 n9708 n9733 0.062666666666666662
r17287 n9732 n9733 0.0235
r17288 n9709 n9734 0.026857142857142857
r17289 n9733 n9734 0.039166666666666669
r17290 n9710 n9735 0.018799999999999997
r17291 n9734 n9735 0.066583333333333342
r17292 n9711 n9736 0.018799999999999997
r17293 n9712 n9737 0.026857142857142857
r17294 n9736 n9737 0.19975000000000001
r17295 n9713 n9738 0.062666666666666662
r17296 n9737 n9738 0.11750000000000001
r17297 n9714 n9739 0.062666666666666662
r17298 n9738 n9739 0.070499999999999993
r17299 n9715 n9740 0.094
r17300 n9739 n9740 0.058750000000000004
r17301 n9716 n9741 0.0235
r17302 n9740 n9741 0.11750000000000001
r17303 n9717 n9742 0.0085454545454545453
r17304 n9741 n9742 0.35249999999999998
r17305 n9718 n9743 0.094
r17306 n9742 n9743 0.28199999999999997
r17307 n9719 n9744 0.062666666666666662
r17308 n9743 n9744 0.058750000000000004
r17309 n9720 n9745 0.062666666666666662
r17310 n9744 n9745 0.070499999999999993
r17311 n9721 n9746 0.047
r17312 n9745 n9746 0.082250000000000004
r17313 n9722 n9747 0.062666666666666662
r17314 n9746 n9747 0.082250000000000004
r17315 n9723 n9748 0.018799999999999997
r17316 n9747 n9748 0.15275
r17317 n9724 n9749 0.018799999999999997
r17318 n9725 n9750 0.026857142857142857
r17319 n9749 n9750 0.19975000000000001
r17320 n9726 n9751 0.062666666666666662
r17321 n9750 n9751 0.11750000000000001
r17322 n9727 n9752 0.062666666666666662
r17323 n9751 n9752 0.070499999999999993
r17324 n9728 n9753 0.094
r17325 n9752 n9753 0.058750000000000004
r17326 n9729 n9754 0.017090909090909091
r17327 n9753 n9754 0.15275
r17328 n9730 n9755 0.0098947368421052635
r17329 n9754 n9755 0.35249999999999998
r17330 n9731 n9756 0.094
r17331 n9755 n9756 0.24674999999999997
r17332 n9732 n9757 0.062666666666666662
r17333 n9756 n9757 0.058750000000000004
r17334 n9733 n9758 0.062666666666666662
r17335 n9757 n9758 0.070499999999999993
r17336 n9734 n9759 0.026857142857142857
r17337 n9758 n9759 0.11750000000000001
r17338 n9735 n9760 0.018799999999999997
r17339 n9759 n9760 0.19975000000000001
r17340 n9736 n9761 0.01175
r17341 n9737 n9762 0.016785714285714286
r17342 n9761 n9762 0.13316666666666668
r17343 n9738 n9763 0.039166666666666669
r17344 n9762 n9763 0.078333333333333338
r17345 n9739 n9764 0.039166666666666669
r17346 n9763 n9764 0.047
r17347 n9740 n9765 0.058750000000000004
r17348 n9764 n9765 0.039166666666666669
r17349 n9741 n9766 0.014687500000000001
r17350 n9765 n9766 0.078333333333333338
r17351 n9742 n9767 0.0053409090909090915
r17352 n9766 n9767 0.23499999999999999
r17353 n9743 n9768 0.058750000000000004
r17354 n9767 n9768 0.188
r17355 n9744 n9769 0.039166666666666669
r17356 n9768 n9769 0.039166666666666669
r17357 n9745 n9770 0.039166666666666669
r17358 n9769 n9770 0.047
r17359 n9746 n9771 0.029375000000000002
r17360 n9770 n9771 0.054833333333333331
r17361 n9747 n9772 0.039166666666666669
r17362 n9771 n9772 0.054833333333333331
r17363 n9748 n9773 0.01175
r17364 n9772 n9773 0.10183333333333335
r17365 n9749 n9774 0.01175
r17366 n9750 n9775 0.016785714285714286
r17367 n9774 n9775 0.13316666666666668
r17368 n9751 n9776 0.039166666666666669
r17369 n9775 n9776 0.078333333333333338
r17370 n9752 n9777 0.039166666666666669
r17371 n9776 n9777 0.047
r17372 n9753 n9778 0.058750000000000004
r17373 n9777 n9778 0.039166666666666669
r17374 n9754 n9779 0.010681818181818183
r17375 n9778 n9779 0.10183333333333335
r17376 n9755 n9780 0.0061842105263157894
r17377 n9779 n9780 0.23499999999999999
r17378 n9756 n9781 0.058750000000000004
r17379 n9780 n9781 0.16449999999999998
r17380 n9757 n9782 0.039166666666666669
r17381 n9781 n9782 0.039166666666666669
r17382 n9758 n9783 0.039166666666666669
r17383 n9782 n9783 0.047
r17384 n9759 n9784 0.016785714285714286
r17385 n9783 n9784 0.078333333333333338
r17386 n9760 n9785 0.01175
r17387 n9784 n9785 0.13316666666666668
r17388 n9761 n9786 0.01175
r17389 n9762 n9787 0.016785714285714286
r17390 n9786 n9787 0.19975000000000001
r17391 n9763 n9788 0.039166666666666669
r17392 n9787 n9788 0.11750000000000001
r17393 n9764 n9789 0.039166666666666669
r17394 n9788 n9789 0.070499999999999993
r17395 n9765 n9790 0.058750000000000004
r17396 n9789 n9790 0.058750000000000004
r17397 n9766 n9791 0.014687500000000001
r17398 n9790 n9791 0.11750000000000001
r17399 n9767 n9792 0.0053409090909090915
r17400 n9791 n9792 0.35249999999999998
r17401 n9768 n9793 0.058750000000000004
r17402 n9792 n9793 0.28199999999999997
r17403 n9769 n9794 0.039166666666666669
r17404 n9793 n9794 0.058750000000000004
r17405 n9770 n9795 0.039166666666666669
r17406 n9794 n9795 0.070499999999999993
r17407 n9771 n9796 0.029375000000000002
r17408 n9795 n9796 0.082250000000000004
r17409 n9772 n9797 0.039166666666666669
r17410 n9796 n9797 0.082250000000000004
r17411 n9773 n9798 0.01175
r17412 n9797 n9798 0.15275
r17413 n9774 n9799 0.01175
r17414 n9775 n9800 0.016785714285714286
r17415 n9799 n9800 0.19975000000000001
r17416 n9776 n9801 0.039166666666666669
r17417 n9800 n9801 0.11750000000000001
r17418 n9777 n9802 0.039166666666666669
r17419 n9801 n9802 0.070499999999999993
r17420 n9778 n9803 0.058750000000000004
r17421 n9802 n9803 0.058750000000000004
r17422 n9779 n9804 0.010681818181818183
r17423 n9803 n9804 0.15275
r17424 n9780 n9805 0.0061842105263157894
r17425 n9804 n9805 0.35249999999999998
r17426 n9781 n9806 0.058750000000000004
r17427 n9805 n9806 0.24674999999999997
r17428 n9782 n9807 0.039166666666666669
r17429 n9806 n9807 0.058750000000000004
r17430 n9783 n9808 0.039166666666666669
r17431 n9807 n9808 0.070499999999999993
r17432 n9784 n9809 0.016785714285714286
r17433 n9808 n9809 0.11750000000000001
r17434 n9785 n9810 0.01175
r17435 n9809 n9810 0.19975000000000001
r17436 n9786 n9811 0.075199999999999989
r17437 n9787 n9812 0.10742857142857143
r17438 n9811 n9812 0.013316666666666668
r17439 n9788 n9813 0.25066666666666665
r17440 n9812 n9813 0.0078333333333333328
r17441 n9789 n9814 0.25066666666666665
r17442 n9813 n9814 0.0046999999999999993
r17443 n9790 n9815 0.376
r17444 n9814 n9815 0.0039166666666666664
r17445 n9791 n9816 0.094
r17446 n9815 n9816 0.0078333333333333328
r17447 n9792 n9817 0.034181818181818181
r17448 n9816 n9817 0.0235
r17449 n9793 n9818 0.376
r17450 n9817 n9818 0.018799999999999997
r17451 n9794 n9819 0.25066666666666665
r17452 n9818 n9819 0.0039166666666666664
r17453 n9795 n9820 0.25066666666666665
r17454 n9819 n9820 0.0046999999999999993
r17455 n9796 n9821 0.188
r17456 n9820 n9821 0.0054833333333333331
r17457 n9797 n9822 0.25066666666666665
r17458 n9821 n9822 0.0054833333333333331
r17459 n9798 n9823 0.075199999999999989
r17460 n9822 n9823 0.010183333333333334
r17461 n9799 n9824 0.075199999999999989
r17462 n9800 n9825 0.10742857142857143
r17463 n9824 n9825 0.013316666666666668
r17464 n9801 n9826 0.25066666666666665
r17465 n9825 n9826 0.0078333333333333328
r17466 n9802 n9827 0.25066666666666665
r17467 n9826 n9827 0.0046999999999999993
r17468 n9803 n9828 0.376
r17469 n9827 n9828 0.0039166666666666664
r17470 n9804 n9829 0.068363636363636363
r17471 n9828 n9829 0.010183333333333334
r17472 n9805 n9830 0.039578947368421054
r17473 n9829 n9830 0.0235
r17474 n9806 n9831 0.376
r17475 n9830 n9831 0.016449999999999999
r17476 n9807 n9832 0.25066666666666665
r17477 n9831 n9832 0.0039166666666666664
r17478 n9808 n9833 0.25066666666666665
r17479 n9832 n9833 0.0046999999999999993
r17480 n9809 n9834 0.10742857142857143
r17481 n9833 n9834 0.0078333333333333328
r17482 n9810 n9835 0.075199999999999989
r17483 n9834 n9835 0.013316666666666668
r17484 n9811 n9836 0.075199999999999989
r17485 n9812 n9837 0.10742857142857143
r17486 n9836 n9837 0.19975000000000001
r17487 n9813 n9838 0.25066666666666665
r17488 n9837 n9838 0.11750000000000001
r17489 n9814 n9839 0.25066666666666665
r17490 n9838 n9839 0.070499999999999993
r17491 n9815 n9840 0.376
r17492 n9839 n9840 0.058750000000000004
r17493 n9816 n9841 0.094
r17494 n9840 n9841 0.11750000000000001
r17495 n9817 n9842 0.034181818181818181
r17496 n9841 n9842 0.35249999999999998
r17497 n9818 n9843 0.376
r17498 n9842 n9843 0.28199999999999997
r17499 n9819 n9844 0.25066666666666665
r17500 n9843 n9844 0.058750000000000004
r17501 n9820 n9845 0.25066666666666665
r17502 n9844 n9845 0.070499999999999993
r17503 n9821 n9846 0.188
r17504 n9845 n9846 0.082250000000000004
r17505 n9822 n9847 0.25066666666666665
r17506 n9846 n9847 0.082250000000000004
r17507 n9823 n9848 0.075199999999999989
r17508 n9847 n9848 0.15275
r17509 n9824 n9849 0.075199999999999989
r17510 n9825 n9850 0.10742857142857143
r17511 n9849 n9850 0.19975000000000001
r17512 n9826 n9851 0.25066666666666665
r17513 n9850 n9851 0.11750000000000001
r17514 n9827 n9852 0.25066666666666665
r17515 n9851 n9852 0.070499999999999993
r17516 n9828 n9853 0.376
r17517 n9852 n9853 0.058750000000000004
r17518 n9829 n9854 0.068363636363636363
r17519 n9853 n9854 0.15275
r17520 n9830 n9855 0.039578947368421054
r17521 n9854 n9855 0.35249999999999998
r17522 n9831 n9856 0.376
r17523 n9855 n9856 0.24674999999999997
r17524 n9832 n9857 0.25066666666666665
r17525 n9856 n9857 0.058750000000000004
r17526 n9833 n9858 0.25066666666666665
r17527 n9857 n9858 0.070499999999999993
r17528 n9834 n9859 0.10742857142857143
r17529 n9858 n9859 0.11750000000000001
r17530 n9835 n9860 0.075199999999999989
r17531 n9859 n9860 0.19975000000000001
r17532 n9836 n9861 0.01175
r17533 n9837 n9862 0.016785714285714286
r17534 n9861 n9862 0.13316666666666668
r17535 n9838 n9863 0.039166666666666669
r17536 n9862 n9863 0.078333333333333338
r17537 n9839 n9864 0.039166666666666669
r17538 n9863 n9864 0.047
r17539 n9840 n9865 0.058750000000000004
r17540 n9864 n9865 0.039166666666666669
r17541 n9841 n9866 0.014687500000000001
r17542 n9865 n9866 0.078333333333333338
r17543 n9842 n9867 0.0053409090909090915
r17544 n9866 n9867 0.23499999999999999
r17545 n9843 n9868 0.058750000000000004
r17546 n9867 n9868 0.188
r17547 n9844 n9869 0.039166666666666669
r17548 n9868 n9869 0.039166666666666669
r17549 n9845 n9870 0.039166666666666669
r17550 n9869 n9870 0.047
r17551 n9846 n9871 0.029375000000000002
r17552 n9870 n9871 0.054833333333333331
r17553 n9847 n9872 0.039166666666666669
r17554 n9871 n9872 0.054833333333333331
r17555 n9848 n9873 0.01175
r17556 n9872 n9873 0.10183333333333335
r17557 n9849 n9874 0.01175
r17558 n9850 n9875 0.016785714285714286
r17559 n9874 n9875 0.13316666666666668
r17560 n9851 n9876 0.039166666666666669
r17561 n9875 n9876 0.078333333333333338
r17562 n9852 n9877 0.039166666666666669
r17563 n9876 n9877 0.047
r17564 n9853 n9878 0.058750000000000004
r17565 n9877 n9878 0.039166666666666669
r17566 n9854 n9879 0.010681818181818183
r17567 n9878 n9879 0.10183333333333335
r17568 n9855 n9880 0.0061842105263157894
r17569 n9879 n9880 0.23499999999999999
r17570 n9856 n9881 0.058750000000000004
r17571 n9880 n9881 0.16449999999999998
r17572 n9857 n9882 0.039166666666666669
r17573 n9881 n9882 0.039166666666666669
r17574 n9858 n9883 0.039166666666666669
r17575 n9882 n9883 0.047
r17576 n9859 n9884 0.016785714285714286
r17577 n9883 n9884 0.078333333333333338
r17578 n9860 n9885 0.01175
r17579 n9884 n9885 0.13316666666666668
r17580 n9861 n9886 0.01175
r17581 n9862 n9887 0.016785714285714286
r17582 n9886 n9887 0.19975000000000001
r17583 n9863 n9888 0.039166666666666669
r17584 n9887 n9888 0.11750000000000001
r17585 n9864 n9889 0.039166666666666669
r17586 n9888 n9889 0.070499999999999993
r17587 n9865 n9890 0.058750000000000004
r17588 n9889 n9890 0.058750000000000004
r17589 n9866 n9891 0.014687500000000001
r17590 n9890 n9891 0.11750000000000001
r17591 n9867 n9892 0.0053409090909090915
r17592 n9891 n9892 0.35249999999999998
r17593 n9868 n9893 0.058750000000000004
r17594 n9892 n9893 0.28199999999999997
r17595 n9869 n9894 0.039166666666666669
r17596 n9893 n9894 0.058750000000000004
r17597 n9870 n9895 0.039166666666666669
r17598 n9894 n9895 0.070499999999999993
r17599 n9871 n9896 0.029375000000000002
r17600 n9895 n9896 0.082250000000000004
r17601 n9872 n9897 0.039166666666666669
r17602 n9896 n9897 0.082250000000000004
r17603 n9873 n9898 0.01175
r17604 n9897 n9898 0.15275
r17605 n9874 n9899 0.01175
r17606 n9875 n9900 0.016785714285714286
r17607 n9899 n9900 0.19975000000000001
r17608 n9876 n9901 0.039166666666666669
r17609 n9900 n9901 0.11750000000000001
r17610 n9877 n9902 0.039166666666666669
r17611 n9901 n9902 0.070499999999999993
r17612 n9878 n9903 0.058750000000000004
r17613 n9902 n9903 0.058750000000000004
r17614 n9879 n9904 0.010681818181818183
r17615 n9903 n9904 0.15275
r17616 n9880 n9905 0.0061842105263157894
r17617 n9904 n9905 0.35249999999999998
r17618 n9881 n9906 0.058750000000000004
r17619 n9905 n9906 0.24674999999999997
r17620 n9882 n9907 0.039166666666666669
r17621 n9906 n9907 0.058750000000000004
r17622 n9883 n9908 0.039166666666666669
r17623 n9907 n9908 0.070499999999999993
r17624 n9884 n9909 0.016785714285714286
r17625 n9908 n9909 0.11750000000000001
r17626 n9885 n9910 0.01175
r17627 n9909 n9910 0.19975000000000001
r17628 n9886 n9911 0.018799999999999997
r17629 n9887 n9912 0.026857142857142857
r17630 n9911 n9912 0.066583333333333342
r17631 n9888 n9913 0.062666666666666662
r17632 n9912 n9913 0.039166666666666669
r17633 n9889 n9914 0.062666666666666662
r17634 n9913 n9914 0.0235
r17635 n9890 n9915 0.094
r17636 n9914 n9915 0.019583333333333335
r17637 n9891 n9916 0.0235
r17638 n9915 n9916 0.039166666666666669
r17639 n9892 n9917 0.0085454545454545453
r17640 n9916 n9917 0.11749999999999999
r17641 n9893 n9918 0.094
r17642 n9917 n9918 0.094
r17643 n9894 n9919 0.062666666666666662
r17644 n9918 n9919 0.019583333333333335
r17645 n9895 n9920 0.062666666666666662
r17646 n9919 n9920 0.0235
r17647 n9896 n9921 0.047
r17648 n9920 n9921 0.027416666666666666
r17649 n9897 n9922 0.062666666666666662
r17650 n9921 n9922 0.027416666666666666
r17651 n9898 n9923 0.018799999999999997
r17652 n9922 n9923 0.050916666666666673
r17653 n9899 n9924 0.018799999999999997
r17654 n9900 n9925 0.026857142857142857
r17655 n9924 n9925 0.066583333333333342
r17656 n9901 n9926 0.062666666666666662
r17657 n9925 n9926 0.039166666666666669
r17658 n9902 n9927 0.062666666666666662
r17659 n9926 n9927 0.0235
r17660 n9903 n9928 0.094
r17661 n9927 n9928 0.019583333333333335
r17662 n9904 n9929 0.017090909090909091
r17663 n9928 n9929 0.050916666666666673
r17664 n9905 n9930 0.0098947368421052635
r17665 n9929 n9930 0.11749999999999999
r17666 n9906 n9931 0.094
r17667 n9930 n9931 0.08224999999999999
r17668 n9907 n9932 0.062666666666666662
r17669 n9931 n9932 0.019583333333333335
r17670 n9908 n9933 0.062666666666666662
r17671 n9932 n9933 0.0235
r17672 n9909 n9934 0.026857142857142857
r17673 n9933 n9934 0.039166666666666669
r17674 n9910 n9935 0.018799999999999997
r17675 n9934 n9935 0.066583333333333342
r17676 n9911 n9936 0.018799999999999997
r17677 n9912 n9937 0.026857142857142857
r17678 n9936 n9937 0.19975000000000001
r17679 n9913 n9938 0.062666666666666662
r17680 n9937 n9938 0.11750000000000001
r17681 n9914 n9939 0.062666666666666662
r17682 n9938 n9939 0.070499999999999993
r17683 n9915 n9940 0.094
r17684 n9939 n9940 0.058750000000000004
r17685 n9916 n9941 0.0235
r17686 n9940 n9941 0.11750000000000001
r17687 n9917 n9942 0.0085454545454545453
r17688 n9941 n9942 0.35249999999999998
r17689 n9918 n9943 0.094
r17690 n9942 n9943 0.28199999999999997
r17691 n9919 n9944 0.062666666666666662
r17692 n9943 n9944 0.058750000000000004
r17693 n9920 n9945 0.062666666666666662
r17694 n9944 n9945 0.070499999999999993
r17695 n9921 n9946 0.047
r17696 n9945 n9946 0.082250000000000004
r17697 n9922 n9947 0.062666666666666662
r17698 n9946 n9947 0.082250000000000004
r17699 n9923 n9948 0.018799999999999997
r17700 n9947 n9948 0.15275
r17701 n9924 n9949 0.018799999999999997
r17702 n9925 n9950 0.026857142857142857
r17703 n9949 n9950 0.19975000000000001
r17704 n9926 n9951 0.062666666666666662
r17705 n9950 n9951 0.11750000000000001
r17706 n9927 n9952 0.062666666666666662
r17707 n9951 n9952 0.070499999999999993
r17708 n9928 n9953 0.094
r17709 n9952 n9953 0.058750000000000004
r17710 n9929 n9954 0.017090909090909091
r17711 n9953 n9954 0.15275
r17712 n9930 n9955 0.0098947368421052635
r17713 n9954 n9955 0.35249999999999998
r17714 n9931 n9956 0.094
r17715 n9955 n9956 0.24674999999999997
r17716 n9932 n9957 0.062666666666666662
r17717 n9956 n9957 0.058750000000000004
r17718 n9933 n9958 0.062666666666666662
r17719 n9957 n9958 0.070499999999999993
r17720 n9934 n9959 0.026857142857142857
r17721 n9958 n9959 0.11750000000000001
r17722 n9935 n9960 0.018799999999999997
r17723 n9959 n9960 0.19975000000000001
r17724 n9936 n9961 0.01175
r17725 n9937 n9962 0.016785714285714286
r17726 n9961 n9962 0.13316666666666668
r17727 n9938 n9963 0.039166666666666669
r17728 n9962 n9963 0.078333333333333338
r17729 n9939 n9964 0.039166666666666669
r17730 n9963 n9964 0.047
r17731 n9940 n9965 0.058750000000000004
r17732 n9964 n9965 0.039166666666666669
r17733 n9941 n9966 0.014687500000000001
r17734 n9965 n9966 0.078333333333333338
r17735 n9942 n9967 0.0053409090909090915
r17736 n9966 n9967 0.23499999999999999
r17737 n9943 n9968 0.058750000000000004
r17738 n9967 n9968 0.188
r17739 n9944 n9969 0.039166666666666669
r17740 n9968 n9969 0.039166666666666669
r17741 n9945 n9970 0.039166666666666669
r17742 n9969 n9970 0.047
r17743 n9946 n9971 0.029375000000000002
r17744 n9970 n9971 0.054833333333333331
r17745 n9947 n9972 0.039166666666666669
r17746 n9971 n9972 0.054833333333333331
r17747 n9948 n9973 0.01175
r17748 n9972 n9973 0.10183333333333335
r17749 n9949 n9974 0.01175
r17750 n9950 n9975 0.016785714285714286
r17751 n9974 n9975 0.13316666666666668
r17752 n9951 n9976 0.039166666666666669
r17753 n9975 n9976 0.078333333333333338
r17754 n9952 n9977 0.039166666666666669
r17755 n9976 n9977 0.047
r17756 n9953 n9978 0.058750000000000004
r17757 n9977 n9978 0.039166666666666669
r17758 n9954 n9979 0.010681818181818183
r17759 n9978 n9979 0.10183333333333335
r17760 n9955 n9980 0.0061842105263157894
r17761 n9979 n9980 0.23499999999999999
r17762 n9956 n9981 0.058750000000000004
r17763 n9980 n9981 0.16449999999999998
r17764 n9957 n9982 0.039166666666666669
r17765 n9981 n9982 0.039166666666666669
r17766 n9958 n9983 0.039166666666666669
r17767 n9982 n9983 0.047
r17768 n9959 n9984 0.016785714285714286
r17769 n9983 n9984 0.078333333333333338
r17770 n9960 n9985 0.01175
r17771 n9984 n9985 0.13316666666666668
r17772 n9961 n9986 0.016449999999999999
r17773 n9962 n9987 0.0235
r17774 n9986 n9987 0.099875000000000005
r17775 n9963 n9988 0.054833333333333331
r17776 n9987 n9988 0.058750000000000004
r17777 n9964 n9989 0.054833333333333331
r17778 n9988 n9989 0.035249999999999997
r17779 n9965 n9990 0.082250000000000004
r17780 n9989 n9990 0.029375000000000002
r17781 n9966 n9991 0.020562500000000001
r17782 n9990 n9991 0.058750000000000004
r17783 n9967 n9992 0.0074772727272727274
r17784 n9991 n9992 0.17624999999999999
r17785 n9968 n9993 0.082250000000000004
r17786 n9992 n9993 0.14099999999999999
r17787 n9969 n9994 0.054833333333333331
r17788 n9993 n9994 0.029375000000000002
r17789 n9970 n9995 0.054833333333333331
r17790 n9994 n9995 0.035249999999999997
r17791 n9971 n9996 0.041125000000000002
r17792 n9995 n9996 0.041125000000000002
r17793 n9972 n9997 0.054833333333333331
r17794 n9996 n9997 0.041125000000000002
r17795 n9973 n9998 0.016449999999999999
r17796 n9997 n9998 0.076374999999999998
r17797 n9974 n9999 0.016449999999999999
r17798 n9975 n10000 0.0235
r17799 n9999 n10000 0.099875000000000005
r17800 n9976 n10001 0.054833333333333331
r17801 n10000 n10001 0.058750000000000004
r17802 n9977 n10002 0.054833333333333331
r17803 n10001 n10002 0.035249999999999997
r17804 n9978 n10003 0.082250000000000004
r17805 n10002 n10003 0.029375000000000002
r17806 n9979 n10004 0.014954545454545455
r17807 n10003 n10004 0.076374999999999998
r17808 n9980 n10005 0.0086578947368421057
r17809 n10004 n10005 0.17624999999999999
r17810 n9981 n10006 0.082250000000000004
r17811 n10005 n10006 0.12337499999999998
r17812 n9982 n10007 0.054833333333333331
r17813 n10006 n10007 0.029375000000000002
r17814 n9983 n10008 0.054833333333333331
r17815 n10007 n10008 0.035249999999999997
r17816 n9984 n10009 0.0235
r17817 n10008 n10009 0.058750000000000004
r17818 n9985 n10010 0.016449999999999999
r17819 n10009 n10010 0.099875000000000005
r17820 n9986 n10011 0.016449999999999999
r17821 n9987 n10012 0.0235
r17822 n10011 n10012 0.13316666666666668
r17823 n9988 n10013 0.054833333333333331
r17824 n10012 n10013 0.078333333333333338
r17825 n9989 n10014 0.054833333333333331
r17826 n10013 n10014 0.047
r17827 n9990 n10015 0.082250000000000004
r17828 n10014 n10015 0.039166666666666669
r17829 n9991 n10016 0.020562500000000001
r17830 n10015 n10016 0.078333333333333338
r17831 n9992 n10017 0.0074772727272727274
r17832 n10016 n10017 0.23499999999999999
r17833 n9993 n10018 0.082250000000000004
r17834 n10017 n10018 0.188
r17835 n9994 n10019 0.054833333333333331
r17836 n10018 n10019 0.039166666666666669
r17837 n9995 n10020 0.054833333333333331
r17838 n10019 n10020 0.047
r17839 n9996 n10021 0.041125000000000002
r17840 n10020 n10021 0.054833333333333331
r17841 n9997 n10022 0.054833333333333331
r17842 n10021 n10022 0.054833333333333331
r17843 n9998 n10023 0.016449999999999999
r17844 n10022 n10023 0.10183333333333335
r17845 n9999 n10024 0.016449999999999999
r17846 n10000 n10025 0.0235
r17847 n10024 n10025 0.13316666666666668
r17848 n10001 n10026 0.054833333333333331
r17849 n10025 n10026 0.078333333333333338
r17850 n10002 n10027 0.054833333333333331
r17851 n10026 n10027 0.047
r17852 n10003 n10028 0.082250000000000004
r17853 n10027 n10028 0.039166666666666669
r17854 n10004 n10029 0.014954545454545455
r17855 n10028 n10029 0.10183333333333335
r17856 n10005 n10030 0.0086578947368421057
r17857 n10029 n10030 0.23499999999999999
r17858 n10006 n10031 0.082250000000000004
r17859 n10030 n10031 0.16449999999999998
r17860 n10007 n10032 0.054833333333333331
r17861 n10031 n10032 0.039166666666666669
r17862 n10008 n10033 0.054833333333333331
r17863 n10032 n10033 0.047
r17864 n10009 n10034 0.0235
r17865 n10033 n10034 0.078333333333333338
r17866 n10010 n10035 0.016449999999999999
r17867 n10034 n10035 0.13316666666666668
r17868 n24 0 158.10000000000002
r17869 n25 0 10.540000000000001
r17870 n26 0 158.10000000000002
r17871 n556 n3102 158.10000000000002
r17872 n557 n3103 10.540000000000001
r17873 n558 n3104 158.10000000000002
r17874 n1096 n3486 167.98125000000002
r17875 n1097 n3487 2687.7000000000003
r17876 n1211 n3593 67.192499999999995
r17877 n1212 n3594 1075.0799999999999
r17878 n1326 n3700 22.397500000000004
r17879 n1327 n3701 358.36000000000007
r17880 n1441 n3807 111.98750000000001
r17881 n1442 n3808 1791.8000000000002
r17882 n1556 n3914 83.990625000000009
r17883 n1557 n3915 1343.8500000000001
r17884 n1671 n4037 111.98750000000001
r17885 n1672 n4038 1791.8000000000002
r17886 n1794 n4160 167.98125000000002
r17887 n1795 n4161 2687.7000000000003
r17888 n2025 n4857 167.98125000000002
r17889 n2026 n4858 2687.7000000000003
r17890 n2148 n4989 111.98750000000001
r17891 n2149 n4990 1791.8000000000002
r17892 n2271 n5112 83.990625000000009
r17893 n2272 n5113 1343.8500000000001
r17894 n2386 n5235 111.98750000000001
r17895 n2387 n5236 1791.8000000000002
r17896 n2501 n5342 22.397500000000004
r17897 n2502 n5343 358.36000000000007
r17898 n2616 n5449 67.192499999999995
r17899 n2617 n5450 1075.0799999999999
r17900 n2731 n5556 167.98125000000002
r17901 n2732 n5557 2687.7000000000003
r17902 n1100 n3490 413.49230769230769
r17903 n1101 n3491 447.95000000000005
r17904 n1102 n3492 767.91428571428582
r17905 n1103 n3493 2687.7000000000003
r17906 n1215 n3597 165.39692307692309
r17907 n1216 n3598 179.18000000000004
r17908 n1217 n3599 307.16571428571433
r17909 n1218 n3600 1075.0799999999999
r17910 n1330 n3704 55.132307692307698
r17911 n1331 n3705 59.726666666666674
r17912 n1332 n3706 102.38857142857144
r17913 n1333 n3707 358.36000000000007
r17914 n1445 n3811 275.66153846153844
r17915 n1446 n3812 298.63333333333338
r17916 n1447 n3813 511.94285714285718
r17917 n1448 n3814 1791.8000000000002
r17918 n1560 n3918 206.74615384615385
r17919 n1561 n3919 223.97500000000002
r17920 n1562 n3920 383.95714285714291
r17921 n1563 n3921 1343.8500000000001
r17922 n1675 n4041 275.66153846153844
r17923 n1676 n4042 298.63333333333338
r17924 n1677 n4043 511.94285714285718
r17925 n1678 n4044 1791.8000000000002
r17926 n1798 n4164 413.49230769230769
r17927 n1799 n4165 447.95000000000005
r17928 n1800 n4166 767.91428571428582
r17929 n1801 n4167 2687.7000000000003
r17930 n2029 n4861 413.49230769230769
r17931 n2030 n4862 447.95000000000005
r17932 n2031 n4863 767.91428571428582
r17933 n2032 n4864 2687.7000000000003
r17934 n2152 n4993 275.66153846153844
r17935 n2153 n4994 298.63333333333338
r17936 n2154 n4995 511.94285714285718
r17937 n2155 n4996 1791.8000000000002
r17938 n2275 n5116 206.74615384615385
r17939 n2276 n5117 223.97500000000002
r17940 n2277 n5118 383.95714285714291
r17941 n2278 n5119 1343.8500000000001
r17942 n2390 n5239 275.66153846153844
r17943 n2391 n5240 298.63333333333338
r17944 n2392 n5241 511.94285714285718
r17945 n2393 n5242 1791.8000000000002
r17946 n2505 n5346 55.132307692307698
r17947 n2506 n5347 59.726666666666674
r17948 n2507 n5348 102.38857142857144
r17949 n2508 n5349 358.36000000000007
r17950 n2620 n5453 165.39692307692309
r17951 n2621 n5454 179.18000000000004
r17952 n2622 n5455 307.16571428571433
r17953 n2623 n5456 1075.0799999999999
r17954 n2735 n5560 413.49230769230769
r17955 n2736 n5561 447.95000000000005
r17956 n2737 n5562 767.91428571428582
r17957 n2738 n5563 2687.7000000000003
r17958 n612 n3232 2687.7000000000003
r17959 n613 n3233 597.26666666666677
r17960 n614 n3234 447.95000000000005
r17961 n615 n3235 597.26666666666677
r17962 n616 n3236 2687.7000000000003
r17963 n768 n3253 179.18000000000004
r17964 n769 n3254 39.817777777777778
r17965 n770 n3255 29.863333333333337
r17966 n771 n3256 39.817777777777778
r17967 n772 n3257 179.18000000000004
r17968 n924 n3274 2687.7000000000003
r17969 n925 n3275 597.26666666666677
r17970 n926 n3276 447.95000000000005
r17971 n927 n3277 597.26666666666677
r17972 n928 n3278 2687.7000000000003
r17973 n1109 n3499 597.26666666666677
r17974 n1110 n3500 447.95000000000005
r17975 n1111 n3501 597.26666666666677
r17976 n1112 n3502 2687.7000000000003
r17977 n1113 n3503 2687.7000000000003
r17978 n1224 n3606 238.90666666666669
r17979 n1225 n3607 179.18000000000004
r17980 n1226 n3608 238.90666666666669
r17981 n1227 n3609 1075.0799999999999
r17982 n1228 n3610 1075.0799999999999
r17983 n1339 n3713 79.635555555555555
r17984 n1340 n3714 59.726666666666674
r17985 n1341 n3715 79.635555555555555
r17986 n1342 n3716 358.36000000000007
r17987 n1343 n3717 358.36000000000007
r17988 n1454 n3820 398.17777777777781
r17989 n1455 n3821 298.63333333333338
r17990 n1456 n3822 398.17777777777781
r17991 n1457 n3823 1791.8000000000002
r17992 n1458 n3824 1791.8000000000002
r17993 n1569 n3927 298.63333333333338
r17994 n1570 n3928 223.97500000000002
r17995 n1571 n3929 298.63333333333338
r17996 n1572 n3930 1343.8500000000001
r17997 n1573 n3931 1343.8500000000001
r17998 n1684 n4050 398.17777777777781
r17999 n1685 n4051 298.63333333333338
r18000 n1686 n4052 398.17777777777781
r18001 n1687 n4053 1791.8000000000002
r18002 n1688 n4054 1791.8000000000002
r18003 n1807 n4173 597.26666666666677
r18004 n1808 n4174 447.95000000000005
r18005 n1809 n4175 597.26666666666677
r18006 n1810 n4176 2687.7000000000003
r18007 n1811 n4177 2687.7000000000003
r18008 n2038 n4870 597.26666666666677
r18009 n2039 n4871 447.95000000000005
r18010 n2040 n4872 597.26666666666677
r18011 n2041 n4873 2687.7000000000003
r18012 n2042 n4874 2687.7000000000003
r18013 n2161 n5002 398.17777777777781
r18014 n2162 n5003 298.63333333333338
r18015 n2163 n5004 398.17777777777781
r18016 n2164 n5005 1791.8000000000002
r18017 n2165 n5006 1791.8000000000002
r18018 n2284 n5125 298.63333333333338
r18019 n2285 n5126 223.97500000000002
r18020 n2286 n5127 298.63333333333338
r18021 n2287 n5128 1343.8500000000001
r18022 n2288 n5129 1343.8500000000001
r18023 n2399 n5248 398.17777777777781
r18024 n2400 n5249 298.63333333333338
r18025 n2401 n5250 398.17777777777781
r18026 n2402 n5251 1791.8000000000002
r18027 n2403 n5252 1791.8000000000002
r18028 n2514 n5355 79.635555555555555
r18029 n2515 n5356 59.726666666666674
r18030 n2516 n5357 79.635555555555555
r18031 n2517 n5358 358.36000000000007
r18032 n2518 n5359 358.36000000000007
r18033 n2629 n5462 238.90666666666669
r18034 n2630 n5463 179.18000000000004
r18035 n2631 n5464 238.90666666666669
r18036 n2632 n5465 1075.0799999999999
r18037 n2633 n5466 1075.0799999999999
r18038 n2744 n5569 597.26666666666677
r18039 n2745 n5570 447.95000000000005
r18040 n2746 n5571 597.26666666666677
r18041 n2747 n5572 2687.7000000000003
r18042 n2748 n5573 2687.7000000000003
r18043 n1117 n3507 167.98125000000002
r18044 n1118 n3508 2687.7000000000003
r18045 n1232 n3614 67.192499999999995
r18046 n1233 n3615 1075.0799999999999
r18047 n1347 n3721 22.397500000000004
r18048 n1348 n3722 358.36000000000007
r18049 n1462 n3828 111.98750000000001
r18050 n1463 n3829 1791.8000000000002
r18051 n1577 n3935 83.990625000000009
r18052 n1578 n3936 1343.8500000000001
r18053 n1692 n4058 111.98750000000001
r18054 n1693 n4059 1791.8000000000002
r18055 n1815 n4181 167.98125000000002
r18056 n1816 n4182 2687.7000000000003
r18057 n2046 n4878 167.98125000000002
r18058 n2047 n4879 2687.7000000000003
r18059 n2169 n5010 111.98750000000001
r18060 n2170 n5011 1791.8000000000002
r18061 n2292 n5133 83.990625000000009
r18062 n2293 n5134 1343.8500000000001
r18063 n2407 n5256 111.98750000000001
r18064 n2408 n5257 1791.8000000000002
r18065 n2522 n5363 22.397500000000004
r18066 n2523 n5364 358.36000000000007
r18067 n2637 n5470 67.192499999999995
r18068 n2638 n5471 1075.0799999999999
r18069 n2752 n5577 167.98125000000002
r18070 n2753 n5578 2687.7000000000003
r18071 n1950 n4528 2687.7000000000003
r18072 n1951 n4529 671.92500000000007
r18073 n1952 n4530 244.33636363636364
r18074 n1953 n4531 2687.7000000000003
r18075 n1962 n4564 179.18000000000004
r18076 n1963 n4565 44.795000000000009
r18077 n1964 n4566 16.289090909090913
r18078 n1965 n4567 179.18000000000004
r18079 n1974 n4599 2687.7000000000003
r18080 n1975 n4600 671.92500000000007
r18081 n1976 n4601 244.33636363636364
r18082 n1977 n4602 2687.7000000000003
r18083 n1126 n3512 167.98125000000002
r18084 n1127 n3513 2687.7000000000003
r18085 n1241 n3619 67.192499999999995
r18086 n1242 n3620 1075.0799999999999
r18087 n1356 n3726 22.397500000000004
r18088 n1357 n3727 358.36000000000007
r18089 n1471 n3833 111.98750000000001
r18090 n1472 n3834 1791.8000000000002
r18091 n1586 n3948 83.990625000000009
r18092 n1587 n3949 1343.8500000000001
r18093 n1705 n4071 111.98750000000001
r18094 n1706 n4072 1791.8000000000002
r18095 n1828 n4199 167.98125000000002
r18096 n1829 n4200 2687.7000000000003
r18097 n2059 n4896 167.98125000000002
r18098 n2060 n4897 2687.7000000000003
r18099 n2182 n5023 111.98750000000001
r18100 n2183 n5024 1791.8000000000002
r18101 n2301 n5146 83.990625000000009
r18102 n2302 n5147 1343.8500000000001
r18103 n2416 n5261 111.98750000000001
r18104 n2417 n5262 1791.8000000000002
r18105 n2531 n5368 22.397500000000004
r18106 n2532 n5369 358.36000000000007
r18107 n2646 n5475 67.192499999999995
r18108 n2647 n5476 1075.0799999999999
r18109 n2761 n5582 167.98125000000002
r18110 n2762 n5583 2687.7000000000003
r18111 n1130 n3516 167.98125000000002
r18112 n1131 n3517 2687.7000000000003
r18113 n1245 n3623 67.192499999999995
r18114 n1246 n3624 1075.0799999999999
r18115 n1360 n3730 22.397500000000004
r18116 n1361 n3731 358.36000000000007
r18117 n1475 n3837 111.98750000000001
r18118 n1476 n3838 1791.8000000000002
r18119 n1590 n3952 83.990625000000009
r18120 n1591 n3953 1343.8500000000001
r18121 n1709 n4075 111.98750000000001
r18122 n1710 n4076 1791.8000000000002
r18123 n1832 n4203 167.98125000000002
r18124 n1833 n4204 2687.7000000000003
r18125 n2063 n4900 167.98125000000002
r18126 n2064 n4901 2687.7000000000003
r18127 n2186 n5027 111.98750000000001
r18128 n2187 n5028 1791.8000000000002
r18129 n2305 n5150 83.990625000000009
r18130 n2306 n5151 1343.8500000000001
r18131 n2420 n5265 111.98750000000001
r18132 n2421 n5266 1791.8000000000002
r18133 n2535 n5372 22.397500000000004
r18134 n2536 n5373 358.36000000000007
r18135 n2650 n5479 67.192499999999995
r18136 n2651 n5480 1075.0799999999999
r18137 n2765 n5586 167.98125000000002
r18138 n2766 n5587 2687.7000000000003
r18139 n1134 n3520 167.98125000000002
r18140 n1135 n3521 2687.7000000000003
r18141 n1249 n3627 67.192499999999995
r18142 n1250 n3628 1075.0799999999999
r18143 n1364 n3734 22.397500000000004
r18144 n1365 n3735 358.36000000000007
r18145 n1479 n3841 111.98750000000001
r18146 n1480 n3842 1791.8000000000002
r18147 n1594 n3956 83.990625000000009
r18148 n1595 n3957 1343.8500000000001
r18149 n1713 n4079 111.98750000000001
r18150 n1714 n4080 1791.8000000000002
r18151 n1836 n4207 167.98125000000002
r18152 n1837 n4208 2687.7000000000003
r18153 n2067 n4904 167.98125000000002
r18154 n2068 n4905 2687.7000000000003
r18155 n2190 n5031 111.98750000000001
r18156 n2191 n5032 1791.8000000000002
r18157 n2309 n5154 83.990625000000009
r18158 n2310 n5155 1343.8500000000001
r18159 n2424 n5269 111.98750000000001
r18160 n2425 n5270 1791.8000000000002
r18161 n2539 n5376 22.397500000000004
r18162 n2540 n5377 358.36000000000007
r18163 n2654 n5483 67.192499999999995
r18164 n2655 n5484 1075.0799999999999
r18165 n2769 n5590 167.98125000000002
r18166 n2770 n5591 2687.7000000000003
r18167 n1138 n3524 167.98125000000002
r18168 n1139 n3525 2687.7000000000003
r18169 n1253 n3631 67.192499999999995
r18170 n1254 n3632 1075.0799999999999
r18171 n1368 n3738 22.397500000000004
r18172 n1369 n3739 358.36000000000007
r18173 n1483 n3845 111.98750000000001
r18174 n1484 n3846 1791.8000000000002
r18175 n1598 n3960 83.990625000000009
r18176 n1599 n3961 1343.8500000000001
r18177 n1717 n4083 111.98750000000001
r18178 n1718 n4084 1791.8000000000002
r18179 n1840 n4211 167.98125000000002
r18180 n1841 n4212 2687.7000000000003
r18181 n2071 n4908 167.98125000000002
r18182 n2072 n4909 2687.7000000000003
r18183 n2194 n5035 111.98750000000001
r18184 n2195 n5036 1791.8000000000002
r18185 n2313 n5158 83.990625000000009
r18186 n2314 n5159 1343.8500000000001
r18187 n2428 n5273 111.98750000000001
r18188 n2429 n5274 1791.8000000000002
r18189 n2543 n5380 22.397500000000004
r18190 n2544 n5381 358.36000000000007
r18191 n2658 n5487 67.192499999999995
r18192 n2659 n5488 1075.0799999999999
r18193 n2773 n5594 167.98125000000002
r18194 n2774 n5595 2687.7000000000003
r18195 n1142 n3528 167.98125000000002
r18196 n1143 n3529 2687.7000000000003
r18197 n1257 n3635 67.192499999999995
r18198 n1258 n3636 1075.0799999999999
r18199 n1372 n3742 22.397500000000004
r18200 n1373 n3743 358.36000000000007
r18201 n1487 n3849 111.98750000000001
r18202 n1488 n3850 1791.8000000000002
r18203 n1602 n3964 83.990625000000009
r18204 n1603 n3965 1343.8500000000001
r18205 n1721 n4087 111.98750000000001
r18206 n1722 n4088 1791.8000000000002
r18207 n1844 n4215 167.98125000000002
r18208 n1845 n4216 2687.7000000000003
r18209 n2075 n4912 167.98125000000002
r18210 n2076 n4913 2687.7000000000003
r18211 n2198 n5039 111.98750000000001
r18212 n2199 n5040 1791.8000000000002
r18213 n2317 n5162 83.990625000000009
r18214 n2318 n5163 1343.8500000000001
r18215 n2432 n5277 111.98750000000001
r18216 n2433 n5278 1791.8000000000002
r18217 n2547 n5384 22.397500000000004
r18218 n2548 n5385 358.36000000000007
r18219 n2662 n5491 67.192499999999995
r18220 n2663 n5492 1075.0799999999999
r18221 n2777 n5598 167.98125000000002
r18222 n2778 n5599 2687.7000000000003
r18223 n1146 n3532 167.98125000000002
r18224 n1147 n3533 2687.7000000000003
r18225 n1261 n3639 67.192499999999995
r18226 n1262 n3640 1075.0799999999999
r18227 n1376 n3746 22.397500000000004
r18228 n1377 n3747 358.36000000000007
r18229 n1491 n3853 111.98750000000001
r18230 n1492 n3854 1791.8000000000002
r18231 n1606 n3968 83.990625000000009
r18232 n1607 n3969 1343.8500000000001
r18233 n1725 n4091 111.98750000000001
r18234 n1726 n4092 1791.8000000000002
r18235 n1848 n4219 167.98125000000002
r18236 n1849 n4220 2687.7000000000003
r18237 n2079 n4916 167.98125000000002
r18238 n2080 n4917 2687.7000000000003
r18239 n2202 n5043 111.98750000000001
r18240 n2203 n5044 1791.8000000000002
r18241 n2321 n5166 83.990625000000009
r18242 n2322 n5167 1343.8500000000001
r18243 n2436 n5281 111.98750000000001
r18244 n2437 n5282 1791.8000000000002
r18245 n2551 n5388 22.397500000000004
r18246 n2552 n5389 358.36000000000007
r18247 n2666 n5495 67.192499999999995
r18248 n2667 n5496 1075.0799999999999
r18249 n2781 n5602 167.98125000000002
r18250 n2782 n5603 2687.7000000000003
r18251 n1150 n3536 167.98125000000002
r18252 n1151 n3537 2687.7000000000003
r18253 n1265 n3643 67.192499999999995
r18254 n1266 n3644 1075.0799999999999
r18255 n1380 n3750 22.397500000000004
r18256 n1381 n3751 358.36000000000007
r18257 n1495 n3857 111.98750000000001
r18258 n1496 n3858 1791.8000000000002
r18259 n1610 n3972 83.990625000000009
r18260 n1611 n3973 1343.8500000000001
r18261 n1729 n4095 111.98750000000001
r18262 n1730 n4096 1791.8000000000002
r18263 n1852 n4223 167.98125000000002
r18264 n1853 n4224 2687.7000000000003
r18265 n2083 n4920 167.98125000000002
r18266 n2084 n4921 2687.7000000000003
r18267 n2206 n5047 111.98750000000001
r18268 n2207 n5048 1791.8000000000002
r18269 n2325 n5170 83.990625000000009
r18270 n2326 n5171 1343.8500000000001
r18271 n2440 n5285 111.98750000000001
r18272 n2441 n5286 1791.8000000000002
r18273 n2555 n5392 22.397500000000004
r18274 n2556 n5393 358.36000000000007
r18275 n2670 n5499 67.192499999999995
r18276 n2671 n5500 1075.0799999999999
r18277 n2785 n5606 167.98125000000002
r18278 n2786 n5607 2687.7000000000003
r18279 n1154 n3540 167.98125000000002
r18280 n1155 n3541 2687.7000000000003
r18281 n1269 n3647 67.192499999999995
r18282 n1270 n3648 1075.0799999999999
r18283 n1384 n3754 22.397500000000004
r18284 n1385 n3755 358.36000000000007
r18285 n1499 n3861 111.98750000000001
r18286 n1500 n3862 1791.8000000000002
r18287 n1614 n3976 83.990625000000009
r18288 n1615 n3977 1343.8500000000001
r18289 n1733 n4099 111.98750000000001
r18290 n1734 n4100 1791.8000000000002
r18291 n1856 n4227 167.98125000000002
r18292 n1857 n4228 2687.7000000000003
r18293 n2087 n4924 167.98125000000002
r18294 n2088 n4925 2687.7000000000003
r18295 n2210 n5051 111.98750000000001
r18296 n2211 n5052 1791.8000000000002
r18297 n2329 n5174 83.990625000000009
r18298 n2330 n5175 1343.8500000000001
r18299 n2444 n5289 111.98750000000001
r18300 n2445 n5290 1791.8000000000002
r18301 n2559 n5396 22.397500000000004
r18302 n2560 n5397 358.36000000000007
r18303 n2674 n5503 67.192499999999995
r18304 n2675 n5504 1075.0799999999999
r18305 n2789 n5610 167.98125000000002
r18306 n2790 n5611 2687.7000000000003
r18307 n1160 n3546 2687.7000000000003
r18308 n1161 n3547 671.92500000000007
r18309 n1162 n3548 244.33636363636364
r18310 n1163 n3549 5375.4000000000005
r18311 n1164 n3550 5375.4000000000005
r18312 n1275 n3653 1075.0799999999999
r18313 n1276 n3654 268.76999999999998
r18314 n1277 n3655 97.734545454545454
r18315 n1278 n3656 2150.1599999999999
r18316 n1279 n3657 2150.1599999999999
r18317 n1390 n3760 358.36000000000007
r18318 n1391 n3761 89.590000000000018
r18319 n1392 n3762 32.578181818181825
r18320 n1393 n3763 716.72000000000014
r18321 n1394 n3764 716.72000000000014
r18322 n1505 n3867 1791.8000000000002
r18323 n1506 n3868 447.95000000000005
r18324 n1507 n3869 162.8909090909091
r18325 n1508 n3870 3583.6000000000004
r18326 n1509 n3871 3583.6000000000004
r18327 n1620 n3982 1343.8500000000001
r18328 n1621 n3983 335.96250000000003
r18329 n1622 n3984 122.16818181818182
r18330 n1623 n3985 2687.7000000000003
r18331 n1624 n3986 2687.7000000000003
r18332 n1739 n4105 1791.8000000000002
r18333 n1740 n4106 447.95000000000005
r18334 n1741 n4107 162.8909090909091
r18335 n1742 n4108 3583.6000000000004
r18336 n1743 n4109 3583.6000000000004
r18337 n1862 n4233 2687.7000000000003
r18338 n1863 n4234 671.92500000000007
r18339 n1864 n4235 244.33636363636364
r18340 n1865 n4236 5375.4000000000005
r18341 n1866 n4237 5375.4000000000005
r18342 n2093 n4930 2687.7000000000003
r18343 n2094 n4931 671.92500000000007
r18344 n2095 n4932 244.33636363636364
r18345 n2096 n4933 5375.4000000000005
r18346 n2097 n4934 5375.4000000000005
r18347 n2216 n5057 1791.8000000000002
r18348 n2217 n5058 447.95000000000005
r18349 n2218 n5059 162.8909090909091
r18350 n2219 n5060 3583.6000000000004
r18351 n2220 n5061 3583.6000000000004
r18352 n2335 n5180 1343.8500000000001
r18353 n2336 n5181 335.96250000000003
r18354 n2337 n5182 122.16818181818182
r18355 n2338 n5183 2687.7000000000003
r18356 n2339 n5184 2687.7000000000003
r18357 n2450 n5295 1791.8000000000002
r18358 n2451 n5296 447.95000000000005
r18359 n2452 n5297 162.8909090909091
r18360 n2453 n5298 3583.6000000000004
r18361 n2454 n5299 3583.6000000000004
r18362 n2565 n5402 358.36000000000007
r18363 n2566 n5403 89.590000000000018
r18364 n2567 n5404 32.578181818181825
r18365 n2568 n5405 716.72000000000014
r18366 n2569 n5406 716.72000000000014
r18367 n2680 n5509 1075.0799999999999
r18368 n2681 n5510 268.76999999999998
r18369 n2682 n5511 97.734545454545454
r18370 n2683 n5512 2150.1599999999999
r18371 n2684 n5513 2150.1599999999999
r18372 n2795 n5616 2687.7000000000003
r18373 n2796 n5617 671.92500000000007
r18374 n2797 n5618 244.33636363636364
r18375 n2798 n5619 5375.4000000000005
r18376 n2799 n5620 5375.4000000000005
r18377 n689 n3241 5375.4000000000005
r18378 n690 n3242 5375.4000000000005
r18379 n691 n3243 537.53999999999996
r18380 n692 n3244 447.95000000000005
r18381 n693 n3245 671.92500000000007
r18382 n694 n3246 2687.7000000000003
r18383 n845 n3262 358.36000000000007
r18384 n846 n3263 358.36000000000007
r18385 n847 n3264 35.836000000000006
r18386 n848 n3265 29.863333333333337
r18387 n849 n3266 44.795000000000009
r18388 n850 n3267 179.18000000000004
r18389 n1001 n3283 5375.4000000000005
r18390 n1002 n3284 5375.4000000000005
r18391 n1003 n3285 537.53999999999996
r18392 n1004 n3286 447.95000000000005
r18393 n1005 n3287 671.92500000000007
r18394 n1006 n3288 2687.7000000000003
r18395 n1172 n3558 895.90000000000009
r18396 n1173 n3559 447.95000000000005
r18397 n1174 n3560 383.95714285714291
r18398 n1175 n3561 2687.7000000000003
r18399 n1287 n3665 358.36000000000007
r18400 n1288 n3666 179.18000000000004
r18401 n1289 n3667 153.58285714285716
r18402 n1290 n3668 1075.0799999999999
r18403 n1402 n3772 119.45333333333335
r18404 n1403 n3773 59.726666666666674
r18405 n1404 n3774 51.194285714285719
r18406 n1405 n3775 358.36000000000007
r18407 n1517 n3879 597.26666666666677
r18408 n1518 n3880 298.63333333333338
r18409 n1519 n3881 255.97142857142859
r18410 n1520 n3882 1791.8000000000002
r18411 n1632 n3994 447.95000000000005
r18412 n1633 n3995 223.97500000000002
r18413 n1634 n3996 191.97857142857146
r18414 n1635 n3997 1343.8500000000001
r18415 n1751 n4117 597.26666666666677
r18416 n1752 n4118 298.63333333333338
r18417 n1753 n4119 255.97142857142859
r18418 n1754 n4120 1791.8000000000002
r18419 n1874 n4245 895.90000000000009
r18420 n1875 n4246 447.95000000000005
r18421 n1876 n4247 383.95714285714291
r18422 n1877 n4248 2687.7000000000003
r18423 n2105 n4942 895.90000000000009
r18424 n2106 n4943 447.95000000000005
r18425 n2107 n4944 383.95714285714291
r18426 n2108 n4945 2687.7000000000003
r18427 n2228 n5069 597.26666666666677
r18428 n2229 n5070 298.63333333333338
r18429 n2230 n5071 255.97142857142859
r18430 n2231 n5072 1791.8000000000002
r18431 n2347 n5192 447.95000000000005
r18432 n2348 n5193 223.97500000000002
r18433 n2349 n5194 191.97857142857146
r18434 n2350 n5195 1343.8500000000001
r18435 n2462 n5307 597.26666666666677
r18436 n2463 n5308 298.63333333333338
r18437 n2464 n5309 255.97142857142859
r18438 n2465 n5310 1791.8000000000002
r18439 n2577 n5414 119.45333333333335
r18440 n2578 n5415 59.726666666666674
r18441 n2579 n5416 51.194285714285719
r18442 n2580 n5417 358.36000000000007
r18443 n2692 n5521 358.36000000000007
r18444 n2693 n5522 179.18000000000004
r18445 n2694 n5523 153.58285714285716
r18446 n2695 n5524 1075.0799999999999
r18447 n2807 n5628 895.90000000000009
r18448 n2808 n5629 447.95000000000005
r18449 n2809 n5630 383.95714285714291
r18450 n2810 n5631 2687.7000000000003
r18451 n1178 n3564 167.98125000000002
r18452 n1179 n3565 2687.7000000000003
r18453 n1293 n3671 67.192499999999995
r18454 n1294 n3672 1075.0799999999999
r18455 n1408 n3778 22.397500000000004
r18456 n1409 n3779 358.36000000000007
r18457 n1523 n3885 111.98750000000001
r18458 n1524 n3886 1791.8000000000002
r18459 n1638 n4000 83.990625000000009
r18460 n1639 n4001 1343.8500000000001
r18461 n1757 n4123 111.98750000000001
r18462 n1758 n4124 1791.8000000000002
r18463 n1880 n4251 167.98125000000002
r18464 n1881 n4252 2687.7000000000003
r18465 n2111 n4948 167.98125000000002
r18466 n2112 n4949 2687.7000000000003
r18467 n2234 n5075 111.98750000000001
r18468 n2235 n5076 1791.8000000000002
r18469 n2353 n5198 83.990625000000009
r18470 n2354 n5199 1343.8500000000001
r18471 n2468 n5313 111.98750000000001
r18472 n2469 n5314 1791.8000000000002
r18473 n2583 n5420 22.397500000000004
r18474 n2584 n5421 358.36000000000007
r18475 n2698 n5527 67.192499999999995
r18476 n2699 n5528 1075.0799999999999
r18477 n2813 n5634 167.98125000000002
r18478 n2814 n5635 2687.7000000000003
r18479 n1182 n3568 167.98125000000002
r18480 n1183 n3569 2687.7000000000003
r18481 n1297 n3675 67.192499999999995
r18482 n1298 n3676 1075.0799999999999
r18483 n1412 n3782 22.397500000000004
r18484 n1413 n3783 358.36000000000007
r18485 n1527 n3889 111.98750000000001
r18486 n1528 n3890 1791.8000000000002
r18487 n1642 n4004 83.990625000000009
r18488 n1643 n4005 1343.8500000000001
r18489 n1761 n4127 111.98750000000001
r18490 n1762 n4128 1791.8000000000002
r18491 n1884 n4255 167.98125000000002
r18492 n1885 n4256 2687.7000000000003
r18493 n2115 n4952 167.98125000000002
r18494 n2116 n4953 2687.7000000000003
r18495 n2238 n5079 111.98750000000001
r18496 n2239 n5080 1791.8000000000002
r18497 n2357 n5202 83.990625000000009
r18498 n2358 n5203 1343.8500000000001
r18499 n2472 n5317 111.98750000000001
r18500 n2473 n5318 1791.8000000000002
r18501 n2587 n5424 22.397500000000004
r18502 n2588 n5425 358.36000000000007
r18503 n2702 n5531 67.192499999999995
r18504 n2703 n5532 1075.0799999999999
r18505 n2817 n5638 167.98125000000002
r18506 n2818 n5639 2687.7000000000003
r18507 n1186 n3572 167.98125000000002
r18508 n1187 n3573 2687.7000000000003
r18509 n1301 n3679 67.192499999999995
r18510 n1302 n3680 1075.0799999999999
r18511 n1416 n3786 22.397500000000004
r18512 n1417 n3787 358.36000000000007
r18513 n1531 n3893 111.98750000000001
r18514 n1532 n3894 1791.8000000000002
r18515 n1646 n4008 83.990625000000009
r18516 n1647 n4009 1343.8500000000001
r18517 n1765 n4131 111.98750000000001
r18518 n1766 n4132 1791.8000000000002
r18519 n1888 n4259 167.98125000000002
r18520 n1889 n4260 2687.7000000000003
r18521 n2119 n4956 167.98125000000002
r18522 n2120 n4957 2687.7000000000003
r18523 n2242 n5083 111.98750000000001
r18524 n2243 n5084 1791.8000000000002
r18525 n2361 n5206 83.990625000000009
r18526 n2362 n5207 1343.8500000000001
r18527 n2476 n5321 111.98750000000001
r18528 n2477 n5322 1791.8000000000002
r18529 n2591 n5428 22.397500000000004
r18530 n2592 n5429 358.36000000000007
r18531 n2706 n5535 67.192499999999995
r18532 n2707 n5536 1075.0799999999999
r18533 n2821 n5642 167.98125000000002
r18534 n2822 n5643 2687.7000000000003
r18535 n1190 n3576 167.98125000000002
r18536 n1191 n3577 2687.7000000000003
r18537 n1305 n3683 67.192499999999995
r18538 n1306 n3684 1075.0799999999999
r18539 n1420 n3790 22.397500000000004
r18540 n1421 n3791 358.36000000000007
r18541 n1535 n3897 111.98750000000001
r18542 n1536 n3898 1791.8000000000002
r18543 n1650 n4012 83.990625000000009
r18544 n1651 n4013 1343.8500000000001
r18545 n1769 n4135 111.98750000000001
r18546 n1770 n4136 1791.8000000000002
r18547 n1892 n4263 167.98125000000002
r18548 n1893 n4264 2687.7000000000003
r18549 n2123 n4960 167.98125000000002
r18550 n2124 n4961 2687.7000000000003
r18551 n2246 n5087 111.98750000000001
r18552 n2247 n5088 1791.8000000000002
r18553 n2365 n5210 83.990625000000009
r18554 n2366 n5211 1343.8500000000001
r18555 n2480 n5325 111.98750000000001
r18556 n2481 n5326 1791.8000000000002
r18557 n2595 n5432 22.397500000000004
r18558 n2596 n5433 358.36000000000007
r18559 n2710 n5539 67.192499999999995
r18560 n2711 n5540 1075.0799999999999
r18561 n2825 n5646 167.98125000000002
r18562 n2826 n5647 2687.7000000000003
r18563 n1194 n3580 167.98125000000002
r18564 n1195 n3581 2687.7000000000003
r18565 n1309 n3687 67.192499999999995
r18566 n1310 n3688 1075.0799999999999
r18567 n1424 n3794 22.397500000000004
r18568 n1425 n3795 358.36000000000007
r18569 n1539 n3901 111.98750000000001
r18570 n1540 n3902 1791.8000000000002
r18571 n1654 n4016 83.990625000000009
r18572 n1655 n4017 1343.8500000000001
r18573 n1773 n4139 111.98750000000001
r18574 n1774 n4140 1791.8000000000002
r18575 n1896 n4267 167.98125000000002
r18576 n1897 n4268 2687.7000000000003
r18577 n2127 n4964 167.98125000000002
r18578 n2128 n4965 2687.7000000000003
r18579 n2250 n5091 111.98750000000001
r18580 n2251 n5092 1791.8000000000002
r18581 n2369 n5214 83.990625000000009
r18582 n2370 n5215 1343.8500000000001
r18583 n2484 n5329 111.98750000000001
r18584 n2485 n5330 1791.8000000000002
r18585 n2599 n5436 22.397500000000004
r18586 n2600 n5437 358.36000000000007
r18587 n2714 n5543 67.192499999999995
r18588 n2715 n5544 1075.0799999999999
r18589 n2829 n5650 167.98125000000002
r18590 n2830 n5651 2687.7000000000003
r18591 n1198 n3584 167.98125000000002
r18592 n1199 n3585 2687.7000000000003
r18593 n1313 n3691 67.192499999999995
r18594 n1314 n3692 1075.0799999999999
r18595 n1428 n3798 22.397500000000004
r18596 n1429 n3799 358.36000000000007
r18597 n1543 n3905 111.98750000000001
r18598 n1544 n3906 1791.8000000000002
r18599 n1658 n4020 83.990625000000009
r18600 n1659 n4021 1343.8500000000001
r18601 n1777 n4143 111.98750000000001
r18602 n1778 n4144 1791.8000000000002
r18603 n1900 n4271 167.98125000000002
r18604 n1901 n4272 2687.7000000000003
r18605 n2131 n4968 167.98125000000002
r18606 n2132 n4969 2687.7000000000003
r18607 n2254 n5095 111.98750000000001
r18608 n2255 n5096 1791.8000000000002
r18609 n2373 n5218 83.990625000000009
r18610 n2374 n5219 1343.8500000000001
r18611 n2488 n5333 111.98750000000001
r18612 n2489 n5334 1791.8000000000002
r18613 n2603 n5440 22.397500000000004
r18614 n2604 n5441 358.36000000000007
r18615 n2718 n5547 67.192499999999995
r18616 n2719 n5548 1075.0799999999999
r18617 n2833 n5654 167.98125000000002
r18618 n2834 n5655 2687.7000000000003
r18619 n1202 n3588 167.98125000000002
r18620 n1203 n3589 2687.7000000000003
r18621 n1317 n3695 67.192499999999995
r18622 n1318 n3696 1075.0799999999999
r18623 n1432 n3802 22.397500000000004
r18624 n1433 n3803 358.36000000000007
r18625 n1547 n3909 111.98750000000001
r18626 n1548 n3910 1791.8000000000002
r18627 n1662 n4024 83.990625000000009
r18628 n1663 n4025 1343.8500000000001
r18629 n1781 n4147 111.98750000000001
r18630 n1782 n4148 1791.8000000000002
r18631 n1904 n4275 167.98125000000002
r18632 n1905 n4276 2687.7000000000003
r18633 n2135 n4972 167.98125000000002
r18634 n2136 n4973 2687.7000000000003
r18635 n2258 n5099 111.98750000000001
r18636 n2259 n5100 1791.8000000000002
r18637 n2377 n5222 83.990625000000009
r18638 n2378 n5223 1343.8500000000001
r18639 n2492 n5337 111.98750000000001
r18640 n2493 n5338 1791.8000000000002
r18641 n2607 n5444 22.397500000000004
r18642 n2608 n5445 358.36000000000007
r18643 n2722 n5551 67.192499999999995
r18644 n2723 n5552 1075.0799999999999
r18645 n2837 n5658 167.98125000000002
r18646 n2838 n5659 2687.7000000000003
r18647 n1956 n4552 2687.7000000000003
r18648 n1957 n4553 488.67272727272729
r18649 n1958 n4554 282.91578947368424
r18650 n1959 n4555 2687.7000000000003
r18651 n1968 n4577 179.18000000000004
r18652 n1969 n4578 32.578181818181825
r18653 n1970 n4579 18.86105263157895
r18654 n1971 n4580 179.18000000000004
r18655 n1980 n4623 2687.7000000000003
r18656 n1981 n4624 488.67272727272729
r18657 n1982 n4625 282.91578947368424
r18658 n1983 n4626 2687.7000000000003
r18659 n34 vdd 158.10000000000002
r18660 n35 vdd 10.540000000000001
r18661 n36 vdd 158.10000000000002
r18662 n566 n3112 158.10000000000002
r18663 n567 n3113 10.540000000000001
r18664 n568 n3114 158.10000000000002
r18665 n3170 n5814 4.5
r18666 n3602 n6878 90
r18667 n3603 n6879 38.571428571428569
r18668 n3709 n6933 30
r18669 n3710 n6934 12.857142857142858
r18670 n3816 n6988 150
r18671 n3817 n6989 64.285714285714278
r18672 n3923 n7068 112.5
r18673 n3924 n7069 48.214285714285715
r18674 n4046 n7148 150
r18675 n4047 n7149 64.285714285714278
r18676 n4998 n7943 150
r18677 n4999 n7944 64.285714285714278
r18678 n5121 n8005 112.5
r18679 n5122 n8006 48.214285714285715
r18680 n5244 n8067 150
r18681 n5245 n8068 64.285714285714278
r18682 n5351 n8129 30
r18683 n5352 n8130 12.857142857142858
r18684 n5458 n8166 90
r18685 n5459 n8167 38.571428571428569
r18686 n3254 n6372 15
r18687 n3255 n6373 11.25
r18688 n3256 n6374 15
r18689 n4565 n7593 16.875
r18690 n4566 n7594 6.1363636363636367
r18691 n3654 n6888 101.25
r18692 n3655 n6889 36.81818181818182
r18693 n3761 n6943 33.75
r18694 n3762 n6944 12.272727272727273
r18695 n3868 n7011 168.75
r18696 n3869 n7012 61.363636363636367
r18697 n3983 n7091 126.5625
r18698 n3984 n7092 46.022727272727273
r18699 n4106 n7171 168.75
r18700 n4107 n7172 61.363636363636367
r18701 n5058 n7966 168.75
r18702 n5059 n7967 61.363636363636367
r18703 n5181 n8028 126.5625
r18704 n5182 n8029 46.022727272727273
r18705 n5296 n8090 168.75
r18706 n5297 n8091 61.363636363636367
r18707 n5403 n8139 33.75
r18708 n5404 n8140 12.272727272727273
r18709 n5510 n8176 101.25
r18710 n5511 n8177 36.81818181818182
r18711 n3264 n6386 13.5
r18712 n3265 n6387 11.25
r18713 n3266 n6388 16.875
r18714 n4578 n7606 12.272727272727273
r18715 n4579 n7607 7.1052631578947372
r18716 n3175 n5824 4.5
r18717 n7477 n9764 606.22222222222229
r18718 n7478 n9765 909.33333333333337
r18719 n7479 n9766 227.33333333333334
r18720 n7480 n9767 82.666666666666671
r18721 n7481 n9768 909.33333333333337
r18722 n7482 n9769 606.22222222222229
r18723 n7539 n9789 909.33333333333337
r18724 n7540 n9790 1364
r18725 n7541 n9791 341
r18726 n7542 n9792 124
r18727 n7543 n9793 1364
r18728 n7544 n9794 909.33333333333337
r18729 n7591 n9814 60.62222222222222
r18730 n7592 n9815 90.933333333333337
r18731 n7593 n9816 22.733333333333334
r18732 n7594 n9817 8.2666666666666675
r18733 n7595 n9818 90.933333333333337
r18734 n7596 n9819 60.62222222222222
r18735 n7642 n9839 909.33333333333337
r18736 n7643 n9840 1364
r18737 n7644 n9841 341
r18738 n7645 n9842 124
r18739 n7646 n9843 1364
r18740 n7647 n9844 909.33333333333337
r18741 n7704 n9864 606.22222222222229
r18742 n7705 n9865 909.33333333333337
r18743 n7706 n9866 227.33333333333334
r18744 n7707 n9867 82.666666666666671
r18745 n7708 n9868 909.33333333333337
r18746 n7709 n9869 606.22222222222229
r18747 n7501 n9777 606.22222222222229
r18748 n7502 n9778 909.33333333333337
r18749 n7503 n9779 165.33333333333334
r18750 n7504 n9780 95.719298245614041
r18751 n7505 n9781 909.33333333333337
r18752 n7506 n9782 606.22222222222229
r18753 n7563 n9802 909.33333333333337
r18754 n7564 n9803 1364
r18755 n7565 n9804 248
r18756 n7566 n9805 143.57894736842107
r18757 n7567 n9806 1364
r18758 n7568 n9807 909.33333333333337
r18759 n7604 n9827 60.62222222222222
r18760 n7605 n9828 90.933333333333337
r18761 n7606 n9829 16.533333333333335
r18762 n7607 n9830 9.5719298245614031
r18763 n7608 n9831 90.933333333333337
r18764 n7609 n9832 60.62222222222222
r18765 n7666 n9852 909.33333333333337
r18766 n7667 n9853 1364
r18767 n7668 n9854 248
r18768 n7669 n9855 143.57894736842107
r18769 n7670 n9856 1364
r18770 n7671 n9857 909.33333333333337
r18771 n7728 n9877 606.22222222222229
r18772 n7729 n9878 909.33333333333337
r18773 n7730 n9879 165.33333333333334
r18774 n7731 n9880 95.719298245614041
r18775 n7732 n9881 909.33333333333337
r18776 n7733 n9882 606.22222222222229
r18777 n1076 t_m2_b 1420.7142857142858
r18778 n1080 t_m2_b 9945
r18779 n1084 t_m2_b 3978
r18780 n1088 t_m2_b 3315
r18781 n1092 t_m2_b 9945
r18782 n1207 t_m2_b 3978
r18783 n1949 t_m2_b 9945
r18784 n1961 t_m2_b 663
r18785 n1973 t_m2_b 9945
r18786 n2612 t_m2_b 3978
r18787 n2727 t_m2_b 9945
r18788 n2842 t_m2_b 3315
r18789 n2846 t_m2_b 2841.4285714285716
r18790 n2850 t_m2_b 1420.7142857142858
r18791 n595 t_m2_b 9945
r18792 n751 t_m2_b 663
r18793 n907 t_m2_b 9945
r18794 n2865 t_m2_b 585
r18795 n599 t_m2_b 169065
r18796 n600 t_m2_b 10566.5625
r18797 n755 t_m2_b 11271
r18798 n756 t_m2_b 704.4375
r18799 n911 t_m2_b 169065
r18800 n912 t_m2_b 10566.5625
r18801 n2869 t_m2_b 9945
r18802 n2870 t_m2_b 621.5625
r18803 n1096 t_m2_s 3341.5625
r18804 n1097 t_m2_s 53465
r18805 n1211 t_m2_s 1336.625
r18806 n1212 t_m2_s 21386
r18807 n1326 t_m2_s 445.54166666666669
r18808 n1327 t_m2_s 7128.666666666667
r18809 n1441 t_m2_s 2227.7083333333335
r18810 n1442 t_m2_s 35643.333333333336
r18811 n1556 t_m2_s 1670.78125
r18812 n1557 t_m2_s 26732.5
r18813 n1671 t_m2_s 2227.7083333333335
r18814 n1672 t_m2_s 35643.333333333336
r18815 n1794 t_m2_s 3341.5625
r18816 n1795 t_m2_s 53465
r18817 n2025 t_m2_d 3341.5625
r18818 n2026 t_m2_d 53465
r18819 n2148 t_m2_d 2227.7083333333335
r18820 n2149 t_m2_d 35643.333333333336
r18821 n2271 t_m2_d 1670.78125
r18822 n2272 t_m2_d 26732.5
r18823 n2386 t_m2_d 2227.7083333333335
r18824 n2387 t_m2_d 35643.333333333336
r18825 n2501 t_m2_d 445.54166666666669
r18826 n2502 t_m2_d 7128.666666666667
r18827 n2616 t_m2_d 1336.625
r18828 n2617 t_m2_d 21386
r18829 n2731 t_m2_d 3341.5625
r18830 n2732 t_m2_d 53465
r18831 n603 t_m2_b 169065
r18832 n604 t_m2_b 26010
r18833 n605 t_m2_b 28177.5
r18834 n606 t_m2_b 48304.285714285717
r18835 n759 t_m2_b 11271
r18836 n760 t_m2_b 1734
r18837 n761 t_m2_b 1878.5
r18838 n762 t_m2_b 3220.2857142857142
r18839 n915 t_m2_b 169065
r18840 n916 t_m2_b 26010
r18841 n917 t_m2_b 28177.5
r18842 n918 t_m2_b 48304.285714285717
r18843 n2873 t_m2_b 9945
r18844 n2874 t_m2_b 1530
r18845 n2875 t_m2_b 1657.5
r18846 n2876 t_m2_b 2841.4285714285716
r18847 n1100 t_m2_s 8225.3846153846152
r18848 n1101 t_m2_s 8910.8333333333339
r18849 n1102 t_m2_s 15275.714285714286
r18850 n1103 t_m2_s 53465
r18851 n1215 t_m2_s 3290.1538461538462
r18852 n1216 t_m2_s 3564.3333333333335
r18853 n1217 t_m2_s 6110.2857142857147
r18854 n1218 t_m2_s 21386
r18855 n1330 t_m2_s 1096.7179487179487
r18856 n1331 t_m2_s 1188.1111111111111
r18857 n1332 t_m2_s 2036.7619047619046
r18858 n1333 t_m2_s 7128.666666666667
r18859 n1445 t_m2_s 5483.5897435897432
r18860 n1446 t_m2_s 5940.5555555555557
r18861 n1447 t_m2_s 10183.809523809523
r18862 n1448 t_m2_s 35643.333333333336
r18863 n1560 t_m2_s 4112.6923076923076
r18864 n1561 t_m2_s 4455.416666666667
r18865 n1562 t_m2_s 7637.8571428571431
r18866 n1563 t_m2_s 26732.5
r18867 n1675 t_m2_s 5483.5897435897432
r18868 n1676 t_m2_s 5940.5555555555557
r18869 n1677 t_m2_s 10183.809523809523
r18870 n1678 t_m2_s 35643.333333333336
r18871 n1798 t_m2_s 8225.3846153846152
r18872 n1799 t_m2_s 8910.8333333333339
r18873 n1800 t_m2_s 15275.714285714286
r18874 n1801 t_m2_s 53465
r18875 n2029 t_m2_d 8225.3846153846152
r18876 n2030 t_m2_d 8910.8333333333339
r18877 n2031 t_m2_d 15275.714285714286
r18878 n2032 t_m2_d 53465
r18879 n2152 t_m2_d 5483.5897435897432
r18880 n2153 t_m2_d 5940.5555555555557
r18881 n2154 t_m2_d 10183.809523809523
r18882 n2155 t_m2_d 35643.333333333336
r18883 n2275 t_m2_d 4112.6923076923076
r18884 n2276 t_m2_d 4455.416666666667
r18885 n2277 t_m2_d 7637.8571428571431
r18886 n2278 t_m2_d 26732.5
r18887 n2390 t_m2_d 5483.5897435897432
r18888 n2391 t_m2_d 5940.5555555555557
r18889 n2392 t_m2_d 10183.809523809523
r18890 n2393 t_m2_d 35643.333333333336
r18891 n2505 t_m2_d 1096.7179487179487
r18892 n2506 t_m2_d 1188.1111111111111
r18893 n2507 t_m2_d 2036.7619047619046
r18894 n2508 t_m2_d 7128.666666666667
r18895 n2620 t_m2_d 3290.1538461538462
r18896 n2621 t_m2_d 3564.3333333333335
r18897 n2622 t_m2_d 6110.2857142857147
r18898 n2623 t_m2_d 21386
r18899 n2735 t_m2_d 8225.3846153846152
r18900 n2736 t_m2_d 8910.8333333333339
r18901 n2737 t_m2_d 15275.714285714286
r18902 n2738 t_m2_d 53465
r18903 n612 t_m2_b 169065
r18904 n613 t_m2_b 37570
r18905 n614 t_m2_b 28177.5
r18906 n615 t_m2_b 37570
r18907 n616 t_m2_b 169065
r18908 n768 t_m2_b 11271
r18909 n769 t_m2_b 2504.6666666666665
r18910 n770 t_m2_b 1878.5
r18911 n771 t_m2_b 2504.6666666666665
r18912 n772 t_m2_b 11271
r18913 n924 t_m2_b 169065
r18914 n925 t_m2_b 37570
r18915 n926 t_m2_b 28177.5
r18916 n927 t_m2_b 37570
r18917 n928 t_m2_b 169065
r18918 n2882 t_m2_b 9945
r18919 n2883 t_m2_b 2210
r18920 n2884 t_m2_b 1657.5
r18921 n2885 t_m2_b 2210
r18922 n2886 t_m2_b 9945
r18923 n1109 t_m2_s 11881.111111111111
r18924 n1110 t_m2_s 8910.8333333333339
r18925 n1111 t_m2_s 11881.111111111111
r18926 n1112 t_m2_s 53465
r18927 n1113 t_m2_s 53465
r18928 n1224 t_m2_s 4752.4444444444443
r18929 n1225 t_m2_s 3564.3333333333335
r18930 n1226 t_m2_s 4752.4444444444443
r18931 n1227 t_m2_s 21386
r18932 n1228 t_m2_s 21386
r18933 n1339 t_m2_s 1584.1481481481483
r18934 n1340 t_m2_s 1188.1111111111111
r18935 n1341 t_m2_s 1584.1481481481483
r18936 n1342 t_m2_s 7128.666666666667
r18937 n1343 t_m2_s 7128.666666666667
r18938 n1454 t_m2_s 7920.7407407407409
r18939 n1455 t_m2_s 5940.5555555555557
r18940 n1456 t_m2_s 7920.7407407407409
r18941 n1457 t_m2_s 35643.333333333336
r18942 n1458 t_m2_s 35643.333333333336
r18943 n1569 t_m2_s 5940.5555555555557
r18944 n1570 t_m2_s 4455.416666666667
r18945 n1571 t_m2_s 5940.5555555555557
r18946 n1572 t_m2_s 26732.5
r18947 n1573 t_m2_s 26732.5
r18948 n1684 t_m2_s 7920.7407407407409
r18949 n1685 t_m2_s 5940.5555555555557
r18950 n1686 t_m2_s 7920.7407407407409
r18951 n1687 t_m2_s 35643.333333333336
r18952 n1688 t_m2_s 35643.333333333336
r18953 n1807 t_m2_s 11881.111111111111
r18954 n1808 t_m2_s 8910.8333333333339
r18955 n1809 t_m2_s 11881.111111111111
r18956 n1810 t_m2_s 53465
r18957 n1811 t_m2_s 53465
r18958 n2038 t_m2_d 11881.111111111111
r18959 n2039 t_m2_d 8910.8333333333339
r18960 n2040 t_m2_d 11881.111111111111
r18961 n2041 t_m2_d 53465
r18962 n2042 t_m2_d 53465
r18963 n2161 t_m2_d 7920.7407407407409
r18964 n2162 t_m2_d 5940.5555555555557
r18965 n2163 t_m2_d 7920.7407407407409
r18966 n2164 t_m2_d 35643.333333333336
r18967 n2165 t_m2_d 35643.333333333336
r18968 n2284 t_m2_d 5940.5555555555557
r18969 n2285 t_m2_d 4455.416666666667
r18970 n2286 t_m2_d 5940.5555555555557
r18971 n2287 t_m2_d 26732.5
r18972 n2288 t_m2_d 26732.5
r18973 n2399 t_m2_d 7920.7407407407409
r18974 n2400 t_m2_d 5940.5555555555557
r18975 n2401 t_m2_d 7920.7407407407409
r18976 n2402 t_m2_d 35643.333333333336
r18977 n2403 t_m2_d 35643.333333333336
r18978 n2514 t_m2_d 1584.1481481481483
r18979 n2515 t_m2_d 1188.1111111111111
r18980 n2516 t_m2_d 1584.1481481481483
r18981 n2517 t_m2_d 7128.666666666667
r18982 n2518 t_m2_d 7128.666666666667
r18983 n2629 t_m2_d 4752.4444444444443
r18984 n2630 t_m2_d 3564.3333333333335
r18985 n2631 t_m2_d 4752.4444444444443
r18986 n2632 t_m2_d 21386
r18987 n2633 t_m2_d 21386
r18988 n2744 t_m2_d 11881.111111111111
r18989 n2745 t_m2_d 8910.8333333333339
r18990 n2746 t_m2_d 11881.111111111111
r18991 n2747 t_m2_d 53465
r18992 n2748 t_m2_d 53465
r18993 n620 t_m2_b 169065
r18994 n621 t_m2_b 10566.5625
r18995 n776 t_m2_b 11271
r18996 n777 t_m2_b 704.4375
r18997 n932 t_m2_b 169065
r18998 n933 t_m2_b 10566.5625
r18999 n2890 t_m2_b 9945
r19000 n2891 t_m2_b 621.5625
r19001 n1117 t_m2_s 3341.5625
r19002 n1118 t_m2_s 53465
r19003 n1232 t_m2_s 1336.625
r19004 n1233 t_m2_s 21386
r19005 n1347 t_m2_s 445.54166666666669
r19006 n1348 t_m2_s 7128.666666666667
r19007 n1462 t_m2_s 2227.7083333333335
r19008 n1463 t_m2_s 35643.333333333336
r19009 n1577 t_m2_s 1670.78125
r19010 n1578 t_m2_s 26732.5
r19011 n1692 t_m2_s 2227.7083333333335
r19012 n1693 t_m2_s 35643.333333333336
r19013 n1815 t_m2_s 3341.5625
r19014 n1816 t_m2_s 53465
r19015 n2046 t_m2_d 3341.5625
r19016 n2047 t_m2_d 53465
r19017 n2169 t_m2_d 2227.7083333333335
r19018 n2170 t_m2_d 35643.333333333336
r19019 n2292 t_m2_d 1670.78125
r19020 n2293 t_m2_d 26732.5
r19021 n2407 t_m2_d 2227.7083333333335
r19022 n2408 t_m2_d 35643.333333333336
r19023 n2522 t_m2_d 445.54166666666669
r19024 n2523 t_m2_d 7128.666666666667
r19025 n2637 t_m2_d 1336.625
r19026 n2638 t_m2_d 21386
r19027 n2752 t_m2_d 3341.5625
r19028 n2753 t_m2_d 53465
r19029 n626 t_m2_b 9945
r19030 n782 t_m2_b 663
r19031 n938 t_m2_b 9945
r19032 n2896 t_m2_b 585
r19033 n1950 t_m2_g 43928
r19034 n1951 t_m2_g 10982
r19035 n1952 t_m2_g 3993.4545454545455
r19036 n1953 t_m2_g 43928
r19037 n1962 t_m2_g 2928.5333333333333
r19038 n1963 t_m2_g 732.13333333333333
r19039 n1964 t_m2_g 266.23030303030305
r19040 n1965 t_m2_g 2928.5333333333333
r19041 n1974 t_m2_g 43928
r19042 n1975 t_m2_g 10982
r19043 n1976 t_m2_g 3993.4545454545455
r19044 n1977 t_m2_g 43928
r19045 n634 t_m2_b 15369.545454545454
r19046 n635 t_m2_b 169065
r19047 n636 t_m2_b 112710
r19048 n637 t_m2_b 112710
r19049 n638 t_m2_b 84532.5
r19050 n790 t_m2_b 1024.6363636363637
r19051 n791 t_m2_b 11271
r19052 n792 t_m2_b 7514
r19053 n793 t_m2_b 7514
r19054 n794 t_m2_b 5635.5
r19055 n946 t_m2_b 15369.545454545454
r19056 n947 t_m2_b 169065
r19057 n948 t_m2_b 112710
r19058 n949 t_m2_b 112710
r19059 n950 t_m2_b 84532.5
r19060 n2904 t_m2_b 904.09090909090901
r19061 n2905 t_m2_b 9945
r19062 n2906 t_m2_b 6630
r19063 n2907 t_m2_b 6630
r19064 n2908 t_m2_b 4972.5
r19065 n1077 t_m2_b 1420.7142857142858
r19066 n1081 t_m2_b 9945
r19067 n1085 t_m2_b 3978
r19068 n1089 t_m2_b 3315
r19069 n1121 t_m2_b 9945
r19070 n1236 t_m2_b 3978
r19071 n1954 t_m2_b 9945
r19072 n1966 t_m2_b 663
r19073 n1978 t_m2_b 9945
r19074 n2641 t_m2_b 3978
r19075 n2756 t_m2_b 9945
r19076 n2843 t_m2_b 3315
r19077 n2847 t_m2_b 2841.4285714285716
r19078 n2851 t_m2_b 1420.7142857142858
r19079 n1078 t_m1_b 449.28571428571433
r19080 n1082 t_m1_b 3145
r19081 n1086 t_m1_b 1258
r19082 n1090 t_m1_b 1048.3333333333333
r19083 n1122 t_m1_b 3145
r19084 n1237 t_m1_b 1258
r19085 n1955 t_m1_b 3145
r19086 n1967 t_m1_b 209.66666666666669
r19087 n1979 t_m1_b 3145
r19088 n2642 t_m1_b 1258
r19089 n2757 t_m1_b 3145
r19090 n2844 t_m1_b 1048.3333333333333
r19091 n2848 t_m1_b 898.57142857142867
r19092 n2852 t_m1_b 449.28571428571433
r19093 n646 t_m1_b 3145
r19094 n802 t_m1_b 209.66666666666669
r19095 n958 t_m1_b 3145
r19096 n2916 t_m1_b 185
r19097 n650 t_m1_b 53465
r19098 n651 t_m1_b 3341.5625
r19099 n806 t_m1_b 3564.3333333333335
r19100 n807 t_m1_b 222.77083333333334
r19101 n962 t_m1_b 53465
r19102 n963 t_m1_b 3341.5625
r19103 n2920 t_m1_b 3145
r19104 n2921 t_m1_b 196.5625
r19105 n1126 t_m1_s 10566.5625
r19106 n1127 t_m1_s 169065
r19107 n1241 t_m1_s 4226.625
r19108 n1242 t_m1_s 67626
r19109 n1356 t_m1_s 1408.875
r19110 n1357 t_m1_s 22542
r19111 n1471 t_m1_s 7044.375
r19112 n1472 t_m1_s 112710
r19113 n1586 t_m1_s 5283.28125
r19114 n1587 t_m1_s 84532.5
r19115 n1705 t_m1_s 7044.375
r19116 n1706 t_m1_s 112710
r19117 n1828 t_m1_s 10566.5625
r19118 n1829 t_m1_s 169065
r19119 n2059 t_m1_d 10566.5625
r19120 n2060 t_m1_d 169065
r19121 n2182 t_m1_d 7044.375
r19122 n2183 t_m1_d 112710
r19123 n2301 t_m1_d 5283.28125
r19124 n2302 t_m1_d 84532.5
r19125 n2416 t_m1_d 7044.375
r19126 n2417 t_m1_d 112710
r19127 n2531 t_m1_d 1408.875
r19128 n2532 t_m1_d 22542
r19129 n2646 t_m1_d 4226.625
r19130 n2647 t_m1_d 67626
r19131 n2761 t_m1_d 10566.5625
r19132 n2762 t_m1_d 169065
r19133 n654 t_m1_b 53465
r19134 n655 t_m1_b 3341.5625
r19135 n810 t_m1_b 3564.3333333333335
r19136 n811 t_m1_b 222.77083333333334
r19137 n966 t_m1_b 53465
r19138 n967 t_m1_b 3341.5625
r19139 n2924 t_m1_b 3145
r19140 n2925 t_m1_b 196.5625
r19141 n1130 t_m1_s 10566.5625
r19142 n1131 t_m1_s 169065
r19143 n1245 t_m1_s 4226.625
r19144 n1246 t_m1_s 67626
r19145 n1360 t_m1_s 1408.875
r19146 n1361 t_m1_s 22542
r19147 n1475 t_m1_s 7044.375
r19148 n1476 t_m1_s 112710
r19149 n1590 t_m1_s 5283.28125
r19150 n1591 t_m1_s 84532.5
r19151 n1709 t_m1_s 7044.375
r19152 n1710 t_m1_s 112710
r19153 n1832 t_m1_s 10566.5625
r19154 n1833 t_m1_s 169065
r19155 n2063 t_m1_d 10566.5625
r19156 n2064 t_m1_d 169065
r19157 n2186 t_m1_d 7044.375
r19158 n2187 t_m1_d 112710
r19159 n2305 t_m1_d 5283.28125
r19160 n2306 t_m1_d 84532.5
r19161 n2420 t_m1_d 7044.375
r19162 n2421 t_m1_d 112710
r19163 n2535 t_m1_d 1408.875
r19164 n2536 t_m1_d 22542
r19165 n2650 t_m1_d 4226.625
r19166 n2651 t_m1_d 67626
r19167 n2765 t_m1_d 10566.5625
r19168 n2766 t_m1_d 169065
r19169 n658 t_m1_b 53465
r19170 n659 t_m1_b 3341.5625
r19171 n814 t_m1_b 3564.3333333333335
r19172 n815 t_m1_b 222.77083333333334
r19173 n970 t_m1_b 53465
r19174 n971 t_m1_b 3341.5625
r19175 n2928 t_m1_b 3145
r19176 n2929 t_m1_b 196.5625
r19177 n1134 t_m1_s 10566.5625
r19178 n1135 t_m1_s 169065
r19179 n1249 t_m1_s 4226.625
r19180 n1250 t_m1_s 67626
r19181 n1364 t_m1_s 1408.875
r19182 n1365 t_m1_s 22542
r19183 n1479 t_m1_s 7044.375
r19184 n1480 t_m1_s 112710
r19185 n1594 t_m1_s 5283.28125
r19186 n1595 t_m1_s 84532.5
r19187 n1713 t_m1_s 7044.375
r19188 n1714 t_m1_s 112710
r19189 n1836 t_m1_s 10566.5625
r19190 n1837 t_m1_s 169065
r19191 n2067 t_m1_d 10566.5625
r19192 n2068 t_m1_d 169065
r19193 n2190 t_m1_d 7044.375
r19194 n2191 t_m1_d 112710
r19195 n2309 t_m1_d 5283.28125
r19196 n2310 t_m1_d 84532.5
r19197 n2424 t_m1_d 7044.375
r19198 n2425 t_m1_d 112710
r19199 n2539 t_m1_d 1408.875
r19200 n2540 t_m1_d 22542
r19201 n2654 t_m1_d 4226.625
r19202 n2655 t_m1_d 67626
r19203 n2769 t_m1_d 10566.5625
r19204 n2770 t_m1_d 169065
r19205 n662 t_m1_b 53465
r19206 n663 t_m1_b 3341.5625
r19207 n818 t_m1_b 3564.3333333333335
r19208 n819 t_m1_b 222.77083333333334
r19209 n974 t_m1_b 53465
r19210 n975 t_m1_b 3341.5625
r19211 n2932 t_m1_b 3145
r19212 n2933 t_m1_b 196.5625
r19213 n1138 t_m1_s 10566.5625
r19214 n1139 t_m1_s 169065
r19215 n1253 t_m1_s 4226.625
r19216 n1254 t_m1_s 67626
r19217 n1368 t_m1_s 1408.875
r19218 n1369 t_m1_s 22542
r19219 n1483 t_m1_s 7044.375
r19220 n1484 t_m1_s 112710
r19221 n1598 t_m1_s 5283.28125
r19222 n1599 t_m1_s 84532.5
r19223 n1717 t_m1_s 7044.375
r19224 n1718 t_m1_s 112710
r19225 n1840 t_m1_s 10566.5625
r19226 n1841 t_m1_s 169065
r19227 n2071 t_m1_d 10566.5625
r19228 n2072 t_m1_d 169065
r19229 n2194 t_m1_d 7044.375
r19230 n2195 t_m1_d 112710
r19231 n2313 t_m1_d 5283.28125
r19232 n2314 t_m1_d 84532.5
r19233 n2428 t_m1_d 7044.375
r19234 n2429 t_m1_d 112710
r19235 n2543 t_m1_d 1408.875
r19236 n2544 t_m1_d 22542
r19237 n2658 t_m1_d 4226.625
r19238 n2659 t_m1_d 67626
r19239 n2773 t_m1_d 10566.5625
r19240 n2774 t_m1_d 169065
r19241 n666 t_m1_b 53465
r19242 n667 t_m1_b 3341.5625
r19243 n822 t_m1_b 3564.3333333333335
r19244 n823 t_m1_b 222.77083333333334
r19245 n978 t_m1_b 53465
r19246 n979 t_m1_b 3341.5625
r19247 n2936 t_m1_b 3145
r19248 n2937 t_m1_b 196.5625
r19249 n1142 t_m1_s 10566.5625
r19250 n1143 t_m1_s 169065
r19251 n1257 t_m1_s 4226.625
r19252 n1258 t_m1_s 67626
r19253 n1372 t_m1_s 1408.875
r19254 n1373 t_m1_s 22542
r19255 n1487 t_m1_s 7044.375
r19256 n1488 t_m1_s 112710
r19257 n1602 t_m1_s 5283.28125
r19258 n1603 t_m1_s 84532.5
r19259 n1721 t_m1_s 7044.375
r19260 n1722 t_m1_s 112710
r19261 n1844 t_m1_s 10566.5625
r19262 n1845 t_m1_s 169065
r19263 n2075 t_m1_d 10566.5625
r19264 n2076 t_m1_d 169065
r19265 n2198 t_m1_d 7044.375
r19266 n2199 t_m1_d 112710
r19267 n2317 t_m1_d 5283.28125
r19268 n2318 t_m1_d 84532.5
r19269 n2432 t_m1_d 7044.375
r19270 n2433 t_m1_d 112710
r19271 n2547 t_m1_d 1408.875
r19272 n2548 t_m1_d 22542
r19273 n2662 t_m1_d 4226.625
r19274 n2663 t_m1_d 67626
r19275 n2777 t_m1_d 10566.5625
r19276 n2778 t_m1_d 169065
r19277 n670 t_m1_b 53465
r19278 n671 t_m1_b 3341.5625
r19279 n826 t_m1_b 3564.3333333333335
r19280 n827 t_m1_b 222.77083333333334
r19281 n982 t_m1_b 53465
r19282 n983 t_m1_b 3341.5625
r19283 n2940 t_m1_b 3145
r19284 n2941 t_m1_b 196.5625
r19285 n1146 t_m1_s 10566.5625
r19286 n1147 t_m1_s 169065
r19287 n1261 t_m1_s 4226.625
r19288 n1262 t_m1_s 67626
r19289 n1376 t_m1_s 1408.875
r19290 n1377 t_m1_s 22542
r19291 n1491 t_m1_s 7044.375
r19292 n1492 t_m1_s 112710
r19293 n1606 t_m1_s 5283.28125
r19294 n1607 t_m1_s 84532.5
r19295 n1725 t_m1_s 7044.375
r19296 n1726 t_m1_s 112710
r19297 n1848 t_m1_s 10566.5625
r19298 n1849 t_m1_s 169065
r19299 n2079 t_m1_d 10566.5625
r19300 n2080 t_m1_d 169065
r19301 n2202 t_m1_d 7044.375
r19302 n2203 t_m1_d 112710
r19303 n2321 t_m1_d 5283.28125
r19304 n2322 t_m1_d 84532.5
r19305 n2436 t_m1_d 7044.375
r19306 n2437 t_m1_d 112710
r19307 n2551 t_m1_d 1408.875
r19308 n2552 t_m1_d 22542
r19309 n2666 t_m1_d 4226.625
r19310 n2667 t_m1_d 67626
r19311 n2781 t_m1_d 10566.5625
r19312 n2782 t_m1_d 169065
r19313 n674 t_m1_b 53465
r19314 n675 t_m1_b 3341.5625
r19315 n830 t_m1_b 3564.3333333333335
r19316 n831 t_m1_b 222.77083333333334
r19317 n986 t_m1_b 53465
r19318 n987 t_m1_b 3341.5625
r19319 n2944 t_m1_b 3145
r19320 n2945 t_m1_b 196.5625
r19321 n1150 t_m1_s 10566.5625
r19322 n1151 t_m1_s 169065
r19323 n1265 t_m1_s 4226.625
r19324 n1266 t_m1_s 67626
r19325 n1380 t_m1_s 1408.875
r19326 n1381 t_m1_s 22542
r19327 n1495 t_m1_s 7044.375
r19328 n1496 t_m1_s 112710
r19329 n1610 t_m1_s 5283.28125
r19330 n1611 t_m1_s 84532.5
r19331 n1729 t_m1_s 7044.375
r19332 n1730 t_m1_s 112710
r19333 n1852 t_m1_s 10566.5625
r19334 n1853 t_m1_s 169065
r19335 n2083 t_m1_d 10566.5625
r19336 n2084 t_m1_d 169065
r19337 n2206 t_m1_d 7044.375
r19338 n2207 t_m1_d 112710
r19339 n2325 t_m1_d 5283.28125
r19340 n2326 t_m1_d 84532.5
r19341 n2440 t_m1_d 7044.375
r19342 n2441 t_m1_d 112710
r19343 n2555 t_m1_d 1408.875
r19344 n2556 t_m1_d 22542
r19345 n2670 t_m1_d 4226.625
r19346 n2671 t_m1_d 67626
r19347 n2785 t_m1_d 10566.5625
r19348 n2786 t_m1_d 169065
r19349 n678 t_m1_b 53465
r19350 n679 t_m1_b 3341.5625
r19351 n834 t_m1_b 3564.3333333333335
r19352 n835 t_m1_b 222.77083333333334
r19353 n990 t_m1_b 53465
r19354 n991 t_m1_b 3341.5625
r19355 n2948 t_m1_b 3145
r19356 n2949 t_m1_b 196.5625
r19357 n1154 t_m1_s 10566.5625
r19358 n1155 t_m1_s 169065
r19359 n1269 t_m1_s 4226.625
r19360 n1270 t_m1_s 67626
r19361 n1384 t_m1_s 1408.875
r19362 n1385 t_m1_s 22542
r19363 n1499 t_m1_s 7044.375
r19364 n1500 t_m1_s 112710
r19365 n1614 t_m1_s 5283.28125
r19366 n1615 t_m1_s 84532.5
r19367 n1733 t_m1_s 7044.375
r19368 n1734 t_m1_s 112710
r19369 n1856 t_m1_s 10566.5625
r19370 n1857 t_m1_s 169065
r19371 n2087 t_m1_d 10566.5625
r19372 n2088 t_m1_d 169065
r19373 n2210 t_m1_d 7044.375
r19374 n2211 t_m1_d 112710
r19375 n2329 t_m1_d 5283.28125
r19376 n2330 t_m1_d 84532.5
r19377 n2444 t_m1_d 7044.375
r19378 n2445 t_m1_d 112710
r19379 n2559 t_m1_d 1408.875
r19380 n2560 t_m1_d 22542
r19381 n2674 t_m1_d 4226.625
r19382 n2675 t_m1_d 67626
r19383 n2789 t_m1_d 10566.5625
r19384 n2790 t_m1_d 169065
r19385 n684 t_m1_b 53465
r19386 n685 t_m1_b 53465
r19387 n686 t_m1_b 13366.25
r19388 n687 t_m1_b 4860.454545454545
r19389 n840 t_m1_b 3564.3333333333335
r19390 n841 t_m1_b 3564.3333333333335
r19391 n842 t_m1_b 891.08333333333337
r19392 n843 t_m1_b 324.03030303030306
r19393 n996 t_m1_b 53465
r19394 n997 t_m1_b 53465
r19395 n998 t_m1_b 13366.25
r19396 n999 t_m1_b 4860.454545454545
r19397 n2954 t_m1_b 3145
r19398 n2955 t_m1_b 3145
r19399 n2956 t_m1_b 786.25
r19400 n2957 t_m1_b 285.90909090909088
r19401 n1160 t_m1_s 169065
r19402 n1161 t_m1_s 42266.25
r19403 n1162 t_m1_s 15369.545454545454
r19404 n1163 t_m1_s 338130
r19405 n1164 t_m1_s 338130
r19406 n1275 t_m1_s 67626
r19407 n1276 t_m1_s 16906.5
r19408 n1277 t_m1_s 6147.818181818182
r19409 n1278 t_m1_s 135252
r19410 n1279 t_m1_s 135252
r19411 n1390 t_m1_s 22542
r19412 n1391 t_m1_s 5635.5
r19413 n1392 t_m1_s 2049.2727272727275
r19414 n1393 t_m1_s 45084
r19415 n1394 t_m1_s 45084
r19416 n1505 t_m1_s 112710
r19417 n1506 t_m1_s 28177.5
r19418 n1507 t_m1_s 10246.363636363636
r19419 n1508 t_m1_s 225420
r19420 n1509 t_m1_s 225420
r19421 n1620 t_m1_s 84532.5
r19422 n1621 t_m1_s 21133.125
r19423 n1622 t_m1_s 7684.772727272727
r19424 n1623 t_m1_s 169065
r19425 n1624 t_m1_s 169065
r19426 n1739 t_m1_s 112710
r19427 n1740 t_m1_s 28177.5
r19428 n1741 t_m1_s 10246.363636363636
r19429 n1742 t_m1_s 225420
r19430 n1743 t_m1_s 225420
r19431 n1862 t_m1_s 169065
r19432 n1863 t_m1_s 42266.25
r19433 n1864 t_m1_s 15369.545454545454
r19434 n1865 t_m1_s 338130
r19435 n1866 t_m1_s 338130
r19436 n2093 t_m1_d 169065
r19437 n2094 t_m1_d 42266.25
r19438 n2095 t_m1_d 15369.545454545454
r19439 n2096 t_m1_d 338130
r19440 n2097 t_m1_d 338130
r19441 n2216 t_m1_d 112710
r19442 n2217 t_m1_d 28177.5
r19443 n2218 t_m1_d 10246.363636363636
r19444 n2219 t_m1_d 225420
r19445 n2220 t_m1_d 225420
r19446 n2335 t_m1_d 84532.5
r19447 n2336 t_m1_d 21133.125
r19448 n2337 t_m1_d 7684.772727272727
r19449 n2338 t_m1_d 169065
r19450 n2339 t_m1_d 169065
r19451 n2450 t_m1_d 112710
r19452 n2451 t_m1_d 28177.5
r19453 n2452 t_m1_d 10246.363636363636
r19454 n2453 t_m1_d 225420
r19455 n2454 t_m1_d 225420
r19456 n2565 t_m1_d 22542
r19457 n2566 t_m1_d 5635.5
r19458 n2567 t_m1_d 2049.2727272727275
r19459 n2568 t_m1_d 45084
r19460 n2569 t_m1_d 45084
r19461 n2680 t_m1_d 67626
r19462 n2681 t_m1_d 16906.5
r19463 n2682 t_m1_d 6147.818181818182
r19464 n2683 t_m1_d 135252
r19465 n2684 t_m1_d 135252
r19466 n2795 t_m1_d 169065
r19467 n2796 t_m1_d 42266.25
r19468 n2797 t_m1_d 15369.545454545454
r19469 n2798 t_m1_d 338130
r19470 n2799 t_m1_d 338130
r19471 n696 t_m1_b 53465
r19472 n697 t_m1_b 17821.666666666668
r19473 n698 t_m1_b 8910.8333333333339
r19474 n699 t_m1_b 7637.8571428571431
r19475 n852 t_m1_b 3564.3333333333335
r19476 n853 t_m1_b 1188.1111111111111
r19477 n854 t_m1_b 594.05555555555554
r19478 n855 t_m1_b 509.19047619047615
r19479 n1008 t_m1_b 53465
r19480 n1009 t_m1_b 17821.666666666668
r19481 n1010 t_m1_b 8910.8333333333339
r19482 n1011 t_m1_b 7637.8571428571431
r19483 n2966 t_m1_b 3145
r19484 n2967 t_m1_b 1048.3333333333333
r19485 n2968 t_m1_b 524.16666666666663
r19486 n2969 t_m1_b 449.28571428571433
r19487 n1172 t_m1_s 56355
r19488 n1173 t_m1_s 28177.5
r19489 n1174 t_m1_s 24152.142857142859
r19490 n1175 t_m1_s 169065
r19491 n1287 t_m1_s 22542
r19492 n1288 t_m1_s 11271
r19493 n1289 t_m1_s 9660.8571428571431
r19494 n1290 t_m1_s 67626
r19495 n1402 t_m1_s 7514
r19496 n1403 t_m1_s 3757
r19497 n1404 t_m1_s 3220.2857142857142
r19498 n1405 t_m1_s 22542
r19499 n1517 t_m1_s 37570
r19500 n1518 t_m1_s 18785
r19501 n1519 t_m1_s 16101.428571428571
r19502 n1520 t_m1_s 112710
r19503 n1632 t_m1_s 28177.5
r19504 n1633 t_m1_s 14088.75
r19505 n1634 t_m1_s 12076.071428571429
r19506 n1635 t_m1_s 84532.5
r19507 n1751 t_m1_s 37570
r19508 n1752 t_m1_s 18785
r19509 n1753 t_m1_s 16101.428571428571
r19510 n1754 t_m1_s 112710
r19511 n1874 t_m1_s 56355
r19512 n1875 t_m1_s 28177.5
r19513 n1876 t_m1_s 24152.142857142859
r19514 n1877 t_m1_s 169065
r19515 n2105 t_m1_d 56355
r19516 n2106 t_m1_d 28177.5
r19517 n2107 t_m1_d 24152.142857142859
r19518 n2108 t_m1_d 169065
r19519 n2228 t_m1_d 37570
r19520 n2229 t_m1_d 18785
r19521 n2230 t_m1_d 16101.428571428571
r19522 n2231 t_m1_d 112710
r19523 n2347 t_m1_d 28177.5
r19524 n2348 t_m1_d 14088.75
r19525 n2349 t_m1_d 12076.071428571429
r19526 n2350 t_m1_d 84532.5
r19527 n2462 t_m1_d 37570
r19528 n2463 t_m1_d 18785
r19529 n2464 t_m1_d 16101.428571428571
r19530 n2465 t_m1_d 112710
r19531 n2577 t_m1_d 7514
r19532 n2578 t_m1_d 3757
r19533 n2579 t_m1_d 3220.2857142857142
r19534 n2580 t_m1_d 22542
r19535 n2692 t_m1_d 22542
r19536 n2693 t_m1_d 11271
r19537 n2694 t_m1_d 9660.8571428571431
r19538 n2695 t_m1_d 67626
r19539 n2807 t_m1_d 56355
r19540 n2808 t_m1_d 28177.5
r19541 n2809 t_m1_d 24152.142857142859
r19542 n2810 t_m1_d 169065
r19543 n702 t_m1_b 53465
r19544 n703 t_m1_b 3341.5625
r19545 n858 t_m1_b 3564.3333333333335
r19546 n859 t_m1_b 222.77083333333334
r19547 n1014 t_m1_b 53465
r19548 n1015 t_m1_b 3341.5625
r19549 n2972 t_m1_b 3145
r19550 n2973 t_m1_b 196.5625
r19551 n1178 t_m1_s 10566.5625
r19552 n1179 t_m1_s 169065
r19553 n1293 t_m1_s 4226.625
r19554 n1294 t_m1_s 67626
r19555 n1408 t_m1_s 1408.875
r19556 n1409 t_m1_s 22542
r19557 n1523 t_m1_s 7044.375
r19558 n1524 t_m1_s 112710
r19559 n1638 t_m1_s 5283.28125
r19560 n1639 t_m1_s 84532.5
r19561 n1757 t_m1_s 7044.375
r19562 n1758 t_m1_s 112710
r19563 n1880 t_m1_s 10566.5625
r19564 n1881 t_m1_s 169065
r19565 n2111 t_m1_d 10566.5625
r19566 n2112 t_m1_d 169065
r19567 n2234 t_m1_d 7044.375
r19568 n2235 t_m1_d 112710
r19569 n2353 t_m1_d 5283.28125
r19570 n2354 t_m1_d 84532.5
r19571 n2468 t_m1_d 7044.375
r19572 n2469 t_m1_d 112710
r19573 n2583 t_m1_d 1408.875
r19574 n2584 t_m1_d 22542
r19575 n2698 t_m1_d 4226.625
r19576 n2699 t_m1_d 67626
r19577 n2813 t_m1_d 10566.5625
r19578 n2814 t_m1_d 169065
r19579 n706 t_m1_b 53465
r19580 n707 t_m1_b 3341.5625
r19581 n862 t_m1_b 3564.3333333333335
r19582 n863 t_m1_b 222.77083333333334
r19583 n1018 t_m1_b 53465
r19584 n1019 t_m1_b 3341.5625
r19585 n2976 t_m1_b 3145
r19586 n2977 t_m1_b 196.5625
r19587 n1182 t_m1_s 10566.5625
r19588 n1183 t_m1_s 169065
r19589 n1297 t_m1_s 4226.625
r19590 n1298 t_m1_s 67626
r19591 n1412 t_m1_s 1408.875
r19592 n1413 t_m1_s 22542
r19593 n1527 t_m1_s 7044.375
r19594 n1528 t_m1_s 112710
r19595 n1642 t_m1_s 5283.28125
r19596 n1643 t_m1_s 84532.5
r19597 n1761 t_m1_s 7044.375
r19598 n1762 t_m1_s 112710
r19599 n1884 t_m1_s 10566.5625
r19600 n1885 t_m1_s 169065
r19601 n2115 t_m1_d 10566.5625
r19602 n2116 t_m1_d 169065
r19603 n2238 t_m1_d 7044.375
r19604 n2239 t_m1_d 112710
r19605 n2357 t_m1_d 5283.28125
r19606 n2358 t_m1_d 84532.5
r19607 n2472 t_m1_d 7044.375
r19608 n2473 t_m1_d 112710
r19609 n2587 t_m1_d 1408.875
r19610 n2588 t_m1_d 22542
r19611 n2702 t_m1_d 4226.625
r19612 n2703 t_m1_d 67626
r19613 n2817 t_m1_d 10566.5625
r19614 n2818 t_m1_d 169065
r19615 n710 t_m1_b 53465
r19616 n711 t_m1_b 3341.5625
r19617 n866 t_m1_b 3564.3333333333335
r19618 n867 t_m1_b 222.77083333333334
r19619 n1022 t_m1_b 53465
r19620 n1023 t_m1_b 3341.5625
r19621 n2980 t_m1_b 3145
r19622 n2981 t_m1_b 196.5625
r19623 n1186 t_m1_s 10566.5625
r19624 n1187 t_m1_s 169065
r19625 n1301 t_m1_s 4226.625
r19626 n1302 t_m1_s 67626
r19627 n1416 t_m1_s 1408.875
r19628 n1417 t_m1_s 22542
r19629 n1531 t_m1_s 7044.375
r19630 n1532 t_m1_s 112710
r19631 n1646 t_m1_s 5283.28125
r19632 n1647 t_m1_s 84532.5
r19633 n1765 t_m1_s 7044.375
r19634 n1766 t_m1_s 112710
r19635 n1888 t_m1_s 10566.5625
r19636 n1889 t_m1_s 169065
r19637 n2119 t_m1_d 10566.5625
r19638 n2120 t_m1_d 169065
r19639 n2242 t_m1_d 7044.375
r19640 n2243 t_m1_d 112710
r19641 n2361 t_m1_d 5283.28125
r19642 n2362 t_m1_d 84532.5
r19643 n2476 t_m1_d 7044.375
r19644 n2477 t_m1_d 112710
r19645 n2591 t_m1_d 1408.875
r19646 n2592 t_m1_d 22542
r19647 n2706 t_m1_d 4226.625
r19648 n2707 t_m1_d 67626
r19649 n2821 t_m1_d 10566.5625
r19650 n2822 t_m1_d 169065
r19651 n714 t_m1_b 53465
r19652 n715 t_m1_b 3341.5625
r19653 n870 t_m1_b 3564.3333333333335
r19654 n871 t_m1_b 222.77083333333334
r19655 n1026 t_m1_b 53465
r19656 n1027 t_m1_b 3341.5625
r19657 n2984 t_m1_b 3145
r19658 n2985 t_m1_b 196.5625
r19659 n1190 t_m1_s 10566.5625
r19660 n1191 t_m1_s 169065
r19661 n1305 t_m1_s 4226.625
r19662 n1306 t_m1_s 67626
r19663 n1420 t_m1_s 1408.875
r19664 n1421 t_m1_s 22542
r19665 n1535 t_m1_s 7044.375
r19666 n1536 t_m1_s 112710
r19667 n1650 t_m1_s 5283.28125
r19668 n1651 t_m1_s 84532.5
r19669 n1769 t_m1_s 7044.375
r19670 n1770 t_m1_s 112710
r19671 n1892 t_m1_s 10566.5625
r19672 n1893 t_m1_s 169065
r19673 n2123 t_m1_d 10566.5625
r19674 n2124 t_m1_d 169065
r19675 n2246 t_m1_d 7044.375
r19676 n2247 t_m1_d 112710
r19677 n2365 t_m1_d 5283.28125
r19678 n2366 t_m1_d 84532.5
r19679 n2480 t_m1_d 7044.375
r19680 n2481 t_m1_d 112710
r19681 n2595 t_m1_d 1408.875
r19682 n2596 t_m1_d 22542
r19683 n2710 t_m1_d 4226.625
r19684 n2711 t_m1_d 67626
r19685 n2825 t_m1_d 10566.5625
r19686 n2826 t_m1_d 169065
r19687 n718 t_m1_b 53465
r19688 n719 t_m1_b 3341.5625
r19689 n874 t_m1_b 3564.3333333333335
r19690 n875 t_m1_b 222.77083333333334
r19691 n1030 t_m1_b 53465
r19692 n1031 t_m1_b 3341.5625
r19693 n2988 t_m1_b 3145
r19694 n2989 t_m1_b 196.5625
r19695 n1194 t_m1_s 10566.5625
r19696 n1195 t_m1_s 169065
r19697 n1309 t_m1_s 4226.625
r19698 n1310 t_m1_s 67626
r19699 n1424 t_m1_s 1408.875
r19700 n1425 t_m1_s 22542
r19701 n1539 t_m1_s 7044.375
r19702 n1540 t_m1_s 112710
r19703 n1654 t_m1_s 5283.28125
r19704 n1655 t_m1_s 84532.5
r19705 n1773 t_m1_s 7044.375
r19706 n1774 t_m1_s 112710
r19707 n1896 t_m1_s 10566.5625
r19708 n1897 t_m1_s 169065
r19709 n2127 t_m1_d 10566.5625
r19710 n2128 t_m1_d 169065
r19711 n2250 t_m1_d 7044.375
r19712 n2251 t_m1_d 112710
r19713 n2369 t_m1_d 5283.28125
r19714 n2370 t_m1_d 84532.5
r19715 n2484 t_m1_d 7044.375
r19716 n2485 t_m1_d 112710
r19717 n2599 t_m1_d 1408.875
r19718 n2600 t_m1_d 22542
r19719 n2714 t_m1_d 4226.625
r19720 n2715 t_m1_d 67626
r19721 n2829 t_m1_d 10566.5625
r19722 n2830 t_m1_d 169065
r19723 n722 t_m1_b 53465
r19724 n723 t_m1_b 3341.5625
r19725 n878 t_m1_b 3564.3333333333335
r19726 n879 t_m1_b 222.77083333333334
r19727 n1034 t_m1_b 53465
r19728 n1035 t_m1_b 3341.5625
r19729 n2992 t_m1_b 3145
r19730 n2993 t_m1_b 196.5625
r19731 n1198 t_m1_s 10566.5625
r19732 n1199 t_m1_s 169065
r19733 n1313 t_m1_s 4226.625
r19734 n1314 t_m1_s 67626
r19735 n1428 t_m1_s 1408.875
r19736 n1429 t_m1_s 22542
r19737 n1543 t_m1_s 7044.375
r19738 n1544 t_m1_s 112710
r19739 n1658 t_m1_s 5283.28125
r19740 n1659 t_m1_s 84532.5
r19741 n1777 t_m1_s 7044.375
r19742 n1778 t_m1_s 112710
r19743 n1900 t_m1_s 10566.5625
r19744 n1901 t_m1_s 169065
r19745 n2131 t_m1_d 10566.5625
r19746 n2132 t_m1_d 169065
r19747 n2254 t_m1_d 7044.375
r19748 n2255 t_m1_d 112710
r19749 n2373 t_m1_d 5283.28125
r19750 n2374 t_m1_d 84532.5
r19751 n2488 t_m1_d 7044.375
r19752 n2489 t_m1_d 112710
r19753 n2603 t_m1_d 1408.875
r19754 n2604 t_m1_d 22542
r19755 n2718 t_m1_d 4226.625
r19756 n2719 t_m1_d 67626
r19757 n2833 t_m1_d 10566.5625
r19758 n2834 t_m1_d 169065
r19759 n726 t_m1_b 53465
r19760 n727 t_m1_b 3341.5625
r19761 n882 t_m1_b 3564.3333333333335
r19762 n883 t_m1_b 222.77083333333334
r19763 n1038 t_m1_b 53465
r19764 n1039 t_m1_b 3341.5625
r19765 n2996 t_m1_b 3145
r19766 n2997 t_m1_b 196.5625
r19767 n1202 t_m1_s 10566.5625
r19768 n1203 t_m1_s 169065
r19769 n1317 t_m1_s 4226.625
r19770 n1318 t_m1_s 67626
r19771 n1432 t_m1_s 1408.875
r19772 n1433 t_m1_s 22542
r19773 n1547 t_m1_s 7044.375
r19774 n1548 t_m1_s 112710
r19775 n1662 t_m1_s 5283.28125
r19776 n1663 t_m1_s 84532.5
r19777 n1781 t_m1_s 7044.375
r19778 n1782 t_m1_s 112710
r19779 n1904 t_m1_s 10566.5625
r19780 n1905 t_m1_s 169065
r19781 n2135 t_m1_d 10566.5625
r19782 n2136 t_m1_d 169065
r19783 n2258 t_m1_d 7044.375
r19784 n2259 t_m1_d 112710
r19785 n2377 t_m1_d 5283.28125
r19786 n2378 t_m1_d 84532.5
r19787 n2492 t_m1_d 7044.375
r19788 n2493 t_m1_d 112710
r19789 n2607 t_m1_d 1408.875
r19790 n2608 t_m1_d 22542
r19791 n2722 t_m1_d 4226.625
r19792 n2723 t_m1_d 67626
r19793 n2837 t_m1_d 10566.5625
r19794 n2838 t_m1_d 169065
r19795 n732 t_m1_b 3145
r19796 n888 t_m1_b 209.66666666666669
r19797 n1044 t_m1_b 3145
r19798 n3002 t_m1_b 185
r19799 n1956 t_m1_g 43928
r19800 n1957 t_m1_g 7986.909090909091
r19801 n1958 t_m1_g 4624
r19802 n1959 t_m1_g 43928
r19803 n1968 t_m1_g 2928.5333333333333
r19804 n1969 t_m1_g 532.4606060606061
r19805 n1970 t_m1_g 308.26666666666665
r19806 n1971 t_m1_g 2928.5333333333333
r19807 n1980 t_m1_g 43928
r19808 n1981 t_m1_g 7986.909090909091
r19809 n1982 t_m1_g 4624
r19810 n1983 t_m1_g 43928
r19811 n740 t_m1_b 5627.8947368421059
r19812 n741 t_m1_b 53465
r19813 n742 t_m1_b 35643.333333333336
r19814 n743 t_m1_b 35643.333333333336
r19815 n744 t_m1_b 15275.714285714286
r19816 n896 t_m1_b 375.19298245614033
r19817 n897 t_m1_b 3564.3333333333335
r19818 n898 t_m1_b 2376.2222222222222
r19819 n899 t_m1_b 2376.2222222222222
r19820 n900 t_m1_b 1018.3809523809523
r19821 n1052 t_m1_b 5627.8947368421059
r19822 n1053 t_m1_b 53465
r19823 n1054 t_m1_b 35643.333333333336
r19824 n1055 t_m1_b 35643.333333333336
r19825 n1056 t_m1_b 15275.714285714286
r19826 n3010 t_m1_b 331.05263157894734
r19827 n3011 t_m1_b 3145
r19828 n3012 t_m1_b 2096.6666666666665
r19829 n3013 t_m1_b 2096.6666666666665
r19830 n3014 t_m1_b 898.57142857142867
r19831 n1079 t_m1_b 449.28571428571433
r19832 n1083 t_m1_b 3145
r19833 n1087 t_m1_b 1258
r19834 n1091 t_m1_b 1048.3333333333333
r19835 n1206 t_m1_b 3145
r19836 n1321 t_m1_b 1258
r19837 n1960 t_m1_b 3145
r19838 n1972 t_m1_b 209.66666666666669
r19839 n1984 t_m1_b 3145
r19840 n2726 t_m1_b 1258
r19841 n2841 t_m1_b 3145
r19842 n2845 t_m1_b 1048.3333333333333
r19843 n2849 t_m1_b 898.57142857142867
r19844 n2853 t_m1_b 449.28571428571433
.save v(out) v(in)
.control
set wr_singlescale
set wr_vecnames
ac dec 50 1000 10000000000.0
let h=(v(out)-0)/(v(in)-0)
let hr=real(h)
let hi=imag(h)
wrdata bode.csv hr hi
quit
.endc
.end
