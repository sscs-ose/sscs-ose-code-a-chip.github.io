.subckt INV VDD IN OUT VSS
XM1 OUT IN VDD VDD sky130_fd_pr__pfet_01v8 l=0.15u w=6.325u
XM2 OUT IN VSS VSS sky130_fd_pr__nfet_01v8 l=0.15u w=1.67u
.ends INV
