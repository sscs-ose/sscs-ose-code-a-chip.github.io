PerfPDN AC points
.lib /home/gokalp/.local/share/perfpdn/pdks/sky130A/libs.tech/ngspice/sky130.lib.spice tt
.option scale=1e-6
.temp 27
.option klu reltol=1e-8 abstol=1e-14 vntol=1e-10
vdd vdd 0 DC 0 AC 0 0
vin in 0 DC 0 AC 1 0
C1 out 0 1e-13
v_m1_d t_m1_d m1_d 0
v_m1_g t_m1_g m1_g -0.89000000000000001
v_m1_s t_m1_s m1_s -1.8
v_m1_b t_m1_b m1_b -1.8
XM1 m1_d m1_g m1_s m1_b sky130_fd_pr__pfet_01v8 L=0.15 W=6.325 nf=1 ad='int(( 1 + 1 ) / 2 ) * 6.325 / 1 * 0.29' as='int(( 1 + 2 ) / 2 ) * 6.325 / 1 * 0.29' pd='2 * int(( 1 + 1 ) / 2 ) * ( 6.325 / 1 + 0.29 )' ps='2 * int(( 1 + 2 ) / 2 ) * ( 6.325 / 1 + 0.29 )' nrd='0.29 / 6.325 ' nrs='0.29 / 6.325 ' sa=0 sb=0 sd=0 mult=1 m=1
v_m2_d t_m2_d m2_d 0
v_m2_g t_m2_g m2_g -0.89000000000000001
v_m2_s t_m2_s m2_s -0
v_m2_b t_m2_b m2_b -0
XM2 m2_d m2_g m2_s m2_b sky130_fd_pr__nfet_01v8 L=0.15 W=1.67 nf=1 ad='int(( 1 + 1 ) / 2 ) * 1.67 / 1 * 0.29' as='int(( 1 + 2 ) / 2 ) * 1.67 / 1 * 0.29' pd='2 * int(( 1 + 1 ) / 2 ) * ( 1.67 / 1 + 0.29 )' ps='2 * int(( 1 + 2 ) / 2 ) * ( 1.67 / 1 + 0.29 )' nrd='0.29 / 1.67 ' nrs='0.29 / 1.67 ' sa=0 sb=0 sd=0 mult=1 m=1
r0 n0 n1 2.9767441860465116
r1 n1 n2 4.9116279069767446
r2 n2 n3 3.7209302325581395
r3 n3 n4 4.7627906976744185
r4 n4 n5 4.7627906976744185
r5 n5 n6 3.7209302325581395
r6 n6 n7 4.9116279069767446
r7 n7 n8 2.9767441860465116
r8 n9 n10 2.9767441860465116
r9 n10 n11 4.3162790697674422
r10 n11 n12 3.4232558139534883
r11 n12 n13 0.89302325581395348
r12 n13 n14 4.7627906976744185
r13 n14 n15 4.7627906976744185
r14 n15 n16 0.89302325581395348
r15 n16 n17 3.4232558139534883
r16 n17 n18 4.3162790697674422
r17 n18 n19 2.9767441860465116
r18 n0 n20 49.280000000000001
r19 n1 n21 49.280000000000001
r20 n20 n21 3.7647058823529411
r21 n2 n22 21.42608695652174
r22 n21 n22 6.2117647058823531
r23 n3 n23 246.40000000000001
r24 n22 n23 4.7058823529411766
r25 n4 n24 16.426666666666666
r26 n23 n24 6.0235294117647058
r27 n5 n25 246.40000000000001
r28 n24 n25 6.0235294117647058
r29 n6 n26 21.42608695652174
r30 n25 n26 4.7058823529411766
r31 n7 n27 49.280000000000001
r32 n26 n27 6.2117647058823531
r33 n8 n28 49.280000000000001
r34 n27 n28 3.7647058823529411
r35 n9 n29 49.280000000000001
r36 n10 n30 49.280000000000001
r37 n29 n30 3.7647058823529411
r38 n11 n31 25.936842105263157
r39 n30 n31 5.4588235294117649
r40 n12 n32 123.2
r41 n31 n32 4.3294117647058821
r42 n13 n33 246.40000000000001
r43 n32 n33 1.1294117647058823
r44 n14 n34 16.426666666666666
r45 n33 n34 6.0235294117647058
r46 n15 n35 246.40000000000001
r47 n34 n35 6.0235294117647058
r48 n16 n36 123.2
r49 n35 n36 1.1294117647058823
r50 n17 n37 25.936842105263157
r51 n36 n37 4.3294117647058821
r52 n18 n38 49.280000000000001
r53 n37 n38 5.4588235294117649
r54 n19 n39 49.280000000000001
r55 n38 n39 3.7647058823529411
r56 n20 n40 49.280000000000001
r57 n21 n41 49.280000000000001
r58 n40 n41 2.9767441860465116
r59 n22 n42 21.42608695652174
r60 n41 n42 4.9116279069767446
r61 n23 n43 246.40000000000001
r62 n42 n43 3.7209302325581395
r63 n24 n44 16.426666666666666
r64 n43 n44 4.7627906976744185
r65 n25 n45 246.40000000000001
r66 n44 n45 4.7627906976744185
r67 n26 n46 21.42608695652174
r68 n45 n46 3.7209302325581395
r69 n27 n47 49.280000000000001
r70 n46 n47 4.9116279069767446
r71 n28 n48 49.280000000000001
r72 n47 n48 2.9767441860465116
r73 n29 n49 49.280000000000001
r74 n30 n50 49.280000000000001
r75 n49 n50 2.9767441860465116
r76 n31 n51 25.936842105263157
r77 n50 n51 4.3162790697674422
r78 n32 n52 123.2
r79 n51 n52 3.4232558139534883
r80 n33 n53 246.40000000000001
r81 n52 n53 0.89302325581395348
r82 n34 n54 16.426666666666666
r83 n53 n54 4.7627906976744185
r84 n35 n55 246.40000000000001
r85 n54 n55 4.7627906976744185
r86 n36 n56 123.2
r87 n55 n56 0.89302325581395348
r88 n37 n57 25.936842105263157
r89 n56 n57 3.4232558139534883
r90 n38 n58 49.280000000000001
r91 n57 n58 4.3162790697674422
r92 n39 n59 49.280000000000001
r93 n58 n59 2.9767441860465116
r94 n43 n60 265.60000000000002
r95 n44 n61 17.706666666666667
r96 n60 n61 5.1200000000000001
r97 n45 n62 265.60000000000002
r98 n61 n62 5.1200000000000001
r99 n53 n63 265.60000000000002
r100 n54 n64 17.706666666666667
r101 n63 n64 5.1200000000000001
r102 n55 n65 265.60000000000002
r103 n64 n65 5.1200000000000001
r104 n60 n66 288
r105 n61 n67 19.199999999999999
r106 n66 n67 4.0960000000000001
r107 n62 n68 288
r108 n67 n68 4.0960000000000001
r109 n63 n70 288
r110 n69 n70 0.76800000000000002
r111 n64 n71 19.199999999999999
r112 n70 n71 4.0960000000000001
r113 n65 n72 288
r114 n71 n72 4.0960000000000001
r115 n72 n73 0.76800000000000002
r116 n66 n74 320
r117 n67 n75 21.333333333333332
r118 n74 n75 4.0960000000000001
r119 n68 n76 320
r120 n75 n76 4.0960000000000001
r121 n69 n77 160
r122 n70 n78 320
r123 n77 n78 0.76800000000000002
r124 n71 n79 21.333333333333332
r125 n78 n79 4.0960000000000001
r126 n72 n80 320
r127 n79 n80 4.0960000000000001
r128 n73 n81 160
r129 n80 n81 0.76800000000000002
r130 n74 n82 320
r131 n75 n83 21.333333333333332
r132 n82 n83 4.0960000000000001
r133 n76 n84 320
r134 n83 n84 4.0960000000000001
r135 n77 n85 160
r136 n78 n86 320
r137 n85 n86 0.76800000000000002
r138 n79 n87 21.333333333333332
r139 n86 n87 4.0960000000000001
r140 n80 n88 320
r141 n87 n88 4.0960000000000001
r142 n81 n89 160
r143 n88 n89 0.76800000000000002
r144 n82 n90 320
r145 n83 n91 21.333333333333332
r146 n90 n91 4.0960000000000001
r147 n84 n92 320
r148 n91 n92 4.0960000000000001
r149 n85 n93 160
r150 n86 n94 320
r151 n93 n94 0.76800000000000002
r152 n87 n95 21.333333333333332
r153 n94 n95 4.0960000000000001
r154 n88 n96 320
r155 n95 n96 4.0960000000000001
r156 n89 n97 160
r157 n96 n97 0.76800000000000002
r158 n90 n98 320
r159 n91 n99 21.333333333333332
r160 n98 n99 4.0960000000000001
r161 n92 n100 320
r162 n99 n100 4.0960000000000001
r163 n93 n101 160
r164 n94 n102 320
r165 n101 n102 0.76800000000000002
r166 n95 n103 21.333333333333332
r167 n102 n103 4.0960000000000001
r168 n96 n104 320
r169 n103 n104 4.0960000000000001
r170 n97 n105 160
r171 n104 n105 0.76800000000000002
r172 n98 n106 320
r173 n99 n107 21.333333333333332
r174 n106 n107 4.0960000000000001
r175 n100 n108 320
r176 n107 n108 4.0960000000000001
r177 n101 n109 160
r178 n102 n110 320
r179 n109 n110 0.76800000000000002
r180 n103 n111 21.333333333333332
r181 n110 n111 4.0960000000000001
r182 n104 n112 320
r183 n111 n112 4.0960000000000001
r184 n105 n113 160
r185 n112 n113 0.76800000000000002
r186 n106 n114 320
r187 n107 n115 21.333333333333332
r188 n114 n115 4.0960000000000001
r189 n108 n116 320
r190 n115 n116 4.0960000000000001
r191 n109 n117 160
r192 n110 n118 320
r193 n117 n118 0.76800000000000002
r194 n111 n119 21.333333333333332
r195 n118 n119 4.0960000000000001
r196 n112 n120 320
r197 n119 n120 4.0960000000000001
r198 n113 n121 160
r199 n120 n121 0.76800000000000002
r200 n114 n122 320
r201 n115 n123 21.333333333333332
r202 n122 n123 4.0960000000000001
r203 n116 n124 320
r204 n123 n124 4.0960000000000001
r205 n117 n125 160
r206 n118 n126 320
r207 n125 n126 0.76800000000000002
r208 n119 n127 21.333333333333332
r209 n126 n127 4.0960000000000001
r210 n120 n128 320
r211 n127 n128 4.0960000000000001
r212 n121 n129 160
r213 n128 n129 0.76800000000000002
r214 n122 n130 320
r215 n123 n131 21.333333333333332
r216 n130 n131 4.0960000000000001
r217 n124 n132 320
r218 n131 n132 4.0960000000000001
r219 n125 n133 160
r220 n126 n134 320
r221 n133 n134 0.76800000000000002
r222 n127 n135 21.333333333333332
r223 n134 n135 4.0960000000000001
r224 n128 n136 320
r225 n135 n136 4.0960000000000001
r226 n129 n137 160
r227 n136 n137 0.76800000000000002
r228 n130 n138 320
r229 n131 n139 21.333333333333332
r230 n138 n139 4.0960000000000001
r231 n132 n140 320
r232 n139 n140 4.0960000000000001
r233 n133 n141 160
r234 n134 n142 320
r235 n141 n142 0.76800000000000002
r236 n135 n143 21.333333333333332
r237 n142 n143 4.0960000000000001
r238 n136 n144 320
r239 n143 n144 4.0960000000000001
r240 n137 n145 160
r241 n144 n145 0.76800000000000002
r242 n138 n146 320
r243 n139 n147 21.333333333333332
r244 n146 n147 4.0960000000000001
r245 n140 n148 320
r246 n147 n148 4.0960000000000001
r247 n141 n149 160
r248 n142 n150 320
r249 n149 n150 0.76800000000000002
r250 n143 n151 21.333333333333332
r251 n150 n151 4.0960000000000001
r252 n144 n152 320
r253 n151 n152 4.0960000000000001
r254 n145 n153 160
r255 n152 n153 0.76800000000000002
r256 n146 n154 320
r257 n147 n155 21.333333333333332
r258 n154 n155 4.0960000000000001
r259 n148 n156 320
r260 n155 n156 4.0960000000000001
r261 n149 n157 160
r262 n150 n158 320
r263 n157 n158 0.76800000000000002
r264 n151 n159 21.333333333333332
r265 n158 n159 4.0960000000000001
r266 n152 n160 320
r267 n159 n160 4.0960000000000001
r268 n153 n161 160
r269 n160 n161 0.76800000000000002
r270 n154 n162 320
r271 n155 n163 21.333333333333332
r272 n162 n163 4.0960000000000001
r273 n156 n164 320
r274 n163 n164 4.0960000000000001
r275 n157 n165 160
r276 n158 n166 320
r277 n165 n166 0.76800000000000002
r278 n159 n167 21.333333333333332
r279 n166 n167 4.0960000000000001
r280 n160 n168 320
r281 n167 n168 4.0960000000000001
r282 n161 n169 160
r283 n168 n169 0.76800000000000002
r284 n162 n170 320
r285 n163 n171 21.333333333333332
r286 n170 n171 4.0960000000000001
r287 n164 n172 320
r288 n171 n172 4.0960000000000001
r289 n165 n173 160
r290 n166 n174 320
r291 n173 n174 0.76800000000000002
r292 n167 n175 21.333333333333332
r293 n174 n175 4.0960000000000001
r294 n168 n176 320
r295 n175 n176 4.0960000000000001
r296 n169 n177 160
r297 n176 n177 0.76800000000000002
r298 n170 n178 320
r299 n171 n179 21.333333333333332
r300 n178 n179 4.0960000000000001
r301 n172 n180 320
r302 n179 n180 4.0960000000000001
r303 n173 n181 160
r304 n174 n182 320
r305 n181 n182 0.76800000000000002
r306 n175 n183 21.333333333333332
r307 n182 n183 4.0960000000000001
r308 n176 n184 320
r309 n183 n184 4.0960000000000001
r310 n177 n185 160
r311 n184 n185 0.76800000000000002
r312 n178 n186 320
r313 n179 n187 21.333333333333332
r314 n186 n187 4.0960000000000001
r315 n180 n188 320
r316 n187 n188 4.0960000000000001
r317 n181 n189 160
r318 n182 n190 320
r319 n189 n190 0.76800000000000002
r320 n183 n191 21.333333333333332
r321 n190 n191 4.0960000000000001
r322 n184 n192 320
r323 n191 n192 4.0960000000000001
r324 n185 n193 160
r325 n192 n193 0.76800000000000002
r326 n186 n194 320
r327 n187 n195 21.333333333333332
r328 n194 n195 4.0960000000000001
r329 n188 n196 320
r330 n195 n196 4.0960000000000001
r331 n189 n197 160
r332 n190 n198 320
r333 n197 n198 0.76800000000000002
r334 n191 n199 21.333333333333332
r335 n198 n199 4.0960000000000001
r336 n192 n200 320
r337 n199 n200 4.0960000000000001
r338 n193 n201 160
r339 n200 n201 0.76800000000000002
r340 n194 n202 320
r341 n195 n203 21.333333333333332
r342 n202 n203 4.0960000000000001
r343 n196 n204 320
r344 n203 n204 4.0960000000000001
r345 n197 n205 160
r346 n198 n206 320
r347 n205 n206 0.76800000000000002
r348 n199 n207 21.333333333333332
r349 n206 n207 4.0960000000000001
r350 n200 n208 320
r351 n207 n208 4.0960000000000001
r352 n201 n209 160
r353 n208 n209 0.76800000000000002
r354 n202 n210 320
r355 n203 n211 21.333333333333332
r356 n210 n211 4.0960000000000001
r357 n204 n212 320
r358 n211 n212 4.0960000000000001
r359 n205 n213 160
r360 n206 n214 320
r361 n213 n214 0.76800000000000002
r362 n207 n215 21.333333333333332
r363 n214 n215 4.0960000000000001
r364 n208 n216 320
r365 n215 n216 4.0960000000000001
r366 n209 n217 160
r367 n216 n217 0.76800000000000002
r368 n210 n218 320
r369 n211 n219 21.333333333333332
r370 n218 n219 4.0960000000000001
r371 n212 n220 320
r372 n219 n220 4.0960000000000001
r373 n213 n221 160
r374 n214 n222 320
r375 n221 n222 0.76800000000000002
r376 n215 n223 21.333333333333332
r377 n222 n223 4.0960000000000001
r378 n216 n224 320
r379 n223 n224 4.0960000000000001
r380 n217 n225 160
r381 n224 n225 0.76800000000000002
r382 n218 n226 320
r383 n219 n227 21.333333333333332
r384 n226 n227 4.0960000000000001
r385 n220 n228 320
r386 n227 n228 4.0960000000000001
r387 n221 n229 160
r388 n222 n230 320
r389 n229 n230 0.76800000000000002
r390 n223 n231 21.333333333333332
r391 n230 n231 4.0960000000000001
r392 n224 n232 320
r393 n231 n232 4.0960000000000001
r394 n225 n233 160
r395 n232 n233 0.76800000000000002
r396 n226 n234 320
r397 n227 n235 21.333333333333332
r398 n234 n235 4.0960000000000001
r399 n228 n236 320
r400 n235 n236 4.0960000000000001
r401 n229 n237 160
r402 n230 n238 320
r403 n237 n238 0.76800000000000002
r404 n231 n239 21.333333333333332
r405 n238 n239 4.0960000000000001
r406 n232 n240 320
r407 n239 n240 4.0960000000000001
r408 n233 n241 160
r409 n240 n241 0.76800000000000002
r410 n234 n242 320
r411 n235 n243 21.333333333333332
r412 n242 n243 4.0960000000000001
r413 n236 n244 320
r414 n243 n244 4.0960000000000001
r415 n237 n245 160
r416 n238 n246 320
r417 n245 n246 0.76800000000000002
r418 n239 n247 21.333333333333332
r419 n246 n247 4.0960000000000001
r420 n240 n248 320
r421 n247 n248 4.0960000000000001
r422 n241 n249 160
r423 n248 n249 0.76800000000000002
r424 n242 n250 320
r425 n243 n251 21.333333333333332
r426 n250 n251 4.0960000000000001
r427 n244 n252 320
r428 n251 n252 4.0960000000000001
r429 n245 n253 160
r430 n246 n254 320
r431 n253 n254 0.76800000000000002
r432 n247 n255 21.333333333333332
r433 n254 n255 4.0960000000000001
r434 n248 n256 320
r435 n255 n256 4.0960000000000001
r436 n249 n257 160
r437 n256 n257 0.76800000000000002
r438 n250 n258 320
r439 n251 n259 21.333333333333332
r440 n258 n259 4.0960000000000001
r441 n252 n260 320
r442 n259 n260 4.0960000000000001
r443 n253 n261 160
r444 n254 n262 320
r445 n261 n262 0.76800000000000002
r446 n255 n263 21.333333333333332
r447 n262 n263 4.0960000000000001
r448 n256 n264 320
r449 n263 n264 4.0960000000000001
r450 n257 n265 160
r451 n264 n265 0.76800000000000002
r452 n258 n266 320
r453 n259 n267 21.333333333333332
r454 n266 n267 4.0960000000000001
r455 n260 n268 320
r456 n267 n268 4.0960000000000001
r457 n261 n269 160
r458 n262 n270 320
r459 n269 n270 0.76800000000000002
r460 n263 n271 21.333333333333332
r461 n270 n271 4.0960000000000001
r462 n264 n272 320
r463 n271 n272 4.0960000000000001
r464 n265 n273 160
r465 n272 n273 0.76800000000000002
r466 n266 n274 320
r467 n267 n275 21.333333333333332
r468 n274 n275 4.0960000000000001
r469 n268 n276 320
r470 n275 n276 4.0960000000000001
r471 n269 n277 160
r472 n270 n278 320
r473 n277 n278 0.76800000000000002
r474 n271 n279 21.333333333333332
r475 n278 n279 4.0960000000000001
r476 n272 n280 320
r477 n279 n280 4.0960000000000001
r478 n273 n281 160
r479 n280 n281 0.76800000000000002
r480 n274 n282 320
r481 n275 n283 21.333333333333332
r482 n282 n283 4.0960000000000001
r483 n276 n284 320
r484 n283 n284 4.0960000000000001
r485 n277 n285 160
r486 n278 n286 320
r487 n285 n286 0.76800000000000002
r488 n279 n287 21.333333333333332
r489 n286 n287 4.0960000000000001
r490 n280 n288 320
r491 n287 n288 4.0960000000000001
r492 n281 n289 160
r493 n288 n289 0.76800000000000002
r494 n282 n290 320
r495 n283 n291 21.333333333333332
r496 n290 n291 4.0960000000000001
r497 n284 n292 320
r498 n291 n292 4.0960000000000001
r499 n285 n293 160
r500 n286 n294 320
r501 n293 n294 0.76800000000000002
r502 n287 n295 21.333333333333332
r503 n294 n295 4.0960000000000001
r504 n288 n296 320
r505 n295 n296 4.0960000000000001
r506 n289 n297 160
r507 n296 n297 0.76800000000000002
r508 n290 n298 320
r509 n291 n299 21.333333333333332
r510 n298 n299 4.0960000000000001
r511 n292 n300 320
r512 n299 n300 4.0960000000000001
r513 n293 n301 160
r514 n294 n302 320
r515 n301 n302 0.76800000000000002
r516 n295 n303 21.333333333333332
r517 n302 n303 4.0960000000000001
r518 n296 n304 320
r519 n303 n304 4.0960000000000001
r520 n297 n305 160
r521 n304 n305 0.76800000000000002
r522 n298 n306 320
r523 n299 n307 21.333333333333332
r524 n306 n307 4.0960000000000001
r525 n300 n308 320
r526 n307 n308 4.0960000000000001
r527 n301 n309 160
r528 n302 n310 320
r529 n309 n310 0.76800000000000002
r530 n303 n311 21.333333333333332
r531 n310 n311 4.0960000000000001
r532 n304 n312 320
r533 n311 n312 4.0960000000000001
r534 n305 n313 160
r535 n312 n313 0.76800000000000002
r536 n306 n314 320
r537 n307 n315 21.333333333333332
r538 n314 n315 4.0960000000000001
r539 n308 n316 320
r540 n315 n316 4.0960000000000001
r541 n309 n317 160
r542 n310 n318 320
r543 n317 n318 0.76800000000000002
r544 n311 n319 21.333333333333332
r545 n318 n319 4.0960000000000001
r546 n312 n320 320
r547 n319 n320 4.0960000000000001
r548 n313 n321 160
r549 n320 n321 0.76800000000000002
r550 n314 n322 320
r551 n315 n323 21.333333333333332
r552 n322 n323 4.0960000000000001
r553 n316 n324 320
r554 n323 n324 4.0960000000000001
r555 n317 n325 160
r556 n318 n326 320
r557 n325 n326 0.76800000000000002
r558 n319 n327 21.333333333333332
r559 n326 n327 4.0960000000000001
r560 n320 n328 320
r561 n327 n328 4.0960000000000001
r562 n321 n329 160
r563 n328 n329 0.76800000000000002
r564 n322 n330 320
r565 n323 n331 21.333333333333332
r566 n330 n331 4.0960000000000001
r567 n324 n332 320
r568 n331 n332 4.0960000000000001
r569 n325 n333 160
r570 n326 n334 320
r571 n333 n334 0.76800000000000002
r572 n327 n335 21.333333333333332
r573 n334 n335 4.0960000000000001
r574 n328 n336 320
r575 n335 n336 4.0960000000000001
r576 n329 n337 160
r577 n336 n337 0.76800000000000002
r578 n330 n338 320
r579 n331 n339 21.333333333333332
r580 n338 n339 4.0960000000000001
r581 n332 n340 320
r582 n339 n340 4.0960000000000001
r583 n333 n341 160
r584 n334 n342 320
r585 n341 n342 0.76800000000000002
r586 n335 n343 21.333333333333332
r587 n342 n343 4.0960000000000001
r588 n336 n344 320
r589 n343 n344 4.0960000000000001
r590 n337 n345 160
r591 n344 n345 0.76800000000000002
r592 n338 n346 320
r593 n339 n347 21.333333333333332
r594 n346 n347 4.0960000000000001
r595 n340 n348 320
r596 n347 n348 4.0960000000000001
r597 n341 n349 160
r598 n342 n350 320
r599 n349 n350 0.76800000000000002
r600 n343 n351 21.333333333333332
r601 n350 n351 4.0960000000000001
r602 n344 n352 320
r603 n351 n352 4.0960000000000001
r604 n345 n353 160
r605 n352 n353 0.76800000000000002
r606 n346 n354 320
r607 n347 n355 21.333333333333332
r608 n354 n355 4.0960000000000001
r609 n348 n356 320
r610 n355 n356 4.0960000000000001
r611 n349 n357 160
r612 n350 n358 320
r613 n357 n358 0.76800000000000002
r614 n351 n359 21.333333333333332
r615 n358 n359 4.0960000000000001
r616 n352 n360 320
r617 n359 n360 4.0960000000000001
r618 n353 n361 160
r619 n360 n361 0.76800000000000002
r620 n354 n362 320
r621 n355 n363 21.333333333333332
r622 n362 n363 4.0960000000000001
r623 n356 n364 320
r624 n363 n364 4.0960000000000001
r625 n357 n365 160
r626 n358 n366 320
r627 n365 n366 0.76800000000000002
r628 n359 n367 21.333333333333332
r629 n366 n367 4.0960000000000001
r630 n360 n368 320
r631 n367 n368 4.0960000000000001
r632 n361 n369 160
r633 n368 n369 0.76800000000000002
r634 n362 n370 320
r635 n363 n371 21.333333333333332
r636 n370 n371 4.0960000000000001
r637 n364 n372 320
r638 n371 n372 4.0960000000000001
r639 n365 n373 160
r640 n366 n374 320
r641 n373 n374 0.76800000000000002
r642 n367 n375 21.333333333333332
r643 n374 n375 4.0960000000000001
r644 n368 n376 320
r645 n375 n376 4.0960000000000001
r646 n369 n377 160
r647 n376 n377 0.76800000000000002
r648 n370 n378 320
r649 n371 n379 21.333333333333332
r650 n378 n379 4.0960000000000001
r651 n372 n380 320
r652 n379 n380 4.0960000000000001
r653 n373 n381 160
r654 n374 n382 320
r655 n381 n382 0.76800000000000002
r656 n375 n383 21.333333333333332
r657 n382 n383 4.0960000000000001
r658 n376 n384 320
r659 n383 n384 4.0960000000000001
r660 n377 n385 160
r661 n384 n385 0.76800000000000002
r662 n378 n386 320
r663 n379 n387 21.333333333333332
r664 n386 n387 4.0960000000000001
r665 n380 n388 320
r666 n387 n388 4.0960000000000001
r667 n381 n389 160
r668 n382 n390 320
r669 n389 n390 0.76800000000000002
r670 n383 n391 21.333333333333332
r671 n390 n391 4.0960000000000001
r672 n384 n392 320
r673 n391 n392 4.0960000000000001
r674 n385 n393 160
r675 n392 n393 0.76800000000000002
r676 n386 n394 320
r677 n387 n395 21.333333333333332
r678 n394 n395 4.0960000000000001
r679 n388 n396 320
r680 n395 n396 4.0960000000000001
r681 n389 n397 160
r682 n390 n398 320
r683 n397 n398 0.76800000000000002
r684 n391 n399 21.333333333333332
r685 n398 n399 4.0960000000000001
r686 n392 n400 320
r687 n399 n400 4.0960000000000001
r688 n393 n401 160
r689 n400 n401 0.76800000000000002
r690 n394 n402 320
r691 n395 n403 21.333333333333332
r692 n402 n403 4.0960000000000001
r693 n396 n404 320
r694 n403 n404 4.0960000000000001
r695 n397 n405 160
r696 n398 n406 320
r697 n405 n406 0.76800000000000002
r698 n399 n407 21.333333333333332
r699 n406 n407 4.0960000000000001
r700 n400 n408 320
r701 n407 n408 4.0960000000000001
r702 n401 n409 160
r703 n408 n409 0.76800000000000002
r704 n402 n410 320
r705 n403 n411 21.333333333333332
r706 n410 n411 4.0960000000000001
r707 n404 n412 320
r708 n411 n412 4.0960000000000001
r709 n405 n413 160
r710 n406 n414 320
r711 n413 n414 0.76800000000000002
r712 n407 n415 21.333333333333332
r713 n414 n415 4.0960000000000001
r714 n408 n416 320
r715 n415 n416 4.0960000000000001
r716 n409 n417 160
r717 n416 n417 0.76800000000000002
r718 n410 n418 320
r719 n411 n419 21.333333333333332
r720 n418 n419 4.0960000000000001
r721 n412 n420 320
r722 n419 n420 4.0960000000000001
r723 n413 n421 160
r724 n414 n422 320
r725 n421 n422 0.76800000000000002
r726 n415 n423 21.333333333333332
r727 n422 n423 4.0960000000000001
r728 n416 n424 320
r729 n423 n424 4.0960000000000001
r730 n417 n425 160
r731 n424 n425 0.76800000000000002
r732 n418 n426 320
r733 n419 n427 21.333333333333332
r734 n426 n427 4.0960000000000001
r735 n420 n428 320
r736 n427 n428 4.0960000000000001
r737 n421 n429 160
r738 n422 n430 320
r739 n429 n430 0.76800000000000002
r740 n423 n431 21.333333333333332
r741 n430 n431 4.0960000000000001
r742 n424 n432 320
r743 n431 n432 4.0960000000000001
r744 n425 n433 160
r745 n432 n433 0.76800000000000002
r746 n426 n434 288
r747 n427 n435 19.199999999999999
r748 n434 n435 5.1200000000000001
r749 n428 n436 288
r750 n435 n436 5.1200000000000001
r751 n430 n437 288
r752 n431 n438 19.199999999999999
r753 n437 n438 5.1200000000000001
r754 n432 n439 288
r755 n438 n439 5.1200000000000001
r756 n440 n441 2.9767441860465116
r757 n441 n442 4.9116279069767446
r758 n434 n443 265.60000000000002
r759 n442 n443 3.7209302325581395
r760 n435 n444 17.706666666666667
r761 n443 n444 4.7627906976744185
r762 n436 n445 265.60000000000002
r763 n444 n445 4.7627906976744185
r764 n445 n446 3.7209302325581395
r765 n446 n447 4.9116279069767446
r766 n447 n448 2.9767441860465116
r767 n449 n450 2.9767441860465116
r768 n450 n451 4.3162790697674422
r769 n451 n452 3.4232558139534883
r770 n437 n453 265.60000000000002
r771 n452 n453 0.89302325581395348
r772 n438 n454 17.706666666666667
r773 n453 n454 4.7627906976744185
r774 n439 n455 265.60000000000002
r775 n454 n455 4.7627906976744185
r776 n455 n456 0.89302325581395348
r777 n456 n457 3.4232558139534883
r778 n457 n458 4.3162790697674422
r779 n458 n459 2.9767441860465116
r780 n440 n460 49.280000000000001
r781 n441 n461 49.280000000000001
r782 n460 n461 3.7647058823529411
r783 n442 n462 21.42608695652174
r784 n461 n462 6.2117647058823531
r785 n443 n463 246.40000000000001
r786 n462 n463 4.7058823529411766
r787 n444 n464 16.426666666666666
r788 n463 n464 6.0235294117647058
r789 n445 n465 246.40000000000001
r790 n464 n465 6.0235294117647058
r791 n446 n466 21.42608695652174
r792 n465 n466 4.7058823529411766
r793 n447 n467 49.280000000000001
r794 n466 n467 6.2117647058823531
r795 n448 n468 49.280000000000001
r796 n467 n468 3.7647058823529411
r797 n449 n469 49.280000000000001
r798 n450 n470 49.280000000000001
r799 n469 n470 3.7647058823529411
r800 n451 n471 25.936842105263157
r801 n470 n471 5.4588235294117649
r802 n452 n472 123.2
r803 n471 n472 4.3294117647058821
r804 n453 n473 246.40000000000001
r805 n472 n473 1.1294117647058823
r806 n454 n474 16.426666666666666
r807 n473 n474 6.0235294117647058
r808 n455 n475 246.40000000000001
r809 n474 n475 6.0235294117647058
r810 n456 n476 123.2
r811 n475 n476 1.1294117647058823
r812 n457 n477 25.936842105263157
r813 n476 n477 4.3294117647058821
r814 n458 n478 49.280000000000001
r815 n477 n478 5.4588235294117649
r816 n459 n479 49.280000000000001
r817 n478 n479 3.7647058823529411
r818 n460 n480 49.280000000000001
r819 n461 n481 49.280000000000001
r820 n480 n481 2.9767441860465116
r821 n462 n482 21.42608695652174
r822 n481 n482 4.9116279069767446
r823 n463 n483 246.40000000000001
r824 n482 n483 3.7209302325581395
r825 n464 n484 16.426666666666666
r826 n483 n484 4.7627906976744185
r827 n465 n485 246.40000000000001
r828 n484 n485 4.7627906976744185
r829 n466 n486 21.42608695652174
r830 n485 n486 3.7209302325581395
r831 n467 n487 49.280000000000001
r832 n486 n487 4.9116279069767446
r833 n468 n488 49.280000000000001
r834 n487 n488 2.9767441860465116
r835 n469 n489 49.280000000000001
r836 n470 n490 49.280000000000001
r837 n489 n490 2.9767441860465116
r838 n471 n491 25.936842105263157
r839 n490 n491 4.3162790697674422
r840 n472 n492 123.2
r841 n491 n492 3.4232558139534883
r842 n473 n493 246.40000000000001
r843 n492 n493 0.89302325581395348
r844 n474 n494 16.426666666666666
r845 n493 n494 4.7627906976744185
r846 n475 n495 246.40000000000001
r847 n494 n495 4.7627906976744185
r848 n476 n496 123.2
r849 n495 n496 0.89302325581395348
r850 n477 n497 25.936842105263157
r851 n496 n497 3.4232558139534883
r852 n478 n498 49.280000000000001
r853 n497 n498 4.3162790697674422
r854 n479 n499 49.280000000000001
r855 n498 n499 2.9767441860465116
r856 n500 n501 208
r857 n501 n502 198.40000000000001
r858 n502 n503 208
r859 n503 n504 185.59999999999999
r860 n504 n505 89.599999999999994
r861 n505 n506 44.799999999999997
r862 n506 n507 38.399999999999999
r863 n507 n508 108.8
r864 n508 n509 108.8
r865 n509 n510 121.59999999999999
r866 n510 n511 121.59999999999999
r867 n511 n512 48
r868 n512 n513 80
r869 n513 n514 60.799999999999997
r870 n514 n515 28.800000000000001
r871 n515 n516 19.199999999999999
r872 n516 n517 41.600000000000001
r873 n517 n518 96
r874 n518 n519 73.599999999999994
r875 n519 n520 12.800000000000001
r876 n520 n521 35.200000000000003
r877 n521 n522 67.200000000000003
r878 n522 n523 67.200000000000003
r879 n523 n524 35.200000000000003
r880 n524 n525 12.800000000000001
r881 n525 n526 73.599999999999994
r882 n526 n527 115.2
r883 n527 n528 54.399999999999999
r884 n528 n529 108.8
r885 n529 n530 108.8
r886 n530 n531 44.799999999999997
r887 n531 n532 51.200000000000003
r888 n532 n533 76.799999999999997
r889 n533 n534 172.80000000000001
r890 n534 n535 124.8
r891 n535 n536 48
r892 n536 n537 54.399999999999999
r893 n537 n538 32
r894 n538 n539 19.199999999999999
r895 n539 n540 16
r896 n540 n541 32
r897 n541 n542 96
r898 n542 n543 76.799999999999997
r899 n543 n544 16
r900 n544 n545 19.199999999999999
r901 n545 n546 22.399999999999999
r902 n546 n547 22.399999999999999
r903 n547 n548 41.600000000000001
r904 n548 n549 188.80000000000001
r905 n549 n550 265.60000000000002
r906 n551 n552 204.80000000000001
r907 n552 n553 192
r908 n553 n554 204.80000000000001
r909 n554 n555 185.59999999999999
r910 n555 n556 89.599999999999994
r911 n556 n557 44.799999999999997
r912 n557 n558 38.399999999999999
r913 n558 n559 108.8
r914 n559 n560 108.8
r915 n560 n561 121.59999999999999
r916 n561 n562 121.59999999999999
r917 n562 n563 108.8
r918 n563 n564 108.8
r919 n564 n565 121.59999999999999
r920 n565 n566 121.59999999999999
r921 n566 n567 108.8
r922 n567 n568 108.8
r923 n568 n569 121.59999999999999
r924 n569 n570 121.59999999999999
r925 n570 n571 108.8
r926 n571 n572 108.8
r927 n572 n573 121.59999999999999
r928 n573 n574 121.59999999999999
r929 n574 n575 108.8
r930 n575 n576 108.8
r931 n576 n577 121.59999999999999
r932 n577 n578 121.59999999999999
r933 n578 n579 108.8
r934 n579 n580 108.8
r935 n580 n581 121.59999999999999
r936 n581 n582 121.59999999999999
r937 n582 n583 108.8
r938 n583 n584 108.8
r939 n584 n585 121.59999999999999
r940 n585 n586 121.59999999999999
r941 n586 n587 108.8
r942 n587 n588 108.8
r943 n588 n589 54.399999999999999
r944 n589 n590 86.400000000000006
r945 n590 n591 67.200000000000003
r946 n591 n592 35.200000000000003
r947 n592 n593 12.800000000000001
r948 n593 n594 32
r949 n594 n595 96
r950 n595 n596 73.599999999999994
r951 n596 n597 6.4000000000000004
r952 n597 n598 6.4000000000000004
r953 n598 n599 35.200000000000003
r954 n599 n600 70.400000000000006
r955 n600 n601 64
r956 n601 n602 32
r957 n602 n603 16
r958 n603 n604 16
r959 n604 n605 25.600000000000001
r960 n605 n606 57.600000000000001
r961 n606 n607 83.200000000000003
r962 n607 n608 51.200000000000003
r963 n608 n609 121.59999999999999
r964 n609 n610 121.59999999999999
r965 n610 n611 108.8
r966 n611 n612 108.8
r967 n612 n613 121.59999999999999
r968 n613 n614 121.59999999999999
r969 n614 n615 108.8
r970 n615 n616 108.8
r971 n616 n617 121.59999999999999
r972 n617 n618 121.59999999999999
r973 n618 n619 108.8
r974 n619 n620 108.8
r975 n620 n621 121.59999999999999
r976 n621 n622 121.59999999999999
r977 n622 n623 108.8
r978 n623 n624 108.8
r979 n624 n625 121.59999999999999
r980 n625 n626 121.59999999999999
r981 n626 n627 108.8
r982 n627 n628 108.8
r983 n628 n629 121.59999999999999
r984 n629 n630 121.59999999999999
r985 n630 n631 108.8
r986 n631 n632 108.8
r987 n632 n633 121.59999999999999
r988 n633 n634 121.59999999999999
r989 n634 n635 108.8
r990 n635 n636 108.8
r991 n636 n637 44.799999999999997
r992 n637 n638 51.200000000000003
r993 n638 n639 76.799999999999997
r994 n639 n640 172.80000000000001
r995 n640 n641 115.2
r996 n641 n642 38.399999999999999
r997 n642 n643 54.399999999999999
r998 n643 n644 32
r999 n644 n645 19.199999999999999
r1000 n645 n646 16
r1001 n646 n647 41.600000000000001
r1002 n647 n648 96
r1003 n648 n649 67.200000000000003
r1004 n649 n650 16
r1005 n650 n651 19.199999999999999
r1006 n651 n652 32
r1007 n652 n653 54.399999999999999
r1008 n653 n654 188.80000000000001
r1009 n654 n655 265.60000000000002
r1010 n500 n656 6.0235294117647058
r1011 n501 n657 6.6064516129032258
r1012 n656 n657 13.866666666666667
r1013 n502 n658 6.6064516129032258
r1014 n657 n658 13.226666666666667
r1015 n503 n659 6.0235294117647058
r1016 n658 n659 13.866666666666667
r1017 n504 n660 8.5333333333333332
r1018 n659 n660 12.373333333333333
r1019 n505 n661 51.200000000000003
r1020 n660 n661 5.9733333333333336
r1021 n506 n662 20.48
r1022 n661 n662 2.9866666666666668
r1023 n507 n663 102.40000000000001
r1024 n662 n663 2.5600000000000001
r1025 n508 n664 6.4000000000000004
r1026 n663 n664 7.253333333333333
r1027 n509 n665 102.40000000000001
r1028 n664 n665 7.253333333333333
r1029 n510 n666 5.6888888888888891
r1030 n665 n666 8.1066666666666674
r1031 n511 n667 102.40000000000001
r1032 n666 n667 8.1066666666666674
r1033 n512 n668 15.753846153846155
r1034 n667 n668 3.2000000000000002
r1035 n513 n669 17.066666666666666
r1036 n668 n669 5.333333333333333
r1037 n514 n670 29.257142857142856
r1038 n669 n670 4.0533333333333337
r1039 n515 n671 102.40000000000001
r1040 n670 n671 1.9199999999999999
r1041 n516 n672 51.200000000000003
r1042 n671 n672 1.28
r1043 n517 n673 22.755555555555556
r1044 n672 n673 2.7733333333333334
r1045 n518 n674 9.7523809523809533
r1046 n673 n674 6.4000000000000004
r1047 n519 n675 102.40000000000001
r1048 n674 n675 4.9066666666666663
r1049 n520 n676 102.40000000000001
r1050 n675 n676 0.85333333333333339
r1051 n521 n677 22.755555555555556
r1052 n676 n677 2.3466666666666667
r1053 n522 n678 17.066666666666666
r1054 n677 n678 4.4800000000000004
r1055 n523 n679 22.755555555555556
r1056 n678 n679 4.4800000000000004
r1057 n524 n680 102.40000000000001
r1058 n679 n680 2.3466666666666667
r1059 n525 n681 102.40000000000001
r1060 n680 n681 0.85333333333333339
r1061 n526 n682 9.7523809523809533
r1062 n681 n682 4.9066666666666663
r1063 n527 n683 13.653333333333334
r1064 n682 n683 7.6799999999999997
r1065 n528 n684 102.40000000000001
r1066 n683 n684 3.6266666666666665
r1067 n529 n685 6.4000000000000004
r1068 n684 n685 7.253333333333333
r1069 n530 n686 102.40000000000001
r1070 n685 n686 7.253333333333333
r1071 n531 n687 17.066666666666666
r1072 n686 n687 2.9866666666666668
r1073 n532 n688 51.200000000000003
r1074 n687 n688 3.4133333333333336
r1075 n533 n689 10.24
r1076 n688 n689 5.1200000000000001
r1077 n534 n690 6.0235294117647058
r1078 n689 n690 11.52
r1079 n535 n691 40.960000000000001
r1080 n690 n691 8.3200000000000003
r1081 n536 n692 20.48
r1082 n691 n692 3.2000000000000002
r1083 n537 n693 29.257142857142856
r1084 n692 n693 3.6266666666666665
r1085 n538 n694 68.266666666666666
r1086 n693 n694 2.1333333333333333
r1087 n539 n695 68.266666666666666
r1088 n694 n695 1.28
r1089 n540 n696 102.40000000000001
r1090 n695 n696 1.0666666666666667
r1091 n541 n697 25.600000000000001
r1092 n696 n697 2.1333333333333333
r1093 n542 n698 9.3090909090909086
r1094 n697 n698 6.4000000000000004
r1095 n543 n699 102.40000000000001
r1096 n698 n699 5.1200000000000001
r1097 n544 n700 68.266666666666666
r1098 n699 n700 1.0666666666666667
r1099 n545 n701 68.266666666666666
r1100 n700 n701 1.28
r1101 n546 n702 51.200000000000003
r1102 n701 n702 1.4933333333333334
r1103 n547 n703 68.266666666666666
r1104 n702 n703 1.4933333333333334
r1105 n548 n704 20.48
r1106 n703 n704 2.7733333333333334
r1107 n549 n705 4.1795918367346943
r1108 n704 n705 12.586666666666666
r1109 n550 n706 6.0235294117647058
r1110 n705 n706 17.706666666666667
r1111 n551 n707 6.0235294117647058
r1112 n552 n708 6.8266666666666671
r1113 n707 n708 13.653333333333334
r1114 n553 n709 6.8266666666666671
r1115 n708 n709 12.800000000000001
r1116 n554 n710 6.0235294117647058
r1117 n709 n710 13.653333333333334
r1118 n555 n711 8.5333333333333332
r1119 n710 n711 12.373333333333333
r1120 n556 n712 51.200000000000003
r1121 n711 n712 5.9733333333333336
r1122 n557 n713 20.48
r1123 n712 n713 2.9866666666666668
r1124 n558 n714 102.40000000000001
r1125 n713 n714 2.5600000000000001
r1126 n559 n715 6.4000000000000004
r1127 n714 n715 7.253333333333333
r1128 n560 n716 102.40000000000001
r1129 n715 n716 7.253333333333333
r1130 n561 n717 5.6888888888888891
r1131 n716 n717 8.1066666666666674
r1132 n562 n718 102.40000000000001
r1133 n717 n718 8.1066666666666674
r1134 n563 n719 6.4000000000000004
r1135 n718 n719 7.253333333333333
r1136 n564 n720 102.40000000000001
r1137 n719 n720 7.253333333333333
r1138 n565 n721 5.6888888888888891
r1139 n720 n721 8.1066666666666674
r1140 n566 n722 102.40000000000001
r1141 n721 n722 8.1066666666666674
r1142 n567 n723 6.4000000000000004
r1143 n722 n723 7.253333333333333
r1144 n568 n724 102.40000000000001
r1145 n723 n724 7.253333333333333
r1146 n569 n725 5.6888888888888891
r1147 n724 n725 8.1066666666666674
r1148 n570 n726 102.40000000000001
r1149 n725 n726 8.1066666666666674
r1150 n571 n727 6.4000000000000004
r1151 n726 n727 7.253333333333333
r1152 n572 n728 102.40000000000001
r1153 n727 n728 7.253333333333333
r1154 n573 n729 5.6888888888888891
r1155 n728 n729 8.1066666666666674
r1156 n574 n730 102.40000000000001
r1157 n729 n730 8.1066666666666674
r1158 n575 n731 6.4000000000000004
r1159 n730 n731 7.253333333333333
r1160 n576 n732 102.40000000000001
r1161 n731 n732 7.253333333333333
r1162 n577 n733 5.6888888888888891
r1163 n732 n733 8.1066666666666674
r1164 n578 n734 102.40000000000001
r1165 n733 n734 8.1066666666666674
r1166 n579 n735 6.4000000000000004
r1167 n734 n735 7.253333333333333
r1168 n580 n736 102.40000000000001
r1169 n735 n736 7.253333333333333
r1170 n581 n737 5.6888888888888891
r1171 n736 n737 8.1066666666666674
r1172 n582 n738 102.40000000000001
r1173 n737 n738 8.1066666666666674
r1174 n583 n739 6.4000000000000004
r1175 n738 n739 7.253333333333333
r1176 n584 n740 102.40000000000001
r1177 n739 n740 7.253333333333333
r1178 n585 n741 5.6888888888888891
r1179 n740 n741 8.1066666666666674
r1180 n586 n742 102.40000000000001
r1181 n741 n742 8.1066666666666674
r1182 n587 n743 6.4000000000000004
r1183 n742 n743 7.253333333333333
r1184 n588 n744 102.40000000000001
r1185 n743 n744 7.253333333333333
r1186 n589 n745 13.653333333333334
r1187 n744 n745 3.6266666666666665
r1188 n590 n746 17.066666666666666
r1189 n745 n746 5.7599999999999998
r1190 n591 n747 22.755555555555556
r1191 n746 n747 4.4800000000000004
r1192 n592 n748 102.40000000000001
r1193 n747 n748 2.3466666666666667
r1194 n593 n749 102.40000000000001
r1195 n748 n749 0.85333333333333339
r1196 n594 n750 25.600000000000001
r1197 n749 n750 2.1333333333333333
r1198 n595 n751 9.3090909090909086
r1199 n750 n751 6.4000000000000004
r1200 n596 n752 204.80000000000001
r1201 n751 n752 4.9066666666666663
r1202 n597 n753 204.80000000000001
r1203 n752 n753 0.42666666666666669
r1204 n598 n754 204.80000000000001
r1205 n753 n754 0.42666666666666669
r1206 n599 n755 20.48
r1207 n754 n755 2.3466666666666667
r1208 n600 n756 17.066666666666666
r1209 n755 n756 4.6933333333333334
r1210 n601 n757 25.600000000000001
r1211 n756 n757 4.2666666666666666
r1212 n602 n758 102.40000000000001
r1213 n757 n758 2.1333333333333333
r1214 n603 n759 68.266666666666666
r1215 n758 n759 1.0666666666666667
r1216 n604 n760 102.40000000000001
r1217 n759 n760 1.0666666666666667
r1218 n605 n761 34.133333333333333
r1219 n760 n761 1.7066666666666668
r1220 n606 n762 17.066666666666666
r1221 n761 n762 3.8399999999999999
r1222 n607 n763 14.628571428571428
r1223 n762 n763 5.5466666666666669
r1224 n608 n764 102.40000000000001
r1225 n763 n764 3.4133333333333336
r1226 n609 n765 5.6888888888888891
r1227 n764 n765 8.1066666666666674
r1228 n610 n766 102.40000000000001
r1229 n765 n766 8.1066666666666674
r1230 n611 n767 6.4000000000000004
r1231 n766 n767 7.253333333333333
r1232 n612 n768 102.40000000000001
r1233 n767 n768 7.253333333333333
r1234 n613 n769 5.6888888888888891
r1235 n768 n769 8.1066666666666674
r1236 n614 n770 102.40000000000001
r1237 n769 n770 8.1066666666666674
r1238 n615 n771 6.4000000000000004
r1239 n770 n771 7.253333333333333
r1240 n616 n772 102.40000000000001
r1241 n771 n772 7.253333333333333
r1242 n617 n773 5.6888888888888891
r1243 n772 n773 8.1066666666666674
r1244 n618 n774 102.40000000000001
r1245 n773 n774 8.1066666666666674
r1246 n619 n775 6.4000000000000004
r1247 n774 n775 7.253333333333333
r1248 n620 n776 102.40000000000001
r1249 n775 n776 7.253333333333333
r1250 n621 n777 5.6888888888888891
r1251 n776 n777 8.1066666666666674
r1252 n622 n778 102.40000000000001
r1253 n777 n778 8.1066666666666674
r1254 n623 n779 6.4000000000000004
r1255 n778 n779 7.253333333333333
r1256 n624 n780 102.40000000000001
r1257 n779 n780 7.253333333333333
r1258 n625 n781 5.6888888888888891
r1259 n780 n781 8.1066666666666674
r1260 n626 n782 102.40000000000001
r1261 n781 n782 8.1066666666666674
r1262 n627 n783 6.4000000000000004
r1263 n782 n783 7.253333333333333
r1264 n628 n784 102.40000000000001
r1265 n783 n784 7.253333333333333
r1266 n629 n785 5.6888888888888891
r1267 n784 n785 8.1066666666666674
r1268 n630 n786 102.40000000000001
r1269 n785 n786 8.1066666666666674
r1270 n631 n787 6.4000000000000004
r1271 n786 n787 7.253333333333333
r1272 n632 n788 102.40000000000001
r1273 n787 n788 7.253333333333333
r1274 n633 n789 5.6888888888888891
r1275 n788 n789 8.1066666666666674
r1276 n634 n790 102.40000000000001
r1277 n789 n790 8.1066666666666674
r1278 n635 n791 6.4000000000000004
r1279 n790 n791 7.253333333333333
r1280 n636 n792 102.40000000000001
r1281 n791 n792 7.253333333333333
r1282 n637 n793 17.066666666666666
r1283 n792 n793 2.9866666666666668
r1284 n638 n794 51.200000000000003
r1285 n793 n794 3.4133333333333336
r1286 n639 n795 10.24
r1287 n794 n795 5.1200000000000001
r1288 n640 n796 6.0235294117647058
r1289 n795 n796 11.52
r1290 n641 n797 102.40000000000001
r1291 n796 n797 7.6799999999999997
r1292 n642 n798 20.48
r1293 n797 n798 2.5600000000000001
r1294 n643 n799 29.257142857142856
r1295 n798 n799 3.6266666666666665
r1296 n644 n800 68.266666666666666
r1297 n799 n800 2.1333333333333333
r1298 n645 n801 68.266666666666666
r1299 n800 n801 1.28
r1300 n646 n802 102.40000000000001
r1301 n801 n802 1.0666666666666667
r1302 n647 n803 18.618181818181817
r1303 n802 n803 2.7733333333333334
r1304 n648 n804 10.778947368421052
r1305 n803 n804 6.4000000000000004
r1306 n649 n805 102.40000000000001
r1307 n804 n805 4.4800000000000004
r1308 n650 n806 68.266666666666666
r1309 n805 n806 1.0666666666666667
r1310 n651 n807 68.266666666666666
r1311 n806 n807 1.28
r1312 n652 n808 29.257142857142856
r1313 n807 n808 2.1333333333333333
r1314 n653 n809 20.48
r1315 n808 n809 3.6266666666666665
r1316 n654 n810 4.1795918367346943
r1317 n809 n810 12.586666666666666
r1318 n655 n811 6.0235294117647058
r1319 n810 n811 17.706666666666667
r1320 n656 n812 6.0235294117647058
r1321 n657 n813 6.6064516129032258
r1322 n812 n813 208
r1323 n658 n814 6.6064516129032258
r1324 n813 n814 198.40000000000001
r1325 n659 n815 6.0235294117647058
r1326 n814 n815 208
r1327 n660 n816 8.5333333333333332
r1328 n815 n816 185.59999999999999
r1329 n661 n817 51.200000000000003
r1330 n816 n817 89.599999999999994
r1331 n662 n818 20.48
r1332 n817 n818 44.799999999999997
r1333 n663 n819 102.40000000000001
r1334 n818 n819 38.399999999999999
r1335 n664 n820 6.4000000000000004
r1336 n819 n820 108.8
r1337 n665 n821 102.40000000000001
r1338 n820 n821 108.8
r1339 n666 n822 5.6888888888888891
r1340 n821 n822 121.59999999999999
r1341 n667 n823 102.40000000000001
r1342 n822 n823 121.59999999999999
r1343 n668 n824 15.753846153846155
r1344 n823 n824 48
r1345 n669 n825 17.066666666666666
r1346 n824 n825 80
r1347 n670 n826 29.257142857142856
r1348 n825 n826 60.799999999999997
r1349 n671 n827 102.40000000000001
r1350 n826 n827 28.800000000000001
r1351 n672 n828 51.200000000000003
r1352 n827 n828 19.199999999999999
r1353 n673 n829 22.755555555555556
r1354 n828 n829 41.600000000000001
r1355 n674 n830 9.7523809523809533
r1356 n829 n830 96
r1357 n675 n831 102.40000000000001
r1358 n830 n831 73.599999999999994
r1359 n676 n832 102.40000000000001
r1360 n831 n832 12.800000000000001
r1361 n677 n833 22.755555555555556
r1362 n832 n833 35.200000000000003
r1363 n678 n834 17.066666666666666
r1364 n833 n834 67.200000000000003
r1365 n679 n835 22.755555555555556
r1366 n834 n835 67.200000000000003
r1367 n680 n836 102.40000000000001
r1368 n835 n836 35.200000000000003
r1369 n681 n837 102.40000000000001
r1370 n836 n837 12.800000000000001
r1371 n682 n838 9.7523809523809533
r1372 n837 n838 73.599999999999994
r1373 n683 n839 13.653333333333334
r1374 n838 n839 115.2
r1375 n684 n840 102.40000000000001
r1376 n839 n840 54.399999999999999
r1377 n685 n841 6.4000000000000004
r1378 n840 n841 108.8
r1379 n686 n842 102.40000000000001
r1380 n841 n842 108.8
r1381 n687 n843 17.066666666666666
r1382 n842 n843 44.799999999999997
r1383 n688 n844 51.200000000000003
r1384 n843 n844 51.200000000000003
r1385 n689 n845 10.24
r1386 n844 n845 76.799999999999997
r1387 n690 n846 6.0235294117647058
r1388 n845 n846 172.80000000000001
r1389 n691 n847 40.960000000000001
r1390 n846 n847 124.8
r1391 n692 n848 20.48
r1392 n847 n848 48
r1393 n693 n849 29.257142857142856
r1394 n848 n849 54.399999999999999
r1395 n694 n850 68.266666666666666
r1396 n849 n850 32
r1397 n695 n851 68.266666666666666
r1398 n850 n851 19.199999999999999
r1399 n696 n852 102.40000000000001
r1400 n851 n852 16
r1401 n697 n853 25.600000000000001
r1402 n852 n853 32
r1403 n698 n854 9.3090909090909086
r1404 n853 n854 96
r1405 n699 n855 102.40000000000001
r1406 n854 n855 76.799999999999997
r1407 n700 n856 68.266666666666666
r1408 n855 n856 16
r1409 n701 n857 68.266666666666666
r1410 n856 n857 19.199999999999999
r1411 n702 n858 51.200000000000003
r1412 n857 n858 22.399999999999999
r1413 n703 n859 68.266666666666666
r1414 n858 n859 22.399999999999999
r1415 n704 n860 20.48
r1416 n859 n860 41.600000000000001
r1417 n705 n861 4.1795918367346943
r1418 n860 n861 188.80000000000001
r1419 n706 n862 6.0235294117647058
r1420 n861 n862 265.60000000000002
r1421 n707 n863 6.0235294117647058
r1422 n708 n864 6.8266666666666671
r1423 n863 n864 204.80000000000001
r1424 n709 n865 6.8266666666666671
r1425 n864 n865 192
r1426 n710 n866 6.0235294117647058
r1427 n865 n866 204.80000000000001
r1428 n711 n867 8.5333333333333332
r1429 n866 n867 185.59999999999999
r1430 n712 n868 51.200000000000003
r1431 n867 n868 89.599999999999994
r1432 n713 n869 20.48
r1433 n868 n869 44.799999999999997
r1434 n714 n870 102.40000000000001
r1435 n869 n870 38.399999999999999
r1436 n715 n871 6.4000000000000004
r1437 n870 n871 108.8
r1438 n716 n872 102.40000000000001
r1439 n871 n872 108.8
r1440 n717 n873 5.6888888888888891
r1441 n872 n873 121.59999999999999
r1442 n718 n874 102.40000000000001
r1443 n873 n874 121.59999999999999
r1444 n719 n875 6.4000000000000004
r1445 n874 n875 108.8
r1446 n720 n876 102.40000000000001
r1447 n875 n876 108.8
r1448 n721 n877 5.6888888888888891
r1449 n876 n877 121.59999999999999
r1450 n722 n878 102.40000000000001
r1451 n877 n878 121.59999999999999
r1452 n723 n879 6.4000000000000004
r1453 n878 n879 108.8
r1454 n724 n880 102.40000000000001
r1455 n879 n880 108.8
r1456 n725 n881 5.6888888888888891
r1457 n880 n881 121.59999999999999
r1458 n726 n882 102.40000000000001
r1459 n881 n882 121.59999999999999
r1460 n727 n883 6.4000000000000004
r1461 n882 n883 108.8
r1462 n728 n884 102.40000000000001
r1463 n883 n884 108.8
r1464 n729 n885 5.6888888888888891
r1465 n884 n885 121.59999999999999
r1466 n730 n886 102.40000000000001
r1467 n885 n886 121.59999999999999
r1468 n731 n887 6.4000000000000004
r1469 n886 n887 108.8
r1470 n732 n888 102.40000000000001
r1471 n887 n888 108.8
r1472 n733 n889 5.6888888888888891
r1473 n888 n889 121.59999999999999
r1474 n734 n890 102.40000000000001
r1475 n889 n890 121.59999999999999
r1476 n735 n891 6.4000000000000004
r1477 n890 n891 108.8
r1478 n736 n892 102.40000000000001
r1479 n891 n892 108.8
r1480 n737 n893 5.6888888888888891
r1481 n892 n893 121.59999999999999
r1482 n738 n894 102.40000000000001
r1483 n893 n894 121.59999999999999
r1484 n739 n895 6.4000000000000004
r1485 n894 n895 108.8
r1486 n740 n896 102.40000000000001
r1487 n895 n896 108.8
r1488 n741 n897 5.6888888888888891
r1489 n896 n897 121.59999999999999
r1490 n742 n898 102.40000000000001
r1491 n897 n898 121.59999999999999
r1492 n743 n899 6.4000000000000004
r1493 n898 n899 108.8
r1494 n744 n900 102.40000000000001
r1495 n899 n900 108.8
r1496 n745 n901 13.653333333333334
r1497 n900 n901 54.399999999999999
r1498 n746 n902 17.066666666666666
r1499 n901 n902 86.400000000000006
r1500 n747 n903 22.755555555555556
r1501 n902 n903 67.200000000000003
r1502 n748 n904 102.40000000000001
r1503 n903 n904 35.200000000000003
r1504 n749 n905 102.40000000000001
r1505 n904 n905 12.800000000000001
r1506 n750 n906 25.600000000000001
r1507 n905 n906 32
r1508 n751 n907 9.3090909090909086
r1509 n906 n907 96
r1510 n752 n908 204.80000000000001
r1511 n907 n908 73.599999999999994
r1512 n753 n909 204.80000000000001
r1513 n908 n909 6.4000000000000004
r1514 n754 n910 204.80000000000001
r1515 n909 n910 6.4000000000000004
r1516 n755 n911 20.48
r1517 n910 n911 35.200000000000003
r1518 n756 n912 17.066666666666666
r1519 n911 n912 70.400000000000006
r1520 n757 n913 25.600000000000001
r1521 n912 n913 64
r1522 n758 n914 102.40000000000001
r1523 n913 n914 32
r1524 n759 n915 68.266666666666666
r1525 n914 n915 16
r1526 n760 n916 102.40000000000001
r1527 n915 n916 16
r1528 n761 n917 34.133333333333333
r1529 n916 n917 25.600000000000001
r1530 n762 n918 17.066666666666666
r1531 n917 n918 57.600000000000001
r1532 n763 n919 14.628571428571428
r1533 n918 n919 83.200000000000003
r1534 n764 n920 102.40000000000001
r1535 n919 n920 51.200000000000003
r1536 n765 n921 5.6888888888888891
r1537 n920 n921 121.59999999999999
r1538 n766 n922 102.40000000000001
r1539 n921 n922 121.59999999999999
r1540 n767 n923 6.4000000000000004
r1541 n922 n923 108.8
r1542 n768 n924 102.40000000000001
r1543 n923 n924 108.8
r1544 n769 n925 5.6888888888888891
r1545 n924 n925 121.59999999999999
r1546 n770 n926 102.40000000000001
r1547 n925 n926 121.59999999999999
r1548 n771 n927 6.4000000000000004
r1549 n926 n927 108.8
r1550 n772 n928 102.40000000000001
r1551 n927 n928 108.8
r1552 n773 n929 5.6888888888888891
r1553 n928 n929 121.59999999999999
r1554 n774 n930 102.40000000000001
r1555 n929 n930 121.59999999999999
r1556 n775 n931 6.4000000000000004
r1557 n930 n931 108.8
r1558 n776 n932 102.40000000000001
r1559 n931 n932 108.8
r1560 n777 n933 5.6888888888888891
r1561 n932 n933 121.59999999999999
r1562 n778 n934 102.40000000000001
r1563 n933 n934 121.59999999999999
r1564 n779 n935 6.4000000000000004
r1565 n934 n935 108.8
r1566 n780 n936 102.40000000000001
r1567 n935 n936 108.8
r1568 n781 n937 5.6888888888888891
r1569 n936 n937 121.59999999999999
r1570 n782 n938 102.40000000000001
r1571 n937 n938 121.59999999999999
r1572 n783 n939 6.4000000000000004
r1573 n938 n939 108.8
r1574 n784 n940 102.40000000000001
r1575 n939 n940 108.8
r1576 n785 n941 5.6888888888888891
r1577 n940 n941 121.59999999999999
r1578 n786 n942 102.40000000000001
r1579 n941 n942 121.59999999999999
r1580 n787 n943 6.4000000000000004
r1581 n942 n943 108.8
r1582 n788 n944 102.40000000000001
r1583 n943 n944 108.8
r1584 n789 n945 5.6888888888888891
r1585 n944 n945 121.59999999999999
r1586 n790 n946 102.40000000000001
r1587 n945 n946 121.59999999999999
r1588 n791 n947 6.4000000000000004
r1589 n946 n947 108.8
r1590 n792 n948 102.40000000000001
r1591 n947 n948 108.8
r1592 n793 n949 17.066666666666666
r1593 n948 n949 44.799999999999997
r1594 n794 n950 51.200000000000003
r1595 n949 n950 51.200000000000003
r1596 n795 n951 10.24
r1597 n950 n951 76.799999999999997
r1598 n796 n952 6.0235294117647058
r1599 n951 n952 172.80000000000001
r1600 n797 n953 102.40000000000001
r1601 n952 n953 115.2
r1602 n798 n954 20.48
r1603 n953 n954 38.399999999999999
r1604 n799 n955 29.257142857142856
r1605 n954 n955 54.399999999999999
r1606 n800 n956 68.266666666666666
r1607 n955 n956 32
r1608 n801 n957 68.266666666666666
r1609 n956 n957 19.199999999999999
r1610 n802 n958 102.40000000000001
r1611 n957 n958 16
r1612 n803 n959 18.618181818181817
r1613 n958 n959 41.600000000000001
r1614 n804 n960 10.778947368421052
r1615 n959 n960 96
r1616 n805 n961 102.40000000000001
r1617 n960 n961 67.200000000000003
r1618 n806 n962 68.266666666666666
r1619 n961 n962 16
r1620 n807 n963 68.266666666666666
r1621 n962 n963 19.199999999999999
r1622 n808 n964 29.257142857142856
r1623 n963 n964 32
r1624 n809 n965 20.48
r1625 n964 n965 54.399999999999999
r1626 n810 n966 4.1795918367346943
r1627 n965 n966 188.80000000000001
r1628 n811 n967 6.0235294117647058
r1629 n966 n967 265.60000000000002
r1630 n812 n968 2.447058823529412
r1631 n862 n969 2.447058823529412
r1632 n863 n970 2.447058823529412
r1633 n967 n971 2.447058823529412
r1634 n968 n972 2.447058823529412
r1635 n969 n973 2.447058823529412
r1636 n970 n974 2.447058823529412
r1637 n971 n975 2.447058823529412
r1638 n972 n976 6.2117647058823531
r1639 n973 n977 6.2117647058823531
r1640 n974 n978 6.2117647058823531
r1641 n975 n979 6.2117647058823531
r1642 n976 n980 11.670588235294117
r1643 n977 n981 11.670588235294117
r1644 n978 n982 11.670588235294117
r1645 n979 n983 11.670588235294117
r1646 n980 n984 8.4705882352941178
r1647 n981 n985 8.4705882352941178
r1648 n982 n986 8.4705882352941178
r1649 n983 n987 8.4705882352941178
r1650 n984 n988 3.0117647058823529
r1651 n985 n989 3.0117647058823529
r1652 n986 n990 3.0117647058823529
r1653 n987 n991 3.0117647058823529
r1654 n988 n992 1.3176470588235294
r1655 n989 n993 1.3176470588235294
r1656 n990 n994 1.3176470588235294
r1657 n991 n995 1.3176470588235294
r1658 n992 n996 2.0705882352941178
r1659 n993 n997 2.0705882352941178
r1660 n994 n998 2.0705882352941178
r1661 n995 n999 2.0705882352941178
r1662 n996 n1000 1.5058823529411764
r1663 n1001 n1002 44.799999999999997
r1664 n1002 n1003 38.399999999999999
r1665 n1003 n1004 108.8
r1666 n1004 n1005 108.8
r1667 n1005 n1006 121.59999999999999
r1668 n1006 n1007 121.59999999999999
r1669 n1007 n1008 48
r1670 n1008 n1009 80
r1671 n1009 n1010 60.799999999999997
r1672 n1010 n1011 28.800000000000001
r1673 n1011 n1012 19.199999999999999
r1674 n1012 n1013 41.600000000000001
r1675 n1013 n1014 96
r1676 n1014 n1015 73.599999999999994
r1677 n1015 n1016 12.800000000000001
r1678 n1016 n1017 35.200000000000003
r1679 n1017 n1018 67.200000000000003
r1680 n1018 n1019 67.200000000000003
r1681 n1019 n1020 35.200000000000003
r1682 n1020 n1021 12.800000000000001
r1683 n1021 n1022 73.599999999999994
r1684 n1022 n1023 115.2
r1685 n1023 n1024 54.399999999999999
r1686 n1024 n1025 108.8
r1687 n1025 n1026 108.8
r1688 n1026 n1027 44.799999999999997
r1689 n1027 n1028 51.200000000000003
r1690 n997 n1029 1.5058823529411764
r1691 n998 n1030 1.5058823529411764
r1692 n1031 n1032 44.799999999999997
r1693 n1032 n1033 38.399999999999999
r1694 n1033 n1034 108.8
r1695 n1034 n1035 108.8
r1696 n1035 n1036 121.59999999999999
r1697 n1036 n1037 121.59999999999999
r1698 n1037 n1038 108.8
r1699 n1038 n1039 108.8
r1700 n1039 n1040 121.59999999999999
r1701 n1040 n1041 121.59999999999999
r1702 n1041 n1042 108.8
r1703 n1042 n1043 108.8
r1704 n1043 n1044 121.59999999999999
r1705 n1044 n1045 121.59999999999999
r1706 n1045 n1046 108.8
r1707 n1046 n1047 108.8
r1708 n1047 n1048 121.59999999999999
r1709 n1048 n1049 121.59999999999999
r1710 n1049 n1050 108.8
r1711 n1050 n1051 108.8
r1712 n1051 n1052 121.59999999999999
r1713 n1052 n1053 121.59999999999999
r1714 n1053 n1054 108.8
r1715 n1054 n1055 108.8
r1716 n1055 n1056 121.59999999999999
r1717 n1056 n1057 121.59999999999999
r1718 n1057 n1058 108.8
r1719 n1058 n1059 108.8
r1720 n1059 n1060 121.59999999999999
r1721 n1060 n1061 121.59999999999999
r1722 n1061 n1062 108.8
r1723 n1062 n1063 108.8
r1724 n1063 n1064 54.399999999999999
r1725 n1064 n1065 86.400000000000006
r1726 n1065 n1066 67.200000000000003
r1727 n1066 n1067 35.200000000000003
r1728 n1067 n1068 12.800000000000001
r1729 n1068 n1069 32
r1730 n1069 n1070 96
r1731 n1070 n1071 73.599999999999994
r1732 n1071 n1072 6.4000000000000004
r1733 n1072 n1073 6.4000000000000004
r1734 n1073 n1074 35.200000000000003
r1735 n1074 n1075 70.400000000000006
r1736 n1075 n1076 64
r1737 n1076 n1077 32
r1738 n1077 n1078 16
r1739 n1078 n1079 16
r1740 n1079 n1080 25.600000000000001
r1741 n1080 n1081 57.600000000000001
r1742 n1081 n1082 83.200000000000003
r1743 n1082 n1083 51.200000000000003
r1744 n1083 n1084 121.59999999999999
r1745 n1084 n1085 121.59999999999999
r1746 n1085 n1086 108.8
r1747 n1086 n1087 108.8
r1748 n1087 n1088 121.59999999999999
r1749 n1088 n1089 121.59999999999999
r1750 n1089 n1090 108.8
r1751 n1090 n1091 108.8
r1752 n1091 n1092 121.59999999999999
r1753 n1092 n1093 121.59999999999999
r1754 n1093 n1094 108.8
r1755 n1094 n1095 108.8
r1756 n1095 n1096 121.59999999999999
r1757 n1096 n1097 121.59999999999999
r1758 n1097 n1098 108.8
r1759 n1098 n1099 108.8
r1760 n1099 n1100 121.59999999999999
r1761 n1100 n1101 121.59999999999999
r1762 n1101 n1102 108.8
r1763 n1102 n1103 108.8
r1764 n1103 n1104 121.59999999999999
r1765 n1104 n1105 121.59999999999999
r1766 n1105 n1106 108.8
r1767 n1106 n1107 108.8
r1768 n1107 n1108 121.59999999999999
r1769 n1108 n1109 121.59999999999999
r1770 n1109 n1110 108.8
r1771 n1110 n1111 108.8
r1772 n1111 n1112 44.799999999999997
r1773 n1112 n1113 51.200000000000003
r1774 n999 n1114 1.5058823529411764
r1775 n1000 n1115 1.3176470588235294
r1776 n1001 n1116 11.199999999999999
r1777 n1002 n1117 4.4800000000000004
r1778 n1116 n1117 17.920000000000002
r1779 n1003 n1118 22.399999999999999
r1780 n1117 n1118 15.359999999999999
r1781 n1004 n1119 1.3999999999999999
r1782 n1118 n1119 43.520000000000003
r1783 n1005 n1120 22.399999999999999
r1784 n1119 n1120 43.520000000000003
r1785 n1006 n1121 1.2444444444444445
r1786 n1120 n1121 48.640000000000001
r1787 n1007 n1122 22.399999999999999
r1788 n1121 n1122 48.640000000000001
r1789 n1008 n1123 3.4461538461538463
r1790 n1122 n1123 19.199999999999999
r1791 n1009 n1124 3.7333333333333334
r1792 n1123 n1124 32
r1793 n1010 n1125 6.4000000000000004
r1794 n1124 n1125 24.32
r1795 n1011 n1126 22.399999999999999
r1796 n1125 n1126 11.52
r1797 n1012 n1127 11.199999999999999
r1798 n1126 n1127 7.6799999999999997
r1799 n1013 n1128 4.9777777777777779
r1800 n1127 n1128 16.640000000000001
r1801 n1014 n1129 2.1333333333333333
r1802 n1128 n1129 38.399999999999999
r1803 n1015 n1130 22.399999999999999
r1804 n1129 n1130 29.440000000000001
r1805 n1016 n1131 22.399999999999999
r1806 n1130 n1131 5.1200000000000001
r1807 n1017 n1132 4.9777777777777779
r1808 n1131 n1132 14.08
r1809 n1018 n1133 3.7333333333333334
r1810 n1132 n1133 26.879999999999999
r1811 n1019 n1134 4.9777777777777779
r1812 n1133 n1134 26.879999999999999
r1813 n1020 n1135 22.399999999999999
r1814 n1134 n1135 14.08
r1815 n1021 n1136 22.399999999999999
r1816 n1135 n1136 5.1200000000000001
r1817 n1022 n1137 2.1333333333333333
r1818 n1136 n1137 29.440000000000001
r1819 n1023 n1138 2.9866666666666668
r1820 n1137 n1138 46.079999999999998
r1821 n1024 n1139 22.399999999999999
r1822 n1138 n1139 21.760000000000002
r1823 n1025 n1140 1.3999999999999999
r1824 n1139 n1140 43.520000000000003
r1825 n1026 n1141 22.399999999999999
r1826 n1140 n1141 43.520000000000003
r1827 n1027 n1142 3.7333333333333334
r1828 n1141 n1142 17.920000000000002
r1829 n1028 n1143 11.199999999999999
r1830 n1142 n1143 20.48
r1831 n1029 n1144 1.3176470588235294
r1832 n1030 n1145 1.3176470588235294
r1833 n1031 n1146 11.199999999999999
r1834 n1032 n1147 4.4800000000000004
r1835 n1146 n1147 17.920000000000002
r1836 n1033 n1148 22.399999999999999
r1837 n1147 n1148 15.359999999999999
r1838 n1034 n1149 1.3999999999999999
r1839 n1148 n1149 43.520000000000003
r1840 n1035 n1150 22.399999999999999
r1841 n1149 n1150 43.520000000000003
r1842 n1036 n1151 1.2444444444444445
r1843 n1150 n1151 48.640000000000001
r1844 n1037 n1152 22.399999999999999
r1845 n1151 n1152 48.640000000000001
r1846 n1038 n1153 1.3999999999999999
r1847 n1152 n1153 43.520000000000003
r1848 n1039 n1154 22.399999999999999
r1849 n1153 n1154 43.520000000000003
r1850 n1040 n1155 1.2444444444444445
r1851 n1154 n1155 48.640000000000001
r1852 n1041 n1156 22.399999999999999
r1853 n1155 n1156 48.640000000000001
r1854 n1042 n1157 1.3999999999999999
r1855 n1156 n1157 43.520000000000003
r1856 n1043 n1158 22.399999999999999
r1857 n1157 n1158 43.520000000000003
r1858 n1044 n1159 1.2444444444444445
r1859 n1158 n1159 48.640000000000001
r1860 n1045 n1160 22.399999999999999
r1861 n1159 n1160 48.640000000000001
r1862 n1046 n1161 1.3999999999999999
r1863 n1160 n1161 43.520000000000003
r1864 n1047 n1162 22.399999999999999
r1865 n1161 n1162 43.520000000000003
r1866 n1048 n1163 1.2444444444444445
r1867 n1162 n1163 48.640000000000001
r1868 n1049 n1164 22.399999999999999
r1869 n1163 n1164 48.640000000000001
r1870 n1050 n1165 1.3999999999999999
r1871 n1164 n1165 43.520000000000003
r1872 n1051 n1166 22.399999999999999
r1873 n1165 n1166 43.520000000000003
r1874 n1052 n1167 1.2444444444444445
r1875 n1166 n1167 48.640000000000001
r1876 n1053 n1168 22.399999999999999
r1877 n1167 n1168 48.640000000000001
r1878 n1054 n1169 1.3999999999999999
r1879 n1168 n1169 43.520000000000003
r1880 n1055 n1170 22.399999999999999
r1881 n1169 n1170 43.520000000000003
r1882 n1056 n1171 1.2444444444444445
r1883 n1170 n1171 48.640000000000001
r1884 n1057 n1172 22.399999999999999
r1885 n1171 n1172 48.640000000000001
r1886 n1058 n1173 1.3999999999999999
r1887 n1172 n1173 43.520000000000003
r1888 n1059 n1174 22.399999999999999
r1889 n1173 n1174 43.520000000000003
r1890 n1060 n1175 1.2444444444444445
r1891 n1174 n1175 48.640000000000001
r1892 n1061 n1176 22.399999999999999
r1893 n1175 n1176 48.640000000000001
r1894 n1062 n1177 1.3999999999999999
r1895 n1176 n1177 43.520000000000003
r1896 n1063 n1178 22.399999999999999
r1897 n1177 n1178 43.520000000000003
r1898 n1064 n1179 2.9866666666666668
r1899 n1178 n1179 21.760000000000002
r1900 n1065 n1180 3.7333333333333334
r1901 n1179 n1180 34.560000000000002
r1902 n1066 n1181 4.9777777777777779
r1903 n1180 n1181 26.879999999999999
r1904 n1067 n1182 22.399999999999999
r1905 n1181 n1182 14.08
r1906 n1068 n1183 22.399999999999999
r1907 n1182 n1183 5.1200000000000001
r1908 n1069 n1184 5.5999999999999996
r1909 n1183 n1184 12.800000000000001
r1910 n1070 n1185 2.0363636363636362
r1911 n1184 n1185 38.399999999999999
r1912 n1071 n1186 44.799999999999997
r1913 n1185 n1186 29.440000000000001
r1914 n1072 n1187 44.799999999999997
r1915 n1186 n1187 2.5600000000000001
r1916 n1073 n1188 44.799999999999997
r1917 n1187 n1188 2.5600000000000001
r1918 n1074 n1189 4.4800000000000004
r1919 n1188 n1189 14.08
r1920 n1075 n1190 3.7333333333333334
r1921 n1189 n1190 28.16
r1922 n1076 n1191 5.5999999999999996
r1923 n1190 n1191 25.600000000000001
r1924 n1077 n1192 22.399999999999999
r1925 n1191 n1192 12.800000000000001
r1926 n1078 n1193 14.933333333333334
r1927 n1192 n1193 6.4000000000000004
r1928 n1079 n1194 22.399999999999999
r1929 n1193 n1194 6.4000000000000004
r1930 n1080 n1195 7.4666666666666668
r1931 n1194 n1195 10.24
r1932 n1081 n1196 3.7333333333333334
r1933 n1195 n1196 23.039999999999999
r1934 n1082 n1197 3.2000000000000002
r1935 n1196 n1197 33.280000000000001
r1936 n1083 n1198 22.399999999999999
r1937 n1197 n1198 20.48
r1938 n1084 n1199 1.2444444444444445
r1939 n1198 n1199 48.640000000000001
r1940 n1085 n1200 22.399999999999999
r1941 n1199 n1200 48.640000000000001
r1942 n1086 n1201 1.3999999999999999
r1943 n1200 n1201 43.520000000000003
r1944 n1087 n1202 22.399999999999999
r1945 n1201 n1202 43.520000000000003
r1946 n1088 n1203 1.2444444444444445
r1947 n1202 n1203 48.640000000000001
r1948 n1089 n1204 22.399999999999999
r1949 n1203 n1204 48.640000000000001
r1950 n1090 n1205 1.3999999999999999
r1951 n1204 n1205 43.520000000000003
r1952 n1091 n1206 22.399999999999999
r1953 n1205 n1206 43.520000000000003
r1954 n1092 n1207 1.2444444444444445
r1955 n1206 n1207 48.640000000000001
r1956 n1093 n1208 22.399999999999999
r1957 n1207 n1208 48.640000000000001
r1958 n1094 n1209 1.3999999999999999
r1959 n1208 n1209 43.520000000000003
r1960 n1095 n1210 22.399999999999999
r1961 n1209 n1210 43.520000000000003
r1962 n1096 n1211 1.2444444444444445
r1963 n1210 n1211 48.640000000000001
r1964 n1097 n1212 22.399999999999999
r1965 n1211 n1212 48.640000000000001
r1966 n1098 n1213 1.3999999999999999
r1967 n1212 n1213 43.520000000000003
r1968 n1099 n1214 22.399999999999999
r1969 n1213 n1214 43.520000000000003
r1970 n1100 n1215 1.2444444444444445
r1971 n1214 n1215 48.640000000000001
r1972 n1101 n1216 22.399999999999999
r1973 n1215 n1216 48.640000000000001
r1974 n1102 n1217 1.3999999999999999
r1975 n1216 n1217 43.520000000000003
r1976 n1103 n1218 22.399999999999999
r1977 n1217 n1218 43.520000000000003
r1978 n1104 n1219 1.2444444444444445
r1979 n1218 n1219 48.640000000000001
r1980 n1105 n1220 22.399999999999999
r1981 n1219 n1220 48.640000000000001
r1982 n1106 n1221 1.3999999999999999
r1983 n1220 n1221 43.520000000000003
r1984 n1107 n1222 22.399999999999999
r1985 n1221 n1222 43.520000000000003
r1986 n1108 n1223 1.2444444444444445
r1987 n1222 n1223 48.640000000000001
r1988 n1109 n1224 22.399999999999999
r1989 n1223 n1224 48.640000000000001
r1990 n1110 n1225 1.3999999999999999
r1991 n1224 n1225 43.520000000000003
r1992 n1111 n1226 22.399999999999999
r1993 n1225 n1226 43.520000000000003
r1994 n1112 n1227 3.7333333333333334
r1995 n1226 n1227 17.920000000000002
r1996 n1113 n1228 11.199999999999999
r1997 n1227 n1228 20.48
r1998 n1114 n1229 1.3176470588235294
r1999 n1115 n1230 3.7647058823529411
r2000 n1116 n1231 32
r2001 n1117 n1232 12.800000000000001
r2002 n1231 n1232 5.9733333333333336
r2003 n1118 n1233 64
r2004 n1232 n1233 5.1200000000000001
r2005 n1119 n1234 4
r2006 n1233 n1234 14.506666666666666
r2007 n1120 n1235 64
r2008 n1234 n1235 14.506666666666666
r2009 n1121 n1236 3.5555555555555554
r2010 n1235 n1236 16.213333333333335
r2011 n1122 n1237 64
r2012 n1236 n1237 16.213333333333335
r2013 n1123 n1238 9.8461538461538467
r2014 n1237 n1238 6.4000000000000004
r2015 n1124 n1239 10.666666666666666
r2016 n1238 n1239 10.666666666666666
r2017 n1125 n1240 18.285714285714285
r2018 n1239 n1240 8.1066666666666674
r2019 n1126 n1241 64
r2020 n1240 n1241 3.8399999999999999
r2021 n1127 n1242 32
r2022 n1241 n1242 2.5600000000000001
r2023 n1128 n1243 14.222222222222221
r2024 n1242 n1243 5.5466666666666669
r2025 n1129 n1244 6.0952380952380949
r2026 n1243 n1244 12.800000000000001
r2027 n1130 n1245 64
r2028 n1244 n1245 9.8133333333333326
r2029 n1131 n1246 64
r2030 n1245 n1246 1.7066666666666668
r2031 n1132 n1247 14.222222222222221
r2032 n1246 n1247 4.6933333333333334
r2033 n1133 n1248 10.666666666666666
r2034 n1247 n1248 8.9600000000000009
r2035 n1134 n1249 14.222222222222221
r2036 n1248 n1249 8.9600000000000009
r2037 n1135 n1250 64
r2038 n1249 n1250 4.6933333333333334
r2039 n1136 n1251 64
r2040 n1250 n1251 1.7066666666666668
r2041 n1137 n1252 6.0952380952380949
r2042 n1251 n1252 9.8133333333333326
r2043 n1138 n1253 8.5333333333333332
r2044 n1252 n1253 15.359999999999999
r2045 n1139 n1254 64
r2046 n1253 n1254 7.253333333333333
r2047 n1140 n1255 4
r2048 n1254 n1255 14.506666666666666
r2049 n1141 n1256 64
r2050 n1255 n1256 14.506666666666666
r2051 n1142 n1257 10.666666666666666
r2052 n1256 n1257 5.9733333333333336
r2053 n1143 n1258 32
r2054 n1257 n1258 6.8266666666666671
r2055 n1144 n1259 3.7647058823529411
r2056 n1145 n1260 3.7647058823529411
r2057 n1146 n1261 32
r2058 n1147 n1262 12.800000000000001
r2059 n1261 n1262 5.9733333333333336
r2060 n1148 n1263 64
r2061 n1262 n1263 5.1200000000000001
r2062 n1149 n1264 4
r2063 n1263 n1264 14.506666666666666
r2064 n1150 n1265 64
r2065 n1264 n1265 14.506666666666666
r2066 n1151 n1266 3.5555555555555554
r2067 n1265 n1266 16.213333333333335
r2068 n1152 n1267 64
r2069 n1266 n1267 16.213333333333335
r2070 n1153 n1268 4
r2071 n1267 n1268 14.506666666666666
r2072 n1154 n1269 64
r2073 n1268 n1269 14.506666666666666
r2074 n1155 n1270 3.5555555555555554
r2075 n1269 n1270 16.213333333333335
r2076 n1156 n1271 64
r2077 n1270 n1271 16.213333333333335
r2078 n1157 n1272 4
r2079 n1271 n1272 14.506666666666666
r2080 n1158 n1273 64
r2081 n1272 n1273 14.506666666666666
r2082 n1159 n1274 3.5555555555555554
r2083 n1273 n1274 16.213333333333335
r2084 n1160 n1275 64
r2085 n1274 n1275 16.213333333333335
r2086 n1161 n1276 4
r2087 n1275 n1276 14.506666666666666
r2088 n1162 n1277 64
r2089 n1276 n1277 14.506666666666666
r2090 n1163 n1278 3.5555555555555554
r2091 n1277 n1278 16.213333333333335
r2092 n1164 n1279 64
r2093 n1278 n1279 16.213333333333335
r2094 n1165 n1280 4
r2095 n1279 n1280 14.506666666666666
r2096 n1166 n1281 64
r2097 n1280 n1281 14.506666666666666
r2098 n1167 n1282 3.5555555555555554
r2099 n1281 n1282 16.213333333333335
r2100 n1168 n1283 64
r2101 n1282 n1283 16.213333333333335
r2102 n1169 n1284 4
r2103 n1283 n1284 14.506666666666666
r2104 n1170 n1285 64
r2105 n1284 n1285 14.506666666666666
r2106 n1171 n1286 3.5555555555555554
r2107 n1285 n1286 16.213333333333335
r2108 n1172 n1287 64
r2109 n1286 n1287 16.213333333333335
r2110 n1173 n1288 4
r2111 n1287 n1288 14.506666666666666
r2112 n1174 n1289 64
r2113 n1288 n1289 14.506666666666666
r2114 n1175 n1290 3.5555555555555554
r2115 n1289 n1290 16.213333333333335
r2116 n1176 n1291 64
r2117 n1290 n1291 16.213333333333335
r2118 n1177 n1292 4
r2119 n1291 n1292 14.506666666666666
r2120 n1178 n1293 64
r2121 n1292 n1293 14.506666666666666
r2122 n1179 n1294 8.5333333333333332
r2123 n1293 n1294 7.253333333333333
r2124 n1180 n1295 10.666666666666666
r2125 n1294 n1295 11.52
r2126 n1181 n1296 14.222222222222221
r2127 n1295 n1296 8.9600000000000009
r2128 n1182 n1297 64
r2129 n1296 n1297 4.6933333333333334
r2130 n1183 n1298 64
r2131 n1297 n1298 1.7066666666666668
r2132 n1184 n1299 16
r2133 n1298 n1299 4.2666666666666666
r2134 n1185 n1300 5.8181818181818183
r2135 n1299 n1300 12.800000000000001
r2136 n1186 n1301 128
r2137 n1300 n1301 9.8133333333333326
r2138 n1187 n1302 128
r2139 n1301 n1302 0.85333333333333339
r2140 n1188 n1303 128
r2141 n1302 n1303 0.85333333333333339
r2142 n1189 n1304 12.800000000000001
r2143 n1303 n1304 4.6933333333333334
r2144 n1190 n1305 10.666666666666666
r2145 n1304 n1305 9.3866666666666667
r2146 n1191 n1306 16
r2147 n1305 n1306 8.5333333333333332
r2148 n1192 n1307 64
r2149 n1306 n1307 4.2666666666666666
r2150 n1193 n1308 42.666666666666664
r2151 n1307 n1308 2.1333333333333333
r2152 n1194 n1309 64
r2153 n1308 n1309 2.1333333333333333
r2154 n1195 n1310 21.333333333333332
r2155 n1309 n1310 3.4133333333333336
r2156 n1196 n1311 10.666666666666666
r2157 n1310 n1311 7.6799999999999997
r2158 n1197 n1312 9.1428571428571423
r2159 n1311 n1312 11.093333333333334
r2160 n1198 n1313 64
r2161 n1312 n1313 6.8266666666666671
r2162 n1199 n1314 3.5555555555555554
r2163 n1313 n1314 16.213333333333335
r2164 n1200 n1315 64
r2165 n1314 n1315 16.213333333333335
r2166 n1201 n1316 4
r2167 n1315 n1316 14.506666666666666
r2168 n1202 n1317 64
r2169 n1316 n1317 14.506666666666666
r2170 n1203 n1318 3.5555555555555554
r2171 n1317 n1318 16.213333333333335
r2172 n1204 n1319 64
r2173 n1318 n1319 16.213333333333335
r2174 n1205 n1320 4
r2175 n1319 n1320 14.506666666666666
r2176 n1206 n1321 64
r2177 n1320 n1321 14.506666666666666
r2178 n1207 n1322 3.5555555555555554
r2179 n1321 n1322 16.213333333333335
r2180 n1208 n1323 64
r2181 n1322 n1323 16.213333333333335
r2182 n1209 n1324 4
r2183 n1323 n1324 14.506666666666666
r2184 n1210 n1325 64
r2185 n1324 n1325 14.506666666666666
r2186 n1211 n1326 3.5555555555555554
r2187 n1325 n1326 16.213333333333335
r2188 n1212 n1327 64
r2189 n1326 n1327 16.213333333333335
r2190 n1213 n1328 4
r2191 n1327 n1328 14.506666666666666
r2192 n1214 n1329 64
r2193 n1328 n1329 14.506666666666666
r2194 n1215 n1330 3.5555555555555554
r2195 n1329 n1330 16.213333333333335
r2196 n1216 n1331 64
r2197 n1330 n1331 16.213333333333335
r2198 n1217 n1332 4
r2199 n1331 n1332 14.506666666666666
r2200 n1218 n1333 64
r2201 n1332 n1333 14.506666666666666
r2202 n1219 n1334 3.5555555555555554
r2203 n1333 n1334 16.213333333333335
r2204 n1220 n1335 64
r2205 n1334 n1335 16.213333333333335
r2206 n1221 n1336 4
r2207 n1335 n1336 14.506666666666666
r2208 n1222 n1337 64
r2209 n1336 n1337 14.506666666666666
r2210 n1223 n1338 3.5555555555555554
r2211 n1337 n1338 16.213333333333335
r2212 n1224 n1339 64
r2213 n1338 n1339 16.213333333333335
r2214 n1225 n1340 4
r2215 n1339 n1340 14.506666666666666
r2216 n1226 n1341 64
r2217 n1340 n1341 14.506666666666666
r2218 n1227 n1342 10.666666666666666
r2219 n1341 n1342 5.9733333333333336
r2220 n1228 n1343 32
r2221 n1342 n1343 6.8266666666666671
r2222 n1229 n1344 3.7647058823529411
r2223 n1230 n1345 3.388235294117647
r2224 n1231 n1346 28.800000000000001
r2225 n1232 n1347 11.52
r2226 n1346 n1347 29.866666666666667
r2227 n1233 n1348 57.600000000000001
r2228 n1347 n1348 25.600000000000001
r2229 n1234 n1349 3.6000000000000001
r2230 n1348 n1349 72.533333333333331
r2231 n1235 n1350 57.600000000000001
r2232 n1349 n1350 72.533333333333331
r2233 n1236 n1351 3.2000000000000002
r2234 n1350 n1351 81.066666666666663
r2235 n1237 n1352 57.600000000000001
r2236 n1351 n1352 81.066666666666663
r2237 n1238 n1353 8.861538461538462
r2238 n1352 n1353 32
r2239 n1239 n1354 9.5999999999999996
r2240 n1353 n1354 53.333333333333336
r2241 n1240 n1355 16.457142857142856
r2242 n1354 n1355 40.533333333333331
r2243 n1241 n1356 57.600000000000001
r2244 n1355 n1356 19.199999999999999
r2245 n1242 n1357 28.800000000000001
r2246 n1356 n1357 12.800000000000001
r2247 n1243 n1358 12.800000000000001
r2248 n1357 n1358 27.733333333333334
r2249 n1244 n1359 5.4857142857142858
r2250 n1358 n1359 64
r2251 n1245 n1360 57.600000000000001
r2252 n1359 n1360 49.06666666666667
r2253 n1246 n1361 57.600000000000001
r2254 n1360 n1361 8.5333333333333332
r2255 n1247 n1362 12.800000000000001
r2256 n1361 n1362 23.466666666666665
r2257 n1248 n1363 9.5999999999999996
r2258 n1362 n1363 44.799999999999997
r2259 n1249 n1364 12.800000000000001
r2260 n1363 n1364 44.799999999999997
r2261 n1250 n1365 57.600000000000001
r2262 n1364 n1365 23.466666666666665
r2263 n1251 n1366 57.600000000000001
r2264 n1365 n1366 8.5333333333333332
r2265 n1252 n1367 5.4857142857142858
r2266 n1366 n1367 49.06666666666667
r2267 n1253 n1368 7.6799999999999997
r2268 n1367 n1368 76.799999999999997
r2269 n1254 n1369 57.600000000000001
r2270 n1368 n1369 36.266666666666666
r2271 n1255 n1370 3.6000000000000001
r2272 n1369 n1370 72.533333333333331
r2273 n1256 n1371 57.600000000000001
r2274 n1370 n1371 72.533333333333331
r2275 n1257 n1372 9.5999999999999996
r2276 n1371 n1372 29.866666666666667
r2277 n1258 n1373 28.800000000000001
r2278 n1372 n1373 34.133333333333333
r2279 n1259 n1374 3.388235294117647
r2280 n1260 n1375 3.388235294117647
r2281 n1261 n1376 28.800000000000001
r2282 n1262 n1377 11.52
r2283 n1376 n1377 29.866666666666667
r2284 n1263 n1378 57.600000000000001
r2285 n1377 n1378 25.600000000000001
r2286 n1264 n1379 3.6000000000000001
r2287 n1378 n1379 72.533333333333331
r2288 n1265 n1380 57.600000000000001
r2289 n1379 n1380 72.533333333333331
r2290 n1266 n1381 3.2000000000000002
r2291 n1380 n1381 81.066666666666663
r2292 n1267 n1382 57.600000000000001
r2293 n1381 n1382 81.066666666666663
r2294 n1268 n1383 3.6000000000000001
r2295 n1382 n1383 72.533333333333331
r2296 n1269 n1384 57.600000000000001
r2297 n1383 n1384 72.533333333333331
r2298 n1270 n1385 3.2000000000000002
r2299 n1384 n1385 81.066666666666663
r2300 n1271 n1386 57.600000000000001
r2301 n1385 n1386 81.066666666666663
r2302 n1272 n1387 3.6000000000000001
r2303 n1386 n1387 72.533333333333331
r2304 n1273 n1388 57.600000000000001
r2305 n1387 n1388 72.533333333333331
r2306 n1274 n1389 3.2000000000000002
r2307 n1388 n1389 81.066666666666663
r2308 n1275 n1390 57.600000000000001
r2309 n1389 n1390 81.066666666666663
r2310 n1276 n1391 3.6000000000000001
r2311 n1390 n1391 72.533333333333331
r2312 n1277 n1392 57.600000000000001
r2313 n1391 n1392 72.533333333333331
r2314 n1278 n1393 3.2000000000000002
r2315 n1392 n1393 81.066666666666663
r2316 n1279 n1394 57.600000000000001
r2317 n1393 n1394 81.066666666666663
r2318 n1280 n1395 3.6000000000000001
r2319 n1394 n1395 72.533333333333331
r2320 n1281 n1396 57.600000000000001
r2321 n1395 n1396 72.533333333333331
r2322 n1282 n1397 3.2000000000000002
r2323 n1396 n1397 81.066666666666663
r2324 n1283 n1398 57.600000000000001
r2325 n1397 n1398 81.066666666666663
r2326 n1284 n1399 3.6000000000000001
r2327 n1398 n1399 72.533333333333331
r2328 n1285 n1400 57.600000000000001
r2329 n1399 n1400 72.533333333333331
r2330 n1286 n1401 3.2000000000000002
r2331 n1400 n1401 81.066666666666663
r2332 n1287 n1402 57.600000000000001
r2333 n1401 n1402 81.066666666666663
r2334 n1288 n1403 3.6000000000000001
r2335 n1402 n1403 72.533333333333331
r2336 n1289 n1404 57.600000000000001
r2337 n1403 n1404 72.533333333333331
r2338 n1290 n1405 3.2000000000000002
r2339 n1404 n1405 81.066666666666663
r2340 n1291 n1406 57.600000000000001
r2341 n1405 n1406 81.066666666666663
r2342 n1292 n1407 3.6000000000000001
r2343 n1406 n1407 72.533333333333331
r2344 n1293 n1408 57.600000000000001
r2345 n1407 n1408 72.533333333333331
r2346 n1294 n1409 7.6799999999999997
r2347 n1408 n1409 36.266666666666666
r2348 n1295 n1410 9.5999999999999996
r2349 n1409 n1410 57.600000000000001
r2350 n1296 n1411 12.800000000000001
r2351 n1410 n1411 44.799999999999997
r2352 n1297 n1412 57.600000000000001
r2353 n1411 n1412 23.466666666666665
r2354 n1298 n1413 57.600000000000001
r2355 n1412 n1413 8.5333333333333332
r2356 n1299 n1414 14.4
r2357 n1413 n1414 21.333333333333332
r2358 n1300 n1415 5.2363636363636363
r2359 n1414 n1415 64
r2360 n1301 n1416 115.2
r2361 n1415 n1416 49.06666666666667
r2362 n1302 n1417 115.2
r2363 n1416 n1417 4.2666666666666666
r2364 n1303 n1418 115.2
r2365 n1417 n1418 4.2666666666666666
r2366 n1304 n1419 11.52
r2367 n1418 n1419 23.466666666666665
r2368 n1305 n1420 9.5999999999999996
r2369 n1419 n1420 46.93333333333333
r2370 n1306 n1421 14.4
r2371 n1420 n1421 42.666666666666664
r2372 n1307 n1422 57.600000000000001
r2373 n1421 n1422 21.333333333333332
r2374 n1308 n1423 38.399999999999999
r2375 n1422 n1423 10.666666666666666
r2376 n1309 n1424 57.600000000000001
r2377 n1423 n1424 10.666666666666666
r2378 n1310 n1425 19.199999999999999
r2379 n1424 n1425 17.066666666666666
r2380 n1311 n1426 9.5999999999999996
r2381 n1425 n1426 38.399999999999999
r2382 n1312 n1427 8.2285714285714278
r2383 n1426 n1427 55.466666666666669
r2384 n1313 n1428 57.600000000000001
r2385 n1427 n1428 34.133333333333333
r2386 n1314 n1429 3.2000000000000002
r2387 n1428 n1429 81.066666666666663
r2388 n1315 n1430 57.600000000000001
r2389 n1429 n1430 81.066666666666663
r2390 n1316 n1431 3.6000000000000001
r2391 n1430 n1431 72.533333333333331
r2392 n1317 n1432 57.600000000000001
r2393 n1431 n1432 72.533333333333331
r2394 n1318 n1433 3.2000000000000002
r2395 n1432 n1433 81.066666666666663
r2396 n1319 n1434 57.600000000000001
r2397 n1433 n1434 81.066666666666663
r2398 n1320 n1435 3.6000000000000001
r2399 n1434 n1435 72.533333333333331
r2400 n1321 n1436 57.600000000000001
r2401 n1435 n1436 72.533333333333331
r2402 n1322 n1437 3.2000000000000002
r2403 n1436 n1437 81.066666666666663
r2404 n1323 n1438 57.600000000000001
r2405 n1437 n1438 81.066666666666663
r2406 n1324 n1439 3.6000000000000001
r2407 n1438 n1439 72.533333333333331
r2408 n1325 n1440 57.600000000000001
r2409 n1439 n1440 72.533333333333331
r2410 n1326 n1441 3.2000000000000002
r2411 n1440 n1441 81.066666666666663
r2412 n1327 n1442 57.600000000000001
r2413 n1441 n1442 81.066666666666663
r2414 n1328 n1443 3.6000000000000001
r2415 n1442 n1443 72.533333333333331
r2416 n1329 n1444 57.600000000000001
r2417 n1443 n1444 72.533333333333331
r2418 n1330 n1445 3.2000000000000002
r2419 n1444 n1445 81.066666666666663
r2420 n1331 n1446 57.600000000000001
r2421 n1445 n1446 81.066666666666663
r2422 n1332 n1447 3.6000000000000001
r2423 n1446 n1447 72.533333333333331
r2424 n1333 n1448 57.600000000000001
r2425 n1447 n1448 72.533333333333331
r2426 n1334 n1449 3.2000000000000002
r2427 n1448 n1449 81.066666666666663
r2428 n1335 n1450 57.600000000000001
r2429 n1449 n1450 81.066666666666663
r2430 n1336 n1451 3.6000000000000001
r2431 n1450 n1451 72.533333333333331
r2432 n1337 n1452 57.600000000000001
r2433 n1451 n1452 72.533333333333331
r2434 n1338 n1453 3.2000000000000002
r2435 n1452 n1453 81.066666666666663
r2436 n1339 n1454 57.600000000000001
r2437 n1453 n1454 81.066666666666663
r2438 n1340 n1455 3.6000000000000001
r2439 n1454 n1455 72.533333333333331
r2440 n1341 n1456 57.600000000000001
r2441 n1455 n1456 72.533333333333331
r2442 n1342 n1457 9.5999999999999996
r2443 n1456 n1457 29.866666666666667
r2444 n1343 n1458 28.800000000000001
r2445 n1457 n1458 34.133333333333333
r2446 n1344 n1459 3.388235294117647
r2447 n1345 n1460 1.3176470588235294
r2448 n1346 n1461 11.199999999999999
r2449 n1347 n1462 4.4800000000000004
r2450 n1461 n1462 22.399999999999999
r2451 n1348 n1463 22.399999999999999
r2452 n1462 n1463 19.199999999999999
r2453 n1349 n1464 1.3999999999999999
r2454 n1463 n1464 54.399999999999999
r2455 n1350 n1465 22.399999999999999
r2456 n1464 n1465 54.399999999999999
r2457 n1351 n1466 1.2444444444444445
r2458 n1465 n1466 60.799999999999997
r2459 n1352 n1467 22.399999999999999
r2460 n1466 n1467 60.799999999999997
r2461 n1353 n1468 3.4461538461538463
r2462 n1467 n1468 24
r2463 n1354 n1469 3.7333333333333334
r2464 n1468 n1469 40
r2465 n1355 n1470 6.4000000000000004
r2466 n1469 n1470 30.399999999999999
r2467 n1356 n1471 22.399999999999999
r2468 n1470 n1471 14.4
r2469 n1357 n1472 11.199999999999999
r2470 n1471 n1472 9.5999999999999996
r2471 n1358 n1473 4.9777777777777779
r2472 n1472 n1473 20.800000000000001
r2473 n1359 n1474 2.1333333333333333
r2474 n1473 n1474 48
r2475 n1360 n1475 22.399999999999999
r2476 n1474 n1475 36.799999999999997
r2477 n1361 n1476 22.399999999999999
r2478 n1475 n1476 6.4000000000000004
r2479 n1362 n1477 4.9777777777777779
r2480 n1476 n1477 17.600000000000001
r2481 n1363 n1478 3.7333333333333334
r2482 n1477 n1478 33.600000000000001
r2483 n1364 n1479 4.9777777777777779
r2484 n1478 n1479 33.600000000000001
r2485 n1365 n1480 22.399999999999999
r2486 n1479 n1480 17.600000000000001
r2487 n1366 n1481 22.399999999999999
r2488 n1480 n1481 6.4000000000000004
r2489 n1367 n1482 2.1333333333333333
r2490 n1481 n1482 36.799999999999997
r2491 n1368 n1483 2.9866666666666668
r2492 n1482 n1483 57.600000000000001
r2493 n1369 n1484 22.399999999999999
r2494 n1483 n1484 27.199999999999999
r2495 n1370 n1485 1.3999999999999999
r2496 n1484 n1485 54.399999999999999
r2497 n1371 n1486 22.399999999999999
r2498 n1485 n1486 54.399999999999999
r2499 n1372 n1487 3.7333333333333334
r2500 n1486 n1487 22.399999999999999
r2501 n1373 n1488 11.199999999999999
r2502 n1487 n1488 25.600000000000001
r2503 n1374 n1489 1.3176470588235294
r2504 n1375 n1490 1.3176470588235294
r2505 n1376 n1491 11.199999999999999
r2506 n1377 n1492 4.4800000000000004
r2507 n1491 n1492 22.399999999999999
r2508 n1378 n1493 22.399999999999999
r2509 n1492 n1493 19.199999999999999
r2510 n1379 n1494 1.3999999999999999
r2511 n1493 n1494 54.399999999999999
r2512 n1380 n1495 22.399999999999999
r2513 n1494 n1495 54.399999999999999
r2514 n1381 n1496 1.2444444444444445
r2515 n1495 n1496 60.799999999999997
r2516 n1382 n1497 22.399999999999999
r2517 n1496 n1497 60.799999999999997
r2518 n1383 n1498 1.3999999999999999
r2519 n1497 n1498 54.399999999999999
r2520 n1384 n1499 22.399999999999999
r2521 n1498 n1499 54.399999999999999
r2522 n1385 n1500 1.2444444444444445
r2523 n1499 n1500 60.799999999999997
r2524 n1386 n1501 22.399999999999999
r2525 n1500 n1501 60.799999999999997
r2526 n1387 n1502 1.3999999999999999
r2527 n1501 n1502 54.399999999999999
r2528 n1388 n1503 22.399999999999999
r2529 n1502 n1503 54.399999999999999
r2530 n1389 n1504 1.2444444444444445
r2531 n1503 n1504 60.799999999999997
r2532 n1390 n1505 22.399999999999999
r2533 n1504 n1505 60.799999999999997
r2534 n1391 n1506 1.3999999999999999
r2535 n1505 n1506 54.399999999999999
r2536 n1392 n1507 22.399999999999999
r2537 n1506 n1507 54.399999999999999
r2538 n1393 n1508 1.2444444444444445
r2539 n1507 n1508 60.799999999999997
r2540 n1394 n1509 22.399999999999999
r2541 n1508 n1509 60.799999999999997
r2542 n1395 n1510 1.3999999999999999
r2543 n1509 n1510 54.399999999999999
r2544 n1396 n1511 22.399999999999999
r2545 n1510 n1511 54.399999999999999
r2546 n1397 n1512 1.2444444444444445
r2547 n1511 n1512 60.799999999999997
r2548 n1398 n1513 22.399999999999999
r2549 n1512 n1513 60.799999999999997
r2550 n1399 n1514 1.3999999999999999
r2551 n1513 n1514 54.399999999999999
r2552 n1400 n1515 22.399999999999999
r2553 n1514 n1515 54.399999999999999
r2554 n1401 n1516 1.2444444444444445
r2555 n1515 n1516 60.799999999999997
r2556 n1402 n1517 22.399999999999999
r2557 n1516 n1517 60.799999999999997
r2558 n1403 n1518 1.3999999999999999
r2559 n1517 n1518 54.399999999999999
r2560 n1404 n1519 22.399999999999999
r2561 n1518 n1519 54.399999999999999
r2562 n1405 n1520 1.2444444444444445
r2563 n1519 n1520 60.799999999999997
r2564 n1406 n1521 22.399999999999999
r2565 n1520 n1521 60.799999999999997
r2566 n1407 n1522 1.3999999999999999
r2567 n1521 n1522 54.399999999999999
r2568 n1408 n1523 22.399999999999999
r2569 n1522 n1523 54.399999999999999
r2570 n1409 n1524 2.9866666666666668
r2571 n1523 n1524 27.199999999999999
r2572 n1410 n1525 3.7333333333333334
r2573 n1524 n1525 43.200000000000003
r2574 n1411 n1526 4.9777777777777779
r2575 n1525 n1526 33.600000000000001
r2576 n1412 n1527 22.399999999999999
r2577 n1526 n1527 17.600000000000001
r2578 n1413 n1528 22.399999999999999
r2579 n1527 n1528 6.4000000000000004
r2580 n1414 n1529 5.5999999999999996
r2581 n1528 n1529 16
r2582 n1415 n1530 2.0363636363636362
r2583 n1529 n1530 48
r2584 n1416 n1531 44.799999999999997
r2585 n1530 n1531 36.799999999999997
r2586 n1417 n1532 44.799999999999997
r2587 n1531 n1532 3.2000000000000002
r2588 n1418 n1533 44.799999999999997
r2589 n1532 n1533 3.2000000000000002
r2590 n1419 n1534 4.4800000000000004
r2591 n1533 n1534 17.600000000000001
r2592 n1420 n1535 3.7333333333333334
r2593 n1534 n1535 35.200000000000003
r2594 n1421 n1536 5.5999999999999996
r2595 n1535 n1536 32
r2596 n1422 n1537 22.399999999999999
r2597 n1536 n1537 16
r2598 n1423 n1538 14.933333333333334
r2599 n1537 n1538 8
r2600 n1424 n1539 22.399999999999999
r2601 n1538 n1539 8
r2602 n1425 n1540 7.4666666666666668
r2603 n1539 n1540 12.800000000000001
r2604 n1426 n1541 3.7333333333333334
r2605 n1540 n1541 28.800000000000001
r2606 n1427 n1542 3.2000000000000002
r2607 n1541 n1542 41.600000000000001
r2608 n1428 n1543 22.399999999999999
r2609 n1542 n1543 25.600000000000001
r2610 n1429 n1544 1.2444444444444445
r2611 n1543 n1544 60.799999999999997
r2612 n1430 n1545 22.399999999999999
r2613 n1544 n1545 60.799999999999997
r2614 n1431 n1546 1.3999999999999999
r2615 n1545 n1546 54.399999999999999
r2616 n1432 n1547 22.399999999999999
r2617 n1546 n1547 54.399999999999999
r2618 n1433 n1548 1.2444444444444445
r2619 n1547 n1548 60.799999999999997
r2620 n1434 n1549 22.399999999999999
r2621 n1548 n1549 60.799999999999997
r2622 n1435 n1550 1.3999999999999999
r2623 n1549 n1550 54.399999999999999
r2624 n1436 n1551 22.399999999999999
r2625 n1550 n1551 54.399999999999999
r2626 n1437 n1552 1.2444444444444445
r2627 n1551 n1552 60.799999999999997
r2628 n1438 n1553 22.399999999999999
r2629 n1552 n1553 60.799999999999997
r2630 n1439 n1554 1.3999999999999999
r2631 n1553 n1554 54.399999999999999
r2632 n1440 n1555 22.399999999999999
r2633 n1554 n1555 54.399999999999999
r2634 n1441 n1556 1.2444444444444445
r2635 n1555 n1556 60.799999999999997
r2636 n1442 n1557 22.399999999999999
r2637 n1556 n1557 60.799999999999997
r2638 n1443 n1558 1.3999999999999999
r2639 n1557 n1558 54.399999999999999
r2640 n1444 n1559 22.399999999999999
r2641 n1558 n1559 54.399999999999999
r2642 n1445 n1560 1.2444444444444445
r2643 n1559 n1560 60.799999999999997
r2644 n1446 n1561 22.399999999999999
r2645 n1560 n1561 60.799999999999997
r2646 n1447 n1562 1.3999999999999999
r2647 n1561 n1562 54.399999999999999
r2648 n1448 n1563 22.399999999999999
r2649 n1562 n1563 54.399999999999999
r2650 n1449 n1564 1.2444444444444445
r2651 n1563 n1564 60.799999999999997
r2652 n1450 n1565 22.399999999999999
r2653 n1564 n1565 60.799999999999997
r2654 n1451 n1566 1.3999999999999999
r2655 n1565 n1566 54.399999999999999
r2656 n1452 n1567 22.399999999999999
r2657 n1566 n1567 54.399999999999999
r2658 n1453 n1568 1.2444444444444445
r2659 n1567 n1568 60.799999999999997
r2660 n1454 n1569 22.399999999999999
r2661 n1568 n1569 60.799999999999997
r2662 n1455 n1570 1.3999999999999999
r2663 n1569 n1570 54.399999999999999
r2664 n1456 n1571 22.399999999999999
r2665 n1570 n1571 54.399999999999999
r2666 n1457 n1572 3.7333333333333334
r2667 n1571 n1572 22.399999999999999
r2668 n1458 n1573 11.199999999999999
r2669 n1572 n1573 25.600000000000001
r2670 n1459 n1574 1.3176470588235294
r2671 n1460 n1575 1.3176470588235294
r2672 n1461 n1576 11.199999999999999
r2673 n1462 n1577 4.4800000000000004
r2674 n1576 n1577 29.866666666666667
r2675 n1463 n1578 22.399999999999999
r2676 n1577 n1578 25.600000000000001
r2677 n1464 n1579 1.3999999999999999
r2678 n1578 n1579 72.533333333333331
r2679 n1465 n1580 22.399999999999999
r2680 n1579 n1580 72.533333333333331
r2681 n1466 n1581 1.2444444444444445
r2682 n1580 n1581 81.066666666666663
r2683 n1467 n1582 22.399999999999999
r2684 n1581 n1582 81.066666666666663
r2685 n1468 n1583 3.4461538461538463
r2686 n1582 n1583 32
r2687 n1469 n1584 3.7333333333333334
r2688 n1583 n1584 53.333333333333336
r2689 n1470 n1585 6.4000000000000004
r2690 n1584 n1585 40.533333333333331
r2691 n1471 n1586 22.399999999999999
r2692 n1585 n1586 19.199999999999999
r2693 n1472 n1587 11.199999999999999
r2694 n1586 n1587 12.800000000000001
r2695 n1473 n1588 4.9777777777777779
r2696 n1587 n1588 27.733333333333334
r2697 n1474 n1589 2.1333333333333333
r2698 n1588 n1589 64
r2699 n1475 n1590 22.399999999999999
r2700 n1589 n1590 49.06666666666667
r2701 n1476 n1591 22.399999999999999
r2702 n1590 n1591 8.5333333333333332
r2703 n1477 n1592 4.9777777777777779
r2704 n1591 n1592 23.466666666666665
r2705 n1478 n1593 3.7333333333333334
r2706 n1592 n1593 44.799999999999997
r2707 n1479 n1594 4.9777777777777779
r2708 n1593 n1594 44.799999999999997
r2709 n1480 n1595 22.399999999999999
r2710 n1594 n1595 23.466666666666665
r2711 n1481 n1596 22.399999999999999
r2712 n1595 n1596 8.5333333333333332
r2713 n1482 n1597 2.1333333333333333
r2714 n1596 n1597 49.06666666666667
r2715 n1483 n1598 2.9866666666666668
r2716 n1597 n1598 76.799999999999997
r2717 n1484 n1599 22.399999999999999
r2718 n1598 n1599 36.266666666666666
r2719 n1485 n1600 1.3999999999999999
r2720 n1599 n1600 72.533333333333331
r2721 n1486 n1601 22.399999999999999
r2722 n1600 n1601 72.533333333333331
r2723 n1487 n1602 3.7333333333333334
r2724 n1601 n1602 29.866666666666667
r2725 n1488 n1603 11.199999999999999
r2726 n1602 n1603 34.133333333333333
r2727 n1604 n1605 21.333333333333332
r2728 n1605 n1606 64
r2729 n1606 n1607 51.200000000000003
r2730 n1489 n1608 1.3176470588235294
r2731 n1490 n1609 1.3176470588235294
r2732 n1491 n1610 11.199999999999999
r2733 n1492 n1611 4.4800000000000004
r2734 n1610 n1611 29.866666666666667
r2735 n1493 n1612 22.399999999999999
r2736 n1611 n1612 25.600000000000001
r2737 n1494 n1613 1.3999999999999999
r2738 n1612 n1613 72.533333333333331
r2739 n1495 n1614 22.399999999999999
r2740 n1613 n1614 72.533333333333331
r2741 n1496 n1615 1.2444444444444445
r2742 n1614 n1615 81.066666666666663
r2743 n1497 n1616 22.399999999999999
r2744 n1615 n1616 81.066666666666663
r2745 n1498 n1617 1.3999999999999999
r2746 n1616 n1617 72.533333333333331
r2747 n1499 n1618 22.399999999999999
r2748 n1617 n1618 72.533333333333331
r2749 n1500 n1619 1.2444444444444445
r2750 n1618 n1619 81.066666666666663
r2751 n1501 n1620 22.399999999999999
r2752 n1619 n1620 81.066666666666663
r2753 n1502 n1621 1.3999999999999999
r2754 n1620 n1621 72.533333333333331
r2755 n1503 n1622 22.399999999999999
r2756 n1621 n1622 72.533333333333331
r2757 n1504 n1623 1.2444444444444445
r2758 n1622 n1623 81.066666666666663
r2759 n1505 n1624 22.399999999999999
r2760 n1623 n1624 81.066666666666663
r2761 n1506 n1625 1.3999999999999999
r2762 n1624 n1625 72.533333333333331
r2763 n1507 n1626 22.399999999999999
r2764 n1625 n1626 72.533333333333331
r2765 n1508 n1627 1.2444444444444445
r2766 n1626 n1627 81.066666666666663
r2767 n1509 n1628 22.399999999999999
r2768 n1627 n1628 81.066666666666663
r2769 n1510 n1629 1.3999999999999999
r2770 n1628 n1629 72.533333333333331
r2771 n1511 n1630 22.399999999999999
r2772 n1629 n1630 72.533333333333331
r2773 n1512 n1631 1.2444444444444445
r2774 n1630 n1631 81.066666666666663
r2775 n1513 n1632 22.399999999999999
r2776 n1631 n1632 81.066666666666663
r2777 n1514 n1633 1.3999999999999999
r2778 n1632 n1633 72.533333333333331
r2779 n1515 n1634 22.399999999999999
r2780 n1633 n1634 72.533333333333331
r2781 n1516 n1635 1.2444444444444445
r2782 n1634 n1635 81.066666666666663
r2783 n1517 n1636 22.399999999999999
r2784 n1635 n1636 81.066666666666663
r2785 n1518 n1637 1.3999999999999999
r2786 n1636 n1637 72.533333333333331
r2787 n1519 n1638 22.399999999999999
r2788 n1637 n1638 72.533333333333331
r2789 n1520 n1639 1.2444444444444445
r2790 n1638 n1639 81.066666666666663
r2791 n1521 n1640 22.399999999999999
r2792 n1639 n1640 81.066666666666663
r2793 n1522 n1641 1.3999999999999999
r2794 n1640 n1641 72.533333333333331
r2795 n1523 n1642 22.399999999999999
r2796 n1641 n1642 72.533333333333331
r2797 n1524 n1643 2.9866666666666668
r2798 n1642 n1643 36.266666666666666
r2799 n1525 n1644 3.7333333333333334
r2800 n1643 n1644 57.600000000000001
r2801 n1526 n1645 4.9777777777777779
r2802 n1644 n1645 44.799999999999997
r2803 n1527 n1646 22.399999999999999
r2804 n1645 n1646 23.466666666666665
r2805 n1528 n1647 22.399999999999999
r2806 n1646 n1647 8.5333333333333332
r2807 n1529 n1648 5.5999999999999996
r2808 n1647 n1648 21.333333333333332
r2809 n1530 n1649 2.0363636363636362
r2810 n1648 n1649 64
r2811 n1531 n1650 44.799999999999997
r2812 n1649 n1650 49.06666666666667
r2813 n1532 n1651 44.799999999999997
r2814 n1650 n1651 4.2666666666666666
r2815 n1533 n1652 44.799999999999997
r2816 n1651 n1652 4.2666666666666666
r2817 n1534 n1653 4.4800000000000004
r2818 n1652 n1653 23.466666666666665
r2819 n1535 n1654 3.7333333333333334
r2820 n1653 n1654 46.93333333333333
r2821 n1536 n1655 5.5999999999999996
r2822 n1654 n1655 42.666666666666664
r2823 n1537 n1656 22.399999999999999
r2824 n1655 n1656 21.333333333333332
r2825 n1538 n1657 14.933333333333334
r2826 n1656 n1657 10.666666666666666
r2827 n1539 n1658 22.399999999999999
r2828 n1657 n1658 10.666666666666666
r2829 n1540 n1659 7.4666666666666668
r2830 n1658 n1659 17.066666666666666
r2831 n1541 n1660 3.7333333333333334
r2832 n1659 n1660 38.399999999999999
r2833 n1542 n1661 3.2000000000000002
r2834 n1660 n1661 55.466666666666669
r2835 n1543 n1662 22.399999999999999
r2836 n1661 n1662 34.133333333333333
r2837 n1544 n1663 1.2444444444444445
r2838 n1662 n1663 81.066666666666663
r2839 n1545 n1664 22.399999999999999
r2840 n1663 n1664 81.066666666666663
r2841 n1546 n1665 1.3999999999999999
r2842 n1664 n1665 72.533333333333331
r2843 n1547 n1666 22.399999999999999
r2844 n1665 n1666 72.533333333333331
r2845 n1548 n1667 1.2444444444444445
r2846 n1666 n1667 81.066666666666663
r2847 n1549 n1668 22.399999999999999
r2848 n1667 n1668 81.066666666666663
r2849 n1550 n1669 1.3999999999999999
r2850 n1668 n1669 72.533333333333331
r2851 n1551 n1670 22.399999999999999
r2852 n1669 n1670 72.533333333333331
r2853 n1552 n1671 1.2444444444444445
r2854 n1670 n1671 81.066666666666663
r2855 n1553 n1672 22.399999999999999
r2856 n1671 n1672 81.066666666666663
r2857 n1554 n1673 1.3999999999999999
r2858 n1672 n1673 72.533333333333331
r2859 n1555 n1674 22.399999999999999
r2860 n1673 n1674 72.533333333333331
r2861 n1556 n1675 1.2444444444444445
r2862 n1674 n1675 81.066666666666663
r2863 n1557 n1676 22.399999999999999
r2864 n1675 n1676 81.066666666666663
r2865 n1558 n1677 1.3999999999999999
r2866 n1676 n1677 72.533333333333331
r2867 n1559 n1678 22.399999999999999
r2868 n1677 n1678 72.533333333333331
r2869 n1560 n1679 1.2444444444444445
r2870 n1678 n1679 81.066666666666663
r2871 n1561 n1680 22.399999999999999
r2872 n1679 n1680 81.066666666666663
r2873 n1562 n1681 1.3999999999999999
r2874 n1680 n1681 72.533333333333331
r2875 n1563 n1682 22.399999999999999
r2876 n1681 n1682 72.533333333333331
r2877 n1564 n1683 1.2444444444444445
r2878 n1682 n1683 81.066666666666663
r2879 n1565 n1684 22.399999999999999
r2880 n1683 n1684 81.066666666666663
r2881 n1566 n1685 1.3999999999999999
r2882 n1684 n1685 72.533333333333331
r2883 n1567 n1686 22.399999999999999
r2884 n1685 n1686 72.533333333333331
r2885 n1568 n1687 1.2444444444444445
r2886 n1686 n1687 81.066666666666663
r2887 n1569 n1688 22.399999999999999
r2888 n1687 n1688 81.066666666666663
r2889 n1570 n1689 1.3999999999999999
r2890 n1688 n1689 72.533333333333331
r2891 n1571 n1690 22.399999999999999
r2892 n1689 n1690 72.533333333333331
r2893 n1572 n1691 3.7333333333333334
r2894 n1690 n1691 29.866666666666667
r2895 n1573 n1692 11.199999999999999
r2896 n1691 n1692 34.133333333333333
r2897 n1693 n1694 27.733333333333334
r2898 n1694 n1695 64
r2899 n1695 n1696 44.799999999999997
r2900 n1574 n1697 1.3176470588235294
r2901 n1575 n1698 0.94117647058823528
r2902 n1576 n1699 8
r2903 n1577 n1700 3.2000000000000002
r2904 n1699 n1700 44.799999999999997
r2905 n1578 n1701 16
r2906 n1700 n1701 38.399999999999999
r2907 n1579 n1702 1
r2908 n1701 n1702 108.8
r2909 n1580 n1703 16
r2910 n1702 n1703 108.8
r2911 n1581 n1704 0.88888888888888884
r2912 n1703 n1704 121.59999999999999
r2913 n1582 n1705 16
r2914 n1704 n1705 121.59999999999999
r2915 n1583 n1706 2.4615384615384617
r2916 n1705 n1706 48
r2917 n1584 n1707 2.6666666666666665
r2918 n1706 n1707 80
r2919 n1585 n1708 4.5714285714285712
r2920 n1707 n1708 60.799999999999997
r2921 n1586 n1709 16
r2922 n1708 n1709 28.800000000000001
r2923 n1587 n1710 8
r2924 n1709 n1710 19.199999999999999
r2925 n1588 n1711 3.5555555555555554
r2926 n1710 n1711 41.600000000000001
r2927 n1589 n1712 1.5238095238095237
r2928 n1711 n1712 96
r2929 n1590 n1713 16
r2930 n1712 n1713 73.599999999999994
r2931 n1591 n1714 16
r2932 n1713 n1714 12.800000000000001
r2933 n1592 n1715 3.5555555555555554
r2934 n1714 n1715 35.200000000000003
r2935 n1593 n1716 2.6666666666666665
r2936 n1715 n1716 67.200000000000003
r2937 n1594 n1717 3.5555555555555554
r2938 n1716 n1717 67.200000000000003
r2939 n1595 n1718 16
r2940 n1717 n1718 35.200000000000003
r2941 n1596 n1719 16
r2942 n1718 n1719 12.800000000000001
r2943 n1597 n1720 1.5238095238095237
r2944 n1719 n1720 73.599999999999994
r2945 n1598 n1721 2.1333333333333333
r2946 n1720 n1721 115.2
r2947 n1599 n1722 16
r2948 n1721 n1722 54.399999999999999
r2949 n1600 n1723 1
r2950 n1722 n1723 108.8
r2951 n1601 n1724 16
r2952 n1723 n1724 108.8
r2953 n1602 n1725 2.6666666666666665
r2954 n1724 n1725 44.799999999999997
r2955 n1603 n1726 8
r2956 n1725 n1726 51.200000000000003
r2957 n1604 n1727 16
r2958 n1605 n1728 4
r2959 n1727 n1728 32
r2960 n1606 n1729 1.4545454545454546
r2961 n1728 n1729 96
r2962 n1607 n1730 16
r2963 n1729 n1730 76.799999999999997
r2964 n1608 n1731 0.94117647058823528
r2965 n1609 n1732 0.94117647058823528
r2966 n1610 n1733 8
r2967 n1611 n1734 3.2000000000000002
r2968 n1733 n1734 44.799999999999997
r2969 n1612 n1735 16
r2970 n1734 n1735 38.399999999999999
r2971 n1613 n1736 1
r2972 n1735 n1736 108.8
r2973 n1614 n1737 16
r2974 n1736 n1737 108.8
r2975 n1615 n1738 0.88888888888888884
r2976 n1737 n1738 121.59999999999999
r2977 n1616 n1739 16
r2978 n1738 n1739 121.59999999999999
r2979 n1617 n1740 1
r2980 n1739 n1740 108.8
r2981 n1618 n1741 16
r2982 n1740 n1741 108.8
r2983 n1619 n1742 0.88888888888888884
r2984 n1741 n1742 121.59999999999999
r2985 n1620 n1743 16
r2986 n1742 n1743 121.59999999999999
r2987 n1621 n1744 1
r2988 n1743 n1744 108.8
r2989 n1622 n1745 16
r2990 n1744 n1745 108.8
r2991 n1623 n1746 0.88888888888888884
r2992 n1745 n1746 121.59999999999999
r2993 n1624 n1747 16
r2994 n1746 n1747 121.59999999999999
r2995 n1625 n1748 1
r2996 n1747 n1748 108.8
r2997 n1626 n1749 16
r2998 n1748 n1749 108.8
r2999 n1627 n1750 0.88888888888888884
r3000 n1749 n1750 121.59999999999999
r3001 n1628 n1751 16
r3002 n1750 n1751 121.59999999999999
r3003 n1629 n1752 1
r3004 n1751 n1752 108.8
r3005 n1630 n1753 16
r3006 n1752 n1753 108.8
r3007 n1631 n1754 0.88888888888888884
r3008 n1753 n1754 121.59999999999999
r3009 n1632 n1755 16
r3010 n1754 n1755 121.59999999999999
r3011 n1633 n1756 1
r3012 n1755 n1756 108.8
r3013 n1634 n1757 16
r3014 n1756 n1757 108.8
r3015 n1635 n1758 0.88888888888888884
r3016 n1757 n1758 121.59999999999999
r3017 n1636 n1759 16
r3018 n1758 n1759 121.59999999999999
r3019 n1637 n1760 1
r3020 n1759 n1760 108.8
r3021 n1638 n1761 16
r3022 n1760 n1761 108.8
r3023 n1639 n1762 0.88888888888888884
r3024 n1761 n1762 121.59999999999999
r3025 n1640 n1763 16
r3026 n1762 n1763 121.59999999999999
r3027 n1641 n1764 1
r3028 n1763 n1764 108.8
r3029 n1642 n1765 16
r3030 n1764 n1765 108.8
r3031 n1643 n1766 2.1333333333333333
r3032 n1765 n1766 54.399999999999999
r3033 n1644 n1767 2.6666666666666665
r3034 n1766 n1767 86.400000000000006
r3035 n1645 n1768 3.5555555555555554
r3036 n1767 n1768 67.200000000000003
r3037 n1646 n1769 16
r3038 n1768 n1769 35.200000000000003
r3039 n1647 n1770 16
r3040 n1769 n1770 12.800000000000001
r3041 n1648 n1771 4
r3042 n1770 n1771 32
r3043 n1649 n1772 1.4545454545454546
r3044 n1771 n1772 96
r3045 n1650 n1773 32
r3046 n1772 n1773 73.599999999999994
r3047 n1651 n1774 32
r3048 n1773 n1774 6.4000000000000004
r3049 n1652 n1775 32
r3050 n1774 n1775 6.4000000000000004
r3051 n1653 n1776 3.2000000000000002
r3052 n1775 n1776 35.200000000000003
r3053 n1654 n1777 2.6666666666666665
r3054 n1776 n1777 70.400000000000006
r3055 n1655 n1778 4
r3056 n1777 n1778 64
r3057 n1656 n1779 16
r3058 n1778 n1779 32
r3059 n1657 n1780 10.666666666666666
r3060 n1779 n1780 16
r3061 n1658 n1781 16
r3062 n1780 n1781 16
r3063 n1659 n1782 5.333333333333333
r3064 n1781 n1782 25.600000000000001
r3065 n1660 n1783 2.6666666666666665
r3066 n1782 n1783 57.600000000000001
r3067 n1661 n1784 2.2857142857142856
r3068 n1783 n1784 83.200000000000003
r3069 n1662 n1785 16
r3070 n1784 n1785 51.200000000000003
r3071 n1663 n1786 0.88888888888888884
r3072 n1785 n1786 121.59999999999999
r3073 n1664 n1787 16
r3074 n1786 n1787 121.59999999999999
r3075 n1665 n1788 1
r3076 n1787 n1788 108.8
r3077 n1666 n1789 16
r3078 n1788 n1789 108.8
r3079 n1667 n1790 0.88888888888888884
r3080 n1789 n1790 121.59999999999999
r3081 n1668 n1791 16
r3082 n1790 n1791 121.59999999999999
r3083 n1669 n1792 1
r3084 n1791 n1792 108.8
r3085 n1670 n1793 16
r3086 n1792 n1793 108.8
r3087 n1671 n1794 0.88888888888888884
r3088 n1793 n1794 121.59999999999999
r3089 n1672 n1795 16
r3090 n1794 n1795 121.59999999999999
r3091 n1673 n1796 1
r3092 n1795 n1796 108.8
r3093 n1674 n1797 16
r3094 n1796 n1797 108.8
r3095 n1675 n1798 0.88888888888888884
r3096 n1797 n1798 121.59999999999999
r3097 n1676 n1799 16
r3098 n1798 n1799 121.59999999999999
r3099 n1677 n1800 1
r3100 n1799 n1800 108.8
r3101 n1678 n1801 16
r3102 n1800 n1801 108.8
r3103 n1679 n1802 0.88888888888888884
r3104 n1801 n1802 121.59999999999999
r3105 n1680 n1803 16
r3106 n1802 n1803 121.59999999999999
r3107 n1681 n1804 1
r3108 n1803 n1804 108.8
r3109 n1682 n1805 16
r3110 n1804 n1805 108.8
r3111 n1683 n1806 0.88888888888888884
r3112 n1805 n1806 121.59999999999999
r3113 n1684 n1807 16
r3114 n1806 n1807 121.59999999999999
r3115 n1685 n1808 1
r3116 n1807 n1808 108.8
r3117 n1686 n1809 16
r3118 n1808 n1809 108.8
r3119 n1687 n1810 0.88888888888888884
r3120 n1809 n1810 121.59999999999999
r3121 n1688 n1811 16
r3122 n1810 n1811 121.59999999999999
r3123 n1689 n1812 1
r3124 n1811 n1812 108.8
r3125 n1690 n1813 16
r3126 n1812 n1813 108.8
r3127 n1691 n1814 2.6666666666666665
r3128 n1813 n1814 44.799999999999997
r3129 n1692 n1815 8
r3130 n1814 n1815 51.200000000000003
r3131 n1693 n1816 16
r3132 n1694 n1817 2.9090909090909092
r3133 n1816 n1817 41.600000000000001
r3134 n1695 n1818 1.6842105263157894
r3135 n1817 n1818 96
r3136 n1696 n1819 16
r3137 n1818 n1819 67.200000000000003
r3138 n1697 n1820 0.94117647058823528
r3139 n1698 n1821 1.5058823529411764
r3140 n1727 n1822 25.600000000000001
r3141 n1728 n1823 6.4000000000000004
r3142 n1822 n1823 10.666666666666666
r3143 n1729 n1824 2.3272727272727272
r3144 n1823 n1824 32
r3145 n1730 n1825 25.600000000000001
r3146 n1824 n1825 25.600000000000001
r3147 n1731 n1826 1.5058823529411764
r3148 n1732 n1827 1.5058823529411764
r3149 n1816 n1828 25.600000000000001
r3150 n1817 n1829 4.6545454545454543
r3151 n1828 n1829 13.866666666666667
r3152 n1818 n1830 2.6947368421052631
r3153 n1829 n1830 32
r3154 n1819 n1831 25.600000000000001
r3155 n1830 n1831 22.399999999999999
r3156 n1820 n1832 1.5058823529411764
r3157 n1821 n1833 1.5058823529411764
r3158 n1822 n1834 25.600000000000001
r3159 n1823 n1835 6.4000000000000004
r3160 n1834 n1835 32
r3161 n1824 n1836 2.3272727272727272
r3162 n1835 n1836 96
r3163 n1825 n1837 25.600000000000001
r3164 n1836 n1837 76.799999999999997
r3165 n1826 n1838 1.5058823529411764
r3166 n1827 n1839 1.5058823529411764
r3167 n1828 n1840 25.600000000000001
r3168 n1829 n1841 4.6545454545454543
r3169 n1840 n1841 41.600000000000001
r3170 n1830 n1842 2.6947368421052631
r3171 n1841 n1842 96
r3172 n1831 n1843 25.600000000000001
r3173 n1842 n1843 67.200000000000003
r3174 n1832 n1844 1.5058823529411764
r3175 n1833 n1845 0.94117647058823528
r3176 n1834 n1846 16
r3177 n1835 n1847 4
r3178 n1846 n1847 21.333333333333332
r3179 n1836 n1848 1.4545454545454546
r3180 n1847 n1848 64
r3181 n1837 n1849 16
r3182 n1848 n1849 51.200000000000003
r3183 n1838 n1850 0.94117647058823528
r3184 n1839 n1851 0.94117647058823528
r3185 n1840 n1852 16
r3186 n1841 n1853 2.9090909090909092
r3187 n1852 n1853 27.733333333333334
r3188 n1842 n1854 1.6842105263157894
r3189 n1853 n1854 64
r3190 n1843 n1855 16
r3191 n1854 n1855 44.799999999999997
r3192 n1844 n1856 0.94117647058823528
r3193 n1845 n1857 0.94117647058823528
r3194 n1846 n1858 16
r3195 n1847 n1859 4
r3196 n1858 n1859 32
r3197 n1848 n1860 1.4545454545454546
r3198 n1859 n1860 96
r3199 n1849 n1861 16
r3200 n1860 n1861 76.799999999999997
r3201 n1850 n1862 0.94117647058823528
r3202 n1851 n1863 0.94117647058823528
r3203 n1852 n1864 16
r3204 n1853 n1865 2.9090909090909092
r3205 n1864 n1865 41.600000000000001
r3206 n1854 n1866 1.6842105263157894
r3207 n1865 n1866 96
r3208 n1855 n1867 16
r3209 n1866 n1867 67.200000000000003
r3210 n1856 n1868 0.94117647058823528
r3211 n1857 n1869 6.0235294117647058
r3212 n1858 n1870 102.40000000000001
r3213 n1859 n1871 25.600000000000001
r3214 n1870 n1871 2.1333333333333333
r3215 n1860 n1872 9.3090909090909086
r3216 n1871 n1872 6.4000000000000004
r3217 n1861 n1873 102.40000000000001
r3218 n1872 n1873 5.1200000000000001
r3219 n1862 n1874 6.0235294117647058
r3220 n1863 n1875 6.0235294117647058
r3221 n1864 n1876 102.40000000000001
r3222 n1865 n1877 18.618181818181817
r3223 n1876 n1877 2.7733333333333334
r3224 n1866 n1878 10.778947368421052
r3225 n1877 n1878 6.4000000000000004
r3226 n1867 n1879 102.40000000000001
r3227 n1878 n1879 4.4800000000000004
r3228 n1868 n1880 6.0235294117647058
r3229 n1869 n1881 6.0235294117647058
r3230 n1870 n1882 102.40000000000001
r3231 n1871 n1883 25.600000000000001
r3232 n1882 n1883 32
r3233 n1872 n1884 9.3090909090909086
r3234 n1883 n1884 96
r3235 n1873 n1885 102.40000000000001
r3236 n1884 n1885 76.799999999999997
r3237 n1874 n1886 6.0235294117647058
r3238 n1875 n1887 6.0235294117647058
r3239 n1876 n1888 102.40000000000001
r3240 n1877 n1889 18.618181818181817
r3241 n1888 n1889 41.600000000000001
r3242 n1878 n1890 10.778947368421052
r3243 n1889 n1890 96
r3244 n1879 n1891 102.40000000000001
r3245 n1890 n1891 67.200000000000003
r3246 n1880 n1892 6.0235294117647058
r3247 n1881 n1893 0.94117647058823528
r3248 n1882 n1894 16
r3249 n1883 n1895 4
r3250 n1894 n1895 21.333333333333332
r3251 n1884 n1896 1.4545454545454546
r3252 n1895 n1896 64
r3253 n1885 n1897 16
r3254 n1896 n1897 51.200000000000003
r3255 n1886 n1898 0.94117647058823528
r3256 n1887 n1899 0.94117647058823528
r3257 n1888 n1900 16
r3258 n1889 n1901 2.9090909090909092
r3259 n1900 n1901 27.733333333333334
r3260 n1890 n1902 1.6842105263157894
r3261 n1901 n1902 64
r3262 n1891 n1903 16
r3263 n1902 n1903 44.799999999999997
r3264 n1892 n1904 0.94117647058823528
r3265 n1893 n1905 0.94117647058823528
r3266 n1894 n1906 16
r3267 n1895 n1907 4
r3268 n1906 n1907 32
r3269 n1896 n1908 1.4545454545454546
r3270 n1907 n1908 96
r3271 n1897 n1909 16
r3272 n1908 n1909 76.799999999999997
r3273 n1898 n1910 0.94117647058823528
r3274 n1899 n1911 0.94117647058823528
r3275 n1900 n1912 16
r3276 n1901 n1913 2.9090909090909092
r3277 n1912 n1913 41.600000000000001
r3278 n1902 n1914 1.6842105263157894
r3279 n1913 n1914 96
r3280 n1903 n1915 16
r3281 n1914 n1915 67.200000000000003
r3282 n1904 n1916 0.94117647058823528
r3283 n1905 n1917 1.5058823529411764
r3284 n1906 n1918 25.600000000000001
r3285 n1907 n1919 6.4000000000000004
r3286 n1918 n1919 10.666666666666666
r3287 n1908 n1920 2.3272727272727272
r3288 n1919 n1920 32
r3289 n1909 n1921 25.600000000000001
r3290 n1920 n1921 25.600000000000001
r3291 n1910 n1922 1.5058823529411764
r3292 n1911 n1923 1.5058823529411764
r3293 n1912 n1924 25.600000000000001
r3294 n1913 n1925 4.6545454545454543
r3295 n1924 n1925 13.866666666666667
r3296 n1914 n1926 2.6947368421052631
r3297 n1925 n1926 32
r3298 n1915 n1927 25.600000000000001
r3299 n1926 n1927 22.399999999999999
r3300 n1916 n1928 1.5058823529411764
r3301 n1917 n1929 1.5058823529411764
r3302 n1930 n1931 44.799999999999997
r3303 n1931 n1932 38.399999999999999
r3304 n1932 n1933 108.8
r3305 n1933 n1934 108.8
r3306 n1934 n1935 121.59999999999999
r3307 n1935 n1936 121.59999999999999
r3308 n1936 n1937 48
r3309 n1937 n1938 80
r3310 n1938 n1939 60.799999999999997
r3311 n1939 n1940 28.800000000000001
r3312 n1940 n1941 19.199999999999999
r3313 n1941 n1942 41.600000000000001
r3314 n1942 n1943 96
r3315 n1943 n1944 73.599999999999994
r3316 n1944 n1945 12.800000000000001
r3317 n1945 n1946 35.200000000000003
r3318 n1946 n1947 67.200000000000003
r3319 n1947 n1948 67.200000000000003
r3320 n1948 n1949 35.200000000000003
r3321 n1949 n1950 12.800000000000001
r3322 n1950 n1951 73.599999999999994
r3323 n1951 n1952 115.2
r3324 n1952 n1953 54.399999999999999
r3325 n1953 n1954 108.8
r3326 n1954 n1955 108.8
r3327 n1955 n1956 44.799999999999997
r3328 n1956 n1957 51.200000000000003
r3329 n1918 n1958 25.600000000000001
r3330 n1919 n1959 6.4000000000000004
r3331 n1958 n1959 32
r3332 n1920 n1960 2.3272727272727272
r3333 n1959 n1960 96
r3334 n1921 n1961 25.600000000000001
r3335 n1960 n1961 76.799999999999997
r3336 n1922 n1962 1.5058823529411764
r3337 n1923 n1963 1.5058823529411764
r3338 n1964 n1965 44.799999999999997
r3339 n1965 n1966 38.399999999999999
r3340 n1966 n1967 108.8
r3341 n1967 n1968 108.8
r3342 n1968 n1969 121.59999999999999
r3343 n1969 n1970 121.59999999999999
r3344 n1970 n1971 108.8
r3345 n1971 n1972 108.8
r3346 n1972 n1973 121.59999999999999
r3347 n1973 n1974 121.59999999999999
r3348 n1974 n1975 108.8
r3349 n1975 n1976 108.8
r3350 n1976 n1977 121.59999999999999
r3351 n1977 n1978 121.59999999999999
r3352 n1978 n1979 108.8
r3353 n1979 n1980 108.8
r3354 n1980 n1981 121.59999999999999
r3355 n1981 n1982 121.59999999999999
r3356 n1982 n1983 108.8
r3357 n1983 n1984 108.8
r3358 n1984 n1985 121.59999999999999
r3359 n1985 n1986 121.59999999999999
r3360 n1986 n1987 108.8
r3361 n1987 n1988 108.8
r3362 n1988 n1989 121.59999999999999
r3363 n1989 n1990 121.59999999999999
r3364 n1990 n1991 108.8
r3365 n1991 n1992 108.8
r3366 n1992 n1993 121.59999999999999
r3367 n1993 n1994 121.59999999999999
r3368 n1994 n1995 108.8
r3369 n1995 n1996 108.8
r3370 n1996 n1997 54.399999999999999
r3371 n1997 n1998 86.400000000000006
r3372 n1998 n1999 67.200000000000003
r3373 n1999 n2000 35.200000000000003
r3374 n2000 n2001 12.800000000000001
r3375 n2001 n2002 32
r3376 n2002 n2003 96
r3377 n2003 n2004 73.599999999999994
r3378 n2004 n2005 6.4000000000000004
r3379 n2005 n2006 6.4000000000000004
r3380 n2006 n2007 35.200000000000003
r3381 n2007 n2008 70.400000000000006
r3382 n2008 n2009 64
r3383 n2009 n2010 32
r3384 n2010 n2011 16
r3385 n2011 n2012 16
r3386 n2012 n2013 25.600000000000001
r3387 n2013 n2014 57.600000000000001
r3388 n2014 n2015 83.200000000000003
r3389 n2015 n2016 51.200000000000003
r3390 n2016 n2017 121.59999999999999
r3391 n2017 n2018 121.59999999999999
r3392 n2018 n2019 108.8
r3393 n2019 n2020 108.8
r3394 n2020 n2021 121.59999999999999
r3395 n2021 n2022 121.59999999999999
r3396 n2022 n2023 108.8
r3397 n2023 n2024 108.8
r3398 n2024 n2025 121.59999999999999
r3399 n2025 n2026 121.59999999999999
r3400 n2026 n2027 108.8
r3401 n2027 n2028 108.8
r3402 n2028 n2029 121.59999999999999
r3403 n2029 n2030 121.59999999999999
r3404 n2030 n2031 108.8
r3405 n2031 n2032 108.8
r3406 n2032 n2033 121.59999999999999
r3407 n2033 n2034 121.59999999999999
r3408 n2034 n2035 108.8
r3409 n2035 n2036 108.8
r3410 n2036 n2037 121.59999999999999
r3411 n2037 n2038 121.59999999999999
r3412 n2038 n2039 108.8
r3413 n2039 n2040 108.8
r3414 n2040 n2041 121.59999999999999
r3415 n2041 n2042 121.59999999999999
r3416 n2042 n2043 108.8
r3417 n2043 n2044 108.8
r3418 n2044 n2045 44.799999999999997
r3419 n2045 n2046 51.200000000000003
r3420 n1924 n2047 25.600000000000001
r3421 n1925 n2048 4.6545454545454543
r3422 n2047 n2048 41.600000000000001
r3423 n1926 n2049 2.6947368421052631
r3424 n2048 n2049 96
r3425 n1927 n2050 25.600000000000001
r3426 n2049 n2050 67.200000000000003
r3427 n1928 n2051 1.5058823529411764
r3428 n1929 n2052 0.94117647058823528
r3429 n1930 n2053 8
r3430 n1931 n2054 3.2000000000000002
r3431 n2053 n2054 29.866666666666667
r3432 n1932 n2055 16
r3433 n2054 n2055 25.600000000000001
r3434 n1933 n2056 1
r3435 n2055 n2056 72.533333333333331
r3436 n1934 n2057 16
r3437 n2056 n2057 72.533333333333331
r3438 n1935 n2058 0.88888888888888884
r3439 n2057 n2058 81.066666666666663
r3440 n1936 n2059 16
r3441 n2058 n2059 81.066666666666663
r3442 n1937 n2060 2.4615384615384617
r3443 n2059 n2060 32
r3444 n1938 n2061 2.6666666666666665
r3445 n2060 n2061 53.333333333333336
r3446 n1939 n2062 4.5714285714285712
r3447 n2061 n2062 40.533333333333331
r3448 n1940 n2063 16
r3449 n2062 n2063 19.199999999999999
r3450 n1941 n2064 8
r3451 n2063 n2064 12.800000000000001
r3452 n1942 n2065 3.5555555555555554
r3453 n2064 n2065 27.733333333333334
r3454 n1943 n2066 1.5238095238095237
r3455 n2065 n2066 64
r3456 n1944 n2067 16
r3457 n2066 n2067 49.06666666666667
r3458 n1945 n2068 16
r3459 n2067 n2068 8.5333333333333332
r3460 n1946 n2069 3.5555555555555554
r3461 n2068 n2069 23.466666666666665
r3462 n1947 n2070 2.6666666666666665
r3463 n2069 n2070 44.799999999999997
r3464 n1948 n2071 3.5555555555555554
r3465 n2070 n2071 44.799999999999997
r3466 n1949 n2072 16
r3467 n2071 n2072 23.466666666666665
r3468 n1950 n2073 16
r3469 n2072 n2073 8.5333333333333332
r3470 n1951 n2074 1.5238095238095237
r3471 n2073 n2074 49.06666666666667
r3472 n1952 n2075 2.1333333333333333
r3473 n2074 n2075 76.799999999999997
r3474 n1953 n2076 16
r3475 n2075 n2076 36.266666666666666
r3476 n1954 n2077 1
r3477 n2076 n2077 72.533333333333331
r3478 n1955 n2078 16
r3479 n2077 n2078 72.533333333333331
r3480 n1956 n2079 2.6666666666666665
r3481 n2078 n2079 29.866666666666667
r3482 n1957 n2080 8
r3483 n2079 n2080 34.133333333333333
r3484 n1958 n2081 16
r3485 n1959 n2082 4
r3486 n2081 n2082 21.333333333333332
r3487 n1960 n2083 1.4545454545454546
r3488 n2082 n2083 64
r3489 n1961 n2084 16
r3490 n2083 n2084 51.200000000000003
r3491 n1962 n2085 0.94117647058823528
r3492 n1963 n2086 0.94117647058823528
r3493 n1964 n2087 8
r3494 n1965 n2088 3.2000000000000002
r3495 n2087 n2088 29.866666666666667
r3496 n1966 n2089 16
r3497 n2088 n2089 25.600000000000001
r3498 n1967 n2090 1
r3499 n2089 n2090 72.533333333333331
r3500 n1968 n2091 16
r3501 n2090 n2091 72.533333333333331
r3502 n1969 n2092 0.88888888888888884
r3503 n2091 n2092 81.066666666666663
r3504 n1970 n2093 16
r3505 n2092 n2093 81.066666666666663
r3506 n1971 n2094 1
r3507 n2093 n2094 72.533333333333331
r3508 n1972 n2095 16
r3509 n2094 n2095 72.533333333333331
r3510 n1973 n2096 0.88888888888888884
r3511 n2095 n2096 81.066666666666663
r3512 n1974 n2097 16
r3513 n2096 n2097 81.066666666666663
r3514 n1975 n2098 1
r3515 n2097 n2098 72.533333333333331
r3516 n1976 n2099 16
r3517 n2098 n2099 72.533333333333331
r3518 n1977 n2100 0.88888888888888884
r3519 n2099 n2100 81.066666666666663
r3520 n1978 n2101 16
r3521 n2100 n2101 81.066666666666663
r3522 n1979 n2102 1
r3523 n2101 n2102 72.533333333333331
r3524 n1980 n2103 16
r3525 n2102 n2103 72.533333333333331
r3526 n1981 n2104 0.88888888888888884
r3527 n2103 n2104 81.066666666666663
r3528 n1982 n2105 16
r3529 n2104 n2105 81.066666666666663
r3530 n1983 n2106 1
r3531 n2105 n2106 72.533333333333331
r3532 n1984 n2107 16
r3533 n2106 n2107 72.533333333333331
r3534 n1985 n2108 0.88888888888888884
r3535 n2107 n2108 81.066666666666663
r3536 n1986 n2109 16
r3537 n2108 n2109 81.066666666666663
r3538 n1987 n2110 1
r3539 n2109 n2110 72.533333333333331
r3540 n1988 n2111 16
r3541 n2110 n2111 72.533333333333331
r3542 n1989 n2112 0.88888888888888884
r3543 n2111 n2112 81.066666666666663
r3544 n1990 n2113 16
r3545 n2112 n2113 81.066666666666663
r3546 n1991 n2114 1
r3547 n2113 n2114 72.533333333333331
r3548 n1992 n2115 16
r3549 n2114 n2115 72.533333333333331
r3550 n1993 n2116 0.88888888888888884
r3551 n2115 n2116 81.066666666666663
r3552 n1994 n2117 16
r3553 n2116 n2117 81.066666666666663
r3554 n1995 n2118 1
r3555 n2117 n2118 72.533333333333331
r3556 n1996 n2119 16
r3557 n2118 n2119 72.533333333333331
r3558 n1997 n2120 2.1333333333333333
r3559 n2119 n2120 36.266666666666666
r3560 n1998 n2121 2.6666666666666665
r3561 n2120 n2121 57.600000000000001
r3562 n1999 n2122 3.5555555555555554
r3563 n2121 n2122 44.799999999999997
r3564 n2000 n2123 16
r3565 n2122 n2123 23.466666666666665
r3566 n2001 n2124 16
r3567 n2123 n2124 8.5333333333333332
r3568 n2002 n2125 4
r3569 n2124 n2125 21.333333333333332
r3570 n2003 n2126 1.4545454545454546
r3571 n2125 n2126 64
r3572 n2004 n2127 32
r3573 n2126 n2127 49.06666666666667
r3574 n2005 n2128 32
r3575 n2127 n2128 4.2666666666666666
r3576 n2006 n2129 32
r3577 n2128 n2129 4.2666666666666666
r3578 n2007 n2130 3.2000000000000002
r3579 n2129 n2130 23.466666666666665
r3580 n2008 n2131 2.6666666666666665
r3581 n2130 n2131 46.93333333333333
r3582 n2009 n2132 4
r3583 n2131 n2132 42.666666666666664
r3584 n2010 n2133 16
r3585 n2132 n2133 21.333333333333332
r3586 n2011 n2134 10.666666666666666
r3587 n2133 n2134 10.666666666666666
r3588 n2012 n2135 16
r3589 n2134 n2135 10.666666666666666
r3590 n2013 n2136 5.333333333333333
r3591 n2135 n2136 17.066666666666666
r3592 n2014 n2137 2.6666666666666665
r3593 n2136 n2137 38.399999999999999
r3594 n2015 n2138 2.2857142857142856
r3595 n2137 n2138 55.466666666666669
r3596 n2016 n2139 16
r3597 n2138 n2139 34.133333333333333
r3598 n2017 n2140 0.88888888888888884
r3599 n2139 n2140 81.066666666666663
r3600 n2018 n2141 16
r3601 n2140 n2141 81.066666666666663
r3602 n2019 n2142 1
r3603 n2141 n2142 72.533333333333331
r3604 n2020 n2143 16
r3605 n2142 n2143 72.533333333333331
r3606 n2021 n2144 0.88888888888888884
r3607 n2143 n2144 81.066666666666663
r3608 n2022 n2145 16
r3609 n2144 n2145 81.066666666666663
r3610 n2023 n2146 1
r3611 n2145 n2146 72.533333333333331
r3612 n2024 n2147 16
r3613 n2146 n2147 72.533333333333331
r3614 n2025 n2148 0.88888888888888884
r3615 n2147 n2148 81.066666666666663
r3616 n2026 n2149 16
r3617 n2148 n2149 81.066666666666663
r3618 n2027 n2150 1
r3619 n2149 n2150 72.533333333333331
r3620 n2028 n2151 16
r3621 n2150 n2151 72.533333333333331
r3622 n2029 n2152 0.88888888888888884
r3623 n2151 n2152 81.066666666666663
r3624 n2030 n2153 16
r3625 n2152 n2153 81.066666666666663
r3626 n2031 n2154 1
r3627 n2153 n2154 72.533333333333331
r3628 n2032 n2155 16
r3629 n2154 n2155 72.533333333333331
r3630 n2033 n2156 0.88888888888888884
r3631 n2155 n2156 81.066666666666663
r3632 n2034 n2157 16
r3633 n2156 n2157 81.066666666666663
r3634 n2035 n2158 1
r3635 n2157 n2158 72.533333333333331
r3636 n2036 n2159 16
r3637 n2158 n2159 72.533333333333331
r3638 n2037 n2160 0.88888888888888884
r3639 n2159 n2160 81.066666666666663
r3640 n2038 n2161 16
r3641 n2160 n2161 81.066666666666663
r3642 n2039 n2162 1
r3643 n2161 n2162 72.533333333333331
r3644 n2040 n2163 16
r3645 n2162 n2163 72.533333333333331
r3646 n2041 n2164 0.88888888888888884
r3647 n2163 n2164 81.066666666666663
r3648 n2042 n2165 16
r3649 n2164 n2165 81.066666666666663
r3650 n2043 n2166 1
r3651 n2165 n2166 72.533333333333331
r3652 n2044 n2167 16
r3653 n2166 n2167 72.533333333333331
r3654 n2045 n2168 2.6666666666666665
r3655 n2167 n2168 29.866666666666667
r3656 n2046 n2169 8
r3657 n2168 n2169 34.133333333333333
r3658 n2047 n2170 16
r3659 n2048 n2171 2.9090909090909092
r3660 n2170 n2171 27.733333333333334
r3661 n2049 n2172 1.6842105263157894
r3662 n2171 n2172 64
r3663 n2050 n2173 16
r3664 n2172 n2173 44.799999999999997
r3665 n2051 n2174 0.94117647058823528
r3666 n2052 n2175 1.3176470588235294
r3667 n2053 n2176 11.199999999999999
r3668 n2054 n2177 4.4800000000000004
r3669 n2176 n2177 22.399999999999999
r3670 n2055 n2178 22.399999999999999
r3671 n2177 n2178 19.199999999999999
r3672 n2056 n2179 1.3999999999999999
r3673 n2178 n2179 54.399999999999999
r3674 n2057 n2180 22.399999999999999
r3675 n2179 n2180 54.399999999999999
r3676 n2058 n2181 1.2444444444444445
r3677 n2180 n2181 60.799999999999997
r3678 n2059 n2182 22.399999999999999
r3679 n2181 n2182 60.799999999999997
r3680 n2060 n2183 3.4461538461538463
r3681 n2182 n2183 24
r3682 n2061 n2184 3.7333333333333334
r3683 n2183 n2184 40
r3684 n2062 n2185 6.4000000000000004
r3685 n2184 n2185 30.399999999999999
r3686 n2063 n2186 22.399999999999999
r3687 n2185 n2186 14.4
r3688 n2064 n2187 11.199999999999999
r3689 n2186 n2187 9.5999999999999996
r3690 n2065 n2188 4.9777777777777779
r3691 n2187 n2188 20.800000000000001
r3692 n2066 n2189 2.1333333333333333
r3693 n2188 n2189 48
r3694 n2067 n2190 22.399999999999999
r3695 n2189 n2190 36.799999999999997
r3696 n2068 n2191 22.399999999999999
r3697 n2190 n2191 6.4000000000000004
r3698 n2069 n2192 4.9777777777777779
r3699 n2191 n2192 17.600000000000001
r3700 n2070 n2193 3.7333333333333334
r3701 n2192 n2193 33.600000000000001
r3702 n2071 n2194 4.9777777777777779
r3703 n2193 n2194 33.600000000000001
r3704 n2072 n2195 22.399999999999999
r3705 n2194 n2195 17.600000000000001
r3706 n2073 n2196 22.399999999999999
r3707 n2195 n2196 6.4000000000000004
r3708 n2074 n2197 2.1333333333333333
r3709 n2196 n2197 36.799999999999997
r3710 n2075 n2198 2.9866666666666668
r3711 n2197 n2198 57.600000000000001
r3712 n2076 n2199 22.399999999999999
r3713 n2198 n2199 27.199999999999999
r3714 n2077 n2200 1.3999999999999999
r3715 n2199 n2200 54.399999999999999
r3716 n2078 n2201 22.399999999999999
r3717 n2200 n2201 54.399999999999999
r3718 n2079 n2202 3.7333333333333334
r3719 n2201 n2202 22.399999999999999
r3720 n2080 n2203 11.199999999999999
r3721 n2202 n2203 25.600000000000001
r3722 n2085 n2204 1.3176470588235294
r3723 n2086 n2205 1.3176470588235294
r3724 n2087 n2206 11.199999999999999
r3725 n2088 n2207 4.4800000000000004
r3726 n2206 n2207 22.399999999999999
r3727 n2089 n2208 22.399999999999999
r3728 n2207 n2208 19.199999999999999
r3729 n2090 n2209 1.3999999999999999
r3730 n2208 n2209 54.399999999999999
r3731 n2091 n2210 22.399999999999999
r3732 n2209 n2210 54.399999999999999
r3733 n2092 n2211 1.2444444444444445
r3734 n2210 n2211 60.799999999999997
r3735 n2093 n2212 22.399999999999999
r3736 n2211 n2212 60.799999999999997
r3737 n2094 n2213 1.3999999999999999
r3738 n2212 n2213 54.399999999999999
r3739 n2095 n2214 22.399999999999999
r3740 n2213 n2214 54.399999999999999
r3741 n2096 n2215 1.2444444444444445
r3742 n2214 n2215 60.799999999999997
r3743 n2097 n2216 22.399999999999999
r3744 n2215 n2216 60.799999999999997
r3745 n2098 n2217 1.3999999999999999
r3746 n2216 n2217 54.399999999999999
r3747 n2099 n2218 22.399999999999999
r3748 n2217 n2218 54.399999999999999
r3749 n2100 n2219 1.2444444444444445
r3750 n2218 n2219 60.799999999999997
r3751 n2101 n2220 22.399999999999999
r3752 n2219 n2220 60.799999999999997
r3753 n2102 n2221 1.3999999999999999
r3754 n2220 n2221 54.399999999999999
r3755 n2103 n2222 22.399999999999999
r3756 n2221 n2222 54.399999999999999
r3757 n2104 n2223 1.2444444444444445
r3758 n2222 n2223 60.799999999999997
r3759 n2105 n2224 22.399999999999999
r3760 n2223 n2224 60.799999999999997
r3761 n2106 n2225 1.3999999999999999
r3762 n2224 n2225 54.399999999999999
r3763 n2107 n2226 22.399999999999999
r3764 n2225 n2226 54.399999999999999
r3765 n2108 n2227 1.2444444444444445
r3766 n2226 n2227 60.799999999999997
r3767 n2109 n2228 22.399999999999999
r3768 n2227 n2228 60.799999999999997
r3769 n2110 n2229 1.3999999999999999
r3770 n2228 n2229 54.399999999999999
r3771 n2111 n2230 22.399999999999999
r3772 n2229 n2230 54.399999999999999
r3773 n2112 n2231 1.2444444444444445
r3774 n2230 n2231 60.799999999999997
r3775 n2113 n2232 22.399999999999999
r3776 n2231 n2232 60.799999999999997
r3777 n2114 n2233 1.3999999999999999
r3778 n2232 n2233 54.399999999999999
r3779 n2115 n2234 22.399999999999999
r3780 n2233 n2234 54.399999999999999
r3781 n2116 n2235 1.2444444444444445
r3782 n2234 n2235 60.799999999999997
r3783 n2117 n2236 22.399999999999999
r3784 n2235 n2236 60.799999999999997
r3785 n2118 n2237 1.3999999999999999
r3786 n2236 n2237 54.399999999999999
r3787 n2119 n2238 22.399999999999999
r3788 n2237 n2238 54.399999999999999
r3789 n2120 n2239 2.9866666666666668
r3790 n2238 n2239 27.199999999999999
r3791 n2121 n2240 3.7333333333333334
r3792 n2239 n2240 43.200000000000003
r3793 n2122 n2241 4.9777777777777779
r3794 n2240 n2241 33.600000000000001
r3795 n2123 n2242 22.399999999999999
r3796 n2241 n2242 17.600000000000001
r3797 n2124 n2243 22.399999999999999
r3798 n2242 n2243 6.4000000000000004
r3799 n2125 n2244 5.5999999999999996
r3800 n2243 n2244 16
r3801 n2126 n2245 2.0363636363636362
r3802 n2244 n2245 48
r3803 n2127 n2246 44.799999999999997
r3804 n2245 n2246 36.799999999999997
r3805 n2128 n2247 44.799999999999997
r3806 n2246 n2247 3.2000000000000002
r3807 n2129 n2248 44.799999999999997
r3808 n2247 n2248 3.2000000000000002
r3809 n2130 n2249 4.4800000000000004
r3810 n2248 n2249 17.600000000000001
r3811 n2131 n2250 3.7333333333333334
r3812 n2249 n2250 35.200000000000003
r3813 n2132 n2251 5.5999999999999996
r3814 n2250 n2251 32
r3815 n2133 n2252 22.399999999999999
r3816 n2251 n2252 16
r3817 n2134 n2253 14.933333333333334
r3818 n2252 n2253 8
r3819 n2135 n2254 22.399999999999999
r3820 n2253 n2254 8
r3821 n2136 n2255 7.4666666666666668
r3822 n2254 n2255 12.800000000000001
r3823 n2137 n2256 3.7333333333333334
r3824 n2255 n2256 28.800000000000001
r3825 n2138 n2257 3.2000000000000002
r3826 n2256 n2257 41.600000000000001
r3827 n2139 n2258 22.399999999999999
r3828 n2257 n2258 25.600000000000001
r3829 n2140 n2259 1.2444444444444445
r3830 n2258 n2259 60.799999999999997
r3831 n2141 n2260 22.399999999999999
r3832 n2259 n2260 60.799999999999997
r3833 n2142 n2261 1.3999999999999999
r3834 n2260 n2261 54.399999999999999
r3835 n2143 n2262 22.399999999999999
r3836 n2261 n2262 54.399999999999999
r3837 n2144 n2263 1.2444444444444445
r3838 n2262 n2263 60.799999999999997
r3839 n2145 n2264 22.399999999999999
r3840 n2263 n2264 60.799999999999997
r3841 n2146 n2265 1.3999999999999999
r3842 n2264 n2265 54.399999999999999
r3843 n2147 n2266 22.399999999999999
r3844 n2265 n2266 54.399999999999999
r3845 n2148 n2267 1.2444444444444445
r3846 n2266 n2267 60.799999999999997
r3847 n2149 n2268 22.399999999999999
r3848 n2267 n2268 60.799999999999997
r3849 n2150 n2269 1.3999999999999999
r3850 n2268 n2269 54.399999999999999
r3851 n2151 n2270 22.399999999999999
r3852 n2269 n2270 54.399999999999999
r3853 n2152 n2271 1.2444444444444445
r3854 n2270 n2271 60.799999999999997
r3855 n2153 n2272 22.399999999999999
r3856 n2271 n2272 60.799999999999997
r3857 n2154 n2273 1.3999999999999999
r3858 n2272 n2273 54.399999999999999
r3859 n2155 n2274 22.399999999999999
r3860 n2273 n2274 54.399999999999999
r3861 n2156 n2275 1.2444444444444445
r3862 n2274 n2275 60.799999999999997
r3863 n2157 n2276 22.399999999999999
r3864 n2275 n2276 60.799999999999997
r3865 n2158 n2277 1.3999999999999999
r3866 n2276 n2277 54.399999999999999
r3867 n2159 n2278 22.399999999999999
r3868 n2277 n2278 54.399999999999999
r3869 n2160 n2279 1.2444444444444445
r3870 n2278 n2279 60.799999999999997
r3871 n2161 n2280 22.399999999999999
r3872 n2279 n2280 60.799999999999997
r3873 n2162 n2281 1.3999999999999999
r3874 n2280 n2281 54.399999999999999
r3875 n2163 n2282 22.399999999999999
r3876 n2281 n2282 54.399999999999999
r3877 n2164 n2283 1.2444444444444445
r3878 n2282 n2283 60.799999999999997
r3879 n2165 n2284 22.399999999999999
r3880 n2283 n2284 60.799999999999997
r3881 n2166 n2285 1.3999999999999999
r3882 n2284 n2285 54.399999999999999
r3883 n2167 n2286 22.399999999999999
r3884 n2285 n2286 54.399999999999999
r3885 n2168 n2287 3.7333333333333334
r3886 n2286 n2287 22.399999999999999
r3887 n2169 n2288 11.199999999999999
r3888 n2287 n2288 25.600000000000001
r3889 n2174 n2289 1.3176470588235294
r3890 n2175 n2290 1.3176470588235294
r3891 n2176 n2291 11.199999999999999
r3892 n2177 n2292 4.4800000000000004
r3893 n2291 n2292 29.866666666666667
r3894 n2178 n2293 22.399999999999999
r3895 n2292 n2293 25.600000000000001
r3896 n2179 n2294 1.3999999999999999
r3897 n2293 n2294 72.533333333333331
r3898 n2180 n2295 22.399999999999999
r3899 n2294 n2295 72.533333333333331
r3900 n2181 n2296 1.2444444444444445
r3901 n2295 n2296 81.066666666666663
r3902 n2182 n2297 22.399999999999999
r3903 n2296 n2297 81.066666666666663
r3904 n2183 n2298 3.4461538461538463
r3905 n2297 n2298 32
r3906 n2184 n2299 3.7333333333333334
r3907 n2298 n2299 53.333333333333336
r3908 n2185 n2300 6.4000000000000004
r3909 n2299 n2300 40.533333333333331
r3910 n2186 n2301 22.399999999999999
r3911 n2300 n2301 19.199999999999999
r3912 n2187 n2302 11.199999999999999
r3913 n2301 n2302 12.800000000000001
r3914 n2188 n2303 4.9777777777777779
r3915 n2302 n2303 27.733333333333334
r3916 n2189 n2304 2.1333333333333333
r3917 n2303 n2304 64
r3918 n2190 n2305 22.399999999999999
r3919 n2304 n2305 49.06666666666667
r3920 n2191 n2306 22.399999999999999
r3921 n2305 n2306 8.5333333333333332
r3922 n2192 n2307 4.9777777777777779
r3923 n2306 n2307 23.466666666666665
r3924 n2193 n2308 3.7333333333333334
r3925 n2307 n2308 44.799999999999997
r3926 n2194 n2309 4.9777777777777779
r3927 n2308 n2309 44.799999999999997
r3928 n2195 n2310 22.399999999999999
r3929 n2309 n2310 23.466666666666665
r3930 n2196 n2311 22.399999999999999
r3931 n2310 n2311 8.5333333333333332
r3932 n2197 n2312 2.1333333333333333
r3933 n2311 n2312 49.06666666666667
r3934 n2198 n2313 2.9866666666666668
r3935 n2312 n2313 76.799999999999997
r3936 n2199 n2314 22.399999999999999
r3937 n2313 n2314 36.266666666666666
r3938 n2200 n2315 1.3999999999999999
r3939 n2314 n2315 72.533333333333331
r3940 n2201 n2316 22.399999999999999
r3941 n2315 n2316 72.533333333333331
r3942 n2202 n2317 3.7333333333333334
r3943 n2316 n2317 29.866666666666667
r3944 n2203 n2318 11.199999999999999
r3945 n2317 n2318 34.133333333333333
r3946 n2204 n2319 1.3176470588235294
r3947 n2205 n2320 1.3176470588235294
r3948 n2206 n2321 11.199999999999999
r3949 n2207 n2322 4.4800000000000004
r3950 n2321 n2322 29.866666666666667
r3951 n2208 n2323 22.399999999999999
r3952 n2322 n2323 25.600000000000001
r3953 n2209 n2324 1.3999999999999999
r3954 n2323 n2324 72.533333333333331
r3955 n2210 n2325 22.399999999999999
r3956 n2324 n2325 72.533333333333331
r3957 n2211 n2326 1.2444444444444445
r3958 n2325 n2326 81.066666666666663
r3959 n2212 n2327 22.399999999999999
r3960 n2326 n2327 81.066666666666663
r3961 n2213 n2328 1.3999999999999999
r3962 n2327 n2328 72.533333333333331
r3963 n2214 n2329 22.399999999999999
r3964 n2328 n2329 72.533333333333331
r3965 n2215 n2330 1.2444444444444445
r3966 n2329 n2330 81.066666666666663
r3967 n2216 n2331 22.399999999999999
r3968 n2330 n2331 81.066666666666663
r3969 n2217 n2332 1.3999999999999999
r3970 n2331 n2332 72.533333333333331
r3971 n2218 n2333 22.399999999999999
r3972 n2332 n2333 72.533333333333331
r3973 n2219 n2334 1.2444444444444445
r3974 n2333 n2334 81.066666666666663
r3975 n2220 n2335 22.399999999999999
r3976 n2334 n2335 81.066666666666663
r3977 n2221 n2336 1.3999999999999999
r3978 n2335 n2336 72.533333333333331
r3979 n2222 n2337 22.399999999999999
r3980 n2336 n2337 72.533333333333331
r3981 n2223 n2338 1.2444444444444445
r3982 n2337 n2338 81.066666666666663
r3983 n2224 n2339 22.399999999999999
r3984 n2338 n2339 81.066666666666663
r3985 n2225 n2340 1.3999999999999999
r3986 n2339 n2340 72.533333333333331
r3987 n2226 n2341 22.399999999999999
r3988 n2340 n2341 72.533333333333331
r3989 n2227 n2342 1.2444444444444445
r3990 n2341 n2342 81.066666666666663
r3991 n2228 n2343 22.399999999999999
r3992 n2342 n2343 81.066666666666663
r3993 n2229 n2344 1.3999999999999999
r3994 n2343 n2344 72.533333333333331
r3995 n2230 n2345 22.399999999999999
r3996 n2344 n2345 72.533333333333331
r3997 n2231 n2346 1.2444444444444445
r3998 n2345 n2346 81.066666666666663
r3999 n2232 n2347 22.399999999999999
r4000 n2346 n2347 81.066666666666663
r4001 n2233 n2348 1.3999999999999999
r4002 n2347 n2348 72.533333333333331
r4003 n2234 n2349 22.399999999999999
r4004 n2348 n2349 72.533333333333331
r4005 n2235 n2350 1.2444444444444445
r4006 n2349 n2350 81.066666666666663
r4007 n2236 n2351 22.399999999999999
r4008 n2350 n2351 81.066666666666663
r4009 n2237 n2352 1.3999999999999999
r4010 n2351 n2352 72.533333333333331
r4011 n2238 n2353 22.399999999999999
r4012 n2352 n2353 72.533333333333331
r4013 n2239 n2354 2.9866666666666668
r4014 n2353 n2354 36.266666666666666
r4015 n2240 n2355 3.7333333333333334
r4016 n2354 n2355 57.600000000000001
r4017 n2241 n2356 4.9777777777777779
r4018 n2355 n2356 44.799999999999997
r4019 n2242 n2357 22.399999999999999
r4020 n2356 n2357 23.466666666666665
r4021 n2243 n2358 22.399999999999999
r4022 n2357 n2358 8.5333333333333332
r4023 n2244 n2359 5.5999999999999996
r4024 n2358 n2359 21.333333333333332
r4025 n2245 n2360 2.0363636363636362
r4026 n2359 n2360 64
r4027 n2246 n2361 44.799999999999997
r4028 n2360 n2361 49.06666666666667
r4029 n2247 n2362 44.799999999999997
r4030 n2361 n2362 4.2666666666666666
r4031 n2248 n2363 44.799999999999997
r4032 n2362 n2363 4.2666666666666666
r4033 n2249 n2364 4.4800000000000004
r4034 n2363 n2364 23.466666666666665
r4035 n2250 n2365 3.7333333333333334
r4036 n2364 n2365 46.93333333333333
r4037 n2251 n2366 5.5999999999999996
r4038 n2365 n2366 42.666666666666664
r4039 n2252 n2367 22.399999999999999
r4040 n2366 n2367 21.333333333333332
r4041 n2253 n2368 14.933333333333334
r4042 n2367 n2368 10.666666666666666
r4043 n2254 n2369 22.399999999999999
r4044 n2368 n2369 10.666666666666666
r4045 n2255 n2370 7.4666666666666668
r4046 n2369 n2370 17.066666666666666
r4047 n2256 n2371 3.7333333333333334
r4048 n2370 n2371 38.399999999999999
r4049 n2257 n2372 3.2000000000000002
r4050 n2371 n2372 55.466666666666669
r4051 n2258 n2373 22.399999999999999
r4052 n2372 n2373 34.133333333333333
r4053 n2259 n2374 1.2444444444444445
r4054 n2373 n2374 81.066666666666663
r4055 n2260 n2375 22.399999999999999
r4056 n2374 n2375 81.066666666666663
r4057 n2261 n2376 1.3999999999999999
r4058 n2375 n2376 72.533333333333331
r4059 n2262 n2377 22.399999999999999
r4060 n2376 n2377 72.533333333333331
r4061 n2263 n2378 1.2444444444444445
r4062 n2377 n2378 81.066666666666663
r4063 n2264 n2379 22.399999999999999
r4064 n2378 n2379 81.066666666666663
r4065 n2265 n2380 1.3999999999999999
r4066 n2379 n2380 72.533333333333331
r4067 n2266 n2381 22.399999999999999
r4068 n2380 n2381 72.533333333333331
r4069 n2267 n2382 1.2444444444444445
r4070 n2381 n2382 81.066666666666663
r4071 n2268 n2383 22.399999999999999
r4072 n2382 n2383 81.066666666666663
r4073 n2269 n2384 1.3999999999999999
r4074 n2383 n2384 72.533333333333331
r4075 n2270 n2385 22.399999999999999
r4076 n2384 n2385 72.533333333333331
r4077 n2271 n2386 1.2444444444444445
r4078 n2385 n2386 81.066666666666663
r4079 n2272 n2387 22.399999999999999
r4080 n2386 n2387 81.066666666666663
r4081 n2273 n2388 1.3999999999999999
r4082 n2387 n2388 72.533333333333331
r4083 n2274 n2389 22.399999999999999
r4084 n2388 n2389 72.533333333333331
r4085 n2275 n2390 1.2444444444444445
r4086 n2389 n2390 81.066666666666663
r4087 n2276 n2391 22.399999999999999
r4088 n2390 n2391 81.066666666666663
r4089 n2277 n2392 1.3999999999999999
r4090 n2391 n2392 72.533333333333331
r4091 n2278 n2393 22.399999999999999
r4092 n2392 n2393 72.533333333333331
r4093 n2279 n2394 1.2444444444444445
r4094 n2393 n2394 81.066666666666663
r4095 n2280 n2395 22.399999999999999
r4096 n2394 n2395 81.066666666666663
r4097 n2281 n2396 1.3999999999999999
r4098 n2395 n2396 72.533333333333331
r4099 n2282 n2397 22.399999999999999
r4100 n2396 n2397 72.533333333333331
r4101 n2283 n2398 1.2444444444444445
r4102 n2397 n2398 81.066666666666663
r4103 n2284 n2399 22.399999999999999
r4104 n2398 n2399 81.066666666666663
r4105 n2285 n2400 1.3999999999999999
r4106 n2399 n2400 72.533333333333331
r4107 n2286 n2401 22.399999999999999
r4108 n2400 n2401 72.533333333333331
r4109 n2287 n2402 3.7333333333333334
r4110 n2401 n2402 29.866666666666667
r4111 n2288 n2403 11.199999999999999
r4112 n2402 n2403 34.133333333333333
r4113 n2289 n2404 1.3176470588235294
r4114 n2290 n2405 3.388235294117647
r4115 n2291 n2406 28.800000000000001
r4116 n2292 n2407 11.52
r4117 n2406 n2407 5.9733333333333336
r4118 n2293 n2408 57.600000000000001
r4119 n2407 n2408 5.1200000000000001
r4120 n2294 n2409 3.6000000000000001
r4121 n2408 n2409 14.506666666666666
r4122 n2295 n2410 57.600000000000001
r4123 n2409 n2410 14.506666666666666
r4124 n2296 n2411 3.2000000000000002
r4125 n2410 n2411 16.213333333333335
r4126 n2297 n2412 57.600000000000001
r4127 n2411 n2412 16.213333333333335
r4128 n2298 n2413 8.861538461538462
r4129 n2412 n2413 6.4000000000000004
r4130 n2299 n2414 9.5999999999999996
r4131 n2413 n2414 10.666666666666666
r4132 n2300 n2415 16.457142857142856
r4133 n2414 n2415 8.1066666666666674
r4134 n2301 n2416 57.600000000000001
r4135 n2415 n2416 3.8399999999999999
r4136 n2302 n2417 28.800000000000001
r4137 n2416 n2417 2.5600000000000001
r4138 n2303 n2418 12.800000000000001
r4139 n2417 n2418 5.5466666666666669
r4140 n2304 n2419 5.4857142857142858
r4141 n2418 n2419 12.800000000000001
r4142 n2305 n2420 57.600000000000001
r4143 n2419 n2420 9.8133333333333326
r4144 n2306 n2421 57.600000000000001
r4145 n2420 n2421 1.7066666666666668
r4146 n2307 n2422 12.800000000000001
r4147 n2421 n2422 4.6933333333333334
r4148 n2308 n2423 9.5999999999999996
r4149 n2422 n2423 8.9600000000000009
r4150 n2309 n2424 12.800000000000001
r4151 n2423 n2424 8.9600000000000009
r4152 n2310 n2425 57.600000000000001
r4153 n2424 n2425 4.6933333333333334
r4154 n2311 n2426 57.600000000000001
r4155 n2425 n2426 1.7066666666666668
r4156 n2312 n2427 5.4857142857142858
r4157 n2426 n2427 9.8133333333333326
r4158 n2313 n2428 7.6799999999999997
r4159 n2427 n2428 15.359999999999999
r4160 n2314 n2429 57.600000000000001
r4161 n2428 n2429 7.253333333333333
r4162 n2315 n2430 3.6000000000000001
r4163 n2429 n2430 14.506666666666666
r4164 n2316 n2431 57.600000000000001
r4165 n2430 n2431 14.506666666666666
r4166 n2317 n2432 9.5999999999999996
r4167 n2431 n2432 5.9733333333333336
r4168 n2318 n2433 28.800000000000001
r4169 n2432 n2433 6.8266666666666671
r4170 n2319 n2434 3.388235294117647
r4171 n2320 n2435 3.388235294117647
r4172 n2321 n2436 28.800000000000001
r4173 n2322 n2437 11.52
r4174 n2436 n2437 5.9733333333333336
r4175 n2323 n2438 57.600000000000001
r4176 n2437 n2438 5.1200000000000001
r4177 n2324 n2439 3.6000000000000001
r4178 n2438 n2439 14.506666666666666
r4179 n2325 n2440 57.600000000000001
r4180 n2439 n2440 14.506666666666666
r4181 n2326 n2441 3.2000000000000002
r4182 n2440 n2441 16.213333333333335
r4183 n2327 n2442 57.600000000000001
r4184 n2441 n2442 16.213333333333335
r4185 n2328 n2443 3.6000000000000001
r4186 n2442 n2443 14.506666666666666
r4187 n2329 n2444 57.600000000000001
r4188 n2443 n2444 14.506666666666666
r4189 n2330 n2445 3.2000000000000002
r4190 n2444 n2445 16.213333333333335
r4191 n2331 n2446 57.600000000000001
r4192 n2445 n2446 16.213333333333335
r4193 n2332 n2447 3.6000000000000001
r4194 n2446 n2447 14.506666666666666
r4195 n2333 n2448 57.600000000000001
r4196 n2447 n2448 14.506666666666666
r4197 n2334 n2449 3.2000000000000002
r4198 n2448 n2449 16.213333333333335
r4199 n2335 n2450 57.600000000000001
r4200 n2449 n2450 16.213333333333335
r4201 n2336 n2451 3.6000000000000001
r4202 n2450 n2451 14.506666666666666
r4203 n2337 n2452 57.600000000000001
r4204 n2451 n2452 14.506666666666666
r4205 n2338 n2453 3.2000000000000002
r4206 n2452 n2453 16.213333333333335
r4207 n2339 n2454 57.600000000000001
r4208 n2453 n2454 16.213333333333335
r4209 n2340 n2455 3.6000000000000001
r4210 n2454 n2455 14.506666666666666
r4211 n2341 n2456 57.600000000000001
r4212 n2455 n2456 14.506666666666666
r4213 n2342 n2457 3.2000000000000002
r4214 n2456 n2457 16.213333333333335
r4215 n2343 n2458 57.600000000000001
r4216 n2457 n2458 16.213333333333335
r4217 n2344 n2459 3.6000000000000001
r4218 n2458 n2459 14.506666666666666
r4219 n2345 n2460 57.600000000000001
r4220 n2459 n2460 14.506666666666666
r4221 n2346 n2461 3.2000000000000002
r4222 n2460 n2461 16.213333333333335
r4223 n2347 n2462 57.600000000000001
r4224 n2461 n2462 16.213333333333335
r4225 n2348 n2463 3.6000000000000001
r4226 n2462 n2463 14.506666666666666
r4227 n2349 n2464 57.600000000000001
r4228 n2463 n2464 14.506666666666666
r4229 n2350 n2465 3.2000000000000002
r4230 n2464 n2465 16.213333333333335
r4231 n2351 n2466 57.600000000000001
r4232 n2465 n2466 16.213333333333335
r4233 n2352 n2467 3.6000000000000001
r4234 n2466 n2467 14.506666666666666
r4235 n2353 n2468 57.600000000000001
r4236 n2467 n2468 14.506666666666666
r4237 n2354 n2469 7.6799999999999997
r4238 n2468 n2469 7.253333333333333
r4239 n2355 n2470 9.5999999999999996
r4240 n2469 n2470 11.52
r4241 n2356 n2471 12.800000000000001
r4242 n2470 n2471 8.9600000000000009
r4243 n2357 n2472 57.600000000000001
r4244 n2471 n2472 4.6933333333333334
r4245 n2358 n2473 57.600000000000001
r4246 n2472 n2473 1.7066666666666668
r4247 n2359 n2474 14.4
r4248 n2473 n2474 4.2666666666666666
r4249 n2360 n2475 5.2363636363636363
r4250 n2474 n2475 12.800000000000001
r4251 n2361 n2476 115.2
r4252 n2475 n2476 9.8133333333333326
r4253 n2362 n2477 115.2
r4254 n2476 n2477 0.85333333333333339
r4255 n2363 n2478 115.2
r4256 n2477 n2478 0.85333333333333339
r4257 n2364 n2479 11.52
r4258 n2478 n2479 4.6933333333333334
r4259 n2365 n2480 9.5999999999999996
r4260 n2479 n2480 9.3866666666666667
r4261 n2366 n2481 14.4
r4262 n2480 n2481 8.5333333333333332
r4263 n2367 n2482 57.600000000000001
r4264 n2481 n2482 4.2666666666666666
r4265 n2368 n2483 38.399999999999999
r4266 n2482 n2483 2.1333333333333333
r4267 n2369 n2484 57.600000000000001
r4268 n2483 n2484 2.1333333333333333
r4269 n2370 n2485 19.199999999999999
r4270 n2484 n2485 3.4133333333333336
r4271 n2371 n2486 9.5999999999999996
r4272 n2485 n2486 7.6799999999999997
r4273 n2372 n2487 8.2285714285714278
r4274 n2486 n2487 11.093333333333334
r4275 n2373 n2488 57.600000000000001
r4276 n2487 n2488 6.8266666666666671
r4277 n2374 n2489 3.2000000000000002
r4278 n2488 n2489 16.213333333333335
r4279 n2375 n2490 57.600000000000001
r4280 n2489 n2490 16.213333333333335
r4281 n2376 n2491 3.6000000000000001
r4282 n2490 n2491 14.506666666666666
r4283 n2377 n2492 57.600000000000001
r4284 n2491 n2492 14.506666666666666
r4285 n2378 n2493 3.2000000000000002
r4286 n2492 n2493 16.213333333333335
r4287 n2379 n2494 57.600000000000001
r4288 n2493 n2494 16.213333333333335
r4289 n2380 n2495 3.6000000000000001
r4290 n2494 n2495 14.506666666666666
r4291 n2381 n2496 57.600000000000001
r4292 n2495 n2496 14.506666666666666
r4293 n2382 n2497 3.2000000000000002
r4294 n2496 n2497 16.213333333333335
r4295 n2383 n2498 57.600000000000001
r4296 n2497 n2498 16.213333333333335
r4297 n2384 n2499 3.6000000000000001
r4298 n2498 n2499 14.506666666666666
r4299 n2385 n2500 57.600000000000001
r4300 n2499 n2500 14.506666666666666
r4301 n2386 n2501 3.2000000000000002
r4302 n2500 n2501 16.213333333333335
r4303 n2387 n2502 57.600000000000001
r4304 n2501 n2502 16.213333333333335
r4305 n2388 n2503 3.6000000000000001
r4306 n2502 n2503 14.506666666666666
r4307 n2389 n2504 57.600000000000001
r4308 n2503 n2504 14.506666666666666
r4309 n2390 n2505 3.2000000000000002
r4310 n2504 n2505 16.213333333333335
r4311 n2391 n2506 57.600000000000001
r4312 n2505 n2506 16.213333333333335
r4313 n2392 n2507 3.6000000000000001
r4314 n2506 n2507 14.506666666666666
r4315 n2393 n2508 57.600000000000001
r4316 n2507 n2508 14.506666666666666
r4317 n2394 n2509 3.2000000000000002
r4318 n2508 n2509 16.213333333333335
r4319 n2395 n2510 57.600000000000001
r4320 n2509 n2510 16.213333333333335
r4321 n2396 n2511 3.6000000000000001
r4322 n2510 n2511 14.506666666666666
r4323 n2397 n2512 57.600000000000001
r4324 n2511 n2512 14.506666666666666
r4325 n2398 n2513 3.2000000000000002
r4326 n2512 n2513 16.213333333333335
r4327 n2399 n2514 57.600000000000001
r4328 n2513 n2514 16.213333333333335
r4329 n2400 n2515 3.6000000000000001
r4330 n2514 n2515 14.506666666666666
r4331 n2401 n2516 57.600000000000001
r4332 n2515 n2516 14.506666666666666
r4333 n2402 n2517 9.5999999999999996
r4334 n2516 n2517 5.9733333333333336
r4335 n2403 n2518 28.800000000000001
r4336 n2517 n2518 6.8266666666666671
r4337 n2404 n2519 3.388235294117647
r4338 n2405 n2520 3.7647058823529411
r4339 n2406 n2521 32
r4340 n2407 n2522 12.800000000000001
r4341 n2521 n2522 17.920000000000002
r4342 n2408 n2523 64
r4343 n2522 n2523 15.359999999999999
r4344 n2409 n2524 4
r4345 n2523 n2524 43.520000000000003
r4346 n2410 n2525 64
r4347 n2524 n2525 43.520000000000003
r4348 n2411 n2526 3.5555555555555554
r4349 n2525 n2526 48.640000000000001
r4350 n2412 n2527 64
r4351 n2526 n2527 48.640000000000001
r4352 n2413 n2528 9.8461538461538467
r4353 n2527 n2528 19.199999999999999
r4354 n2414 n2529 10.666666666666666
r4355 n2528 n2529 32
r4356 n2415 n2530 18.285714285714285
r4357 n2529 n2530 24.32
r4358 n2416 n2531 64
r4359 n2530 n2531 11.52
r4360 n2417 n2532 32
r4361 n2531 n2532 7.6799999999999997
r4362 n2418 n2533 14.222222222222221
r4363 n2532 n2533 16.640000000000001
r4364 n2419 n2534 6.0952380952380949
r4365 n2533 n2534 38.399999999999999
r4366 n2420 n2535 64
r4367 n2534 n2535 29.440000000000001
r4368 n2421 n2536 64
r4369 n2535 n2536 5.1200000000000001
r4370 n2422 n2537 14.222222222222221
r4371 n2536 n2537 14.08
r4372 n2423 n2538 10.666666666666666
r4373 n2537 n2538 26.879999999999999
r4374 n2424 n2539 14.222222222222221
r4375 n2538 n2539 26.879999999999999
r4376 n2425 n2540 64
r4377 n2539 n2540 14.08
r4378 n2426 n2541 64
r4379 n2540 n2541 5.1200000000000001
r4380 n2427 n2542 6.0952380952380949
r4381 n2541 n2542 29.440000000000001
r4382 n2428 n2543 8.5333333333333332
r4383 n2542 n2543 46.079999999999998
r4384 n2429 n2544 64
r4385 n2543 n2544 21.760000000000002
r4386 n2430 n2545 4
r4387 n2544 n2545 43.520000000000003
r4388 n2431 n2546 64
r4389 n2545 n2546 43.520000000000003
r4390 n2432 n2547 10.666666666666666
r4391 n2546 n2547 17.920000000000002
r4392 n2433 n2548 32
r4393 n2547 n2548 20.48
r4394 n2434 n2549 3.7647058823529411
r4395 n2435 n2550 3.7647058823529411
r4396 n2436 n2551 32
r4397 n2437 n2552 12.800000000000001
r4398 n2551 n2552 17.920000000000002
r4399 n2438 n2553 64
r4400 n2552 n2553 15.359999999999999
r4401 n2439 n2554 4
r4402 n2553 n2554 43.520000000000003
r4403 n2440 n2555 64
r4404 n2554 n2555 43.520000000000003
r4405 n2441 n2556 3.5555555555555554
r4406 n2555 n2556 48.640000000000001
r4407 n2442 n2557 64
r4408 n2556 n2557 48.640000000000001
r4409 n2443 n2558 4
r4410 n2557 n2558 43.520000000000003
r4411 n2444 n2559 64
r4412 n2558 n2559 43.520000000000003
r4413 n2445 n2560 3.5555555555555554
r4414 n2559 n2560 48.640000000000001
r4415 n2446 n2561 64
r4416 n2560 n2561 48.640000000000001
r4417 n2447 n2562 4
r4418 n2561 n2562 43.520000000000003
r4419 n2448 n2563 64
r4420 n2562 n2563 43.520000000000003
r4421 n2449 n2564 3.5555555555555554
r4422 n2563 n2564 48.640000000000001
r4423 n2450 n2565 64
r4424 n2564 n2565 48.640000000000001
r4425 n2451 n2566 4
r4426 n2565 n2566 43.520000000000003
r4427 n2452 n2567 64
r4428 n2566 n2567 43.520000000000003
r4429 n2453 n2568 3.5555555555555554
r4430 n2567 n2568 48.640000000000001
r4431 n2454 n2569 64
r4432 n2568 n2569 48.640000000000001
r4433 n2455 n2570 4
r4434 n2569 n2570 43.520000000000003
r4435 n2456 n2571 64
r4436 n2570 n2571 43.520000000000003
r4437 n2457 n2572 3.5555555555555554
r4438 n2571 n2572 48.640000000000001
r4439 n2458 n2573 64
r4440 n2572 n2573 48.640000000000001
r4441 n2459 n2574 4
r4442 n2573 n2574 43.520000000000003
r4443 n2460 n2575 64
r4444 n2574 n2575 43.520000000000003
r4445 n2461 n2576 3.5555555555555554
r4446 n2575 n2576 48.640000000000001
r4447 n2462 n2577 64
r4448 n2576 n2577 48.640000000000001
r4449 n2463 n2578 4
r4450 n2577 n2578 43.520000000000003
r4451 n2464 n2579 64
r4452 n2578 n2579 43.520000000000003
r4453 n2465 n2580 3.5555555555555554
r4454 n2579 n2580 48.640000000000001
r4455 n2466 n2581 64
r4456 n2580 n2581 48.640000000000001
r4457 n2467 n2582 4
r4458 n2581 n2582 43.520000000000003
r4459 n2468 n2583 64
r4460 n2582 n2583 43.520000000000003
r4461 n2469 n2584 8.5333333333333332
r4462 n2583 n2584 21.760000000000002
r4463 n2470 n2585 10.666666666666666
r4464 n2584 n2585 34.560000000000002
r4465 n2471 n2586 14.222222222222221
r4466 n2585 n2586 26.879999999999999
r4467 n2472 n2587 64
r4468 n2586 n2587 14.08
r4469 n2473 n2588 64
r4470 n2587 n2588 5.1200000000000001
r4471 n2474 n2589 16
r4472 n2588 n2589 12.800000000000001
r4473 n2475 n2590 5.8181818181818183
r4474 n2589 n2590 38.399999999999999
r4475 n2476 n2591 128
r4476 n2590 n2591 29.440000000000001
r4477 n2477 n2592 128
r4478 n2591 n2592 2.5600000000000001
r4479 n2478 n2593 128
r4480 n2592 n2593 2.5600000000000001
r4481 n2479 n2594 12.800000000000001
r4482 n2593 n2594 14.08
r4483 n2480 n2595 10.666666666666666
r4484 n2594 n2595 28.16
r4485 n2481 n2596 16
r4486 n2595 n2596 25.600000000000001
r4487 n2482 n2597 64
r4488 n2596 n2597 12.800000000000001
r4489 n2483 n2598 42.666666666666664
r4490 n2597 n2598 6.4000000000000004
r4491 n2484 n2599 64
r4492 n2598 n2599 6.4000000000000004
r4493 n2485 n2600 21.333333333333332
r4494 n2599 n2600 10.24
r4495 n2486 n2601 10.666666666666666
r4496 n2600 n2601 23.039999999999999
r4497 n2487 n2602 9.1428571428571423
r4498 n2601 n2602 33.280000000000001
r4499 n2488 n2603 64
r4500 n2602 n2603 20.48
r4501 n2489 n2604 3.5555555555555554
r4502 n2603 n2604 48.640000000000001
r4503 n2490 n2605 64
r4504 n2604 n2605 48.640000000000001
r4505 n2491 n2606 4
r4506 n2605 n2606 43.520000000000003
r4507 n2492 n2607 64
r4508 n2606 n2607 43.520000000000003
r4509 n2493 n2608 3.5555555555555554
r4510 n2607 n2608 48.640000000000001
r4511 n2494 n2609 64
r4512 n2608 n2609 48.640000000000001
r4513 n2495 n2610 4
r4514 n2609 n2610 43.520000000000003
r4515 n2496 n2611 64
r4516 n2610 n2611 43.520000000000003
r4517 n2497 n2612 3.5555555555555554
r4518 n2611 n2612 48.640000000000001
r4519 n2498 n2613 64
r4520 n2612 n2613 48.640000000000001
r4521 n2499 n2614 4
r4522 n2613 n2614 43.520000000000003
r4523 n2500 n2615 64
r4524 n2614 n2615 43.520000000000003
r4525 n2501 n2616 3.5555555555555554
r4526 n2615 n2616 48.640000000000001
r4527 n2502 n2617 64
r4528 n2616 n2617 48.640000000000001
r4529 n2503 n2618 4
r4530 n2617 n2618 43.520000000000003
r4531 n2504 n2619 64
r4532 n2618 n2619 43.520000000000003
r4533 n2505 n2620 3.5555555555555554
r4534 n2619 n2620 48.640000000000001
r4535 n2506 n2621 64
r4536 n2620 n2621 48.640000000000001
r4537 n2507 n2622 4
r4538 n2621 n2622 43.520000000000003
r4539 n2508 n2623 64
r4540 n2622 n2623 43.520000000000003
r4541 n2509 n2624 3.5555555555555554
r4542 n2623 n2624 48.640000000000001
r4543 n2510 n2625 64
r4544 n2624 n2625 48.640000000000001
r4545 n2511 n2626 4
r4546 n2625 n2626 43.520000000000003
r4547 n2512 n2627 64
r4548 n2626 n2627 43.520000000000003
r4549 n2513 n2628 3.5555555555555554
r4550 n2627 n2628 48.640000000000001
r4551 n2514 n2629 64
r4552 n2628 n2629 48.640000000000001
r4553 n2515 n2630 4
r4554 n2629 n2630 43.520000000000003
r4555 n2516 n2631 64
r4556 n2630 n2631 43.520000000000003
r4557 n2517 n2632 10.666666666666666
r4558 n2631 n2632 17.920000000000002
r4559 n2518 n2633 32
r4560 n2632 n2633 20.48
r4561 n2519 n2634 3.7647058823529411
r4562 n2520 n2635 1.3176470588235294
r4563 n2521 n2636 11.199999999999999
r4564 n2522 n2637 4.4800000000000004
r4565 n2636 n2637 44.799999999999997
r4566 n2523 n2638 22.399999999999999
r4567 n2637 n2638 38.399999999999999
r4568 n2524 n2639 1.3999999999999999
r4569 n2638 n2639 108.8
r4570 n2525 n2640 22.399999999999999
r4571 n2639 n2640 108.8
r4572 n2526 n2641 1.2444444444444445
r4573 n2640 n2641 121.59999999999999
r4574 n2527 n2642 22.399999999999999
r4575 n2641 n2642 121.59999999999999
r4576 n2528 n2643 3.4461538461538463
r4577 n2642 n2643 48
r4578 n2529 n2644 3.7333333333333334
r4579 n2643 n2644 80
r4580 n2530 n2645 6.4000000000000004
r4581 n2644 n2645 60.799999999999997
r4582 n2531 n2646 22.399999999999999
r4583 n2645 n2646 28.800000000000001
r4584 n2532 n2647 11.199999999999999
r4585 n2646 n2647 19.199999999999999
r4586 n2533 n2648 4.9777777777777779
r4587 n2647 n2648 41.600000000000001
r4588 n2534 n2649 2.1333333333333333
r4589 n2648 n2649 96
r4590 n2535 n2650 22.399999999999999
r4591 n2649 n2650 73.599999999999994
r4592 n2536 n2651 22.399999999999999
r4593 n2650 n2651 12.800000000000001
r4594 n2537 n2652 4.9777777777777779
r4595 n2651 n2652 35.200000000000003
r4596 n2538 n2653 3.7333333333333334
r4597 n2652 n2653 67.200000000000003
r4598 n2539 n2654 4.9777777777777779
r4599 n2653 n2654 67.200000000000003
r4600 n2540 n2655 22.399999999999999
r4601 n2654 n2655 35.200000000000003
r4602 n2541 n2656 22.399999999999999
r4603 n2655 n2656 12.800000000000001
r4604 n2542 n2657 2.1333333333333333
r4605 n2656 n2657 73.599999999999994
r4606 n2543 n2658 2.9866666666666668
r4607 n2657 n2658 115.2
r4608 n2544 n2659 22.399999999999999
r4609 n2658 n2659 54.399999999999999
r4610 n2545 n2660 1.3999999999999999
r4611 n2659 n2660 108.8
r4612 n2546 n2661 22.399999999999999
r4613 n2660 n2661 108.8
r4614 n2547 n2662 3.7333333333333334
r4615 n2661 n2662 44.799999999999997
r4616 n2548 n2663 11.199999999999999
r4617 n2662 n2663 51.200000000000003
r4618 n2549 n2664 1.3176470588235294
r4619 n2550 n2665 1.3176470588235294
r4620 n2551 n2666 11.199999999999999
r4621 n2552 n2667 4.4800000000000004
r4622 n2666 n2667 44.799999999999997
r4623 n2553 n2668 22.399999999999999
r4624 n2667 n2668 38.399999999999999
r4625 n2554 n2669 1.3999999999999999
r4626 n2668 n2669 108.8
r4627 n2555 n2670 22.399999999999999
r4628 n2669 n2670 108.8
r4629 n2556 n2671 1.2444444444444445
r4630 n2670 n2671 121.59999999999999
r4631 n2557 n2672 22.399999999999999
r4632 n2671 n2672 121.59999999999999
r4633 n2558 n2673 1.3999999999999999
r4634 n2672 n2673 108.8
r4635 n2559 n2674 22.399999999999999
r4636 n2673 n2674 108.8
r4637 n2560 n2675 1.2444444444444445
r4638 n2674 n2675 121.59999999999999
r4639 n2561 n2676 22.399999999999999
r4640 n2675 n2676 121.59999999999999
r4641 n2562 n2677 1.3999999999999999
r4642 n2676 n2677 108.8
r4643 n2563 n2678 22.399999999999999
r4644 n2677 n2678 108.8
r4645 n2564 n2679 1.2444444444444445
r4646 n2678 n2679 121.59999999999999
r4647 n2565 n2680 22.399999999999999
r4648 n2679 n2680 121.59999999999999
r4649 n2566 n2681 1.3999999999999999
r4650 n2680 n2681 108.8
r4651 n2567 n2682 22.399999999999999
r4652 n2681 n2682 108.8
r4653 n2568 n2683 1.2444444444444445
r4654 n2682 n2683 121.59999999999999
r4655 n2569 n2684 22.399999999999999
r4656 n2683 n2684 121.59999999999999
r4657 n2570 n2685 1.3999999999999999
r4658 n2684 n2685 108.8
r4659 n2571 n2686 22.399999999999999
r4660 n2685 n2686 108.8
r4661 n2572 n2687 1.2444444444444445
r4662 n2686 n2687 121.59999999999999
r4663 n2573 n2688 22.399999999999999
r4664 n2687 n2688 121.59999999999999
r4665 n2574 n2689 1.3999999999999999
r4666 n2688 n2689 108.8
r4667 n2575 n2690 22.399999999999999
r4668 n2689 n2690 108.8
r4669 n2576 n2691 1.2444444444444445
r4670 n2690 n2691 121.59999999999999
r4671 n2577 n2692 22.399999999999999
r4672 n2691 n2692 121.59999999999999
r4673 n2578 n2693 1.3999999999999999
r4674 n2692 n2693 108.8
r4675 n2579 n2694 22.399999999999999
r4676 n2693 n2694 108.8
r4677 n2580 n2695 1.2444444444444445
r4678 n2694 n2695 121.59999999999999
r4679 n2581 n2696 22.399999999999999
r4680 n2695 n2696 121.59999999999999
r4681 n2582 n2697 1.3999999999999999
r4682 n2696 n2697 108.8
r4683 n2583 n2698 22.399999999999999
r4684 n2697 n2698 108.8
r4685 n2584 n2699 2.9866666666666668
r4686 n2698 n2699 54.399999999999999
r4687 n2585 n2700 3.7333333333333334
r4688 n2699 n2700 86.400000000000006
r4689 n2586 n2701 4.9777777777777779
r4690 n2700 n2701 67.200000000000003
r4691 n2587 n2702 22.399999999999999
r4692 n2701 n2702 35.200000000000003
r4693 n2588 n2703 22.399999999999999
r4694 n2702 n2703 12.800000000000001
r4695 n2589 n2704 5.5999999999999996
r4696 n2703 n2704 32
r4697 n2590 n2705 2.0363636363636362
r4698 n2704 n2705 96
r4699 n2591 n2706 44.799999999999997
r4700 n2705 n2706 73.599999999999994
r4701 n2592 n2707 44.799999999999997
r4702 n2706 n2707 6.4000000000000004
r4703 n2593 n2708 44.799999999999997
r4704 n2707 n2708 6.4000000000000004
r4705 n2594 n2709 4.4800000000000004
r4706 n2708 n2709 35.200000000000003
r4707 n2595 n2710 3.7333333333333334
r4708 n2709 n2710 70.400000000000006
r4709 n2596 n2711 5.5999999999999996
r4710 n2710 n2711 64
r4711 n2597 n2712 22.399999999999999
r4712 n2711 n2712 32
r4713 n2598 n2713 14.933333333333334
r4714 n2712 n2713 16
r4715 n2599 n2714 22.399999999999999
r4716 n2713 n2714 16
r4717 n2600 n2715 7.4666666666666668
r4718 n2714 n2715 25.600000000000001
r4719 n2601 n2716 3.7333333333333334
r4720 n2715 n2716 57.600000000000001
r4721 n2602 n2717 3.2000000000000002
r4722 n2716 n2717 83.200000000000003
r4723 n2603 n2718 22.399999999999999
r4724 n2717 n2718 51.200000000000003
r4725 n2604 n2719 1.2444444444444445
r4726 n2718 n2719 121.59999999999999
r4727 n2605 n2720 22.399999999999999
r4728 n2719 n2720 121.59999999999999
r4729 n2606 n2721 1.3999999999999999
r4730 n2720 n2721 108.8
r4731 n2607 n2722 22.399999999999999
r4732 n2721 n2722 108.8
r4733 n2608 n2723 1.2444444444444445
r4734 n2722 n2723 121.59999999999999
r4735 n2609 n2724 22.399999999999999
r4736 n2723 n2724 121.59999999999999
r4737 n2610 n2725 1.3999999999999999
r4738 n2724 n2725 108.8
r4739 n2611 n2726 22.399999999999999
r4740 n2725 n2726 108.8
r4741 n2612 n2727 1.2444444444444445
r4742 n2726 n2727 121.59999999999999
r4743 n2613 n2728 22.399999999999999
r4744 n2727 n2728 121.59999999999999
r4745 n2614 n2729 1.3999999999999999
r4746 n2728 n2729 108.8
r4747 n2615 n2730 22.399999999999999
r4748 n2729 n2730 108.8
r4749 n2616 n2731 1.2444444444444445
r4750 n2730 n2731 121.59999999999999
r4751 n2617 n2732 22.399999999999999
r4752 n2731 n2732 121.59999999999999
r4753 n2618 n2733 1.3999999999999999
r4754 n2732 n2733 108.8
r4755 n2619 n2734 22.399999999999999
r4756 n2733 n2734 108.8
r4757 n2620 n2735 1.2444444444444445
r4758 n2734 n2735 121.59999999999999
r4759 n2621 n2736 22.399999999999999
r4760 n2735 n2736 121.59999999999999
r4761 n2622 n2737 1.3999999999999999
r4762 n2736 n2737 108.8
r4763 n2623 n2738 22.399999999999999
r4764 n2737 n2738 108.8
r4765 n2624 n2739 1.2444444444444445
r4766 n2738 n2739 121.59999999999999
r4767 n2625 n2740 22.399999999999999
r4768 n2739 n2740 121.59999999999999
r4769 n2626 n2741 1.3999999999999999
r4770 n2740 n2741 108.8
r4771 n2627 n2742 22.399999999999999
r4772 n2741 n2742 108.8
r4773 n2628 n2743 1.2444444444444445
r4774 n2742 n2743 121.59999999999999
r4775 n2629 n2744 22.399999999999999
r4776 n2743 n2744 121.59999999999999
r4777 n2630 n2745 1.3999999999999999
r4778 n2744 n2745 108.8
r4779 n2631 n2746 22.399999999999999
r4780 n2745 n2746 108.8
r4781 n2632 n2747 3.7333333333333334
r4782 n2746 n2747 44.799999999999997
r4783 n2633 n2748 11.199999999999999
r4784 n2747 n2748 51.200000000000003
r4785 n2634 n2749 1.3176470588235294
r4786 n2635 n2750 1.5058823529411764
r4787 n2664 n2751 1.5058823529411764
r4788 n2665 n2752 1.5058823529411764
r4789 n2749 n2753 1.5058823529411764
r4790 n2750 n2754 2.447058823529412
r4791 n2751 n2755 2.447058823529412
r4792 n2752 n2756 2.447058823529412
r4793 n2753 n2757 2.447058823529412
r4794 n2754 n2758 3.9529411764705884
r4795 n2755 n2759 3.9529411764705884
r4796 n2756 n2760 3.9529411764705884
r4797 n2757 n2761 3.9529411764705884
r4798 n2758 n2762 9.7129411764705882
r4799 n2759 n2763 9.7129411764705882
r4800 n2760 n2764 9.7129411764705882
r4801 n2761 n2765 9.7129411764705882
r4802 n2762 n2766 14.117647058823529
r4803 n2763 n2767 14.117647058823529
r4804 n2764 n2768 14.117647058823529
r4805 n2765 n2769 14.117647058823529
r4806 n2766 n2770 13.440000000000001
r4807 n2770 n2771 12.235294117647058
r4808 n2771 n2772 11.670588235294117
r4809 n2772 n2773 12.235294117647058
r4810 n2773 n2774 10.91764705882353
r4811 n2774 n2775 5.2705882352941176
r4812 n2775 n2776 2.6352941176470588
r4813 n2776 n2777 2.2588235294117647
r4814 n2777 n2778 6.4000000000000004
r4815 n2778 n2779 6.4000000000000004
r4816 n2779 n2780 7.1529411764705886
r4817 n2780 n2781 7.1529411764705886
r4818 n2781 n2782 2.8235294117647061
r4819 n2782 n2783 4.7058823529411766
r4820 n2783 n2784 3.5764705882352943
r4821 n2784 n2785 1.6941176470588235
r4822 n2785 n2786 1.1294117647058823
r4823 n2786 n2787 2.447058823529412
r4824 n2787 n2788 5.6470588235294121
r4825 n2788 n2789 4.3294117647058821
r4826 n2789 n2790 0.75294117647058822
r4827 n2790 n2791 2.0705882352941178
r4828 n2791 n2792 3.9529411764705884
r4829 n2792 n2793 3.9529411764705884
r4830 n2793 n2794 2.0705882352941178
r4831 n2794 n2795 0.75294117647058822
r4832 n2795 n2796 4.3294117647058821
r4833 n2796 n2797 6.776470588235294
r4834 n2797 n2798 3.2000000000000002
r4835 n2798 n2799 6.4000000000000004
r4836 n2799 n2800 6.4000000000000004
r4837 n2800 n2801 2.6352941176470588
r4838 n2801 n2802 3.0117647058823529
r4839 n2802 n2803 4.5176470588235293
r4840 n2803 n2804 10.164705882352941
r4841 n2804 n2805 7.341176470588235
r4842 n2805 n2806 2.8235294117647061
r4843 n2806 n2807 3.2000000000000002
r4844 n2807 n2808 1.8823529411764706
r4845 n2808 n2809 1.1294117647058823
r4846 n2809 n2810 0.94117647058823528
r4847 n2810 n2811 1.8823529411764706
r4848 n2811 n2812 5.6470588235294121
r4849 n2812 n2813 4.5176470588235293
r4850 n2813 n2814 0.94117647058823528
r4851 n2814 n2815 1.1294117647058823
r4852 n2815 n2816 1.3176470588235294
r4853 n2816 n2817 1.3176470588235294
r4854 n2817 n2818 2.447058823529412
r4855 n2818 n2819 11.105882352941176
r4856 n2767 n2820 13.440000000000001
r4857 n2819 n2820 15.623529411764705
r4858 n2768 n2821 13.440000000000001
r4859 n2821 n2822 12.047058823529412
r4860 n2822 n2823 11.294117647058824
r4861 n2823 n2824 12.047058823529412
r4862 n2824 n2825 10.91764705882353
r4863 n2825 n2826 5.2705882352941176
r4864 n2826 n2827 2.6352941176470588
r4865 n2827 n2828 2.2588235294117647
r4866 n2828 n2829 6.4000000000000004
r4867 n2829 n2830 6.4000000000000004
r4868 n2830 n2831 7.1529411764705886
r4869 n2831 n2832 7.1529411764705886
r4870 n2832 n2833 6.4000000000000004
r4871 n2833 n2834 6.4000000000000004
r4872 n2834 n2835 7.1529411764705886
r4873 n2835 n2836 7.1529411764705886
r4874 n2836 n2837 6.4000000000000004
r4875 n2837 n2838 6.4000000000000004
r4876 n2838 n2839 7.1529411764705886
r4877 n2839 n2840 7.1529411764705886
r4878 n2840 n2841 6.4000000000000004
r4879 n2841 n2842 6.4000000000000004
r4880 n2842 n2843 7.1529411764705886
r4881 n2843 n2844 7.1529411764705886
r4882 n2844 n2845 6.4000000000000004
r4883 n2845 n2846 6.4000000000000004
r4884 n2846 n2847 7.1529411764705886
r4885 n2847 n2848 7.1529411764705886
r4886 n2848 n2849 6.4000000000000004
r4887 n2849 n2850 6.4000000000000004
r4888 n2850 n2851 7.1529411764705886
r4889 n2851 n2852 7.1529411764705886
r4890 n2852 n2853 6.4000000000000004
r4891 n2853 n2854 6.4000000000000004
r4892 n2854 n2855 7.1529411764705886
r4893 n2855 n2856 7.1529411764705886
r4894 n2856 n2857 6.4000000000000004
r4895 n2857 n2858 6.4000000000000004
r4896 n2858 n2859 3.2000000000000002
r4897 n2859 n2860 5.0823529411764703
r4898 n2860 n2861 3.9529411764705884
r4899 n2861 n2862 2.0705882352941178
r4900 n2862 n2863 0.75294117647058822
r4901 n2863 n2864 1.8823529411764706
r4902 n2864 n2865 5.6470588235294121
r4903 n2865 n2866 4.3294117647058821
r4904 n2866 n2867 0.37647058823529411
r4905 n2867 n2868 0.37647058823529411
r4906 n2868 n2869 2.0705882352941178
r4907 n2869 n2870 4.1411764705882357
r4908 n2870 n2871 3.7647058823529411
r4909 n2871 n2872 1.8823529411764706
r4910 n2872 n2873 0.94117647058823528
r4911 n2873 n2874 0.94117647058823528
r4912 n2874 n2875 1.5058823529411764
r4913 n2875 n2876 3.388235294117647
r4914 n2876 n2877 4.8941176470588239
r4915 n2877 n2878 3.0117647058823529
r4916 n2878 n2879 7.1529411764705886
r4917 n2879 n2880 7.1529411764705886
r4918 n2880 n2881 6.4000000000000004
r4919 n2881 n2882 6.4000000000000004
r4920 n2882 n2883 7.1529411764705886
r4921 n2883 n2884 7.1529411764705886
r4922 n2884 n2885 6.4000000000000004
r4923 n2885 n2886 6.4000000000000004
r4924 n2886 n2887 7.1529411764705886
r4925 n2887 n2888 7.1529411764705886
r4926 n2888 n2889 6.4000000000000004
r4927 n2889 n2890 6.4000000000000004
r4928 n2890 n2891 7.1529411764705886
r4929 n2891 n2892 7.1529411764705886
r4930 n2892 n2893 6.4000000000000004
r4931 n2893 n2894 6.4000000000000004
r4932 n2894 n2895 7.1529411764705886
r4933 n2895 n2896 7.1529411764705886
r4934 n2896 n2897 6.4000000000000004
r4935 n2897 n2898 6.4000000000000004
r4936 n2898 n2899 7.1529411764705886
r4937 n2899 n2900 7.1529411764705886
r4938 n2900 n2901 6.4000000000000004
r4939 n2901 n2902 6.4000000000000004
r4940 n2902 n2903 7.1529411764705886
r4941 n2903 n2904 7.1529411764705886
r4942 n2904 n2905 6.4000000000000004
r4943 n2905 n2906 6.4000000000000004
r4944 n2906 n2907 2.6352941176470588
r4945 n2907 n2908 3.0117647058823529
r4946 n2908 n2909 4.5176470588235293
r4947 n2909 n2910 10.164705882352941
r4948 n2910 n2911 6.776470588235294
r4949 n2911 n2912 2.2588235294117647
r4950 n2912 n2913 3.2000000000000002
r4951 n2913 n2914 1.8823529411764706
r4952 n2914 n2915 1.1294117647058823
r4953 n2915 n2916 0.94117647058823528
r4954 n2916 n2917 2.447058823529412
r4955 n2917 n2918 5.6470588235294121
r4956 n2918 n2919 3.9529411764705884
r4957 n2919 n2920 0.94117647058823528
r4958 n2920 n2921 1.1294117647058823
r4959 n2921 n2922 1.8823529411764706
r4960 n2922 n2923 3.2000000000000002
r4961 n2923 n2924 11.105882352941176
r4962 n2769 n2925 13.440000000000001
r4963 n2924 n2925 15.623529411764705
r4964 n2986 n2987 0.029069767441860465
r4965 n2987 n2988 0.047965116279069769
r4966 n2988 n2989 0.036337209302325583
r4967 n2989 n2990 0.046511627906976744
r4968 n2990 n2991 0.046511627906976744
r4969 n2991 n2992 0.036337209302325583
r4970 n2992 n2993 0.047965116279069769
r4971 n2993 n2994 0.029069767441860465
r4972 n2995 n2996 0.029069767441860465
r4973 n2996 n2997 0.042151162790697673
r4974 n2997 n2998 0.033430232558139532
r4975 n2998 n2999 0.0087209302325581394
r4976 n2999 n3000 0.046511627906976744
r4977 n3000 n3001 0.046511627906976744
r4978 n3001 n3002 0.0087209302325581394
r4979 n3002 n3003 0.033430232558139532
r4980 n3003 n3004 0.042151162790697673
r4981 n3004 n3005 0.029069767441860465
r4982 n2986 n3006 0.48125000000000001
r4983 n2987 n3007 0.48125000000000001
r4984 n3006 n3007 0.036764705882352942
r4985 n2988 n3008 0.20923913043478262
r4986 n3007 n3008 0.060661764705882353
r4987 n2989 n3009 2.40625
r4988 n3008 n3009 0.04595588235294118
r4989 n2990 n3010 0.16041666666666668
r4990 n3009 n3010 0.058823529411764705
r4991 n2991 n3011 2.40625
r4992 n3010 n3011 0.058823529411764705
r4993 n2992 n3012 0.20923913043478262
r4994 n3011 n3012 0.04595588235294118
r4995 n2993 n3013 0.48125000000000001
r4996 n3012 n3013 0.060661764705882353
r4997 n2994 n3014 0.48125000000000001
r4998 n3013 n3014 0.036764705882352942
r4999 n2995 n3015 0.48125000000000001
r5000 n2996 n3016 0.48125000000000001
r5001 n3015 n3016 0.036764705882352942
r5002 n2997 n3017 0.25328947368421051
r5003 n3016 n3017 0.053308823529411763
r5004 n2998 n3018 1.203125
r5005 n3017 n3018 0.042279411764705885
r5006 n2999 n3019 2.40625
r5007 n3018 n3019 0.011029411764705883
r5008 n3000 n3020 0.16041666666666668
r5009 n3019 n3020 0.058823529411764705
r5010 n3001 n3021 2.40625
r5011 n3020 n3021 0.058823529411764705
r5012 n3002 n3022 1.203125
r5013 n3021 n3022 0.011029411764705883
r5014 n3003 n3023 0.25328947368421051
r5015 n3022 n3023 0.042279411764705885
r5016 n3004 n3024 0.48125000000000001
r5017 n3023 n3024 0.053308823529411763
r5018 n3005 n3025 0.48125000000000001
r5019 n3024 n3025 0.036764705882352942
r5020 n3006 n3026 0.48125000000000001
r5021 n3007 n3027 0.48125000000000001
r5022 n3026 n3027 0.029069767441860465
r5023 n3008 n3028 0.20923913043478262
r5024 n3027 n3028 0.047965116279069769
r5025 n3009 n3029 2.40625
r5026 n3028 n3029 0.036337209302325583
r5027 n3010 n3030 0.16041666666666668
r5028 n3029 n3030 0.046511627906976744
r5029 n3011 n3031 2.40625
r5030 n3030 n3031 0.046511627906976744
r5031 n3012 n3032 0.20923913043478262
r5032 n3031 n3032 0.036337209302325583
r5033 n3013 n3033 0.48125000000000001
r5034 n3032 n3033 0.047965116279069769
r5035 n3014 n3034 0.48125000000000001
r5036 n3033 n3034 0.029069767441860465
r5037 n3015 n3035 0.48125000000000001
r5038 n3016 n3036 0.48125000000000001
r5039 n3035 n3036 0.029069767441860465
r5040 n3017 n3037 0.25328947368421051
r5041 n3036 n3037 0.042151162790697673
r5042 n3018 n3038 1.203125
r5043 n3037 n3038 0.033430232558139532
r5044 n3019 n3039 2.40625
r5045 n3038 n3039 0.0087209302325581394
r5046 n3020 n3040 0.16041666666666668
r5047 n3039 n3040 0.046511627906976744
r5048 n3021 n3041 2.40625
r5049 n3040 n3041 0.046511627906976744
r5050 n3022 n3042 1.203125
r5051 n3041 n3042 0.0087209302325581394
r5052 n3023 n3043 0.25328947368421051
r5053 n3042 n3043 0.033430232558139532
r5054 n3024 n3044 0.48125000000000001
r5055 n3043 n3044 0.042151162790697673
r5056 n3025 n3045 0.48125000000000001
r5057 n3044 n3045 0.029069767441860465
r5058 n3028 n3046 0.22554347826086957
r5059 n3029 n3047 2.59375
r5060 n3046 n3047 0.0390625
r5061 n3030 n3048 0.17291666666666666
r5062 n3047 n3048 0.050000000000000003
r5063 n3031 n3049 2.59375
r5064 n3048 n3049 0.050000000000000003
r5065 n3032 n3050 0.22554347826086957
r5066 n3049 n3050 0.0390625
r5067 n3037 n3051 0.27302631578947367
r5068 n3038 n3052 1.296875
r5069 n3051 n3052 0.035937499999999997
r5070 n3039 n3053 2.59375
r5071 n3052 n3053 0.0093749999999999997
r5072 n3040 n3054 0.17291666666666666
r5073 n3053 n3054 0.050000000000000003
r5074 n3041 n3055 2.59375
r5075 n3054 n3055 0.050000000000000003
r5076 n3042 n3056 1.296875
r5077 n3055 n3056 0.0093749999999999997
r5078 n3043 n3057 0.27302631578947367
r5079 n3056 n3057 0.035937499999999997
r5080 n3046 n3058 0.21739130434782608
r5081 n3047 n3059 2.5
r5082 n3058 n3059 0.0390625
r5083 n3048 n3060 0.16666666666666666
r5084 n3059 n3060 0.050000000000000003
r5085 n3049 n3061 2.5
r5086 n3060 n3061 0.050000000000000003
r5087 n3050 n3062 0.21739130434782608
r5088 n3061 n3062 0.0390625
r5089 n3051 n3063 0.26315789473684209
r5090 n3052 n3064 1.25
r5091 n3063 n3064 0.035937499999999997
r5092 n3053 n3065 2.5
r5093 n3064 n3065 0.0093749999999999997
r5094 n3054 n3066 0.16666666666666666
r5095 n3065 n3066 0.050000000000000003
r5096 n3055 n3067 2.5
r5097 n3066 n3067 0.050000000000000003
r5098 n3056 n3068 1.25
r5099 n3067 n3068 0.0093749999999999997
r5100 n3057 n3069 0.26315789473684209
r5101 n3068 n3069 0.035937499999999997
r5102 n3058 n3070 0.23097826086956522
r5103 n3059 n3071 2.65625
r5104 n3070 n3071 0.034722222222222224
r5105 n3060 n3072 0.17708333333333334
r5106 n3071 n3072 0.044444444444444446
r5107 n3061 n3073 2.65625
r5108 n3072 n3073 0.044444444444444446
r5109 n3062 n3074 0.23097826086956522
r5110 n3073 n3074 0.034722222222222224
r5111 n3063 n3075 0.27960526315789475
r5112 n3064 n3076 1.328125
r5113 n3075 n3076 0.031944444444444442
r5114 n3065 n3077 2.65625
r5115 n3076 n3077 0.0083333333333333332
r5116 n3066 n3078 0.17708333333333334
r5117 n3077 n3078 0.044444444444444446
r5118 n3067 n3079 2.65625
r5119 n3078 n3079 0.044444444444444446
r5120 n3068 n3080 1.328125
r5121 n3079 n3080 0.0083333333333333332
r5122 n3069 n3081 0.27960526315789475
r5123 n3080 n3081 0.031944444444444442
r5124 n3070 n3082 0.20380434782608695
r5125 n3071 n3083 2.34375
r5126 n3082 n3083 0.052083333333333336
r5127 n3072 n3084 0.15625
r5128 n3083 n3084 0.066666666666666666
r5129 n3073 n3085 2.34375
r5130 n3084 n3085 0.066666666666666666
r5131 n3074 n3086 0.20380434782608695
r5132 n3085 n3086 0.052083333333333336
r5133 n3075 n3087 0.24671052631578946
r5134 n3076 n3088 1.171875
r5135 n3087 n3088 0.04791666666666667
r5136 n3077 n3089 2.34375
r5137 n3088 n3089 0.012500000000000001
r5138 n3078 n3090 0.15625
r5139 n3089 n3090 0.066666666666666666
r5140 n3079 n3091 2.34375
r5141 n3090 n3091 0.066666666666666666
r5142 n3080 n3092 1.171875
r5143 n3091 n3092 0.012500000000000001
r5144 n3081 n3093 0.24671052631578946
r5145 n3092 n3093 0.04791666666666667
r5146 n3082 n3094 0.14945652173913043
r5147 n3083 n3095 1.71875
r5148 n3094 n3095 0.0625
r5149 n3084 n3096 0.11458333333333333
r5150 n3095 n3096 0.080000000000000002
r5151 n3085 n3097 1.71875
r5152 n3096 n3097 0.080000000000000002
r5153 n3086 n3098 0.14945652173913043
r5154 n3097 n3098 0.0625
r5155 n3087 n3099 0.18092105263157895
r5156 n3088 n3100 0.859375
r5157 n3099 n3100 0.057500000000000002
r5158 n3089 n3101 1.71875
r5159 n3100 n3101 0.014999999999999999
r5160 n3090 n3102 0.11458333333333333
r5161 n3101 n3102 0.080000000000000002
r5162 n3091 n3103 1.71875
r5163 n3102 n3103 0.080000000000000002
r5164 n3092 n3104 0.859375
r5165 n3103 n3104 0.014999999999999999
r5166 n3093 n3105 0.18092105263157895
r5167 n3104 n3105 0.057500000000000002
r5168 n3106 n3107 0.71875
r5169 n3107 n3108 0.125
r5170 n3108 n3109 0.34375
r5171 n3109 n3110 0.65625
r5172 n3110 n3111 0.65625
r5173 n3111 n3112 0.34375
r5174 n3112 n3113 0.125
r5175 n3113 n3114 0.71875
r5176 n3115 n3116 0.71875
r5177 n3116 n3117 0.0625
r5178 n3117 n3118 0.0625
r5179 n3118 n3119 0.34375
r5180 n3119 n3120 0.6875
r5181 n3120 n3121 0.625
r5182 n3121 n3122 0.3125
r5183 n3122 n3123 0.15625
r5184 n3123 n3124 0.15625
r5185 n3124 n3125 0.25
r5186 n3125 n3126 0.5625
r5187 n3106 n3127 0.038690476190476192
r5188 n3107 n3128 0.40625
r5189 n3127 n3128 0.13068181818181818
r5190 n3108 n3129 0.40625
r5191 n3128 n3129 0.022727272727272728
r5192 n3109 n3130 0.090277777777777776
r5193 n3129 n3130 0.0625
r5194 n3110 n3131 0.067708333333333329
r5195 n3130 n3131 0.11931818181818182
r5196 n3111 n3132 0.090277777777777776
r5197 n3131 n3132 0.11931818181818182
r5198 n3112 n3133 0.40625
r5199 n3132 n3133 0.0625
r5200 n3113 n3134 0.40625
r5201 n3133 n3134 0.022727272727272728
r5202 n3114 n3135 0.038690476190476192
r5203 n3134 n3135 0.13068181818181818
r5204 n3115 n3136 0.036931818181818184
r5205 n3116 n3137 0.8125
r5206 n3136 n3137 0.13068181818181818
r5207 n3117 n3138 0.8125
r5208 n3137 n3138 0.011363636363636364
r5209 n3118 n3139 0.8125
r5210 n3138 n3139 0.011363636363636364
r5211 n3119 n3140 0.081250000000000003
r5212 n3139 n3140 0.0625
r5213 n3120 n3141 0.067708333333333329
r5214 n3140 n3141 0.125
r5215 n3121 n3142 0.1015625
r5216 n3141 n3142 0.11363636363636363
r5217 n3122 n3143 0.40625
r5218 n3142 n3143 0.056818181818181816
r5219 n3123 n3144 0.27083333333333331
r5220 n3143 n3144 0.028409090909090908
r5221 n3124 n3145 0.40625
r5222 n3144 n3145 0.028409090909090908
r5223 n3125 n3146 0.13541666666666666
r5224 n3145 n3146 0.045454545454545456
r5225 n3126 n3147 0.067708333333333329
r5226 n3146 n3147 0.10227272727272728
r5227 n3127 n3148 0.038690476190476192
r5228 n3128 n3149 0.40625
r5229 n3148 n3149 0.71875
r5230 n3129 n3150 0.40625
r5231 n3149 n3150 0.125
r5232 n3130 n3151 0.090277777777777776
r5233 n3150 n3151 0.34375
r5234 n3131 n3152 0.067708333333333329
r5235 n3151 n3152 0.65625
r5236 n3132 n3153 0.090277777777777776
r5237 n3152 n3153 0.65625
r5238 n3133 n3154 0.40625
r5239 n3153 n3154 0.34375
r5240 n3134 n3155 0.40625
r5241 n3154 n3155 0.125
r5242 n3135 n3156 0.038690476190476192
r5243 n3155 n3156 0.71875
r5244 n3136 n3157 0.036931818181818184
r5245 n3137 n3158 0.8125
r5246 n3157 n3158 0.71875
r5247 n3138 n3159 0.8125
r5248 n3158 n3159 0.0625
r5249 n3139 n3160 0.8125
r5250 n3159 n3160 0.0625
r5251 n3140 n3161 0.081250000000000003
r5252 n3160 n3161 0.34375
r5253 n3141 n3162 0.067708333333333329
r5254 n3161 n3162 0.6875
r5255 n3142 n3163 0.1015625
r5256 n3162 n3163 0.625
r5257 n3143 n3164 0.40625
r5258 n3163 n3164 0.3125
r5259 n3144 n3165 0.27083333333333331
r5260 n3164 n3165 0.15625
r5261 n3145 n3166 0.40625
r5262 n3165 n3166 0.15625
r5263 n3146 n3167 0.13541666666666666
r5264 n3166 n3167 0.25
r5265 n3147 n3168 0.067708333333333329
r5266 n3167 n3168 0.5625
r5267 n3148 n3169 0.095238095238095233
r5268 n3149 n3170 1
r5269 n3169 n3170 0.04791666666666667
r5270 n3150 n3171 1
r5271 n3170 n3171 0.0083333333333333332
r5272 n3151 n3172 0.22222222222222221
r5273 n3171 n3172 0.022916666666666665
r5274 n3152 n3173 0.16666666666666666
r5275 n3172 n3173 0.043749999999999997
r5276 n3153 n3174 0.22222222222222221
r5277 n3173 n3174 0.043749999999999997
r5278 n3154 n3175 1
r5279 n3174 n3175 0.022916666666666665
r5280 n3155 n3176 1
r5281 n3175 n3176 0.0083333333333333332
r5282 n3156 n3177 0.095238095238095233
r5283 n3176 n3177 0.04791666666666667
r5284 n3157 n3178 0.090909090909090912
r5285 n3158 n3179 2
r5286 n3178 n3179 0.04791666666666667
r5287 n3159 n3180 2
r5288 n3179 n3180 0.0041666666666666666
r5289 n3160 n3181 2
r5290 n3180 n3181 0.0041666666666666666
r5291 n3161 n3182 0.20000000000000001
r5292 n3181 n3182 0.022916666666666665
r5293 n3162 n3183 0.16666666666666666
r5294 n3182 n3183 0.04583333333333333
r5295 n3163 n3184 0.25
r5296 n3183 n3184 0.041666666666666664
r5297 n3164 n3185 1
r5298 n3184 n3185 0.020833333333333332
r5299 n3165 n3186 0.66666666666666663
r5300 n3185 n3186 0.010416666666666666
r5301 n3166 n3187 1
r5302 n3186 n3187 0.010416666666666666
r5303 n3167 n3188 0.33333333333333331
r5304 n3187 n3188 0.016666666666666666
r5305 n3168 n3189 0.16666666666666666
r5306 n3188 n3189 0.037499999999999999
r5307 n3169 n3190 0.095238095238095233
r5308 n3170 n3191 1
r5309 n3190 n3191 0.71875
r5310 n3171 n3192 1
r5311 n3191 n3192 0.125
r5312 n3172 n3193 0.22222222222222221
r5313 n3192 n3193 0.34375
r5314 n3173 n3194 0.16666666666666666
r5315 n3193 n3194 0.65625
r5316 n3174 n3195 0.22222222222222221
r5317 n3194 n3195 0.65625
r5318 n3175 n3196 1
r5319 n3195 n3196 0.34375
r5320 n3176 n3197 1
r5321 n3196 n3197 0.125
r5322 n3177 n3198 0.095238095238095233
r5323 n3197 n3198 0.71875
r5324 n3178 n3199 0.090909090909090912
r5325 n3179 n3200 2
r5326 n3199 n3200 0.71875
r5327 n3180 n3201 2
r5328 n3200 n3201 0.0625
r5329 n3181 n3202 2
r5330 n3201 n3202 0.0625
r5331 n3182 n3203 0.20000000000000001
r5332 n3202 n3203 0.34375
r5333 n3183 n3204 0.16666666666666666
r5334 n3203 n3204 0.6875
r5335 n3184 n3205 0.25
r5336 n3204 n3205 0.625
r5337 n3185 n3206 1
r5338 n3205 n3206 0.3125
r5339 n3186 n3207 0.66666666666666663
r5340 n3206 n3207 0.15625
r5341 n3187 n3208 1
r5342 n3207 n3208 0.15625
r5343 n3188 n3209 0.33333333333333331
r5344 n3208 n3209 0.25
r5345 n3189 n3210 0.16666666666666666
r5346 n3209 n3210 0.5625
r5347 n3190 n3211 0.038690476190476192
r5348 n3191 n3212 0.40625
r5349 n3211 n3212 0.13068181818181818
r5350 n3192 n3213 0.40625
r5351 n3212 n3213 0.022727272727272728
r5352 n3193 n3214 0.090277777777777776
r5353 n3213 n3214 0.0625
r5354 n3194 n3215 0.067708333333333329
r5355 n3214 n3215 0.11931818181818182
r5356 n3195 n3216 0.090277777777777776
r5357 n3215 n3216 0.11931818181818182
r5358 n3196 n3217 0.40625
r5359 n3216 n3217 0.0625
r5360 n3197 n3218 0.40625
r5361 n3217 n3218 0.022727272727272728
r5362 n3198 n3219 0.038690476190476192
r5363 n3218 n3219 0.13068181818181818
r5364 n3199 n3220 0.036931818181818184
r5365 n3200 n3221 0.8125
r5366 n3220 n3221 0.13068181818181818
r5367 n3201 n3222 0.8125
r5368 n3221 n3222 0.011363636363636364
r5369 n3202 n3223 0.8125
r5370 n3222 n3223 0.011363636363636364
r5371 n3203 n3224 0.081250000000000003
r5372 n3223 n3224 0.0625
r5373 n3204 n3225 0.067708333333333329
r5374 n3224 n3225 0.125
r5375 n3205 n3226 0.1015625
r5376 n3225 n3226 0.11363636363636363
r5377 n3206 n3227 0.40625
r5378 n3226 n3227 0.056818181818181816
r5379 n3207 n3228 0.27083333333333331
r5380 n3227 n3228 0.028409090909090908
r5381 n3208 n3229 0.40625
r5382 n3228 n3229 0.028409090909090908
r5383 n3209 n3230 0.13541666666666666
r5384 n3229 n3230 0.045454545454545456
r5385 n3210 n3231 0.067708333333333329
r5386 n3230 n3231 0.10227272727272728
r5387 n3211 n3232 0.038690476190476192
r5388 n3212 n3233 0.40625
r5389 n3232 n3233 0.71875
r5390 n3213 n3234 0.40625
r5391 n3233 n3234 0.125
r5392 n3214 n3235 0.090277777777777776
r5393 n3234 n3235 0.34375
r5394 n3215 n3236 0.067708333333333329
r5395 n3235 n3236 0.65625
r5396 n3216 n3237 0.090277777777777776
r5397 n3236 n3237 0.65625
r5398 n3217 n3238 0.40625
r5399 n3237 n3238 0.34375
r5400 n3218 n3239 0.40625
r5401 n3238 n3239 0.125
r5402 n3219 n3240 0.038690476190476192
r5403 n3239 n3240 0.71875
r5404 n3220 n3241 0.036931818181818184
r5405 n3221 n3242 0.8125
r5406 n3241 n3242 0.71875
r5407 n3222 n3243 0.8125
r5408 n3242 n3243 0.0625
r5409 n3223 n3244 0.8125
r5410 n3243 n3244 0.0625
r5411 n3224 n3245 0.081250000000000003
r5412 n3244 n3245 0.34375
r5413 n3225 n3246 0.067708333333333329
r5414 n3245 n3246 0.6875
r5415 n3226 n3247 0.1015625
r5416 n3246 n3247 0.625
r5417 n3227 n3248 0.40625
r5418 n3247 n3248 0.3125
r5419 n3228 n3249 0.27083333333333331
r5420 n3248 n3249 0.15625
r5421 n3229 n3250 0.40625
r5422 n3249 n3250 0.15625
r5423 n3230 n3251 0.13541666666666666
r5424 n3250 n3251 0.25
r5425 n3231 n3252 0.067708333333333329
r5426 n3251 n3252 0.5625
r5427 n3253 n3254 0.59375
r5428 n3254 n3255 0.28125
r5429 n3255 n3256 0.1875
r5430 n3256 n3257 0.40625
r5431 n3257 n3258 0.9375
r5432 n3258 n3259 0.71875
r5433 n3259 n3260 0.125
r5434 n3260 n3261 0.34375
r5435 n3261 n3262 0.65625
r5436 n3263 n3264 0.65625
r5437 n3264 n3265 0.34375
r5438 n3265 n3266 0.125
r5439 n3266 n3267 0.3125
r5440 n3267 n3268 0.9375
r5441 n3268 n3269 0.71875
r5442 n3269 n3270 0.0625
r5443 n3270 n3271 0.0625
r5444 n3271 n3272 0.34375
r5445 n3272 n3273 0.6875
r5446 n3253 n3274 0.036458333333333336
r5447 n3254 n3275 0.0625
r5448 n3274 n3275 0.23749999999999999
r5449 n3255 n3276 0.21875
r5450 n3275 n3276 0.1125
r5451 n3256 n3277 0.109375
r5452 n3276 n3277 0.074999999999999997
r5453 n3257 n3278 0.048611111111111112
r5454 n3277 n3278 0.16250000000000001
r5455 n3258 n3279 0.020833333333333332
r5456 n3278 n3279 0.375
r5457 n3259 n3280 0.21875
r5458 n3279 n3280 0.28749999999999998
r5459 n3260 n3281 0.21875
r5460 n3280 n3281 0.050000000000000003
r5461 n3261 n3282 0.048611111111111112
r5462 n3281 n3282 0.13750000000000001
r5463 n3262 n3283 0.036458333333333336
r5464 n3282 n3283 0.26250000000000001
r5465 n3263 n3284 0.036458333333333336
r5466 n3264 n3285 0.048611111111111112
r5467 n3284 n3285 0.26250000000000001
r5468 n3265 n3286 0.21875
r5469 n3285 n3286 0.13750000000000001
r5470 n3266 n3287 0.21875
r5471 n3286 n3287 0.050000000000000003
r5472 n3267 n3288 0.0546875
r5473 n3287 n3288 0.125
r5474 n3268 n3289 0.019886363636363636
r5475 n3288 n3289 0.375
r5476 n3269 n3290 0.4375
r5477 n3289 n3290 0.28749999999999998
r5478 n3270 n3291 0.4375
r5479 n3290 n3291 0.025000000000000001
r5480 n3271 n3292 0.4375
r5481 n3291 n3292 0.025000000000000001
r5482 n3272 n3293 0.043749999999999997
r5483 n3292 n3293 0.13750000000000001
r5484 n3273 n3294 0.036458333333333336
r5485 n3293 n3294 0.27500000000000002
r5486 n3295 n3296 0.125
r5487 n3296 n3297 0.35416666666666669
r5488 n3297 n3298 0.35416666666666669
r5489 n3298 n3299 0.39583333333333331
r5490 n3299 n3300 0.39583333333333331
r5491 n3300 n3301 0.15625
r5492 n3274 n3302 0.057291666666666664
r5493 n3301 n3302 0.26041666666666669
r5494 n3275 n3303 0.098214285714285712
r5495 n3302 n3303 0.19791666666666666
r5496 n3276 n3304 0.34375
r5497 n3303 n3304 0.09375
r5498 n3277 n3305 0.171875
r5499 n3304 n3305 0.0625
r5500 n3278 n3306 0.076388888888888895
r5501 n3305 n3306 0.13541666666666666
r5502 n3279 n3307 0.03273809523809524
r5503 n3306 n3307 0.3125
r5504 n3280 n3308 0.34375
r5505 n3307 n3308 0.23958333333333334
r5506 n3281 n3309 0.34375
r5507 n3308 n3309 0.041666666666666664
r5508 n3282 n3310 0.076388888888888895
r5509 n3309 n3310 0.11458333333333333
r5510 n3283 n3311 0.057291666666666664
r5511 n3310 n3311 0.21875
r5512 n3311 n3312 0.21875
r5513 n3312 n3313 0.11458333333333333
r5514 n3313 n3314 0.041666666666666664
r5515 n3314 n3315 0.23958333333333334
r5516 n3315 n3316 0.375
r5517 n3316 n3317 0.17708333333333334
r5518 n3317 n3318 0.35416666666666669
r5519 n3318 n3319 0.35416666666666669
r5520 n3319 n3320 0.14583333333333334
r5521 n3321 n3322 0.125
r5522 n3322 n3323 0.35416666666666669
r5523 n3323 n3324 0.35416666666666669
r5524 n3324 n3325 0.39583333333333331
r5525 n3325 n3326 0.39583333333333331
r5526 n3326 n3327 0.35416666666666669
r5527 n3327 n3328 0.35416666666666669
r5528 n3328 n3329 0.39583333333333331
r5529 n3329 n3330 0.39583333333333331
r5530 n3330 n3331 0.35416666666666669
r5531 n3331 n3332 0.35416666666666669
r5532 n3332 n3333 0.39583333333333331
r5533 n3333 n3334 0.39583333333333331
r5534 n3334 n3335 0.35416666666666669
r5535 n3335 n3336 0.35416666666666669
r5536 n3336 n3337 0.39583333333333331
r5537 n3337 n3338 0.39583333333333331
r5538 n3338 n3339 0.35416666666666669
r5539 n3339 n3340 0.35416666666666669
r5540 n3340 n3341 0.39583333333333331
r5541 n3341 n3342 0.39583333333333331
r5542 n3342 n3343 0.35416666666666669
r5543 n3343 n3344 0.35416666666666669
r5544 n3344 n3345 0.39583333333333331
r5545 n3345 n3346 0.39583333333333331
r5546 n3346 n3347 0.35416666666666669
r5547 n3347 n3348 0.35416666666666669
r5548 n3348 n3349 0.39583333333333331
r5549 n3349 n3350 0.39583333333333331
r5550 n3350 n3351 0.35416666666666669
r5551 n3351 n3352 0.35416666666666669
r5552 n3352 n3353 0.17708333333333334
r5553 n3284 n3354 0.057291666666666664
r5554 n3353 n3354 0.28125
r5555 n3285 n3355 0.076388888888888895
r5556 n3354 n3355 0.21875
r5557 n3286 n3356 0.34375
r5558 n3355 n3356 0.11458333333333333
r5559 n3287 n3357 0.34375
r5560 n3356 n3357 0.041666666666666664
r5561 n3288 n3358 0.0859375
r5562 n3357 n3358 0.10416666666666667
r5563 n3289 n3359 0.03125
r5564 n3358 n3359 0.3125
r5565 n3290 n3360 0.6875
r5566 n3359 n3360 0.23958333333333334
r5567 n3291 n3361 0.6875
r5568 n3360 n3361 0.020833333333333332
r5569 n3292 n3362 0.6875
r5570 n3361 n3362 0.020833333333333332
r5571 n3293 n3363 0.068750000000000006
r5572 n3362 n3363 0.11458333333333333
r5573 n3294 n3364 0.057291666666666664
r5574 n3363 n3364 0.22916666666666666
r5575 n3364 n3365 0.20833333333333334
r5576 n3365 n3366 0.10416666666666667
r5577 n3366 n3367 0.052083333333333336
r5578 n3367 n3368 0.052083333333333336
r5579 n3368 n3369 0.083333333333333329
r5580 n3369 n3370 0.1875
r5581 n3370 n3371 0.27083333333333331
r5582 n3371 n3372 0.16666666666666666
r5583 n3372 n3373 0.39583333333333331
r5584 n3373 n3374 0.39583333333333331
r5585 n3374 n3375 0.35416666666666669
r5586 n3375 n3376 0.35416666666666669
r5587 n3376 n3377 0.39583333333333331
r5588 n3377 n3378 0.39583333333333331
r5589 n3378 n3379 0.35416666666666669
r5590 n3379 n3380 0.35416666666666669
r5591 n3380 n3381 0.39583333333333331
r5592 n3381 n3382 0.39583333333333331
r5593 n3382 n3383 0.35416666666666669
r5594 n3383 n3384 0.35416666666666669
r5595 n3384 n3385 0.39583333333333331
r5596 n3385 n3386 0.39583333333333331
r5597 n3386 n3387 0.35416666666666669
r5598 n3387 n3388 0.35416666666666669
r5599 n3388 n3389 0.39583333333333331
r5600 n3389 n3390 0.39583333333333331
r5601 n3390 n3391 0.35416666666666669
r5602 n3391 n3392 0.35416666666666669
r5603 n3392 n3393 0.39583333333333331
r5604 n3393 n3394 0.39583333333333331
r5605 n3394 n3395 0.35416666666666669
r5606 n3395 n3396 0.35416666666666669
r5607 n3396 n3397 0.39583333333333331
r5608 n3397 n3398 0.39583333333333331
r5609 n3398 n3399 0.35416666666666669
r5610 n3399 n3400 0.35416666666666669
r5611 n3400 n3401 0.14583333333333334
r5612 n3295 n3402 0.050000000000000003
r5613 n3296 n3403 0.25
r5614 n3402 n3403 0.375
r5615 n3297 n3404 0.015625
r5616 n3403 n3404 1.0625
r5617 n3298 n3405 0.25
r5618 n3404 n3405 1.0625
r5619 n3299 n3406 0.013888888888888888
r5620 n3405 n3406 1.1875
r5621 n3300 n3407 0.25
r5622 n3406 n3407 1.1875
r5623 n3301 n3408 0.038461538461538464
r5624 n3407 n3408 0.46875
r5625 n3302 n3409 0.041666666666666664
r5626 n3408 n3409 0.78125
r5627 n3303 n3410 0.071428571428571425
r5628 n3409 n3410 0.59375
r5629 n3304 n3411 0.25
r5630 n3410 n3411 0.28125
r5631 n3305 n3412 0.125
r5632 n3411 n3412 0.1875
r5633 n3306 n3413 0.055555555555555552
r5634 n3412 n3413 0.40625
r5635 n3307 n3414 0.023809523809523808
r5636 n3413 n3414 0.9375
r5637 n3308 n3415 0.25
r5638 n3414 n3415 0.71875
r5639 n3309 n3416 0.25
r5640 n3415 n3416 0.125
r5641 n3310 n3417 0.055555555555555552
r5642 n3416 n3417 0.34375
r5643 n3311 n3418 0.041666666666666664
r5644 n3417 n3418 0.65625
r5645 n3312 n3419 0.055555555555555552
r5646 n3418 n3419 0.65625
r5647 n3313 n3420 0.25
r5648 n3419 n3420 0.34375
r5649 n3314 n3421 0.25
r5650 n3420 n3421 0.125
r5651 n3315 n3422 0.023809523809523808
r5652 n3421 n3422 0.71875
r5653 n3316 n3423 0.033333333333333333
r5654 n3422 n3423 1.125
r5655 n3317 n3424 0.25
r5656 n3423 n3424 0.53125
r5657 n3318 n3425 0.015625
r5658 n3424 n3425 1.0625
r5659 n3319 n3426 0.25
r5660 n3425 n3426 1.0625
r5661 n3320 n3427 0.041666666666666664
r5662 n3426 n3427 0.4375
r5663 n3321 n3428 0.050000000000000003
r5664 n3322 n3429 0.25
r5665 n3428 n3429 0.375
r5666 n3323 n3430 0.015625
r5667 n3429 n3430 1.0625
r5668 n3324 n3431 0.25
r5669 n3430 n3431 1.0625
r5670 n3325 n3432 0.013888888888888888
r5671 n3431 n3432 1.1875
r5672 n3326 n3433 0.25
r5673 n3432 n3433 1.1875
r5674 n3327 n3434 0.015625
r5675 n3433 n3434 1.0625
r5676 n3328 n3435 0.25
r5677 n3434 n3435 1.0625
r5678 n3329 n3436 0.013888888888888888
r5679 n3435 n3436 1.1875
r5680 n3330 n3437 0.25
r5681 n3436 n3437 1.1875
r5682 n3331 n3438 0.015625
r5683 n3437 n3438 1.0625
r5684 n3332 n3439 0.25
r5685 n3438 n3439 1.0625
r5686 n3333 n3440 0.013888888888888888
r5687 n3439 n3440 1.1875
r5688 n3334 n3441 0.25
r5689 n3440 n3441 1.1875
r5690 n3335 n3442 0.015625
r5691 n3441 n3442 1.0625
r5692 n3336 n3443 0.25
r5693 n3442 n3443 1.0625
r5694 n3337 n3444 0.013888888888888888
r5695 n3443 n3444 1.1875
r5696 n3338 n3445 0.25
r5697 n3444 n3445 1.1875
r5698 n3339 n3446 0.015625
r5699 n3445 n3446 1.0625
r5700 n3340 n3447 0.25
r5701 n3446 n3447 1.0625
r5702 n3341 n3448 0.013888888888888888
r5703 n3447 n3448 1.1875
r5704 n3342 n3449 0.25
r5705 n3448 n3449 1.1875
r5706 n3343 n3450 0.015625
r5707 n3449 n3450 1.0625
r5708 n3344 n3451 0.25
r5709 n3450 n3451 1.0625
r5710 n3345 n3452 0.013888888888888888
r5711 n3451 n3452 1.1875
r5712 n3346 n3453 0.25
r5713 n3452 n3453 1.1875
r5714 n3347 n3454 0.015625
r5715 n3453 n3454 1.0625
r5716 n3348 n3455 0.25
r5717 n3454 n3455 1.0625
r5718 n3349 n3456 0.013888888888888888
r5719 n3455 n3456 1.1875
r5720 n3350 n3457 0.25
r5721 n3456 n3457 1.1875
r5722 n3351 n3458 0.015625
r5723 n3457 n3458 1.0625
r5724 n3352 n3459 0.25
r5725 n3458 n3459 1.0625
r5726 n3353 n3460 0.033333333333333333
r5727 n3459 n3460 0.53125
r5728 n3354 n3461 0.041666666666666664
r5729 n3460 n3461 0.84375
r5730 n3355 n3462 0.055555555555555552
r5731 n3461 n3462 0.65625
r5732 n3356 n3463 0.25
r5733 n3462 n3463 0.34375
r5734 n3357 n3464 0.25
r5735 n3463 n3464 0.125
r5736 n3358 n3465 0.0625
r5737 n3464 n3465 0.3125
r5738 n3359 n3466 0.022727272727272728
r5739 n3465 n3466 0.9375
r5740 n3360 n3467 0.5
r5741 n3466 n3467 0.71875
r5742 n3361 n3468 0.5
r5743 n3467 n3468 0.0625
r5744 n3362 n3469 0.5
r5745 n3468 n3469 0.0625
r5746 n3363 n3470 0.050000000000000003
r5747 n3469 n3470 0.34375
r5748 n3364 n3471 0.041666666666666664
r5749 n3470 n3471 0.6875
r5750 n3365 n3472 0.0625
r5751 n3471 n3472 0.625
r5752 n3366 n3473 0.25
r5753 n3472 n3473 0.3125
r5754 n3367 n3474 0.16666666666666666
r5755 n3473 n3474 0.15625
r5756 n3368 n3475 0.25
r5757 n3474 n3475 0.15625
r5758 n3369 n3476 0.083333333333333329
r5759 n3475 n3476 0.25
r5760 n3370 n3477 0.041666666666666664
r5761 n3476 n3477 0.5625
r5762 n3371 n3478 0.035714285714285712
r5763 n3477 n3478 0.8125
r5764 n3372 n3479 0.25
r5765 n3478 n3479 0.5
r5766 n3373 n3480 0.013888888888888888
r5767 n3479 n3480 1.1875
r5768 n3374 n3481 0.25
r5769 n3480 n3481 1.1875
r5770 n3375 n3482 0.015625
r5771 n3481 n3482 1.0625
r5772 n3376 n3483 0.25
r5773 n3482 n3483 1.0625
r5774 n3377 n3484 0.013888888888888888
r5775 n3483 n3484 1.1875
r5776 n3378 n3485 0.25
r5777 n3484 n3485 1.1875
r5778 n3379 n3486 0.015625
r5779 n3485 n3486 1.0625
r5780 n3380 n3487 0.25
r5781 n3486 n3487 1.0625
r5782 n3381 n3488 0.013888888888888888
r5783 n3487 n3488 1.1875
r5784 n3382 n3489 0.25
r5785 n3488 n3489 1.1875
r5786 n3383 n3490 0.015625
r5787 n3489 n3490 1.0625
r5788 n3384 n3491 0.25
r5789 n3490 n3491 1.0625
r5790 n3385 n3492 0.013888888888888888
r5791 n3491 n3492 1.1875
r5792 n3386 n3493 0.25
r5793 n3492 n3493 1.1875
r5794 n3387 n3494 0.015625
r5795 n3493 n3494 1.0625
r5796 n3388 n3495 0.25
r5797 n3494 n3495 1.0625
r5798 n3389 n3496 0.013888888888888888
r5799 n3495 n3496 1.1875
r5800 n3390 n3497 0.25
r5801 n3496 n3497 1.1875
r5802 n3391 n3498 0.015625
r5803 n3497 n3498 1.0625
r5804 n3392 n3499 0.25
r5805 n3498 n3499 1.0625
r5806 n3393 n3500 0.013888888888888888
r5807 n3499 n3500 1.1875
r5808 n3394 n3501 0.25
r5809 n3500 n3501 1.1875
r5810 n3395 n3502 0.015625
r5811 n3501 n3502 1.0625
r5812 n3396 n3503 0.25
r5813 n3502 n3503 1.0625
r5814 n3397 n3504 0.013888888888888888
r5815 n3503 n3504 1.1875
r5816 n3398 n3505 0.25
r5817 n3504 n3505 1.1875
r5818 n3399 n3506 0.015625
r5819 n3505 n3506 1.0625
r5820 n3400 n3507 0.25
r5821 n3506 n3507 1.0625
r5822 n3401 n3508 0.041666666666666664
r5823 n3507 n3508 0.4375
r5824 n3402 n3509 0.043749999999999997
r5825 n3403 n3510 0.21875
r5826 n3509 n3510 0.14999999999999999
r5827 n3404 n3511 0.013671875
r5828 n3510 n3511 0.42499999999999999
r5829 n3405 n3512 0.21875
r5830 n3511 n3512 0.42499999999999999
r5831 n3406 n3513 0.012152777777777778
r5832 n3512 n3513 0.47499999999999998
r5833 n3407 n3514 0.21875
r5834 n3513 n3514 0.47499999999999998
r5835 n3408 n3515 0.033653846153846152
r5836 n3514 n3515 0.1875
r5837 n3409 n3516 0.036458333333333336
r5838 n3515 n3516 0.3125
r5839 n3410 n3517 0.0625
r5840 n3516 n3517 0.23749999999999999
r5841 n3411 n3518 0.21875
r5842 n3517 n3518 0.1125
r5843 n3412 n3519 0.109375
r5844 n3518 n3519 0.074999999999999997
r5845 n3413 n3520 0.048611111111111112
r5846 n3519 n3520 0.16250000000000001
r5847 n3414 n3521 0.020833333333333332
r5848 n3520 n3521 0.375
r5849 n3415 n3522 0.21875
r5850 n3521 n3522 0.28749999999999998
r5851 n3416 n3523 0.21875
r5852 n3522 n3523 0.050000000000000003
r5853 n3417 n3524 0.048611111111111112
r5854 n3523 n3524 0.13750000000000001
r5855 n3418 n3525 0.036458333333333336
r5856 n3524 n3525 0.26250000000000001
r5857 n3419 n3526 0.048611111111111112
r5858 n3525 n3526 0.26250000000000001
r5859 n3420 n3527 0.21875
r5860 n3526 n3527 0.13750000000000001
r5861 n3421 n3528 0.21875
r5862 n3527 n3528 0.050000000000000003
r5863 n3422 n3529 0.020833333333333332
r5864 n3528 n3529 0.28749999999999998
r5865 n3423 n3530 0.029166666666666667
r5866 n3529 n3530 0.45000000000000001
r5867 n3424 n3531 0.21875
r5868 n3530 n3531 0.21249999999999999
r5869 n3425 n3532 0.013671875
r5870 n3531 n3532 0.42499999999999999
r5871 n3426 n3533 0.21875
r5872 n3532 n3533 0.42499999999999999
r5873 n3427 n3534 0.036458333333333336
r5874 n3533 n3534 0.17499999999999999
r5875 n3428 n3535 0.043749999999999997
r5876 n3429 n3536 0.21875
r5877 n3535 n3536 0.14999999999999999
r5878 n3430 n3537 0.013671875
r5879 n3536 n3537 0.42499999999999999
r5880 n3431 n3538 0.21875
r5881 n3537 n3538 0.42499999999999999
r5882 n3432 n3539 0.012152777777777778
r5883 n3538 n3539 0.47499999999999998
r5884 n3433 n3540 0.21875
r5885 n3539 n3540 0.47499999999999998
r5886 n3434 n3541 0.013671875
r5887 n3540 n3541 0.42499999999999999
r5888 n3435 n3542 0.21875
r5889 n3541 n3542 0.42499999999999999
r5890 n3436 n3543 0.012152777777777778
r5891 n3542 n3543 0.47499999999999998
r5892 n3437 n3544 0.21875
r5893 n3543 n3544 0.47499999999999998
r5894 n3438 n3545 0.013671875
r5895 n3544 n3545 0.42499999999999999
r5896 n3439 n3546 0.21875
r5897 n3545 n3546 0.42499999999999999
r5898 n3440 n3547 0.012152777777777778
r5899 n3546 n3547 0.47499999999999998
r5900 n3441 n3548 0.21875
r5901 n3547 n3548 0.47499999999999998
r5902 n3442 n3549 0.013671875
r5903 n3548 n3549 0.42499999999999999
r5904 n3443 n3550 0.21875
r5905 n3549 n3550 0.42499999999999999
r5906 n3444 n3551 0.012152777777777778
r5907 n3550 n3551 0.47499999999999998
r5908 n3445 n3552 0.21875
r5909 n3551 n3552 0.47499999999999998
r5910 n3446 n3553 0.013671875
r5911 n3552 n3553 0.42499999999999999
r5912 n3447 n3554 0.21875
r5913 n3553 n3554 0.42499999999999999
r5914 n3448 n3555 0.012152777777777778
r5915 n3554 n3555 0.47499999999999998
r5916 n3449 n3556 0.21875
r5917 n3555 n3556 0.47499999999999998
r5918 n3450 n3557 0.013671875
r5919 n3556 n3557 0.42499999999999999
r5920 n3451 n3558 0.21875
r5921 n3557 n3558 0.42499999999999999
r5922 n3452 n3559 0.012152777777777778
r5923 n3558 n3559 0.47499999999999998
r5924 n3453 n3560 0.21875
r5925 n3559 n3560 0.47499999999999998
r5926 n3454 n3561 0.013671875
r5927 n3560 n3561 0.42499999999999999
r5928 n3455 n3562 0.21875
r5929 n3561 n3562 0.42499999999999999
r5930 n3456 n3563 0.012152777777777778
r5931 n3562 n3563 0.47499999999999998
r5932 n3457 n3564 0.21875
r5933 n3563 n3564 0.47499999999999998
r5934 n3458 n3565 0.013671875
r5935 n3564 n3565 0.42499999999999999
r5936 n3459 n3566 0.21875
r5937 n3565 n3566 0.42499999999999999
r5938 n3460 n3567 0.029166666666666667
r5939 n3566 n3567 0.21249999999999999
r5940 n3461 n3568 0.036458333333333336
r5941 n3567 n3568 0.33750000000000002
r5942 n3462 n3569 0.048611111111111112
r5943 n3568 n3569 0.26250000000000001
r5944 n3463 n3570 0.21875
r5945 n3569 n3570 0.13750000000000001
r5946 n3464 n3571 0.21875
r5947 n3570 n3571 0.050000000000000003
r5948 n3465 n3572 0.0546875
r5949 n3571 n3572 0.125
r5950 n3466 n3573 0.019886363636363636
r5951 n3572 n3573 0.375
r5952 n3467 n3574 0.4375
r5953 n3573 n3574 0.28749999999999998
r5954 n3468 n3575 0.4375
r5955 n3574 n3575 0.025000000000000001
r5956 n3469 n3576 0.4375
r5957 n3575 n3576 0.025000000000000001
r5958 n3470 n3577 0.043749999999999997
r5959 n3576 n3577 0.13750000000000001
r5960 n3471 n3578 0.036458333333333336
r5961 n3577 n3578 0.27500000000000002
r5962 n3472 n3579 0.0546875
r5963 n3578 n3579 0.25
r5964 n3473 n3580 0.21875
r5965 n3579 n3580 0.125
r5966 n3474 n3581 0.14583333333333334
r5967 n3580 n3581 0.0625
r5968 n3475 n3582 0.21875
r5969 n3581 n3582 0.0625
r5970 n3476 n3583 0.072916666666666671
r5971 n3582 n3583 0.10000000000000001
r5972 n3477 n3584 0.036458333333333336
r5973 n3583 n3584 0.22500000000000001
r5974 n3478 n3585 0.03125
r5975 n3584 n3585 0.32500000000000001
r5976 n3479 n3586 0.21875
r5977 n3585 n3586 0.20000000000000001
r5978 n3480 n3587 0.012152777777777778
r5979 n3586 n3587 0.47499999999999998
r5980 n3481 n3588 0.21875
r5981 n3587 n3588 0.47499999999999998
r5982 n3482 n3589 0.013671875
r5983 n3588 n3589 0.42499999999999999
r5984 n3483 n3590 0.21875
r5985 n3589 n3590 0.42499999999999999
r5986 n3484 n3591 0.012152777777777778
r5987 n3590 n3591 0.47499999999999998
r5988 n3485 n3592 0.21875
r5989 n3591 n3592 0.47499999999999998
r5990 n3486 n3593 0.013671875
r5991 n3592 n3593 0.42499999999999999
r5992 n3487 n3594 0.21875
r5993 n3593 n3594 0.42499999999999999
r5994 n3488 n3595 0.012152777777777778
r5995 n3594 n3595 0.47499999999999998
r5996 n3489 n3596 0.21875
r5997 n3595 n3596 0.47499999999999998
r5998 n3490 n3597 0.013671875
r5999 n3596 n3597 0.42499999999999999
r6000 n3491 n3598 0.21875
r6001 n3597 n3598 0.42499999999999999
r6002 n3492 n3599 0.012152777777777778
r6003 n3598 n3599 0.47499999999999998
r6004 n3493 n3600 0.21875
r6005 n3599 n3600 0.47499999999999998
r6006 n3494 n3601 0.013671875
r6007 n3600 n3601 0.42499999999999999
r6008 n3495 n3602 0.21875
r6009 n3601 n3602 0.42499999999999999
r6010 n3496 n3603 0.012152777777777778
r6011 n3602 n3603 0.47499999999999998
r6012 n3497 n3604 0.21875
r6013 n3603 n3604 0.47499999999999998
r6014 n3498 n3605 0.013671875
r6015 n3604 n3605 0.42499999999999999
r6016 n3499 n3606 0.21875
r6017 n3605 n3606 0.42499999999999999
r6018 n3500 n3607 0.012152777777777778
r6019 n3606 n3607 0.47499999999999998
r6020 n3501 n3608 0.21875
r6021 n3607 n3608 0.47499999999999998
r6022 n3502 n3609 0.013671875
r6023 n3608 n3609 0.42499999999999999
r6024 n3503 n3610 0.21875
r6025 n3609 n3610 0.42499999999999999
r6026 n3504 n3611 0.012152777777777778
r6027 n3610 n3611 0.47499999999999998
r6028 n3505 n3612 0.21875
r6029 n3611 n3612 0.47499999999999998
r6030 n3506 n3613 0.013671875
r6031 n3612 n3613 0.42499999999999999
r6032 n3507 n3614 0.21875
r6033 n3613 n3614 0.42499999999999999
r6034 n3508 n3615 0.036458333333333336
r6035 n3614 n3615 0.17499999999999999
r6036 n3509 n3616 0.125
r6037 n3510 n3617 0.625
r6038 n3616 n3617 0.050000000000000003
r6039 n3511 n3618 0.0390625
r6040 n3617 n3618 0.14166666666666666
r6041 n3512 n3619 0.625
r6042 n3618 n3619 0.14166666666666666
r6043 n3513 n3620 0.034722222222222224
r6044 n3619 n3620 0.15833333333333333
r6045 n3514 n3621 0.625
r6046 n3620 n3621 0.15833333333333333
r6047 n3515 n3622 0.096153846153846159
r6048 n3621 n3622 0.0625
r6049 n3516 n3623 0.10416666666666667
r6050 n3622 n3623 0.10416666666666667
r6051 n3517 n3624 0.17857142857142858
r6052 n3623 n3624 0.079166666666666663
r6053 n3518 n3625 0.625
r6054 n3624 n3625 0.037499999999999999
r6055 n3519 n3626 0.3125
r6056 n3625 n3626 0.025000000000000001
r6057 n3520 n3627 0.1388888888888889
r6058 n3626 n3627 0.054166666666666669
r6059 n3521 n3628 0.059523809523809521
r6060 n3627 n3628 0.125
r6061 n3522 n3629 0.625
r6062 n3628 n3629 0.09583333333333334
r6063 n3523 n3630 0.625
r6064 n3629 n3630 0.016666666666666666
r6065 n3524 n3631 0.1388888888888889
r6066 n3630 n3631 0.04583333333333333
r6067 n3525 n3632 0.10416666666666667
r6068 n3631 n3632 0.087499999999999994
r6069 n3526 n3633 0.1388888888888889
r6070 n3632 n3633 0.087499999999999994
r6071 n3527 n3634 0.625
r6072 n3633 n3634 0.04583333333333333
r6073 n3528 n3635 0.625
r6074 n3634 n3635 0.016666666666666666
r6075 n3529 n3636 0.059523809523809521
r6076 n3635 n3636 0.09583333333333334
r6077 n3530 n3637 0.083333333333333329
r6078 n3636 n3637 0.14999999999999999
r6079 n3531 n3638 0.625
r6080 n3637 n3638 0.070833333333333331
r6081 n3532 n3639 0.0390625
r6082 n3638 n3639 0.14166666666666666
r6083 n3533 n3640 0.625
r6084 n3639 n3640 0.14166666666666666
r6085 n3534 n3641 0.10416666666666667
r6086 n3640 n3641 0.058333333333333334
r6087 n3535 n3642 0.125
r6088 n3536 n3643 0.625
r6089 n3642 n3643 0.050000000000000003
r6090 n3537 n3644 0.0390625
r6091 n3643 n3644 0.14166666666666666
r6092 n3538 n3645 0.625
r6093 n3644 n3645 0.14166666666666666
r6094 n3539 n3646 0.034722222222222224
r6095 n3645 n3646 0.15833333333333333
r6096 n3540 n3647 0.625
r6097 n3646 n3647 0.15833333333333333
r6098 n3541 n3648 0.0390625
r6099 n3647 n3648 0.14166666666666666
r6100 n3542 n3649 0.625
r6101 n3648 n3649 0.14166666666666666
r6102 n3543 n3650 0.034722222222222224
r6103 n3649 n3650 0.15833333333333333
r6104 n3544 n3651 0.625
r6105 n3650 n3651 0.15833333333333333
r6106 n3545 n3652 0.0390625
r6107 n3651 n3652 0.14166666666666666
r6108 n3546 n3653 0.625
r6109 n3652 n3653 0.14166666666666666
r6110 n3547 n3654 0.034722222222222224
r6111 n3653 n3654 0.15833333333333333
r6112 n3548 n3655 0.625
r6113 n3654 n3655 0.15833333333333333
r6114 n3549 n3656 0.0390625
r6115 n3655 n3656 0.14166666666666666
r6116 n3550 n3657 0.625
r6117 n3656 n3657 0.14166666666666666
r6118 n3551 n3658 0.034722222222222224
r6119 n3657 n3658 0.15833333333333333
r6120 n3552 n3659 0.625
r6121 n3658 n3659 0.15833333333333333
r6122 n3553 n3660 0.0390625
r6123 n3659 n3660 0.14166666666666666
r6124 n3554 n3661 0.625
r6125 n3660 n3661 0.14166666666666666
r6126 n3555 n3662 0.034722222222222224
r6127 n3661 n3662 0.15833333333333333
r6128 n3556 n3663 0.625
r6129 n3662 n3663 0.15833333333333333
r6130 n3557 n3664 0.0390625
r6131 n3663 n3664 0.14166666666666666
r6132 n3558 n3665 0.625
r6133 n3664 n3665 0.14166666666666666
r6134 n3559 n3666 0.034722222222222224
r6135 n3665 n3666 0.15833333333333333
r6136 n3560 n3667 0.625
r6137 n3666 n3667 0.15833333333333333
r6138 n3561 n3668 0.0390625
r6139 n3667 n3668 0.14166666666666666
r6140 n3562 n3669 0.625
r6141 n3668 n3669 0.14166666666666666
r6142 n3563 n3670 0.034722222222222224
r6143 n3669 n3670 0.15833333333333333
r6144 n3564 n3671 0.625
r6145 n3670 n3671 0.15833333333333333
r6146 n3565 n3672 0.0390625
r6147 n3671 n3672 0.14166666666666666
r6148 n3566 n3673 0.625
r6149 n3672 n3673 0.14166666666666666
r6150 n3567 n3674 0.083333333333333329
r6151 n3673 n3674 0.070833333333333331
r6152 n3568 n3675 0.10416666666666667
r6153 n3674 n3675 0.1125
r6154 n3569 n3676 0.1388888888888889
r6155 n3675 n3676 0.087499999999999994
r6156 n3570 n3677 0.625
r6157 n3676 n3677 0.04583333333333333
r6158 n3571 n3678 0.625
r6159 n3677 n3678 0.016666666666666666
r6160 n3572 n3679 0.15625
r6161 n3678 n3679 0.041666666666666664
r6162 n3573 n3680 0.056818181818181816
r6163 n3679 n3680 0.125
r6164 n3574 n3681 1.25
r6165 n3680 n3681 0.09583333333333334
r6166 n3575 n3682 1.25
r6167 n3681 n3682 0.0083333333333333332
r6168 n3576 n3683 1.25
r6169 n3682 n3683 0.0083333333333333332
r6170 n3577 n3684 0.125
r6171 n3683 n3684 0.04583333333333333
r6172 n3578 n3685 0.10416666666666667
r6173 n3684 n3685 0.09166666666666666
r6174 n3579 n3686 0.15625
r6175 n3685 n3686 0.083333333333333329
r6176 n3580 n3687 0.625
r6177 n3686 n3687 0.041666666666666664
r6178 n3581 n3688 0.41666666666666669
r6179 n3687 n3688 0.020833333333333332
r6180 n3582 n3689 0.625
r6181 n3688 n3689 0.020833333333333332
r6182 n3583 n3690 0.20833333333333334
r6183 n3689 n3690 0.033333333333333333
r6184 n3584 n3691 0.10416666666666667
r6185 n3690 n3691 0.074999999999999997
r6186 n3585 n3692 0.089285714285714288
r6187 n3691 n3692 0.10833333333333334
r6188 n3586 n3693 0.625
r6189 n3692 n3693 0.066666666666666666
r6190 n3587 n3694 0.034722222222222224
r6191 n3693 n3694 0.15833333333333333
r6192 n3588 n3695 0.625
r6193 n3694 n3695 0.15833333333333333
r6194 n3589 n3696 0.0390625
r6195 n3695 n3696 0.14166666666666666
r6196 n3590 n3697 0.625
r6197 n3696 n3697 0.14166666666666666
r6198 n3591 n3698 0.034722222222222224
r6199 n3697 n3698 0.15833333333333333
r6200 n3592 n3699 0.625
r6201 n3698 n3699 0.15833333333333333
r6202 n3593 n3700 0.0390625
r6203 n3699 n3700 0.14166666666666666
r6204 n3594 n3701 0.625
r6205 n3700 n3701 0.14166666666666666
r6206 n3595 n3702 0.034722222222222224
r6207 n3701 n3702 0.15833333333333333
r6208 n3596 n3703 0.625
r6209 n3702 n3703 0.15833333333333333
r6210 n3597 n3704 0.0390625
r6211 n3703 n3704 0.14166666666666666
r6212 n3598 n3705 0.625
r6213 n3704 n3705 0.14166666666666666
r6214 n3599 n3706 0.034722222222222224
r6215 n3705 n3706 0.15833333333333333
r6216 n3600 n3707 0.625
r6217 n3706 n3707 0.15833333333333333
r6218 n3601 n3708 0.0390625
r6219 n3707 n3708 0.14166666666666666
r6220 n3602 n3709 0.625
r6221 n3708 n3709 0.14166666666666666
r6222 n3603 n3710 0.034722222222222224
r6223 n3709 n3710 0.15833333333333333
r6224 n3604 n3711 0.625
r6225 n3710 n3711 0.15833333333333333
r6226 n3605 n3712 0.0390625
r6227 n3711 n3712 0.14166666666666666
r6228 n3606 n3713 0.625
r6229 n3712 n3713 0.14166666666666666
r6230 n3607 n3714 0.034722222222222224
r6231 n3713 n3714 0.15833333333333333
r6232 n3608 n3715 0.625
r6233 n3714 n3715 0.15833333333333333
r6234 n3609 n3716 0.0390625
r6235 n3715 n3716 0.14166666666666666
r6236 n3610 n3717 0.625
r6237 n3716 n3717 0.14166666666666666
r6238 n3611 n3718 0.034722222222222224
r6239 n3717 n3718 0.15833333333333333
r6240 n3612 n3719 0.625
r6241 n3718 n3719 0.15833333333333333
r6242 n3613 n3720 0.0390625
r6243 n3719 n3720 0.14166666666666666
r6244 n3614 n3721 0.625
r6245 n3720 n3721 0.14166666666666666
r6246 n3615 n3722 0.10416666666666667
r6247 n3721 n3722 0.058333333333333334
r6248 n3616 n3723 0.1125
r6249 n3617 n3724 0.5625
r6250 n3723 n3724 0.25
r6251 n3618 n3725 0.03515625
r6252 n3724 n3725 0.70833333333333337
r6253 n3619 n3726 0.5625
r6254 n3725 n3726 0.70833333333333337
r6255 n3620 n3727 0.03125
r6256 n3726 n3727 0.79166666666666663
r6257 n3621 n3728 0.5625
r6258 n3727 n3728 0.79166666666666663
r6259 n3622 n3729 0.086538461538461536
r6260 n3728 n3729 0.3125
r6261 n3623 n3730 0.09375
r6262 n3729 n3730 0.52083333333333337
r6263 n3624 n3731 0.16071428571428573
r6264 n3730 n3731 0.39583333333333331
r6265 n3625 n3732 0.5625
r6266 n3731 n3732 0.1875
r6267 n3626 n3733 0.28125
r6268 n3732 n3733 0.125
r6269 n3627 n3734 0.125
r6270 n3733 n3734 0.27083333333333331
r6271 n3628 n3735 0.053571428571428568
r6272 n3734 n3735 0.625
r6273 n3629 n3736 0.5625
r6274 n3735 n3736 0.47916666666666669
r6275 n3630 n3737 0.5625
r6276 n3736 n3737 0.083333333333333329
r6277 n3631 n3738 0.125
r6278 n3737 n3738 0.22916666666666666
r6279 n3632 n3739 0.09375
r6280 n3738 n3739 0.4375
r6281 n3633 n3740 0.125
r6282 n3739 n3740 0.4375
r6283 n3634 n3741 0.5625
r6284 n3740 n3741 0.22916666666666666
r6285 n3635 n3742 0.5625
r6286 n3741 n3742 0.083333333333333329
r6287 n3636 n3743 0.053571428571428568
r6288 n3742 n3743 0.47916666666666669
r6289 n3637 n3744 0.074999999999999997
r6290 n3743 n3744 0.75
r6291 n3638 n3745 0.5625
r6292 n3744 n3745 0.35416666666666669
r6293 n3639 n3746 0.03515625
r6294 n3745 n3746 0.70833333333333337
r6295 n3640 n3747 0.5625
r6296 n3746 n3747 0.70833333333333337
r6297 n3641 n3748 0.09375
r6298 n3747 n3748 0.29166666666666669
r6299 n3642 n3749 0.1125
r6300 n3643 n3750 0.5625
r6301 n3749 n3750 0.25
r6302 n3644 n3751 0.03515625
r6303 n3750 n3751 0.70833333333333337
r6304 n3645 n3752 0.5625
r6305 n3751 n3752 0.70833333333333337
r6306 n3646 n3753 0.03125
r6307 n3752 n3753 0.79166666666666663
r6308 n3647 n3754 0.5625
r6309 n3753 n3754 0.79166666666666663
r6310 n3648 n3755 0.03515625
r6311 n3754 n3755 0.70833333333333337
r6312 n3649 n3756 0.5625
r6313 n3755 n3756 0.70833333333333337
r6314 n3650 n3757 0.03125
r6315 n3756 n3757 0.79166666666666663
r6316 n3651 n3758 0.5625
r6317 n3757 n3758 0.79166666666666663
r6318 n3652 n3759 0.03515625
r6319 n3758 n3759 0.70833333333333337
r6320 n3653 n3760 0.5625
r6321 n3759 n3760 0.70833333333333337
r6322 n3654 n3761 0.03125
r6323 n3760 n3761 0.79166666666666663
r6324 n3655 n3762 0.5625
r6325 n3761 n3762 0.79166666666666663
r6326 n3656 n3763 0.03515625
r6327 n3762 n3763 0.70833333333333337
r6328 n3657 n3764 0.5625
r6329 n3763 n3764 0.70833333333333337
r6330 n3658 n3765 0.03125
r6331 n3764 n3765 0.79166666666666663
r6332 n3659 n3766 0.5625
r6333 n3765 n3766 0.79166666666666663
r6334 n3660 n3767 0.03515625
r6335 n3766 n3767 0.70833333333333337
r6336 n3661 n3768 0.5625
r6337 n3767 n3768 0.70833333333333337
r6338 n3662 n3769 0.03125
r6339 n3768 n3769 0.79166666666666663
r6340 n3663 n3770 0.5625
r6341 n3769 n3770 0.79166666666666663
r6342 n3664 n3771 0.03515625
r6343 n3770 n3771 0.70833333333333337
r6344 n3665 n3772 0.5625
r6345 n3771 n3772 0.70833333333333337
r6346 n3666 n3773 0.03125
r6347 n3772 n3773 0.79166666666666663
r6348 n3667 n3774 0.5625
r6349 n3773 n3774 0.79166666666666663
r6350 n3668 n3775 0.03515625
r6351 n3774 n3775 0.70833333333333337
r6352 n3669 n3776 0.5625
r6353 n3775 n3776 0.70833333333333337
r6354 n3670 n3777 0.03125
r6355 n3776 n3777 0.79166666666666663
r6356 n3671 n3778 0.5625
r6357 n3777 n3778 0.79166666666666663
r6358 n3672 n3779 0.03515625
r6359 n3778 n3779 0.70833333333333337
r6360 n3673 n3780 0.5625
r6361 n3779 n3780 0.70833333333333337
r6362 n3674 n3781 0.074999999999999997
r6363 n3780 n3781 0.35416666666666669
r6364 n3675 n3782 0.09375
r6365 n3781 n3782 0.5625
r6366 n3676 n3783 0.125
r6367 n3782 n3783 0.4375
r6368 n3677 n3784 0.5625
r6369 n3783 n3784 0.22916666666666666
r6370 n3678 n3785 0.5625
r6371 n3784 n3785 0.083333333333333329
r6372 n3679 n3786 0.140625
r6373 n3785 n3786 0.20833333333333334
r6374 n3680 n3787 0.05113636363636364
r6375 n3786 n3787 0.625
r6376 n3681 n3788 1.125
r6377 n3787 n3788 0.47916666666666669
r6378 n3682 n3789 1.125
r6379 n3788 n3789 0.041666666666666664
r6380 n3683 n3790 1.125
r6381 n3789 n3790 0.041666666666666664
r6382 n3684 n3791 0.1125
r6383 n3790 n3791 0.22916666666666666
r6384 n3685 n3792 0.09375
r6385 n3791 n3792 0.45833333333333331
r6386 n3686 n3793 0.140625
r6387 n3792 n3793 0.41666666666666669
r6388 n3687 n3794 0.5625
r6389 n3793 n3794 0.20833333333333334
r6390 n3688 n3795 0.375
r6391 n3794 n3795 0.10416666666666667
r6392 n3689 n3796 0.5625
r6393 n3795 n3796 0.10416666666666667
r6394 n3690 n3797 0.1875
r6395 n3796 n3797 0.16666666666666666
r6396 n3691 n3798 0.09375
r6397 n3797 n3798 0.375
r6398 n3692 n3799 0.080357142857142863
r6399 n3798 n3799 0.54166666666666663
r6400 n3693 n3800 0.5625
r6401 n3799 n3800 0.33333333333333331
r6402 n3694 n3801 0.03125
r6403 n3800 n3801 0.79166666666666663
r6404 n3695 n3802 0.5625
r6405 n3801 n3802 0.79166666666666663
r6406 n3696 n3803 0.03515625
r6407 n3802 n3803 0.70833333333333337
r6408 n3697 n3804 0.5625
r6409 n3803 n3804 0.70833333333333337
r6410 n3698 n3805 0.03125
r6411 n3804 n3805 0.79166666666666663
r6412 n3699 n3806 0.5625
r6413 n3805 n3806 0.79166666666666663
r6414 n3700 n3807 0.03515625
r6415 n3806 n3807 0.70833333333333337
r6416 n3701 n3808 0.5625
r6417 n3807 n3808 0.70833333333333337
r6418 n3702 n3809 0.03125
r6419 n3808 n3809 0.79166666666666663
r6420 n3703 n3810 0.5625
r6421 n3809 n3810 0.79166666666666663
r6422 n3704 n3811 0.03515625
r6423 n3810 n3811 0.70833333333333337
r6424 n3705 n3812 0.5625
r6425 n3811 n3812 0.70833333333333337
r6426 n3706 n3813 0.03125
r6427 n3812 n3813 0.79166666666666663
r6428 n3707 n3814 0.5625
r6429 n3813 n3814 0.79166666666666663
r6430 n3708 n3815 0.03515625
r6431 n3814 n3815 0.70833333333333337
r6432 n3709 n3816 0.5625
r6433 n3815 n3816 0.70833333333333337
r6434 n3710 n3817 0.03125
r6435 n3816 n3817 0.79166666666666663
r6436 n3711 n3818 0.5625
r6437 n3817 n3818 0.79166666666666663
r6438 n3712 n3819 0.03515625
r6439 n3818 n3819 0.70833333333333337
r6440 n3713 n3820 0.5625
r6441 n3819 n3820 0.70833333333333337
r6442 n3714 n3821 0.03125
r6443 n3820 n3821 0.79166666666666663
r6444 n3715 n3822 0.5625
r6445 n3821 n3822 0.79166666666666663
r6446 n3716 n3823 0.03515625
r6447 n3822 n3823 0.70833333333333337
r6448 n3717 n3824 0.5625
r6449 n3823 n3824 0.70833333333333337
r6450 n3718 n3825 0.03125
r6451 n3824 n3825 0.79166666666666663
r6452 n3719 n3826 0.5625
r6453 n3825 n3826 0.79166666666666663
r6454 n3720 n3827 0.03515625
r6455 n3826 n3827 0.70833333333333337
r6456 n3721 n3828 0.5625
r6457 n3827 n3828 0.70833333333333337
r6458 n3722 n3829 0.09375
r6459 n3828 n3829 0.29166666666666669
r6460 n3723 n3830 0.043749999999999997
r6461 n3724 n3831 0.21875
r6462 n3830 n3831 0.1875
r6463 n3725 n3832 0.013671875
r6464 n3831 n3832 0.53125
r6465 n3726 n3833 0.21875
r6466 n3832 n3833 0.53125
r6467 n3727 n3834 0.012152777777777778
r6468 n3833 n3834 0.59375
r6469 n3728 n3835 0.21875
r6470 n3834 n3835 0.59375
r6471 n3729 n3836 0.033653846153846152
r6472 n3835 n3836 0.234375
r6473 n3730 n3837 0.036458333333333336
r6474 n3836 n3837 0.390625
r6475 n3731 n3838 0.0625
r6476 n3837 n3838 0.296875
r6477 n3732 n3839 0.21875
r6478 n3838 n3839 0.140625
r6479 n3733 n3840 0.109375
r6480 n3839 n3840 0.09375
r6481 n3734 n3841 0.048611111111111112
r6482 n3840 n3841 0.203125
r6483 n3735 n3842 0.020833333333333332
r6484 n3841 n3842 0.46875
r6485 n3736 n3843 0.21875
r6486 n3842 n3843 0.359375
r6487 n3737 n3844 0.21875
r6488 n3843 n3844 0.0625
r6489 n3738 n3845 0.048611111111111112
r6490 n3844 n3845 0.171875
r6491 n3739 n3846 0.036458333333333336
r6492 n3845 n3846 0.328125
r6493 n3740 n3847 0.048611111111111112
r6494 n3846 n3847 0.328125
r6495 n3741 n3848 0.21875
r6496 n3847 n3848 0.171875
r6497 n3742 n3849 0.21875
r6498 n3848 n3849 0.0625
r6499 n3743 n3850 0.020833333333333332
r6500 n3849 n3850 0.359375
r6501 n3744 n3851 0.029166666666666667
r6502 n3850 n3851 0.5625
r6503 n3745 n3852 0.21875
r6504 n3851 n3852 0.265625
r6505 n3746 n3853 0.013671875
r6506 n3852 n3853 0.53125
r6507 n3747 n3854 0.21875
r6508 n3853 n3854 0.53125
r6509 n3748 n3855 0.036458333333333336
r6510 n3854 n3855 0.21875
r6511 n3856 n3857 0.09375
r6512 n3857 n3858 0.078125
r6513 n3858 n3859 0.15625
r6514 n3859 n3860 0.46875
r6515 n3860 n3861 0.375
r6516 n3861 n3862 0.078125
r6517 n3862 n3863 0.09375
r6518 n3749 n3864 0.043749999999999997
r6519 n3750 n3865 0.21875
r6520 n3864 n3865 0.1875
r6521 n3751 n3866 0.013671875
r6522 n3865 n3866 0.53125
r6523 n3752 n3867 0.21875
r6524 n3866 n3867 0.53125
r6525 n3753 n3868 0.012152777777777778
r6526 n3867 n3868 0.59375
r6527 n3754 n3869 0.21875
r6528 n3868 n3869 0.59375
r6529 n3755 n3870 0.013671875
r6530 n3869 n3870 0.53125
r6531 n3756 n3871 0.21875
r6532 n3870 n3871 0.53125
r6533 n3757 n3872 0.012152777777777778
r6534 n3871 n3872 0.59375
r6535 n3758 n3873 0.21875
r6536 n3872 n3873 0.59375
r6537 n3759 n3874 0.013671875
r6538 n3873 n3874 0.53125
r6539 n3760 n3875 0.21875
r6540 n3874 n3875 0.53125
r6541 n3761 n3876 0.012152777777777778
r6542 n3875 n3876 0.59375
r6543 n3762 n3877 0.21875
r6544 n3876 n3877 0.59375
r6545 n3763 n3878 0.013671875
r6546 n3877 n3878 0.53125
r6547 n3764 n3879 0.21875
r6548 n3878 n3879 0.53125
r6549 n3765 n3880 0.012152777777777778
r6550 n3879 n3880 0.59375
r6551 n3766 n3881 0.21875
r6552 n3880 n3881 0.59375
r6553 n3767 n3882 0.013671875
r6554 n3881 n3882 0.53125
r6555 n3768 n3883 0.21875
r6556 n3882 n3883 0.53125
r6557 n3769 n3884 0.012152777777777778
r6558 n3883 n3884 0.59375
r6559 n3770 n3885 0.21875
r6560 n3884 n3885 0.59375
r6561 n3771 n3886 0.013671875
r6562 n3885 n3886 0.53125
r6563 n3772 n3887 0.21875
r6564 n3886 n3887 0.53125
r6565 n3773 n3888 0.012152777777777778
r6566 n3887 n3888 0.59375
r6567 n3774 n3889 0.21875
r6568 n3888 n3889 0.59375
r6569 n3775 n3890 0.013671875
r6570 n3889 n3890 0.53125
r6571 n3776 n3891 0.21875
r6572 n3890 n3891 0.53125
r6573 n3777 n3892 0.012152777777777778
r6574 n3891 n3892 0.59375
r6575 n3778 n3893 0.21875
r6576 n3892 n3893 0.59375
r6577 n3779 n3894 0.013671875
r6578 n3893 n3894 0.53125
r6579 n3780 n3895 0.21875
r6580 n3894 n3895 0.53125
r6581 n3781 n3896 0.029166666666666667
r6582 n3895 n3896 0.265625
r6583 n3782 n3897 0.036458333333333336
r6584 n3896 n3897 0.421875
r6585 n3783 n3898 0.048611111111111112
r6586 n3897 n3898 0.328125
r6587 n3784 n3899 0.21875
r6588 n3898 n3899 0.171875
r6589 n3785 n3900 0.21875
r6590 n3899 n3900 0.0625
r6591 n3786 n3901 0.0546875
r6592 n3900 n3901 0.15625
r6593 n3787 n3902 0.019886363636363636
r6594 n3901 n3902 0.46875
r6595 n3788 n3903 0.4375
r6596 n3902 n3903 0.359375
r6597 n3789 n3904 0.4375
r6598 n3903 n3904 0.03125
r6599 n3790 n3905 0.4375
r6600 n3904 n3905 0.03125
r6601 n3791 n3906 0.043749999999999997
r6602 n3905 n3906 0.171875
r6603 n3792 n3907 0.036458333333333336
r6604 n3906 n3907 0.34375
r6605 n3793 n3908 0.0546875
r6606 n3907 n3908 0.3125
r6607 n3794 n3909 0.21875
r6608 n3908 n3909 0.15625
r6609 n3795 n3910 0.14583333333333334
r6610 n3909 n3910 0.078125
r6611 n3796 n3911 0.21875
r6612 n3910 n3911 0.078125
r6613 n3797 n3912 0.072916666666666671
r6614 n3911 n3912 0.125
r6615 n3798 n3913 0.036458333333333336
r6616 n3912 n3913 0.28125
r6617 n3799 n3914 0.03125
r6618 n3913 n3914 0.40625
r6619 n3800 n3915 0.21875
r6620 n3914 n3915 0.25
r6621 n3801 n3916 0.012152777777777778
r6622 n3915 n3916 0.59375
r6623 n3802 n3917 0.21875
r6624 n3916 n3917 0.59375
r6625 n3803 n3918 0.013671875
r6626 n3917 n3918 0.53125
r6627 n3804 n3919 0.21875
r6628 n3918 n3919 0.53125
r6629 n3805 n3920 0.012152777777777778
r6630 n3919 n3920 0.59375
r6631 n3806 n3921 0.21875
r6632 n3920 n3921 0.59375
r6633 n3807 n3922 0.013671875
r6634 n3921 n3922 0.53125
r6635 n3808 n3923 0.21875
r6636 n3922 n3923 0.53125
r6637 n3809 n3924 0.012152777777777778
r6638 n3923 n3924 0.59375
r6639 n3810 n3925 0.21875
r6640 n3924 n3925 0.59375
r6641 n3811 n3926 0.013671875
r6642 n3925 n3926 0.53125
r6643 n3812 n3927 0.21875
r6644 n3926 n3927 0.53125
r6645 n3813 n3928 0.012152777777777778
r6646 n3927 n3928 0.59375
r6647 n3814 n3929 0.21875
r6648 n3928 n3929 0.59375
r6649 n3815 n3930 0.013671875
r6650 n3929 n3930 0.53125
r6651 n3816 n3931 0.21875
r6652 n3930 n3931 0.53125
r6653 n3817 n3932 0.012152777777777778
r6654 n3931 n3932 0.59375
r6655 n3818 n3933 0.21875
r6656 n3932 n3933 0.59375
r6657 n3819 n3934 0.013671875
r6658 n3933 n3934 0.53125
r6659 n3820 n3935 0.21875
r6660 n3934 n3935 0.53125
r6661 n3821 n3936 0.012152777777777778
r6662 n3935 n3936 0.59375
r6663 n3822 n3937 0.21875
r6664 n3936 n3937 0.59375
r6665 n3823 n3938 0.013671875
r6666 n3937 n3938 0.53125
r6667 n3824 n3939 0.21875
r6668 n3938 n3939 0.53125
r6669 n3825 n3940 0.012152777777777778
r6670 n3939 n3940 0.59375
r6671 n3826 n3941 0.21875
r6672 n3940 n3941 0.59375
r6673 n3827 n3942 0.013671875
r6674 n3941 n3942 0.53125
r6675 n3828 n3943 0.21875
r6676 n3942 n3943 0.53125
r6677 n3829 n3944 0.036458333333333336
r6678 n3943 n3944 0.21875
r6679 n3945 n3946 0.09375
r6680 n3946 n3947 0.078125
r6681 n3947 n3948 0.203125
r6682 n3948 n3949 0.46875
r6683 n3949 n3950 0.328125
r6684 n3950 n3951 0.078125
r6685 n3951 n3952 0.09375
r6686 n3830 n3953 0.043749999999999997
r6687 n3831 n3954 0.21875
r6688 n3953 n3954 0.25
r6689 n3832 n3955 0.013671875
r6690 n3954 n3955 0.70833333333333337
r6691 n3833 n3956 0.21875
r6692 n3955 n3956 0.70833333333333337
r6693 n3834 n3957 0.012152777777777778
r6694 n3956 n3957 0.79166666666666663
r6695 n3835 n3958 0.21875
r6696 n3957 n3958 0.79166666666666663
r6697 n3836 n3959 0.033653846153846152
r6698 n3958 n3959 0.3125
r6699 n3837 n3960 0.036458333333333336
r6700 n3959 n3960 0.52083333333333337
r6701 n3838 n3961 0.0625
r6702 n3960 n3961 0.39583333333333331
r6703 n3839 n3962 0.21875
r6704 n3961 n3962 0.1875
r6705 n3840 n3963 0.109375
r6706 n3962 n3963 0.125
r6707 n3841 n3964 0.048611111111111112
r6708 n3963 n3964 0.27083333333333331
r6709 n3842 n3965 0.020833333333333332
r6710 n3964 n3965 0.625
r6711 n3843 n3966 0.21875
r6712 n3965 n3966 0.47916666666666669
r6713 n3844 n3967 0.21875
r6714 n3966 n3967 0.083333333333333329
r6715 n3845 n3968 0.048611111111111112
r6716 n3967 n3968 0.22916666666666666
r6717 n3846 n3969 0.036458333333333336
r6718 n3968 n3969 0.4375
r6719 n3847 n3970 0.048611111111111112
r6720 n3969 n3970 0.4375
r6721 n3848 n3971 0.21875
r6722 n3970 n3971 0.22916666666666666
r6723 n3849 n3972 0.21875
r6724 n3971 n3972 0.083333333333333329
r6725 n3850 n3973 0.020833333333333332
r6726 n3972 n3973 0.47916666666666669
r6727 n3851 n3974 0.029166666666666667
r6728 n3973 n3974 0.75
r6729 n3852 n3975 0.21875
r6730 n3974 n3975 0.35416666666666669
r6731 n3853 n3976 0.013671875
r6732 n3975 n3976 0.70833333333333337
r6733 n3854 n3977 0.21875
r6734 n3976 n3977 0.70833333333333337
r6735 n3855 n3978 0.036458333333333336
r6736 n3977 n3978 0.29166666666666669
r6737 n3856 n3979 0.14583333333333334
r6738 n3857 n3980 0.14583333333333334
r6739 n3979 n3980 0.125
r6740 n3858 n3981 0.21875
r6741 n3980 n3981 0.10416666666666667
r6742 n3859 n3982 0.0546875
r6743 n3981 n3982 0.20833333333333334
r6744 n3860 n3983 0.019886363636363636
r6745 n3982 n3983 0.625
r6746 n3861 n3984 0.21875
r6747 n3983 n3984 0.5
r6748 n3862 n3985 0.14583333333333334
r6749 n3984 n3985 0.10416666666666667
r6750 n3863 n3986 0.14583333333333334
r6751 n3985 n3986 0.125
r6752 n3864 n3987 0.043749999999999997
r6753 n3865 n3988 0.21875
r6754 n3987 n3988 0.25
r6755 n3866 n3989 0.013671875
r6756 n3988 n3989 0.70833333333333337
r6757 n3867 n3990 0.21875
r6758 n3989 n3990 0.70833333333333337
r6759 n3868 n3991 0.012152777777777778
r6760 n3990 n3991 0.79166666666666663
r6761 n3869 n3992 0.21875
r6762 n3991 n3992 0.79166666666666663
r6763 n3870 n3993 0.013671875
r6764 n3992 n3993 0.70833333333333337
r6765 n3871 n3994 0.21875
r6766 n3993 n3994 0.70833333333333337
r6767 n3872 n3995 0.012152777777777778
r6768 n3994 n3995 0.79166666666666663
r6769 n3873 n3996 0.21875
r6770 n3995 n3996 0.79166666666666663
r6771 n3874 n3997 0.013671875
r6772 n3996 n3997 0.70833333333333337
r6773 n3875 n3998 0.21875
r6774 n3997 n3998 0.70833333333333337
r6775 n3876 n3999 0.012152777777777778
r6776 n3998 n3999 0.79166666666666663
r6777 n3877 n4000 0.21875
r6778 n3999 n4000 0.79166666666666663
r6779 n3878 n4001 0.013671875
r6780 n4000 n4001 0.70833333333333337
r6781 n3879 n4002 0.21875
r6782 n4001 n4002 0.70833333333333337
r6783 n3880 n4003 0.012152777777777778
r6784 n4002 n4003 0.79166666666666663
r6785 n3881 n4004 0.21875
r6786 n4003 n4004 0.79166666666666663
r6787 n3882 n4005 0.013671875
r6788 n4004 n4005 0.70833333333333337
r6789 n3883 n4006 0.21875
r6790 n4005 n4006 0.70833333333333337
r6791 n3884 n4007 0.012152777777777778
r6792 n4006 n4007 0.79166666666666663
r6793 n3885 n4008 0.21875
r6794 n4007 n4008 0.79166666666666663
r6795 n3886 n4009 0.013671875
r6796 n4008 n4009 0.70833333333333337
r6797 n3887 n4010 0.21875
r6798 n4009 n4010 0.70833333333333337
r6799 n3888 n4011 0.012152777777777778
r6800 n4010 n4011 0.79166666666666663
r6801 n3889 n4012 0.21875
r6802 n4011 n4012 0.79166666666666663
r6803 n3890 n4013 0.013671875
r6804 n4012 n4013 0.70833333333333337
r6805 n3891 n4014 0.21875
r6806 n4013 n4014 0.70833333333333337
r6807 n3892 n4015 0.012152777777777778
r6808 n4014 n4015 0.79166666666666663
r6809 n3893 n4016 0.21875
r6810 n4015 n4016 0.79166666666666663
r6811 n3894 n4017 0.013671875
r6812 n4016 n4017 0.70833333333333337
r6813 n3895 n4018 0.21875
r6814 n4017 n4018 0.70833333333333337
r6815 n3896 n4019 0.029166666666666667
r6816 n4018 n4019 0.35416666666666669
r6817 n3897 n4020 0.036458333333333336
r6818 n4019 n4020 0.5625
r6819 n3898 n4021 0.048611111111111112
r6820 n4020 n4021 0.4375
r6821 n3899 n4022 0.21875
r6822 n4021 n4022 0.22916666666666666
r6823 n3900 n4023 0.21875
r6824 n4022 n4023 0.083333333333333329
r6825 n3901 n4024 0.0546875
r6826 n4023 n4024 0.20833333333333334
r6827 n3902 n4025 0.019886363636363636
r6828 n4024 n4025 0.625
r6829 n3903 n4026 0.4375
r6830 n4025 n4026 0.47916666666666669
r6831 n3904 n4027 0.4375
r6832 n4026 n4027 0.041666666666666664
r6833 n3905 n4028 0.4375
r6834 n4027 n4028 0.041666666666666664
r6835 n3906 n4029 0.043749999999999997
r6836 n4028 n4029 0.22916666666666666
r6837 n3907 n4030 0.036458333333333336
r6838 n4029 n4030 0.45833333333333331
r6839 n3908 n4031 0.0546875
r6840 n4030 n4031 0.41666666666666669
r6841 n3909 n4032 0.21875
r6842 n4031 n4032 0.20833333333333334
r6843 n3910 n4033 0.14583333333333334
r6844 n4032 n4033 0.10416666666666667
r6845 n3911 n4034 0.21875
r6846 n4033 n4034 0.10416666666666667
r6847 n3912 n4035 0.072916666666666671
r6848 n4034 n4035 0.16666666666666666
r6849 n3913 n4036 0.036458333333333336
r6850 n4035 n4036 0.375
r6851 n3914 n4037 0.03125
r6852 n4036 n4037 0.54166666666666663
r6853 n3915 n4038 0.21875
r6854 n4037 n4038 0.33333333333333331
r6855 n3916 n4039 0.012152777777777778
r6856 n4038 n4039 0.79166666666666663
r6857 n3917 n4040 0.21875
r6858 n4039 n4040 0.79166666666666663
r6859 n3918 n4041 0.013671875
r6860 n4040 n4041 0.70833333333333337
r6861 n3919 n4042 0.21875
r6862 n4041 n4042 0.70833333333333337
r6863 n3920 n4043 0.012152777777777778
r6864 n4042 n4043 0.79166666666666663
r6865 n3921 n4044 0.21875
r6866 n4043 n4044 0.79166666666666663
r6867 n3922 n4045 0.013671875
r6868 n4044 n4045 0.70833333333333337
r6869 n3923 n4046 0.21875
r6870 n4045 n4046 0.70833333333333337
r6871 n3924 n4047 0.012152777777777778
r6872 n4046 n4047 0.79166666666666663
r6873 n3925 n4048 0.21875
r6874 n4047 n4048 0.79166666666666663
r6875 n3926 n4049 0.013671875
r6876 n4048 n4049 0.70833333333333337
r6877 n3927 n4050 0.21875
r6878 n4049 n4050 0.70833333333333337
r6879 n3928 n4051 0.012152777777777778
r6880 n4050 n4051 0.79166666666666663
r6881 n3929 n4052 0.21875
r6882 n4051 n4052 0.79166666666666663
r6883 n3930 n4053 0.013671875
r6884 n4052 n4053 0.70833333333333337
r6885 n3931 n4054 0.21875
r6886 n4053 n4054 0.70833333333333337
r6887 n3932 n4055 0.012152777777777778
r6888 n4054 n4055 0.79166666666666663
r6889 n3933 n4056 0.21875
r6890 n4055 n4056 0.79166666666666663
r6891 n3934 n4057 0.013671875
r6892 n4056 n4057 0.70833333333333337
r6893 n3935 n4058 0.21875
r6894 n4057 n4058 0.70833333333333337
r6895 n3936 n4059 0.012152777777777778
r6896 n4058 n4059 0.79166666666666663
r6897 n3937 n4060 0.21875
r6898 n4059 n4060 0.79166666666666663
r6899 n3938 n4061 0.013671875
r6900 n4060 n4061 0.70833333333333337
r6901 n3939 n4062 0.21875
r6902 n4061 n4062 0.70833333333333337
r6903 n3940 n4063 0.012152777777777778
r6904 n4062 n4063 0.79166666666666663
r6905 n3941 n4064 0.21875
r6906 n4063 n4064 0.79166666666666663
r6907 n3942 n4065 0.013671875
r6908 n4064 n4065 0.70833333333333337
r6909 n3943 n4066 0.21875
r6910 n4065 n4066 0.70833333333333337
r6911 n3944 n4067 0.036458333333333336
r6912 n4066 n4067 0.29166666666666669
r6913 n3945 n4068 0.14583333333333334
r6914 n3946 n4069 0.14583333333333334
r6915 n4068 n4069 0.125
r6916 n3947 n4070 0.21875
r6917 n4069 n4070 0.10416666666666667
r6918 n3948 n4071 0.039772727272727272
r6919 n4070 n4071 0.27083333333333331
r6920 n3949 n4072 0.023026315789473683
r6921 n4071 n4072 0.625
r6922 n3950 n4073 0.21875
r6923 n4072 n4073 0.4375
r6924 n3951 n4074 0.14583333333333334
r6925 n4073 n4074 0.10416666666666667
r6926 n3952 n4075 0.14583333333333334
r6927 n4074 n4075 0.125
r6928 n3953 n4076 0.03125
r6929 n3954 n4077 0.15625
r6930 n4076 n4077 0.375
r6931 n3955 n4078 0.009765625
r6932 n4077 n4078 1.0625
r6933 n3956 n4079 0.15625
r6934 n4078 n4079 1.0625
r6935 n3957 n4080 0.0086805555555555559
r6936 n4079 n4080 1.1875
r6937 n3958 n4081 0.15625
r6938 n4080 n4081 1.1875
r6939 n3959 n4082 0.02403846153846154
r6940 n4081 n4082 0.46875
r6941 n3960 n4083 0.026041666666666668
r6942 n4082 n4083 0.78125
r6943 n3961 n4084 0.044642857142857144
r6944 n4083 n4084 0.59375
r6945 n3962 n4085 0.15625
r6946 n4084 n4085 0.28125
r6947 n3963 n4086 0.078125
r6948 n4085 n4086 0.1875
r6949 n3964 n4087 0.034722222222222224
r6950 n4086 n4087 0.40625
r6951 n3965 n4088 0.01488095238095238
r6952 n4087 n4088 0.9375
r6953 n3966 n4089 0.15625
r6954 n4088 n4089 0.71875
r6955 n3967 n4090 0.15625
r6956 n4089 n4090 0.125
r6957 n3968 n4091 0.034722222222222224
r6958 n4090 n4091 0.34375
r6959 n3969 n4092 0.026041666666666668
r6960 n4091 n4092 0.65625
r6961 n3970 n4093 0.034722222222222224
r6962 n4092 n4093 0.65625
r6963 n3971 n4094 0.15625
r6964 n4093 n4094 0.34375
r6965 n3972 n4095 0.15625
r6966 n4094 n4095 0.125
r6967 n3973 n4096 0.01488095238095238
r6968 n4095 n4096 0.71875
r6969 n3974 n4097 0.020833333333333332
r6970 n4096 n4097 1.125
r6971 n3975 n4098 0.15625
r6972 n4097 n4098 0.53125
r6973 n3976 n4099 0.009765625
r6974 n4098 n4099 1.0625
r6975 n3977 n4100 0.15625
r6976 n4099 n4100 1.0625
r6977 n3978 n4101 0.026041666666666668
r6978 n4100 n4101 0.4375
r6979 n4102 n4103 0.53125
r6980 n3979 n4104 0.10416666666666667
r6981 n4103 n4104 0.3125
r6982 n3980 n4105 0.10416666666666667
r6983 n4104 n4105 0.1875
r6984 n3981 n4106 0.15625
r6985 n4105 n4106 0.15625
r6986 n3982 n4107 0.0390625
r6987 n4106 n4107 0.3125
r6988 n3983 n4108 0.014204545454545454
r6989 n4107 n4108 0.9375
r6990 n3984 n4109 0.15625
r6991 n4108 n4109 0.75
r6992 n3985 n4110 0.10416666666666667
r6993 n4109 n4110 0.15625
r6994 n3986 n4111 0.10416666666666667
r6995 n4110 n4111 0.1875
r6996 n4111 n4112 0.21875
r6997 n4112 n4113 0.21875
r6998 n4113 n4114 0.40625
r6999 n3987 n4115 0.03125
r7000 n3988 n4116 0.15625
r7001 n4115 n4116 0.375
r7002 n3989 n4117 0.009765625
r7003 n4116 n4117 1.0625
r7004 n3990 n4118 0.15625
r7005 n4117 n4118 1.0625
r7006 n3991 n4119 0.0086805555555555559
r7007 n4118 n4119 1.1875
r7008 n3992 n4120 0.15625
r7009 n4119 n4120 1.1875
r7010 n3993 n4121 0.009765625
r7011 n4120 n4121 1.0625
r7012 n3994 n4122 0.15625
r7013 n4121 n4122 1.0625
r7014 n3995 n4123 0.0086805555555555559
r7015 n4122 n4123 1.1875
r7016 n3996 n4124 0.15625
r7017 n4123 n4124 1.1875
r7018 n3997 n4125 0.009765625
r7019 n4124 n4125 1.0625
r7020 n3998 n4126 0.15625
r7021 n4125 n4126 1.0625
r7022 n3999 n4127 0.0086805555555555559
r7023 n4126 n4127 1.1875
r7024 n4000 n4128 0.15625
r7025 n4127 n4128 1.1875
r7026 n4001 n4129 0.009765625
r7027 n4128 n4129 1.0625
r7028 n4002 n4130 0.15625
r7029 n4129 n4130 1.0625
r7030 n4003 n4131 0.0086805555555555559
r7031 n4130 n4131 1.1875
r7032 n4004 n4132 0.15625
r7033 n4131 n4132 1.1875
r7034 n4005 n4133 0.009765625
r7035 n4132 n4133 1.0625
r7036 n4006 n4134 0.15625
r7037 n4133 n4134 1.0625
r7038 n4007 n4135 0.0086805555555555559
r7039 n4134 n4135 1.1875
r7040 n4008 n4136 0.15625
r7041 n4135 n4136 1.1875
r7042 n4009 n4137 0.009765625
r7043 n4136 n4137 1.0625
r7044 n4010 n4138 0.15625
r7045 n4137 n4138 1.0625
r7046 n4011 n4139 0.0086805555555555559
r7047 n4138 n4139 1.1875
r7048 n4012 n4140 0.15625
r7049 n4139 n4140 1.1875
r7050 n4013 n4141 0.009765625
r7051 n4140 n4141 1.0625
r7052 n4014 n4142 0.15625
r7053 n4141 n4142 1.0625
r7054 n4015 n4143 0.0086805555555555559
r7055 n4142 n4143 1.1875
r7056 n4016 n4144 0.15625
r7057 n4143 n4144 1.1875
r7058 n4017 n4145 0.009765625
r7059 n4144 n4145 1.0625
r7060 n4018 n4146 0.15625
r7061 n4145 n4146 1.0625
r7062 n4019 n4147 0.020833333333333332
r7063 n4146 n4147 0.53125
r7064 n4020 n4148 0.026041666666666668
r7065 n4147 n4148 0.84375
r7066 n4021 n4149 0.034722222222222224
r7067 n4148 n4149 0.65625
r7068 n4022 n4150 0.15625
r7069 n4149 n4150 0.34375
r7070 n4023 n4151 0.15625
r7071 n4150 n4151 0.125
r7072 n4024 n4152 0.0390625
r7073 n4151 n4152 0.3125
r7074 n4025 n4153 0.014204545454545454
r7075 n4152 n4153 0.9375
r7076 n4026 n4154 0.3125
r7077 n4153 n4154 0.71875
r7078 n4027 n4155 0.3125
r7079 n4154 n4155 0.0625
r7080 n4028 n4156 0.3125
r7081 n4155 n4156 0.0625
r7082 n4029 n4157 0.03125
r7083 n4156 n4157 0.34375
r7084 n4030 n4158 0.026041666666666668
r7085 n4157 n4158 0.6875
r7086 n4031 n4159 0.0390625
r7087 n4158 n4159 0.625
r7088 n4032 n4160 0.15625
r7089 n4159 n4160 0.3125
r7090 n4033 n4161 0.10416666666666667
r7091 n4160 n4161 0.15625
r7092 n4034 n4162 0.15625
r7093 n4161 n4162 0.15625
r7094 n4035 n4163 0.052083333333333336
r7095 n4162 n4163 0.25
r7096 n4036 n4164 0.026041666666666668
r7097 n4163 n4164 0.5625
r7098 n4037 n4165 0.022321428571428572
r7099 n4164 n4165 0.8125
r7100 n4038 n4166 0.15625
r7101 n4165 n4166 0.5
r7102 n4039 n4167 0.0086805555555555559
r7103 n4166 n4167 1.1875
r7104 n4040 n4168 0.15625
r7105 n4167 n4168 1.1875
r7106 n4041 n4169 0.009765625
r7107 n4168 n4169 1.0625
r7108 n4042 n4170 0.15625
r7109 n4169 n4170 1.0625
r7110 n4043 n4171 0.0086805555555555559
r7111 n4170 n4171 1.1875
r7112 n4044 n4172 0.15625
r7113 n4171 n4172 1.1875
r7114 n4045 n4173 0.009765625
r7115 n4172 n4173 1.0625
r7116 n4046 n4174 0.15625
r7117 n4173 n4174 1.0625
r7118 n4047 n4175 0.0086805555555555559
r7119 n4174 n4175 1.1875
r7120 n4048 n4176 0.15625
r7121 n4175 n4176 1.1875
r7122 n4049 n4177 0.009765625
r7123 n4176 n4177 1.0625
r7124 n4050 n4178 0.15625
r7125 n4177 n4178 1.0625
r7126 n4051 n4179 0.0086805555555555559
r7127 n4178 n4179 1.1875
r7128 n4052 n4180 0.15625
r7129 n4179 n4180 1.1875
r7130 n4053 n4181 0.009765625
r7131 n4180 n4181 1.0625
r7132 n4054 n4182 0.15625
r7133 n4181 n4182 1.0625
r7134 n4055 n4183 0.0086805555555555559
r7135 n4182 n4183 1.1875
r7136 n4056 n4184 0.15625
r7137 n4183 n4184 1.1875
r7138 n4057 n4185 0.009765625
r7139 n4184 n4185 1.0625
r7140 n4058 n4186 0.15625
r7141 n4185 n4186 1.0625
r7142 n4059 n4187 0.0086805555555555559
r7143 n4186 n4187 1.1875
r7144 n4060 n4188 0.15625
r7145 n4187 n4188 1.1875
r7146 n4061 n4189 0.009765625
r7147 n4188 n4189 1.0625
r7148 n4062 n4190 0.15625
r7149 n4189 n4190 1.0625
r7150 n4063 n4191 0.0086805555555555559
r7151 n4190 n4191 1.1875
r7152 n4064 n4192 0.15625
r7153 n4191 n4192 1.1875
r7154 n4065 n4193 0.009765625
r7155 n4192 n4193 1.0625
r7156 n4066 n4194 0.15625
r7157 n4193 n4194 1.0625
r7158 n4067 n4195 0.026041666666666668
r7159 n4194 n4195 0.4375
r7160 n4196 n4197 0.53125
r7161 n4068 n4198 0.10416666666666667
r7162 n4197 n4198 0.3125
r7163 n4069 n4199 0.10416666666666667
r7164 n4198 n4199 0.1875
r7165 n4070 n4200 0.15625
r7166 n4199 n4200 0.15625
r7167 n4071 n4201 0.028409090909090908
r7168 n4200 n4201 0.40625
r7169 n4072 n4202 0.016447368421052631
r7170 n4201 n4202 0.9375
r7171 n4073 n4203 0.15625
r7172 n4202 n4203 0.65625
r7173 n4074 n4204 0.10416666666666667
r7174 n4203 n4204 0.15625
r7175 n4075 n4205 0.10416666666666667
r7176 n4204 n4205 0.1875
r7177 n4205 n4206 0.3125
r7178 n4206 n4207 0.53125
r7179 n4076 n4208 0.050000000000000003
r7180 n4077 n4209 0.25
r7181 n4208 n4209 0.125
r7182 n4078 n4210 0.015625
r7183 n4209 n4210 0.35416666666666669
r7184 n4079 n4211 0.25
r7185 n4210 n4211 0.35416666666666669
r7186 n4080 n4212 0.013888888888888888
r7187 n4211 n4212 0.39583333333333331
r7188 n4081 n4213 0.25
r7189 n4212 n4213 0.39583333333333331
r7190 n4082 n4214 0.038461538461538464
r7191 n4213 n4214 0.15625
r7192 n4083 n4215 0.041666666666666664
r7193 n4214 n4215 0.26041666666666669
r7194 n4084 n4216 0.071428571428571425
r7195 n4215 n4216 0.19791666666666666
r7196 n4085 n4217 0.25
r7197 n4216 n4217 0.09375
r7198 n4086 n4218 0.125
r7199 n4217 n4218 0.0625
r7200 n4087 n4219 0.055555555555555552
r7201 n4218 n4219 0.13541666666666666
r7202 n4088 n4220 0.023809523809523808
r7203 n4219 n4220 0.3125
r7204 n4089 n4221 0.25
r7205 n4220 n4221 0.23958333333333334
r7206 n4090 n4222 0.25
r7207 n4221 n4222 0.041666666666666664
r7208 n4091 n4223 0.055555555555555552
r7209 n4222 n4223 0.11458333333333333
r7210 n4092 n4224 0.041666666666666664
r7211 n4223 n4224 0.21875
r7212 n4093 n4225 0.055555555555555552
r7213 n4224 n4225 0.21875
r7214 n4094 n4226 0.25
r7215 n4225 n4226 0.11458333333333333
r7216 n4095 n4227 0.25
r7217 n4226 n4227 0.041666666666666664
r7218 n4096 n4228 0.023809523809523808
r7219 n4227 n4228 0.23958333333333334
r7220 n4097 n4229 0.033333333333333333
r7221 n4228 n4229 0.375
r7222 n4098 n4230 0.25
r7223 n4229 n4230 0.17708333333333334
r7224 n4099 n4231 0.015625
r7225 n4230 n4231 0.35416666666666669
r7226 n4100 n4232 0.25
r7227 n4231 n4232 0.35416666666666669
r7228 n4101 n4233 0.041666666666666664
r7229 n4232 n4233 0.14583333333333334
r7230 n4102 n4234 0.050000000000000003
r7231 n4103 n4235 0.071428571428571425
r7232 n4234 n4235 0.17708333333333334
r7233 n4104 n4236 0.16666666666666666
r7234 n4235 n4236 0.10416666666666667
r7235 n4105 n4237 0.16666666666666666
r7236 n4236 n4237 0.0625
r7237 n4106 n4238 0.25
r7238 n4237 n4238 0.052083333333333336
r7239 n4107 n4239 0.0625
r7240 n4238 n4239 0.10416666666666667
r7241 n4108 n4240 0.022727272727272728
r7242 n4239 n4240 0.3125
r7243 n4109 n4241 0.25
r7244 n4240 n4241 0.25
r7245 n4110 n4242 0.16666666666666666
r7246 n4241 n4242 0.052083333333333336
r7247 n4111 n4243 0.16666666666666666
r7248 n4242 n4243 0.0625
r7249 n4112 n4244 0.125
r7250 n4243 n4244 0.072916666666666671
r7251 n4113 n4245 0.16666666666666666
r7252 n4244 n4245 0.072916666666666671
r7253 n4114 n4246 0.050000000000000003
r7254 n4245 n4246 0.13541666666666666
r7255 n4115 n4247 0.050000000000000003
r7256 n4116 n4248 0.25
r7257 n4247 n4248 0.125
r7258 n4117 n4249 0.015625
r7259 n4248 n4249 0.35416666666666669
r7260 n4118 n4250 0.25
r7261 n4249 n4250 0.35416666666666669
r7262 n4119 n4251 0.013888888888888888
r7263 n4250 n4251 0.39583333333333331
r7264 n4120 n4252 0.25
r7265 n4251 n4252 0.39583333333333331
r7266 n4121 n4253 0.015625
r7267 n4252 n4253 0.35416666666666669
r7268 n4122 n4254 0.25
r7269 n4253 n4254 0.35416666666666669
r7270 n4123 n4255 0.013888888888888888
r7271 n4254 n4255 0.39583333333333331
r7272 n4124 n4256 0.25
r7273 n4255 n4256 0.39583333333333331
r7274 n4125 n4257 0.015625
r7275 n4256 n4257 0.35416666666666669
r7276 n4126 n4258 0.25
r7277 n4257 n4258 0.35416666666666669
r7278 n4127 n4259 0.013888888888888888
r7279 n4258 n4259 0.39583333333333331
r7280 n4128 n4260 0.25
r7281 n4259 n4260 0.39583333333333331
r7282 n4129 n4261 0.015625
r7283 n4260 n4261 0.35416666666666669
r7284 n4130 n4262 0.25
r7285 n4261 n4262 0.35416666666666669
r7286 n4131 n4263 0.013888888888888888
r7287 n4262 n4263 0.39583333333333331
r7288 n4132 n4264 0.25
r7289 n4263 n4264 0.39583333333333331
r7290 n4133 n4265 0.015625
r7291 n4264 n4265 0.35416666666666669
r7292 n4134 n4266 0.25
r7293 n4265 n4266 0.35416666666666669
r7294 n4135 n4267 0.013888888888888888
r7295 n4266 n4267 0.39583333333333331
r7296 n4136 n4268 0.25
r7297 n4267 n4268 0.39583333333333331
r7298 n4137 n4269 0.015625
r7299 n4268 n4269 0.35416666666666669
r7300 n4138 n4270 0.25
r7301 n4269 n4270 0.35416666666666669
r7302 n4139 n4271 0.013888888888888888
r7303 n4270 n4271 0.39583333333333331
r7304 n4140 n4272 0.25
r7305 n4271 n4272 0.39583333333333331
r7306 n4141 n4273 0.015625
r7307 n4272 n4273 0.35416666666666669
r7308 n4142 n4274 0.25
r7309 n4273 n4274 0.35416666666666669
r7310 n4143 n4275 0.013888888888888888
r7311 n4274 n4275 0.39583333333333331
r7312 n4144 n4276 0.25
r7313 n4275 n4276 0.39583333333333331
r7314 n4145 n4277 0.015625
r7315 n4276 n4277 0.35416666666666669
r7316 n4146 n4278 0.25
r7317 n4277 n4278 0.35416666666666669
r7318 n4147 n4279 0.033333333333333333
r7319 n4278 n4279 0.17708333333333334
r7320 n4148 n4280 0.041666666666666664
r7321 n4279 n4280 0.28125
r7322 n4149 n4281 0.055555555555555552
r7323 n4280 n4281 0.21875
r7324 n4150 n4282 0.25
r7325 n4281 n4282 0.11458333333333333
r7326 n4151 n4283 0.25
r7327 n4282 n4283 0.041666666666666664
r7328 n4152 n4284 0.0625
r7329 n4283 n4284 0.10416666666666667
r7330 n4153 n4285 0.022727272727272728
r7331 n4284 n4285 0.3125
r7332 n4154 n4286 0.5
r7333 n4285 n4286 0.23958333333333334
r7334 n4155 n4287 0.5
r7335 n4286 n4287 0.020833333333333332
r7336 n4156 n4288 0.5
r7337 n4287 n4288 0.020833333333333332
r7338 n4157 n4289 0.050000000000000003
r7339 n4288 n4289 0.11458333333333333
r7340 n4158 n4290 0.041666666666666664
r7341 n4289 n4290 0.22916666666666666
r7342 n4159 n4291 0.0625
r7343 n4290 n4291 0.20833333333333334
r7344 n4160 n4292 0.25
r7345 n4291 n4292 0.10416666666666667
r7346 n4161 n4293 0.16666666666666666
r7347 n4292 n4293 0.052083333333333336
r7348 n4162 n4294 0.25
r7349 n4293 n4294 0.052083333333333336
r7350 n4163 n4295 0.083333333333333329
r7351 n4294 n4295 0.083333333333333329
r7352 n4164 n4296 0.041666666666666664
r7353 n4295 n4296 0.1875
r7354 n4165 n4297 0.035714285714285712
r7355 n4296 n4297 0.27083333333333331
r7356 n4166 n4298 0.25
r7357 n4297 n4298 0.16666666666666666
r7358 n4167 n4299 0.013888888888888888
r7359 n4298 n4299 0.39583333333333331
r7360 n4168 n4300 0.25
r7361 n4299 n4300 0.39583333333333331
r7362 n4169 n4301 0.015625
r7363 n4300 n4301 0.35416666666666669
r7364 n4170 n4302 0.25
r7365 n4301 n4302 0.35416666666666669
r7366 n4171 n4303 0.013888888888888888
r7367 n4302 n4303 0.39583333333333331
r7368 n4172 n4304 0.25
r7369 n4303 n4304 0.39583333333333331
r7370 n4173 n4305 0.015625
r7371 n4304 n4305 0.35416666666666669
r7372 n4174 n4306 0.25
r7373 n4305 n4306 0.35416666666666669
r7374 n4175 n4307 0.013888888888888888
r7375 n4306 n4307 0.39583333333333331
r7376 n4176 n4308 0.25
r7377 n4307 n4308 0.39583333333333331
r7378 n4177 n4309 0.015625
r7379 n4308 n4309 0.35416666666666669
r7380 n4178 n4310 0.25
r7381 n4309 n4310 0.35416666666666669
r7382 n4179 n4311 0.013888888888888888
r7383 n4310 n4311 0.39583333333333331
r7384 n4180 n4312 0.25
r7385 n4311 n4312 0.39583333333333331
r7386 n4181 n4313 0.015625
r7387 n4312 n4313 0.35416666666666669
r7388 n4182 n4314 0.25
r7389 n4313 n4314 0.35416666666666669
r7390 n4183 n4315 0.013888888888888888
r7391 n4314 n4315 0.39583333333333331
r7392 n4184 n4316 0.25
r7393 n4315 n4316 0.39583333333333331
r7394 n4185 n4317 0.015625
r7395 n4316 n4317 0.35416666666666669
r7396 n4186 n4318 0.25
r7397 n4317 n4318 0.35416666666666669
r7398 n4187 n4319 0.013888888888888888
r7399 n4318 n4319 0.39583333333333331
r7400 n4188 n4320 0.25
r7401 n4319 n4320 0.39583333333333331
r7402 n4189 n4321 0.015625
r7403 n4320 n4321 0.35416666666666669
r7404 n4190 n4322 0.25
r7405 n4321 n4322 0.35416666666666669
r7406 n4191 n4323 0.013888888888888888
r7407 n4322 n4323 0.39583333333333331
r7408 n4192 n4324 0.25
r7409 n4323 n4324 0.39583333333333331
r7410 n4193 n4325 0.015625
r7411 n4324 n4325 0.35416666666666669
r7412 n4194 n4326 0.25
r7413 n4325 n4326 0.35416666666666669
r7414 n4195 n4327 0.041666666666666664
r7415 n4326 n4327 0.14583333333333334
r7416 n4196 n4328 0.050000000000000003
r7417 n4197 n4329 0.071428571428571425
r7418 n4328 n4329 0.17708333333333334
r7419 n4198 n4330 0.16666666666666666
r7420 n4329 n4330 0.10416666666666667
r7421 n4199 n4331 0.16666666666666666
r7422 n4330 n4331 0.0625
r7423 n4200 n4332 0.25
r7424 n4331 n4332 0.052083333333333336
r7425 n4201 n4333 0.045454545454545456
r7426 n4332 n4333 0.13541666666666666
r7427 n4202 n4334 0.026315789473684209
r7428 n4333 n4334 0.3125
r7429 n4203 n4335 0.25
r7430 n4334 n4335 0.21875
r7431 n4204 n4336 0.16666666666666666
r7432 n4335 n4336 0.052083333333333336
r7433 n4205 n4337 0.16666666666666666
r7434 n4336 n4337 0.0625
r7435 n4206 n4338 0.071428571428571425
r7436 n4337 n4338 0.10416666666666667
r7437 n4207 n4339 0.050000000000000003
r7438 n4338 n4339 0.17708333333333334
r7439 n4215 n4340 0.041666666666666664
r7440 n4216 n4341 0.071428571428571425
r7441 n4340 n4341 0.59375
r7442 n4217 n4342 0.25
r7443 n4341 n4342 0.28125
r7444 n4218 n4343 0.125
r7445 n4342 n4343 0.1875
r7446 n4219 n4344 0.055555555555555552
r7447 n4343 n4344 0.40625
r7448 n4220 n4345 0.023809523809523808
r7449 n4344 n4345 0.9375
r7450 n4221 n4346 0.25
r7451 n4345 n4346 0.71875
r7452 n4222 n4347 0.25
r7453 n4346 n4347 0.125
r7454 n4223 n4348 0.055555555555555552
r7455 n4347 n4348 0.34375
r7456 n4224 n4349 0.041666666666666664
r7457 n4348 n4349 0.65625
r7458 n4234 n4350 0.050000000000000003
r7459 n4235 n4351 0.071428571428571425
r7460 n4350 n4351 0.53125
r7461 n4236 n4352 0.16666666666666666
r7462 n4351 n4352 0.3125
r7463 n4237 n4353 0.16666666666666666
r7464 n4352 n4353 0.1875
r7465 n4238 n4354 0.25
r7466 n4353 n4354 0.15625
r7467 n4239 n4355 0.0625
r7468 n4354 n4355 0.3125
r7469 n4240 n4356 0.022727272727272728
r7470 n4355 n4356 0.9375
r7471 n4241 n4357 0.25
r7472 n4356 n4357 0.75
r7473 n4242 n4358 0.16666666666666666
r7474 n4357 n4358 0.15625
r7475 n4243 n4359 0.16666666666666666
r7476 n4358 n4359 0.1875
r7477 n4244 n4360 0.125
r7478 n4359 n4360 0.21875
r7479 n4245 n4361 0.16666666666666666
r7480 n4360 n4361 0.21875
r7481 n4246 n4362 0.050000000000000003
r7482 n4361 n4362 0.40625
r7483 n4280 n4363 0.041666666666666664
r7484 n4281 n4364 0.055555555555555552
r7485 n4363 n4364 0.65625
r7486 n4282 n4365 0.25
r7487 n4364 n4365 0.34375
r7488 n4283 n4366 0.25
r7489 n4365 n4366 0.125
r7490 n4284 n4367 0.0625
r7491 n4366 n4367 0.3125
r7492 n4285 n4368 0.022727272727272728
r7493 n4367 n4368 0.9375
r7494 n4286 n4369 0.5
r7495 n4368 n4369 0.71875
r7496 n4287 n4370 0.5
r7497 n4369 n4370 0.0625
r7498 n4288 n4371 0.5
r7499 n4370 n4371 0.0625
r7500 n4289 n4372 0.050000000000000003
r7501 n4371 n4372 0.34375
r7502 n4290 n4373 0.041666666666666664
r7503 n4372 n4373 0.6875
r7504 n4328 n4374 0.050000000000000003
r7505 n4329 n4375 0.071428571428571425
r7506 n4374 n4375 0.53125
r7507 n4330 n4376 0.16666666666666666
r7508 n4375 n4376 0.3125
r7509 n4331 n4377 0.16666666666666666
r7510 n4376 n4377 0.1875
r7511 n4332 n4378 0.25
r7512 n4377 n4378 0.15625
r7513 n4333 n4379 0.045454545454545456
r7514 n4378 n4379 0.40625
r7515 n4334 n4380 0.026315789473684209
r7516 n4379 n4380 0.9375
r7517 n4335 n4381 0.25
r7518 n4380 n4381 0.65625
r7519 n4336 n4382 0.16666666666666666
r7520 n4381 n4382 0.15625
r7521 n4337 n4383 0.16666666666666666
r7522 n4382 n4383 0.1875
r7523 n4338 n4384 0.071428571428571425
r7524 n4383 n4384 0.3125
r7525 n4339 n4385 0.050000000000000003
r7526 n4384 n4385 0.53125
r7527 n4340 n4386 0.026041666666666668
r7528 n4341 n4387 0.044642857142857144
r7529 n4386 n4387 0.39583333333333331
r7530 n4342 n4388 0.15625
r7531 n4387 n4388 0.1875
r7532 n4343 n4389 0.078125
r7533 n4388 n4389 0.125
r7534 n4344 n4390 0.034722222222222224
r7535 n4389 n4390 0.27083333333333331
r7536 n4345 n4391 0.01488095238095238
r7537 n4390 n4391 0.625
r7538 n4346 n4392 0.15625
r7539 n4391 n4392 0.47916666666666669
r7540 n4347 n4393 0.15625
r7541 n4392 n4393 0.083333333333333329
r7542 n4348 n4394 0.034722222222222224
r7543 n4393 n4394 0.22916666666666666
r7544 n4349 n4395 0.026041666666666668
r7545 n4394 n4395 0.4375
r7546 n4350 n4396 0.03125
r7547 n4351 n4397 0.044642857142857144
r7548 n4396 n4397 0.35416666666666669
r7549 n4352 n4398 0.10416666666666667
r7550 n4397 n4398 0.20833333333333334
r7551 n4353 n4399 0.10416666666666667
r7552 n4398 n4399 0.125
r7553 n4354 n4400 0.15625
r7554 n4399 n4400 0.10416666666666667
r7555 n4355 n4401 0.0390625
r7556 n4400 n4401 0.20833333333333334
r7557 n4356 n4402 0.014204545454545454
r7558 n4401 n4402 0.625
r7559 n4357 n4403 0.15625
r7560 n4402 n4403 0.5
r7561 n4358 n4404 0.10416666666666667
r7562 n4403 n4404 0.10416666666666667
r7563 n4359 n4405 0.10416666666666667
r7564 n4404 n4405 0.125
r7565 n4360 n4406 0.078125
r7566 n4405 n4406 0.14583333333333334
r7567 n4361 n4407 0.10416666666666667
r7568 n4406 n4407 0.14583333333333334
r7569 n4362 n4408 0.03125
r7570 n4407 n4408 0.27083333333333331
r7571 n4363 n4409 0.026041666666666668
r7572 n4364 n4410 0.034722222222222224
r7573 n4409 n4410 0.4375
r7574 n4365 n4411 0.15625
r7575 n4410 n4411 0.22916666666666666
r7576 n4366 n4412 0.15625
r7577 n4411 n4412 0.083333333333333329
r7578 n4367 n4413 0.0390625
r7579 n4412 n4413 0.20833333333333334
r7580 n4368 n4414 0.014204545454545454
r7581 n4413 n4414 0.625
r7582 n4369 n4415 0.3125
r7583 n4414 n4415 0.47916666666666669
r7584 n4370 n4416 0.3125
r7585 n4415 n4416 0.041666666666666664
r7586 n4371 n4417 0.3125
r7587 n4416 n4417 0.041666666666666664
r7588 n4372 n4418 0.03125
r7589 n4417 n4418 0.22916666666666666
r7590 n4373 n4419 0.026041666666666668
r7591 n4418 n4419 0.45833333333333331
r7592 n4374 n4420 0.03125
r7593 n4375 n4421 0.044642857142857144
r7594 n4420 n4421 0.35416666666666669
r7595 n4376 n4422 0.10416666666666667
r7596 n4421 n4422 0.20833333333333334
r7597 n4377 n4423 0.10416666666666667
r7598 n4422 n4423 0.125
r7599 n4378 n4424 0.15625
r7600 n4423 n4424 0.10416666666666667
r7601 n4379 n4425 0.028409090909090908
r7602 n4424 n4425 0.27083333333333331
r7603 n4380 n4426 0.016447368421052631
r7604 n4425 n4426 0.625
r7605 n4381 n4427 0.15625
r7606 n4426 n4427 0.4375
r7607 n4382 n4428 0.10416666666666667
r7608 n4427 n4428 0.10416666666666667
r7609 n4383 n4429 0.10416666666666667
r7610 n4428 n4429 0.125
r7611 n4384 n4430 0.044642857142857144
r7612 n4429 n4430 0.20833333333333334
r7613 n4385 n4431 0.03125
r7614 n4430 n4431 0.35416666666666669
r7615 n4386 n4432 0.026041666666666668
r7616 n4387 n4433 0.044642857142857144
r7617 n4432 n4433 0.59375
r7618 n4388 n4434 0.15625
r7619 n4433 n4434 0.28125
r7620 n4389 n4435 0.078125
r7621 n4434 n4435 0.1875
r7622 n4390 n4436 0.034722222222222224
r7623 n4435 n4436 0.40625
r7624 n4391 n4437 0.01488095238095238
r7625 n4436 n4437 0.9375
r7626 n4392 n4438 0.15625
r7627 n4437 n4438 0.71875
r7628 n4393 n4439 0.15625
r7629 n4438 n4439 0.125
r7630 n4394 n4440 0.034722222222222224
r7631 n4439 n4440 0.34375
r7632 n4395 n4441 0.026041666666666668
r7633 n4440 n4441 0.65625
r7634 n4396 n4442 0.03125
r7635 n4397 n4443 0.044642857142857144
r7636 n4442 n4443 0.53125
r7637 n4398 n4444 0.10416666666666667
r7638 n4443 n4444 0.3125
r7639 n4399 n4445 0.10416666666666667
r7640 n4444 n4445 0.1875
r7641 n4400 n4446 0.15625
r7642 n4445 n4446 0.15625
r7643 n4401 n4447 0.0390625
r7644 n4446 n4447 0.3125
r7645 n4402 n4448 0.014204545454545454
r7646 n4447 n4448 0.9375
r7647 n4403 n4449 0.15625
r7648 n4448 n4449 0.75
r7649 n4404 n4450 0.10416666666666667
r7650 n4449 n4450 0.15625
r7651 n4405 n4451 0.10416666666666667
r7652 n4450 n4451 0.1875
r7653 n4406 n4452 0.078125
r7654 n4451 n4452 0.21875
r7655 n4407 n4453 0.10416666666666667
r7656 n4452 n4453 0.21875
r7657 n4408 n4454 0.03125
r7658 n4453 n4454 0.40625
r7659 n4409 n4455 0.026041666666666668
r7660 n4410 n4456 0.034722222222222224
r7661 n4455 n4456 0.65625
r7662 n4411 n4457 0.15625
r7663 n4456 n4457 0.34375
r7664 n4412 n4458 0.15625
r7665 n4457 n4458 0.125
r7666 n4413 n4459 0.0390625
r7667 n4458 n4459 0.3125
r7668 n4414 n4460 0.014204545454545454
r7669 n4459 n4460 0.9375
r7670 n4415 n4461 0.3125
r7671 n4460 n4461 0.71875
r7672 n4416 n4462 0.3125
r7673 n4461 n4462 0.0625
r7674 n4417 n4463 0.3125
r7675 n4462 n4463 0.0625
r7676 n4418 n4464 0.03125
r7677 n4463 n4464 0.34375
r7678 n4419 n4465 0.026041666666666668
r7679 n4464 n4465 0.6875
r7680 n4420 n4466 0.03125
r7681 n4421 n4467 0.044642857142857144
r7682 n4466 n4467 0.53125
r7683 n4422 n4468 0.10416666666666667
r7684 n4467 n4468 0.3125
r7685 n4423 n4469 0.10416666666666667
r7686 n4468 n4469 0.1875
r7687 n4424 n4470 0.15625
r7688 n4469 n4470 0.15625
r7689 n4425 n4471 0.028409090909090908
r7690 n4470 n4471 0.40625
r7691 n4426 n4472 0.016447368421052631
r7692 n4471 n4472 0.9375
r7693 n4427 n4473 0.15625
r7694 n4472 n4473 0.65625
r7695 n4428 n4474 0.10416666666666667
r7696 n4473 n4474 0.15625
r7697 n4429 n4475 0.10416666666666667
r7698 n4474 n4475 0.1875
r7699 n4430 n4476 0.044642857142857144
r7700 n4475 n4476 0.3125
r7701 n4431 n4477 0.03125
r7702 n4476 n4477 0.53125
r7703 n4442 n4478 0.20000000000000001
r7704 n4443 n4479 0.2857142857142857
r7705 n4478 n4479 0.035416666666666666
r7706 n4444 n4480 0.66666666666666663
r7707 n4479 n4480 0.020833333333333332
r7708 n4445 n4481 0.66666666666666663
r7709 n4480 n4481 0.012500000000000001
r7710 n4446 n4482 1
r7711 n4481 n4482 0.010416666666666666
r7712 n4447 n4483 0.25
r7713 n4482 n4483 0.020833333333333332
r7714 n4448 n4484 0.090909090909090912
r7715 n4483 n4484 0.0625
r7716 n4449 n4485 1
r7717 n4484 n4485 0.050000000000000003
r7718 n4450 n4486 0.66666666666666663
r7719 n4485 n4486 0.010416666666666666
r7720 n4451 n4487 0.66666666666666663
r7721 n4486 n4487 0.012500000000000001
r7722 n4452 n4488 0.5
r7723 n4487 n4488 0.014583333333333334
r7724 n4453 n4489 0.66666666666666663
r7725 n4488 n4489 0.014583333333333334
r7726 n4454 n4490 0.20000000000000001
r7727 n4489 n4490 0.027083333333333334
r7728 n4466 n4491 0.20000000000000001
r7729 n4467 n4492 0.2857142857142857
r7730 n4491 n4492 0.035416666666666666
r7731 n4468 n4493 0.66666666666666663
r7732 n4492 n4493 0.020833333333333332
r7733 n4469 n4494 0.66666666666666663
r7734 n4493 n4494 0.012500000000000001
r7735 n4470 n4495 1
r7736 n4494 n4495 0.010416666666666666
r7737 n4471 n4496 0.18181818181818182
r7738 n4495 n4496 0.027083333333333334
r7739 n4472 n4497 0.10526315789473684
r7740 n4496 n4497 0.0625
r7741 n4473 n4498 1
r7742 n4497 n4498 0.043749999999999997
r7743 n4474 n4499 0.66666666666666663
r7744 n4498 n4499 0.010416666666666666
r7745 n4475 n4500 0.66666666666666663
r7746 n4499 n4500 0.012500000000000001
r7747 n4476 n4501 0.2857142857142857
r7748 n4500 n4501 0.020833333333333332
r7749 n4477 n4502 0.20000000000000001
r7750 n4501 n4502 0.035416666666666666
r7751 n4503 n4504 0.59375
r7752 n4504 n4505 0.28125
r7753 n4505 n4506 0.1875
r7754 n4506 n4507 0.40625
r7755 n4507 n4508 0.9375
r7756 n4508 n4509 0.71875
r7757 n4509 n4510 0.125
r7758 n4510 n4511 0.34375
r7759 n4511 n4512 0.65625
r7760 n4478 n4513 0.20000000000000001
r7761 n4479 n4514 0.2857142857142857
r7762 n4513 n4514 0.53125
r7763 n4480 n4515 0.66666666666666663
r7764 n4514 n4515 0.3125
r7765 n4481 n4516 0.66666666666666663
r7766 n4515 n4516 0.1875
r7767 n4482 n4517 1
r7768 n4516 n4517 0.15625
r7769 n4483 n4518 0.25
r7770 n4517 n4518 0.3125
r7771 n4484 n4519 0.090909090909090912
r7772 n4518 n4519 0.9375
r7773 n4485 n4520 1
r7774 n4519 n4520 0.75
r7775 n4486 n4521 0.66666666666666663
r7776 n4520 n4521 0.15625
r7777 n4487 n4522 0.66666666666666663
r7778 n4521 n4522 0.1875
r7779 n4488 n4523 0.5
r7780 n4522 n4523 0.21875
r7781 n4489 n4524 0.66666666666666663
r7782 n4523 n4524 0.21875
r7783 n4490 n4525 0.20000000000000001
r7784 n4524 n4525 0.40625
r7785 n4526 n4527 0.65625
r7786 n4527 n4528 0.34375
r7787 n4528 n4529 0.125
r7788 n4529 n4530 0.3125
r7789 n4530 n4531 0.9375
r7790 n4531 n4532 0.71875
r7791 n4532 n4533 0.0625
r7792 n4533 n4534 0.0625
r7793 n4534 n4535 0.34375
r7794 n4535 n4536 0.6875
r7795 n4491 n4537 0.20000000000000001
r7796 n4492 n4538 0.2857142857142857
r7797 n4537 n4538 0.53125
r7798 n4493 n4539 0.66666666666666663
r7799 n4538 n4539 0.3125
r7800 n4494 n4540 0.66666666666666663
r7801 n4539 n4540 0.1875
r7802 n4495 n4541 1
r7803 n4540 n4541 0.15625
r7804 n4496 n4542 0.18181818181818182
r7805 n4541 n4542 0.40625
r7806 n4497 n4543 0.10526315789473684
r7807 n4542 n4543 0.9375
r7808 n4498 n4544 1
r7809 n4543 n4544 0.65625
r7810 n4499 n4545 0.66666666666666663
r7811 n4544 n4545 0.15625
r7812 n4500 n4546 0.66666666666666663
r7813 n4545 n4546 0.1875
r7814 n4501 n4547 0.2857142857142857
r7815 n4546 n4547 0.3125
r7816 n4502 n4548 0.20000000000000001
r7817 n4547 n4548 0.53125
r7818 n4503 n4549 0.026041666666666668
r7819 n4504 n4550 0.044642857142857144
r7820 n4549 n4550 0.39583333333333331
r7821 n4505 n4551 0.15625
r7822 n4550 n4551 0.1875
r7823 n4506 n4552 0.078125
r7824 n4551 n4552 0.125
r7825 n4507 n4553 0.034722222222222224
r7826 n4552 n4553 0.27083333333333331
r7827 n4508 n4554 0.01488095238095238
r7828 n4553 n4554 0.625
r7829 n4509 n4555 0.15625
r7830 n4554 n4555 0.47916666666666669
r7831 n4510 n4556 0.15625
r7832 n4555 n4556 0.083333333333333329
r7833 n4511 n4557 0.034722222222222224
r7834 n4556 n4557 0.22916666666666666
r7835 n4512 n4558 0.026041666666666668
r7836 n4557 n4558 0.4375
r7837 n4513 n4559 0.03125
r7838 n4514 n4560 0.044642857142857144
r7839 n4559 n4560 0.35416666666666669
r7840 n4515 n4561 0.10416666666666667
r7841 n4560 n4561 0.20833333333333334
r7842 n4516 n4562 0.10416666666666667
r7843 n4561 n4562 0.125
r7844 n4517 n4563 0.15625
r7845 n4562 n4563 0.10416666666666667
r7846 n4518 n4564 0.0390625
r7847 n4563 n4564 0.20833333333333334
r7848 n4519 n4565 0.014204545454545454
r7849 n4564 n4565 0.625
r7850 n4520 n4566 0.15625
r7851 n4565 n4566 0.5
r7852 n4521 n4567 0.10416666666666667
r7853 n4566 n4567 0.10416666666666667
r7854 n4522 n4568 0.10416666666666667
r7855 n4567 n4568 0.125
r7856 n4523 n4569 0.078125
r7857 n4568 n4569 0.14583333333333334
r7858 n4524 n4570 0.10416666666666667
r7859 n4569 n4570 0.14583333333333334
r7860 n4525 n4571 0.03125
r7861 n4570 n4571 0.27083333333333331
r7862 n4526 n4572 0.026041666666666668
r7863 n4527 n4573 0.034722222222222224
r7864 n4572 n4573 0.4375
r7865 n4528 n4574 0.15625
r7866 n4573 n4574 0.22916666666666666
r7867 n4529 n4575 0.15625
r7868 n4574 n4575 0.083333333333333329
r7869 n4530 n4576 0.0390625
r7870 n4575 n4576 0.20833333333333334
r7871 n4531 n4577 0.014204545454545454
r7872 n4576 n4577 0.625
r7873 n4532 n4578 0.3125
r7874 n4577 n4578 0.47916666666666669
r7875 n4533 n4579 0.3125
r7876 n4578 n4579 0.041666666666666664
r7877 n4534 n4580 0.3125
r7878 n4579 n4580 0.041666666666666664
r7879 n4535 n4581 0.03125
r7880 n4580 n4581 0.22916666666666666
r7881 n4536 n4582 0.026041666666666668
r7882 n4581 n4582 0.45833333333333331
r7883 n4537 n4583 0.03125
r7884 n4538 n4584 0.044642857142857144
r7885 n4583 n4584 0.35416666666666669
r7886 n4539 n4585 0.10416666666666667
r7887 n4584 n4585 0.20833333333333334
r7888 n4540 n4586 0.10416666666666667
r7889 n4585 n4586 0.125
r7890 n4541 n4587 0.15625
r7891 n4586 n4587 0.10416666666666667
r7892 n4542 n4588 0.028409090909090908
r7893 n4587 n4588 0.27083333333333331
r7894 n4543 n4589 0.016447368421052631
r7895 n4588 n4589 0.625
r7896 n4544 n4590 0.15625
r7897 n4589 n4590 0.4375
r7898 n4545 n4591 0.10416666666666667
r7899 n4590 n4591 0.10416666666666667
r7900 n4546 n4592 0.10416666666666667
r7901 n4591 n4592 0.125
r7902 n4547 n4593 0.044642857142857144
r7903 n4592 n4593 0.20833333333333334
r7904 n4548 n4594 0.03125
r7905 n4593 n4594 0.35416666666666669
r7906 n4549 n4595 0.026041666666666668
r7907 n4550 n4596 0.044642857142857144
r7908 n4595 n4596 0.59375
r7909 n4551 n4597 0.15625
r7910 n4596 n4597 0.28125
r7911 n4552 n4598 0.078125
r7912 n4597 n4598 0.1875
r7913 n4553 n4599 0.034722222222222224
r7914 n4598 n4599 0.40625
r7915 n4554 n4600 0.01488095238095238
r7916 n4599 n4600 0.9375
r7917 n4555 n4601 0.15625
r7918 n4600 n4601 0.71875
r7919 n4556 n4602 0.15625
r7920 n4601 n4602 0.125
r7921 n4557 n4603 0.034722222222222224
r7922 n4602 n4603 0.34375
r7923 n4558 n4604 0.026041666666666668
r7924 n4603 n4604 0.65625
r7925 n4559 n4605 0.03125
r7926 n4560 n4606 0.044642857142857144
r7927 n4605 n4606 0.53125
r7928 n4561 n4607 0.10416666666666667
r7929 n4606 n4607 0.3125
r7930 n4562 n4608 0.10416666666666667
r7931 n4607 n4608 0.1875
r7932 n4563 n4609 0.15625
r7933 n4608 n4609 0.15625
r7934 n4564 n4610 0.0390625
r7935 n4609 n4610 0.3125
r7936 n4565 n4611 0.014204545454545454
r7937 n4610 n4611 0.9375
r7938 n4566 n4612 0.15625
r7939 n4611 n4612 0.75
r7940 n4567 n4613 0.10416666666666667
r7941 n4612 n4613 0.15625
r7942 n4568 n4614 0.10416666666666667
r7943 n4613 n4614 0.1875
r7944 n4569 n4615 0.078125
r7945 n4614 n4615 0.21875
r7946 n4570 n4616 0.10416666666666667
r7947 n4615 n4616 0.21875
r7948 n4571 n4617 0.03125
r7949 n4616 n4617 0.40625
r7950 n4572 n4618 0.026041666666666668
r7951 n4573 n4619 0.034722222222222224
r7952 n4618 n4619 0.65625
r7953 n4574 n4620 0.15625
r7954 n4619 n4620 0.34375
r7955 n4575 n4621 0.15625
r7956 n4620 n4621 0.125
r7957 n4576 n4622 0.0390625
r7958 n4621 n4622 0.3125
r7959 n4577 n4623 0.014204545454545454
r7960 n4622 n4623 0.9375
r7961 n4578 n4624 0.3125
r7962 n4623 n4624 0.71875
r7963 n4579 n4625 0.3125
r7964 n4624 n4625 0.0625
r7965 n4580 n4626 0.3125
r7966 n4625 n4626 0.0625
r7967 n4581 n4627 0.03125
r7968 n4626 n4627 0.34375
r7969 n4582 n4628 0.026041666666666668
r7970 n4627 n4628 0.6875
r7971 n4583 n4629 0.03125
r7972 n4584 n4630 0.044642857142857144
r7973 n4629 n4630 0.53125
r7974 n4585 n4631 0.10416666666666667
r7975 n4630 n4631 0.3125
r7976 n4586 n4632 0.10416666666666667
r7977 n4631 n4632 0.1875
r7978 n4587 n4633 0.15625
r7979 n4632 n4633 0.15625
r7980 n4588 n4634 0.028409090909090908
r7981 n4633 n4634 0.40625
r7982 n4589 n4635 0.016447368421052631
r7983 n4634 n4635 0.9375
r7984 n4590 n4636 0.15625
r7985 n4635 n4636 0.65625
r7986 n4591 n4637 0.10416666666666667
r7987 n4636 n4637 0.15625
r7988 n4592 n4638 0.10416666666666667
r7989 n4637 n4638 0.1875
r7990 n4593 n4639 0.044642857142857144
r7991 n4638 n4639 0.3125
r7992 n4594 n4640 0.03125
r7993 n4639 n4640 0.53125
r7994 n4641 n4642 0.125
r7995 n4642 n4643 0.35416666666666669
r7996 n4643 n4644 0.35416666666666669
r7997 n4644 n4645 0.39583333333333331
r7998 n4645 n4646 0.39583333333333331
r7999 n4646 n4647 0.15625
r8000 n4595 n4648 0.041666666666666664
r8001 n4647 n4648 0.26041666666666669
r8002 n4596 n4649 0.071428571428571425
r8003 n4648 n4649 0.19791666666666666
r8004 n4597 n4650 0.25
r8005 n4649 n4650 0.09375
r8006 n4598 n4651 0.125
r8007 n4650 n4651 0.0625
r8008 n4599 n4652 0.055555555555555552
r8009 n4651 n4652 0.13541666666666666
r8010 n4600 n4653 0.023809523809523808
r8011 n4652 n4653 0.3125
r8012 n4601 n4654 0.25
r8013 n4653 n4654 0.23958333333333334
r8014 n4602 n4655 0.25
r8015 n4654 n4655 0.041666666666666664
r8016 n4603 n4656 0.055555555555555552
r8017 n4655 n4656 0.11458333333333333
r8018 n4604 n4657 0.041666666666666664
r8019 n4656 n4657 0.21875
r8020 n4657 n4658 0.21875
r8021 n4658 n4659 0.11458333333333333
r8022 n4659 n4660 0.041666666666666664
r8023 n4660 n4661 0.23958333333333334
r8024 n4661 n4662 0.375
r8025 n4662 n4663 0.17708333333333334
r8026 n4663 n4664 0.35416666666666669
r8027 n4664 n4665 0.35416666666666669
r8028 n4665 n4666 0.14583333333333334
r8029 n4605 n4667 0.050000000000000003
r8030 n4606 n4668 0.071428571428571425
r8031 n4667 n4668 0.17708333333333334
r8032 n4607 n4669 0.16666666666666666
r8033 n4668 n4669 0.10416666666666667
r8034 n4608 n4670 0.16666666666666666
r8035 n4669 n4670 0.0625
r8036 n4609 n4671 0.25
r8037 n4670 n4671 0.052083333333333336
r8038 n4610 n4672 0.0625
r8039 n4671 n4672 0.10416666666666667
r8040 n4611 n4673 0.022727272727272728
r8041 n4672 n4673 0.3125
r8042 n4612 n4674 0.25
r8043 n4673 n4674 0.25
r8044 n4613 n4675 0.16666666666666666
r8045 n4674 n4675 0.052083333333333336
r8046 n4614 n4676 0.16666666666666666
r8047 n4675 n4676 0.0625
r8048 n4615 n4677 0.125
r8049 n4676 n4677 0.072916666666666671
r8050 n4616 n4678 0.16666666666666666
r8051 n4677 n4678 0.072916666666666671
r8052 n4617 n4679 0.050000000000000003
r8053 n4678 n4679 0.13541666666666666
r8054 n4680 n4681 0.125
r8055 n4681 n4682 0.35416666666666669
r8056 n4682 n4683 0.35416666666666669
r8057 n4683 n4684 0.39583333333333331
r8058 n4684 n4685 0.39583333333333331
r8059 n4685 n4686 0.35416666666666669
r8060 n4686 n4687 0.35416666666666669
r8061 n4687 n4688 0.39583333333333331
r8062 n4688 n4689 0.39583333333333331
r8063 n4689 n4690 0.35416666666666669
r8064 n4690 n4691 0.35416666666666669
r8065 n4691 n4692 0.39583333333333331
r8066 n4692 n4693 0.39583333333333331
r8067 n4693 n4694 0.35416666666666669
r8068 n4694 n4695 0.35416666666666669
r8069 n4695 n4696 0.39583333333333331
r8070 n4696 n4697 0.39583333333333331
r8071 n4697 n4698 0.35416666666666669
r8072 n4698 n4699 0.35416666666666669
r8073 n4699 n4700 0.39583333333333331
r8074 n4700 n4701 0.39583333333333331
r8075 n4701 n4702 0.35416666666666669
r8076 n4702 n4703 0.35416666666666669
r8077 n4703 n4704 0.39583333333333331
r8078 n4704 n4705 0.39583333333333331
r8079 n4705 n4706 0.35416666666666669
r8080 n4706 n4707 0.35416666666666669
r8081 n4707 n4708 0.39583333333333331
r8082 n4708 n4709 0.39583333333333331
r8083 n4709 n4710 0.35416666666666669
r8084 n4710 n4711 0.35416666666666669
r8085 n4711 n4712 0.17708333333333334
r8086 n4618 n4713 0.041666666666666664
r8087 n4712 n4713 0.28125
r8088 n4619 n4714 0.055555555555555552
r8089 n4713 n4714 0.21875
r8090 n4620 n4715 0.25
r8091 n4714 n4715 0.11458333333333333
r8092 n4621 n4716 0.25
r8093 n4715 n4716 0.041666666666666664
r8094 n4622 n4717 0.0625
r8095 n4716 n4717 0.10416666666666667
r8096 n4623 n4718 0.022727272727272728
r8097 n4717 n4718 0.3125
r8098 n4624 n4719 0.5
r8099 n4718 n4719 0.23958333333333334
r8100 n4625 n4720 0.5
r8101 n4719 n4720 0.020833333333333332
r8102 n4626 n4721 0.5
r8103 n4720 n4721 0.020833333333333332
r8104 n4627 n4722 0.050000000000000003
r8105 n4721 n4722 0.11458333333333333
r8106 n4628 n4723 0.041666666666666664
r8107 n4722 n4723 0.22916666666666666
r8108 n4723 n4724 0.20833333333333334
r8109 n4724 n4725 0.10416666666666667
r8110 n4725 n4726 0.052083333333333336
r8111 n4726 n4727 0.052083333333333336
r8112 n4727 n4728 0.083333333333333329
r8113 n4728 n4729 0.1875
r8114 n4729 n4730 0.27083333333333331
r8115 n4730 n4731 0.16666666666666666
r8116 n4731 n4732 0.39583333333333331
r8117 n4732 n4733 0.39583333333333331
r8118 n4733 n4734 0.35416666666666669
r8119 n4734 n4735 0.35416666666666669
r8120 n4735 n4736 0.39583333333333331
r8121 n4736 n4737 0.39583333333333331
r8122 n4737 n4738 0.35416666666666669
r8123 n4738 n4739 0.35416666666666669
r8124 n4739 n4740 0.39583333333333331
r8125 n4740 n4741 0.39583333333333331
r8126 n4741 n4742 0.35416666666666669
r8127 n4742 n4743 0.35416666666666669
r8128 n4743 n4744 0.39583333333333331
r8129 n4744 n4745 0.39583333333333331
r8130 n4745 n4746 0.35416666666666669
r8131 n4746 n4747 0.35416666666666669
r8132 n4747 n4748 0.39583333333333331
r8133 n4748 n4749 0.39583333333333331
r8134 n4749 n4750 0.35416666666666669
r8135 n4750 n4751 0.35416666666666669
r8136 n4751 n4752 0.39583333333333331
r8137 n4752 n4753 0.39583333333333331
r8138 n4753 n4754 0.35416666666666669
r8139 n4754 n4755 0.35416666666666669
r8140 n4755 n4756 0.39583333333333331
r8141 n4756 n4757 0.39583333333333331
r8142 n4757 n4758 0.35416666666666669
r8143 n4758 n4759 0.35416666666666669
r8144 n4759 n4760 0.14583333333333334
r8145 n4629 n4761 0.050000000000000003
r8146 n4630 n4762 0.071428571428571425
r8147 n4761 n4762 0.17708333333333334
r8148 n4631 n4763 0.16666666666666666
r8149 n4762 n4763 0.10416666666666667
r8150 n4632 n4764 0.16666666666666666
r8151 n4763 n4764 0.0625
r8152 n4633 n4765 0.25
r8153 n4764 n4765 0.052083333333333336
r8154 n4634 n4766 0.045454545454545456
r8155 n4765 n4766 0.13541666666666666
r8156 n4635 n4767 0.026315789473684209
r8157 n4766 n4767 0.3125
r8158 n4636 n4768 0.25
r8159 n4767 n4768 0.21875
r8160 n4637 n4769 0.16666666666666666
r8161 n4768 n4769 0.052083333333333336
r8162 n4638 n4770 0.16666666666666666
r8163 n4769 n4770 0.0625
r8164 n4639 n4771 0.071428571428571425
r8165 n4770 n4771 0.10416666666666667
r8166 n4640 n4772 0.050000000000000003
r8167 n4771 n4772 0.17708333333333334
r8168 n4641 n4773 0.050000000000000003
r8169 n4642 n4774 0.25
r8170 n4773 n4774 0.375
r8171 n4643 n4775 0.015625
r8172 n4774 n4775 1.0625
r8173 n4644 n4776 0.25
r8174 n4775 n4776 1.0625
r8175 n4645 n4777 0.013888888888888888
r8176 n4776 n4777 1.1875
r8177 n4646 n4778 0.25
r8178 n4777 n4778 1.1875
r8179 n4647 n4779 0.038461538461538464
r8180 n4778 n4779 0.46875
r8181 n4648 n4780 0.041666666666666664
r8182 n4779 n4780 0.78125
r8183 n4649 n4781 0.071428571428571425
r8184 n4780 n4781 0.59375
r8185 n4650 n4782 0.25
r8186 n4781 n4782 0.28125
r8187 n4651 n4783 0.125
r8188 n4782 n4783 0.1875
r8189 n4652 n4784 0.055555555555555552
r8190 n4783 n4784 0.40625
r8191 n4653 n4785 0.023809523809523808
r8192 n4784 n4785 0.9375
r8193 n4654 n4786 0.25
r8194 n4785 n4786 0.71875
r8195 n4655 n4787 0.25
r8196 n4786 n4787 0.125
r8197 n4656 n4788 0.055555555555555552
r8198 n4787 n4788 0.34375
r8199 n4657 n4789 0.041666666666666664
r8200 n4788 n4789 0.65625
r8201 n4658 n4790 0.055555555555555552
r8202 n4789 n4790 0.65625
r8203 n4659 n4791 0.25
r8204 n4790 n4791 0.34375
r8205 n4660 n4792 0.25
r8206 n4791 n4792 0.125
r8207 n4661 n4793 0.023809523809523808
r8208 n4792 n4793 0.71875
r8209 n4662 n4794 0.033333333333333333
r8210 n4793 n4794 1.125
r8211 n4663 n4795 0.25
r8212 n4794 n4795 0.53125
r8213 n4664 n4796 0.015625
r8214 n4795 n4796 1.0625
r8215 n4665 n4797 0.25
r8216 n4796 n4797 1.0625
r8217 n4666 n4798 0.041666666666666664
r8218 n4797 n4798 0.4375
r8219 n4667 n4799 0.050000000000000003
r8220 n4668 n4800 0.071428571428571425
r8221 n4799 n4800 0.53125
r8222 n4669 n4801 0.16666666666666666
r8223 n4800 n4801 0.3125
r8224 n4670 n4802 0.16666666666666666
r8225 n4801 n4802 0.1875
r8226 n4671 n4803 0.25
r8227 n4802 n4803 0.15625
r8228 n4672 n4804 0.0625
r8229 n4803 n4804 0.3125
r8230 n4673 n4805 0.022727272727272728
r8231 n4804 n4805 0.9375
r8232 n4674 n4806 0.25
r8233 n4805 n4806 0.75
r8234 n4675 n4807 0.16666666666666666
r8235 n4806 n4807 0.15625
r8236 n4676 n4808 0.16666666666666666
r8237 n4807 n4808 0.1875
r8238 n4677 n4809 0.125
r8239 n4808 n4809 0.21875
r8240 n4678 n4810 0.16666666666666666
r8241 n4809 n4810 0.21875
r8242 n4679 n4811 0.050000000000000003
r8243 n4810 n4811 0.40625
r8244 n4680 n4812 0.050000000000000003
r8245 n4681 n4813 0.25
r8246 n4812 n4813 0.375
r8247 n4682 n4814 0.015625
r8248 n4813 n4814 1.0625
r8249 n4683 n4815 0.25
r8250 n4814 n4815 1.0625
r8251 n4684 n4816 0.013888888888888888
r8252 n4815 n4816 1.1875
r8253 n4685 n4817 0.25
r8254 n4816 n4817 1.1875
r8255 n4686 n4818 0.015625
r8256 n4817 n4818 1.0625
r8257 n4687 n4819 0.25
r8258 n4818 n4819 1.0625
r8259 n4688 n4820 0.013888888888888888
r8260 n4819 n4820 1.1875
r8261 n4689 n4821 0.25
r8262 n4820 n4821 1.1875
r8263 n4690 n4822 0.015625
r8264 n4821 n4822 1.0625
r8265 n4691 n4823 0.25
r8266 n4822 n4823 1.0625
r8267 n4692 n4824 0.013888888888888888
r8268 n4823 n4824 1.1875
r8269 n4693 n4825 0.25
r8270 n4824 n4825 1.1875
r8271 n4694 n4826 0.015625
r8272 n4825 n4826 1.0625
r8273 n4695 n4827 0.25
r8274 n4826 n4827 1.0625
r8275 n4696 n4828 0.013888888888888888
r8276 n4827 n4828 1.1875
r8277 n4697 n4829 0.25
r8278 n4828 n4829 1.1875
r8279 n4698 n4830 0.015625
r8280 n4829 n4830 1.0625
r8281 n4699 n4831 0.25
r8282 n4830 n4831 1.0625
r8283 n4700 n4832 0.013888888888888888
r8284 n4831 n4832 1.1875
r8285 n4701 n4833 0.25
r8286 n4832 n4833 1.1875
r8287 n4702 n4834 0.015625
r8288 n4833 n4834 1.0625
r8289 n4703 n4835 0.25
r8290 n4834 n4835 1.0625
r8291 n4704 n4836 0.013888888888888888
r8292 n4835 n4836 1.1875
r8293 n4705 n4837 0.25
r8294 n4836 n4837 1.1875
r8295 n4706 n4838 0.015625
r8296 n4837 n4838 1.0625
r8297 n4707 n4839 0.25
r8298 n4838 n4839 1.0625
r8299 n4708 n4840 0.013888888888888888
r8300 n4839 n4840 1.1875
r8301 n4709 n4841 0.25
r8302 n4840 n4841 1.1875
r8303 n4710 n4842 0.015625
r8304 n4841 n4842 1.0625
r8305 n4711 n4843 0.25
r8306 n4842 n4843 1.0625
r8307 n4712 n4844 0.033333333333333333
r8308 n4843 n4844 0.53125
r8309 n4713 n4845 0.041666666666666664
r8310 n4844 n4845 0.84375
r8311 n4714 n4846 0.055555555555555552
r8312 n4845 n4846 0.65625
r8313 n4715 n4847 0.25
r8314 n4846 n4847 0.34375
r8315 n4716 n4848 0.25
r8316 n4847 n4848 0.125
r8317 n4717 n4849 0.0625
r8318 n4848 n4849 0.3125
r8319 n4718 n4850 0.022727272727272728
r8320 n4849 n4850 0.9375
r8321 n4719 n4851 0.5
r8322 n4850 n4851 0.71875
r8323 n4720 n4852 0.5
r8324 n4851 n4852 0.0625
r8325 n4721 n4853 0.5
r8326 n4852 n4853 0.0625
r8327 n4722 n4854 0.050000000000000003
r8328 n4853 n4854 0.34375
r8329 n4723 n4855 0.041666666666666664
r8330 n4854 n4855 0.6875
r8331 n4724 n4856 0.0625
r8332 n4855 n4856 0.625
r8333 n4725 n4857 0.25
r8334 n4856 n4857 0.3125
r8335 n4726 n4858 0.16666666666666666
r8336 n4857 n4858 0.15625
r8337 n4727 n4859 0.25
r8338 n4858 n4859 0.15625
r8339 n4728 n4860 0.083333333333333329
r8340 n4859 n4860 0.25
r8341 n4729 n4861 0.041666666666666664
r8342 n4860 n4861 0.5625
r8343 n4730 n4862 0.035714285714285712
r8344 n4861 n4862 0.8125
r8345 n4731 n4863 0.25
r8346 n4862 n4863 0.5
r8347 n4732 n4864 0.013888888888888888
r8348 n4863 n4864 1.1875
r8349 n4733 n4865 0.25
r8350 n4864 n4865 1.1875
r8351 n4734 n4866 0.015625
r8352 n4865 n4866 1.0625
r8353 n4735 n4867 0.25
r8354 n4866 n4867 1.0625
r8355 n4736 n4868 0.013888888888888888
r8356 n4867 n4868 1.1875
r8357 n4737 n4869 0.25
r8358 n4868 n4869 1.1875
r8359 n4738 n4870 0.015625
r8360 n4869 n4870 1.0625
r8361 n4739 n4871 0.25
r8362 n4870 n4871 1.0625
r8363 n4740 n4872 0.013888888888888888
r8364 n4871 n4872 1.1875
r8365 n4741 n4873 0.25
r8366 n4872 n4873 1.1875
r8367 n4742 n4874 0.015625
r8368 n4873 n4874 1.0625
r8369 n4743 n4875 0.25
r8370 n4874 n4875 1.0625
r8371 n4744 n4876 0.013888888888888888
r8372 n4875 n4876 1.1875
r8373 n4745 n4877 0.25
r8374 n4876 n4877 1.1875
r8375 n4746 n4878 0.015625
r8376 n4877 n4878 1.0625
r8377 n4747 n4879 0.25
r8378 n4878 n4879 1.0625
r8379 n4748 n4880 0.013888888888888888
r8380 n4879 n4880 1.1875
r8381 n4749 n4881 0.25
r8382 n4880 n4881 1.1875
r8383 n4750 n4882 0.015625
r8384 n4881 n4882 1.0625
r8385 n4751 n4883 0.25
r8386 n4882 n4883 1.0625
r8387 n4752 n4884 0.013888888888888888
r8388 n4883 n4884 1.1875
r8389 n4753 n4885 0.25
r8390 n4884 n4885 1.1875
r8391 n4754 n4886 0.015625
r8392 n4885 n4886 1.0625
r8393 n4755 n4887 0.25
r8394 n4886 n4887 1.0625
r8395 n4756 n4888 0.013888888888888888
r8396 n4887 n4888 1.1875
r8397 n4757 n4889 0.25
r8398 n4888 n4889 1.1875
r8399 n4758 n4890 0.015625
r8400 n4889 n4890 1.0625
r8401 n4759 n4891 0.25
r8402 n4890 n4891 1.0625
r8403 n4760 n4892 0.041666666666666664
r8404 n4891 n4892 0.4375
r8405 n4761 n4893 0.050000000000000003
r8406 n4762 n4894 0.071428571428571425
r8407 n4893 n4894 0.53125
r8408 n4763 n4895 0.16666666666666666
r8409 n4894 n4895 0.3125
r8410 n4764 n4896 0.16666666666666666
r8411 n4895 n4896 0.1875
r8412 n4765 n4897 0.25
r8413 n4896 n4897 0.15625
r8414 n4766 n4898 0.045454545454545456
r8415 n4897 n4898 0.40625
r8416 n4767 n4899 0.026315789473684209
r8417 n4898 n4899 0.9375
r8418 n4768 n4900 0.25
r8419 n4899 n4900 0.65625
r8420 n4769 n4901 0.16666666666666666
r8421 n4900 n4901 0.15625
r8422 n4770 n4902 0.16666666666666666
r8423 n4901 n4902 0.1875
r8424 n4771 n4903 0.071428571428571425
r8425 n4902 n4903 0.3125
r8426 n4772 n4904 0.050000000000000003
r8427 n4903 n4904 0.53125
r8428 n4773 n4905 0.03125
r8429 n4774 n4906 0.15625
r8430 n4905 n4906 0.25
r8431 n4775 n4907 0.009765625
r8432 n4906 n4907 0.70833333333333337
r8433 n4776 n4908 0.15625
r8434 n4907 n4908 0.70833333333333337
r8435 n4777 n4909 0.0086805555555555559
r8436 n4908 n4909 0.79166666666666663
r8437 n4778 n4910 0.15625
r8438 n4909 n4910 0.79166666666666663
r8439 n4779 n4911 0.02403846153846154
r8440 n4910 n4911 0.3125
r8441 n4780 n4912 0.026041666666666668
r8442 n4911 n4912 0.52083333333333337
r8443 n4781 n4913 0.044642857142857144
r8444 n4912 n4913 0.39583333333333331
r8445 n4782 n4914 0.15625
r8446 n4913 n4914 0.1875
r8447 n4783 n4915 0.078125
r8448 n4914 n4915 0.125
r8449 n4784 n4916 0.034722222222222224
r8450 n4915 n4916 0.27083333333333331
r8451 n4785 n4917 0.01488095238095238
r8452 n4916 n4917 0.625
r8453 n4786 n4918 0.15625
r8454 n4917 n4918 0.47916666666666669
r8455 n4787 n4919 0.15625
r8456 n4918 n4919 0.083333333333333329
r8457 n4788 n4920 0.034722222222222224
r8458 n4919 n4920 0.22916666666666666
r8459 n4789 n4921 0.026041666666666668
r8460 n4920 n4921 0.4375
r8461 n4790 n4922 0.034722222222222224
r8462 n4921 n4922 0.4375
r8463 n4791 n4923 0.15625
r8464 n4922 n4923 0.22916666666666666
r8465 n4792 n4924 0.15625
r8466 n4923 n4924 0.083333333333333329
r8467 n4793 n4925 0.01488095238095238
r8468 n4924 n4925 0.47916666666666669
r8469 n4794 n4926 0.020833333333333332
r8470 n4925 n4926 0.75
r8471 n4795 n4927 0.15625
r8472 n4926 n4927 0.35416666666666669
r8473 n4796 n4928 0.009765625
r8474 n4927 n4928 0.70833333333333337
r8475 n4797 n4929 0.15625
r8476 n4928 n4929 0.70833333333333337
r8477 n4798 n4930 0.026041666666666668
r8478 n4929 n4930 0.29166666666666669
r8479 n4801 n4931 0.10416666666666667
r8480 n4802 n4932 0.10416666666666667
r8481 n4931 n4932 0.125
r8482 n4803 n4933 0.15625
r8483 n4932 n4933 0.10416666666666667
r8484 n4804 n4934 0.0390625
r8485 n4933 n4934 0.20833333333333334
r8486 n4805 n4935 0.014204545454545454
r8487 n4934 n4935 0.625
r8488 n4806 n4936 0.15625
r8489 n4935 n4936 0.5
r8490 n4807 n4937 0.10416666666666667
r8491 n4936 n4937 0.10416666666666667
r8492 n4808 n4938 0.10416666666666667
r8493 n4937 n4938 0.125
r8494 n4812 n4939 0.03125
r8495 n4813 n4940 0.15625
r8496 n4939 n4940 0.25
r8497 n4814 n4941 0.009765625
r8498 n4940 n4941 0.70833333333333337
r8499 n4815 n4942 0.15625
r8500 n4941 n4942 0.70833333333333337
r8501 n4816 n4943 0.0086805555555555559
r8502 n4942 n4943 0.79166666666666663
r8503 n4817 n4944 0.15625
r8504 n4943 n4944 0.79166666666666663
r8505 n4818 n4945 0.009765625
r8506 n4944 n4945 0.70833333333333337
r8507 n4819 n4946 0.15625
r8508 n4945 n4946 0.70833333333333337
r8509 n4820 n4947 0.0086805555555555559
r8510 n4946 n4947 0.79166666666666663
r8511 n4821 n4948 0.15625
r8512 n4947 n4948 0.79166666666666663
r8513 n4822 n4949 0.009765625
r8514 n4948 n4949 0.70833333333333337
r8515 n4823 n4950 0.15625
r8516 n4949 n4950 0.70833333333333337
r8517 n4824 n4951 0.0086805555555555559
r8518 n4950 n4951 0.79166666666666663
r8519 n4825 n4952 0.15625
r8520 n4951 n4952 0.79166666666666663
r8521 n4826 n4953 0.009765625
r8522 n4952 n4953 0.70833333333333337
r8523 n4827 n4954 0.15625
r8524 n4953 n4954 0.70833333333333337
r8525 n4828 n4955 0.0086805555555555559
r8526 n4954 n4955 0.79166666666666663
r8527 n4829 n4956 0.15625
r8528 n4955 n4956 0.79166666666666663
r8529 n4830 n4957 0.009765625
r8530 n4956 n4957 0.70833333333333337
r8531 n4831 n4958 0.15625
r8532 n4957 n4958 0.70833333333333337
r8533 n4832 n4959 0.0086805555555555559
r8534 n4958 n4959 0.79166666666666663
r8535 n4833 n4960 0.15625
r8536 n4959 n4960 0.79166666666666663
r8537 n4834 n4961 0.009765625
r8538 n4960 n4961 0.70833333333333337
r8539 n4835 n4962 0.15625
r8540 n4961 n4962 0.70833333333333337
r8541 n4836 n4963 0.0086805555555555559
r8542 n4962 n4963 0.79166666666666663
r8543 n4837 n4964 0.15625
r8544 n4963 n4964 0.79166666666666663
r8545 n4838 n4965 0.009765625
r8546 n4964 n4965 0.70833333333333337
r8547 n4839 n4966 0.15625
r8548 n4965 n4966 0.70833333333333337
r8549 n4840 n4967 0.0086805555555555559
r8550 n4966 n4967 0.79166666666666663
r8551 n4841 n4968 0.15625
r8552 n4967 n4968 0.79166666666666663
r8553 n4842 n4969 0.009765625
r8554 n4968 n4969 0.70833333333333337
r8555 n4843 n4970 0.15625
r8556 n4969 n4970 0.70833333333333337
r8557 n4844 n4971 0.020833333333333332
r8558 n4970 n4971 0.35416666666666669
r8559 n4845 n4972 0.026041666666666668
r8560 n4971 n4972 0.5625
r8561 n4846 n4973 0.034722222222222224
r8562 n4972 n4973 0.4375
r8563 n4847 n4974 0.15625
r8564 n4973 n4974 0.22916666666666666
r8565 n4848 n4975 0.15625
r8566 n4974 n4975 0.083333333333333329
r8567 n4849 n4976 0.0390625
r8568 n4975 n4976 0.20833333333333334
r8569 n4850 n4977 0.014204545454545454
r8570 n4976 n4977 0.625
r8571 n4851 n4978 0.3125
r8572 n4977 n4978 0.47916666666666669
r8573 n4852 n4979 0.3125
r8574 n4978 n4979 0.041666666666666664
r8575 n4853 n4980 0.3125
r8576 n4979 n4980 0.041666666666666664
r8577 n4854 n4981 0.03125
r8578 n4980 n4981 0.22916666666666666
r8579 n4855 n4982 0.026041666666666668
r8580 n4981 n4982 0.45833333333333331
r8581 n4856 n4983 0.0390625
r8582 n4982 n4983 0.41666666666666669
r8583 n4857 n4984 0.15625
r8584 n4983 n4984 0.20833333333333334
r8585 n4858 n4985 0.10416666666666667
r8586 n4984 n4985 0.10416666666666667
r8587 n4859 n4986 0.15625
r8588 n4985 n4986 0.10416666666666667
r8589 n4860 n4987 0.052083333333333336
r8590 n4986 n4987 0.16666666666666666
r8591 n4861 n4988 0.026041666666666668
r8592 n4987 n4988 0.375
r8593 n4862 n4989 0.022321428571428572
r8594 n4988 n4989 0.54166666666666663
r8595 n4863 n4990 0.15625
r8596 n4989 n4990 0.33333333333333331
r8597 n4864 n4991 0.0086805555555555559
r8598 n4990 n4991 0.79166666666666663
r8599 n4865 n4992 0.15625
r8600 n4991 n4992 0.79166666666666663
r8601 n4866 n4993 0.009765625
r8602 n4992 n4993 0.70833333333333337
r8603 n4867 n4994 0.15625
r8604 n4993 n4994 0.70833333333333337
r8605 n4868 n4995 0.0086805555555555559
r8606 n4994 n4995 0.79166666666666663
r8607 n4869 n4996 0.15625
r8608 n4995 n4996 0.79166666666666663
r8609 n4870 n4997 0.009765625
r8610 n4996 n4997 0.70833333333333337
r8611 n4871 n4998 0.15625
r8612 n4997 n4998 0.70833333333333337
r8613 n4872 n4999 0.0086805555555555559
r8614 n4998 n4999 0.79166666666666663
r8615 n4873 n5000 0.15625
r8616 n4999 n5000 0.79166666666666663
r8617 n4874 n5001 0.009765625
r8618 n5000 n5001 0.70833333333333337
r8619 n4875 n5002 0.15625
r8620 n5001 n5002 0.70833333333333337
r8621 n4876 n5003 0.0086805555555555559
r8622 n5002 n5003 0.79166666666666663
r8623 n4877 n5004 0.15625
r8624 n5003 n5004 0.79166666666666663
r8625 n4878 n5005 0.009765625
r8626 n5004 n5005 0.70833333333333337
r8627 n4879 n5006 0.15625
r8628 n5005 n5006 0.70833333333333337
r8629 n4880 n5007 0.0086805555555555559
r8630 n5006 n5007 0.79166666666666663
r8631 n4881 n5008 0.15625
r8632 n5007 n5008 0.79166666666666663
r8633 n4882 n5009 0.009765625
r8634 n5008 n5009 0.70833333333333337
r8635 n4883 n5010 0.15625
r8636 n5009 n5010 0.70833333333333337
r8637 n4884 n5011 0.0086805555555555559
r8638 n5010 n5011 0.79166666666666663
r8639 n4885 n5012 0.15625
r8640 n5011 n5012 0.79166666666666663
r8641 n4886 n5013 0.009765625
r8642 n5012 n5013 0.70833333333333337
r8643 n4887 n5014 0.15625
r8644 n5013 n5014 0.70833333333333337
r8645 n4888 n5015 0.0086805555555555559
r8646 n5014 n5015 0.79166666666666663
r8647 n4889 n5016 0.15625
r8648 n5015 n5016 0.79166666666666663
r8649 n4890 n5017 0.009765625
r8650 n5016 n5017 0.70833333333333337
r8651 n4891 n5018 0.15625
r8652 n5017 n5018 0.70833333333333337
r8653 n4892 n5019 0.026041666666666668
r8654 n5018 n5019 0.29166666666666669
r8655 n4895 n5020 0.10416666666666667
r8656 n4896 n5021 0.10416666666666667
r8657 n5020 n5021 0.125
r8658 n4897 n5022 0.15625
r8659 n5021 n5022 0.10416666666666667
r8660 n4898 n5023 0.028409090909090908
r8661 n5022 n5023 0.27083333333333331
r8662 n4899 n5024 0.016447368421052631
r8663 n5023 n5024 0.625
r8664 n4900 n5025 0.15625
r8665 n5024 n5025 0.4375
r8666 n4901 n5026 0.10416666666666667
r8667 n5025 n5026 0.10416666666666667
r8668 n4902 n5027 0.10416666666666667
r8669 n5026 n5027 0.125
r8670 n4905 n5028 0.043749999999999997
r8671 n4906 n5029 0.21875
r8672 n5028 n5029 0.1875
r8673 n4907 n5030 0.013671875
r8674 n5029 n5030 0.53125
r8675 n4908 n5031 0.21875
r8676 n5030 n5031 0.53125
r8677 n4909 n5032 0.012152777777777778
r8678 n5031 n5032 0.59375
r8679 n4910 n5033 0.21875
r8680 n5032 n5033 0.59375
r8681 n4911 n5034 0.033653846153846152
r8682 n5033 n5034 0.234375
r8683 n4912 n5035 0.036458333333333336
r8684 n5034 n5035 0.390625
r8685 n4913 n5036 0.0625
r8686 n5035 n5036 0.296875
r8687 n4914 n5037 0.21875
r8688 n5036 n5037 0.140625
r8689 n4915 n5038 0.109375
r8690 n5037 n5038 0.09375
r8691 n4916 n5039 0.048611111111111112
r8692 n5038 n5039 0.203125
r8693 n4917 n5040 0.020833333333333332
r8694 n5039 n5040 0.46875
r8695 n4918 n5041 0.21875
r8696 n5040 n5041 0.359375
r8697 n4919 n5042 0.21875
r8698 n5041 n5042 0.0625
r8699 n4920 n5043 0.048611111111111112
r8700 n5042 n5043 0.171875
r8701 n4921 n5044 0.036458333333333336
r8702 n5043 n5044 0.328125
r8703 n4922 n5045 0.048611111111111112
r8704 n5044 n5045 0.328125
r8705 n4923 n5046 0.21875
r8706 n5045 n5046 0.171875
r8707 n4924 n5047 0.21875
r8708 n5046 n5047 0.0625
r8709 n4925 n5048 0.020833333333333332
r8710 n5047 n5048 0.359375
r8711 n4926 n5049 0.029166666666666667
r8712 n5048 n5049 0.5625
r8713 n4927 n5050 0.21875
r8714 n5049 n5050 0.265625
r8715 n4928 n5051 0.013671875
r8716 n5050 n5051 0.53125
r8717 n4929 n5052 0.21875
r8718 n5051 n5052 0.53125
r8719 n4930 n5053 0.036458333333333336
r8720 n5052 n5053 0.21875
r8721 n4931 n5054 0.14583333333333334
r8722 n4932 n5055 0.14583333333333334
r8723 n5054 n5055 0.09375
r8724 n4933 n5056 0.21875
r8725 n5055 n5056 0.078125
r8726 n4934 n5057 0.0546875
r8727 n5056 n5057 0.15625
r8728 n4935 n5058 0.019886363636363636
r8729 n5057 n5058 0.46875
r8730 n4936 n5059 0.21875
r8731 n5058 n5059 0.375
r8732 n4937 n5060 0.14583333333333334
r8733 n5059 n5060 0.078125
r8734 n4938 n5061 0.14583333333333334
r8735 n5060 n5061 0.09375
r8736 n4939 n5062 0.043749999999999997
r8737 n4940 n5063 0.21875
r8738 n5062 n5063 0.1875
r8739 n4941 n5064 0.013671875
r8740 n5063 n5064 0.53125
r8741 n4942 n5065 0.21875
r8742 n5064 n5065 0.53125
r8743 n4943 n5066 0.012152777777777778
r8744 n5065 n5066 0.59375
r8745 n4944 n5067 0.21875
r8746 n5066 n5067 0.59375
r8747 n4945 n5068 0.013671875
r8748 n5067 n5068 0.53125
r8749 n4946 n5069 0.21875
r8750 n5068 n5069 0.53125
r8751 n4947 n5070 0.012152777777777778
r8752 n5069 n5070 0.59375
r8753 n4948 n5071 0.21875
r8754 n5070 n5071 0.59375
r8755 n4949 n5072 0.013671875
r8756 n5071 n5072 0.53125
r8757 n4950 n5073 0.21875
r8758 n5072 n5073 0.53125
r8759 n4951 n5074 0.012152777777777778
r8760 n5073 n5074 0.59375
r8761 n4952 n5075 0.21875
r8762 n5074 n5075 0.59375
r8763 n4953 n5076 0.013671875
r8764 n5075 n5076 0.53125
r8765 n4954 n5077 0.21875
r8766 n5076 n5077 0.53125
r8767 n4955 n5078 0.012152777777777778
r8768 n5077 n5078 0.59375
r8769 n4956 n5079 0.21875
r8770 n5078 n5079 0.59375
r8771 n4957 n5080 0.013671875
r8772 n5079 n5080 0.53125
r8773 n4958 n5081 0.21875
r8774 n5080 n5081 0.53125
r8775 n4959 n5082 0.012152777777777778
r8776 n5081 n5082 0.59375
r8777 n4960 n5083 0.21875
r8778 n5082 n5083 0.59375
r8779 n4961 n5084 0.013671875
r8780 n5083 n5084 0.53125
r8781 n4962 n5085 0.21875
r8782 n5084 n5085 0.53125
r8783 n4963 n5086 0.012152777777777778
r8784 n5085 n5086 0.59375
r8785 n4964 n5087 0.21875
r8786 n5086 n5087 0.59375
r8787 n4965 n5088 0.013671875
r8788 n5087 n5088 0.53125
r8789 n4966 n5089 0.21875
r8790 n5088 n5089 0.53125
r8791 n4967 n5090 0.012152777777777778
r8792 n5089 n5090 0.59375
r8793 n4968 n5091 0.21875
r8794 n5090 n5091 0.59375
r8795 n4969 n5092 0.013671875
r8796 n5091 n5092 0.53125
r8797 n4970 n5093 0.21875
r8798 n5092 n5093 0.53125
r8799 n4971 n5094 0.029166666666666667
r8800 n5093 n5094 0.265625
r8801 n4972 n5095 0.036458333333333336
r8802 n5094 n5095 0.421875
r8803 n4973 n5096 0.048611111111111112
r8804 n5095 n5096 0.328125
r8805 n4974 n5097 0.21875
r8806 n5096 n5097 0.171875
r8807 n4975 n5098 0.21875
r8808 n5097 n5098 0.0625
r8809 n4976 n5099 0.0546875
r8810 n5098 n5099 0.15625
r8811 n4977 n5100 0.019886363636363636
r8812 n5099 n5100 0.46875
r8813 n4978 n5101 0.4375
r8814 n5100 n5101 0.359375
r8815 n4979 n5102 0.4375
r8816 n5101 n5102 0.03125
r8817 n4980 n5103 0.4375
r8818 n5102 n5103 0.03125
r8819 n4981 n5104 0.043749999999999997
r8820 n5103 n5104 0.171875
r8821 n4982 n5105 0.036458333333333336
r8822 n5104 n5105 0.34375
r8823 n4983 n5106 0.0546875
r8824 n5105 n5106 0.3125
r8825 n4984 n5107 0.21875
r8826 n5106 n5107 0.15625
r8827 n4985 n5108 0.14583333333333334
r8828 n5107 n5108 0.078125
r8829 n4986 n5109 0.21875
r8830 n5108 n5109 0.078125
r8831 n4987 n5110 0.072916666666666671
r8832 n5109 n5110 0.125
r8833 n4988 n5111 0.036458333333333336
r8834 n5110 n5111 0.28125
r8835 n4989 n5112 0.03125
r8836 n5111 n5112 0.40625
r8837 n4990 n5113 0.21875
r8838 n5112 n5113 0.25
r8839 n4991 n5114 0.012152777777777778
r8840 n5113 n5114 0.59375
r8841 n4992 n5115 0.21875
r8842 n5114 n5115 0.59375
r8843 n4993 n5116 0.013671875
r8844 n5115 n5116 0.53125
r8845 n4994 n5117 0.21875
r8846 n5116 n5117 0.53125
r8847 n4995 n5118 0.012152777777777778
r8848 n5117 n5118 0.59375
r8849 n4996 n5119 0.21875
r8850 n5118 n5119 0.59375
r8851 n4997 n5120 0.013671875
r8852 n5119 n5120 0.53125
r8853 n4998 n5121 0.21875
r8854 n5120 n5121 0.53125
r8855 n4999 n5122 0.012152777777777778
r8856 n5121 n5122 0.59375
r8857 n5000 n5123 0.21875
r8858 n5122 n5123 0.59375
r8859 n5001 n5124 0.013671875
r8860 n5123 n5124 0.53125
r8861 n5002 n5125 0.21875
r8862 n5124 n5125 0.53125
r8863 n5003 n5126 0.012152777777777778
r8864 n5125 n5126 0.59375
r8865 n5004 n5127 0.21875
r8866 n5126 n5127 0.59375
r8867 n5005 n5128 0.013671875
r8868 n5127 n5128 0.53125
r8869 n5006 n5129 0.21875
r8870 n5128 n5129 0.53125
r8871 n5007 n5130 0.012152777777777778
r8872 n5129 n5130 0.59375
r8873 n5008 n5131 0.21875
r8874 n5130 n5131 0.59375
r8875 n5009 n5132 0.013671875
r8876 n5131 n5132 0.53125
r8877 n5010 n5133 0.21875
r8878 n5132 n5133 0.53125
r8879 n5011 n5134 0.012152777777777778
r8880 n5133 n5134 0.59375
r8881 n5012 n5135 0.21875
r8882 n5134 n5135 0.59375
r8883 n5013 n5136 0.013671875
r8884 n5135 n5136 0.53125
r8885 n5014 n5137 0.21875
r8886 n5136 n5137 0.53125
r8887 n5015 n5138 0.012152777777777778
r8888 n5137 n5138 0.59375
r8889 n5016 n5139 0.21875
r8890 n5138 n5139 0.59375
r8891 n5017 n5140 0.013671875
r8892 n5139 n5140 0.53125
r8893 n5018 n5141 0.21875
r8894 n5140 n5141 0.53125
r8895 n5019 n5142 0.036458333333333336
r8896 n5141 n5142 0.21875
r8897 n5020 n5143 0.14583333333333334
r8898 n5021 n5144 0.14583333333333334
r8899 n5143 n5144 0.09375
r8900 n5022 n5145 0.21875
r8901 n5144 n5145 0.078125
r8902 n5023 n5146 0.039772727272727272
r8903 n5145 n5146 0.203125
r8904 n5024 n5147 0.023026315789473683
r8905 n5146 n5147 0.46875
r8906 n5025 n5148 0.21875
r8907 n5147 n5148 0.328125
r8908 n5026 n5149 0.14583333333333334
r8909 n5148 n5149 0.078125
r8910 n5027 n5150 0.14583333333333334
r8911 n5149 n5150 0.09375
r8912 n5028 n5151 0.043749999999999997
r8913 n5029 n5152 0.21875
r8914 n5151 n5152 0.25
r8915 n5030 n5153 0.013671875
r8916 n5152 n5153 0.70833333333333337
r8917 n5031 n5154 0.21875
r8918 n5153 n5154 0.70833333333333337
r8919 n5032 n5155 0.012152777777777778
r8920 n5154 n5155 0.79166666666666663
r8921 n5033 n5156 0.21875
r8922 n5155 n5156 0.79166666666666663
r8923 n5034 n5157 0.033653846153846152
r8924 n5156 n5157 0.3125
r8925 n5035 n5158 0.036458333333333336
r8926 n5157 n5158 0.52083333333333337
r8927 n5036 n5159 0.0625
r8928 n5158 n5159 0.39583333333333331
r8929 n5037 n5160 0.21875
r8930 n5159 n5160 0.1875
r8931 n5038 n5161 0.109375
r8932 n5160 n5161 0.125
r8933 n5039 n5162 0.048611111111111112
r8934 n5161 n5162 0.27083333333333331
r8935 n5040 n5163 0.020833333333333332
r8936 n5162 n5163 0.625
r8937 n5041 n5164 0.21875
r8938 n5163 n5164 0.47916666666666669
r8939 n5042 n5165 0.21875
r8940 n5164 n5165 0.083333333333333329
r8941 n5043 n5166 0.048611111111111112
r8942 n5165 n5166 0.22916666666666666
r8943 n5044 n5167 0.036458333333333336
r8944 n5166 n5167 0.4375
r8945 n5045 n5168 0.048611111111111112
r8946 n5167 n5168 0.4375
r8947 n5046 n5169 0.21875
r8948 n5168 n5169 0.22916666666666666
r8949 n5047 n5170 0.21875
r8950 n5169 n5170 0.083333333333333329
r8951 n5048 n5171 0.020833333333333332
r8952 n5170 n5171 0.47916666666666669
r8953 n5049 n5172 0.029166666666666667
r8954 n5171 n5172 0.75
r8955 n5050 n5173 0.21875
r8956 n5172 n5173 0.35416666666666669
r8957 n5051 n5174 0.013671875
r8958 n5173 n5174 0.70833333333333337
r8959 n5052 n5175 0.21875
r8960 n5174 n5175 0.70833333333333337
r8961 n5053 n5176 0.036458333333333336
r8962 n5175 n5176 0.29166666666666669
r8963 n5062 n5177 0.043749999999999997
r8964 n5063 n5178 0.21875
r8965 n5177 n5178 0.25
r8966 n5064 n5179 0.013671875
r8967 n5178 n5179 0.70833333333333337
r8968 n5065 n5180 0.21875
r8969 n5179 n5180 0.70833333333333337
r8970 n5066 n5181 0.012152777777777778
r8971 n5180 n5181 0.79166666666666663
r8972 n5067 n5182 0.21875
r8973 n5181 n5182 0.79166666666666663
r8974 n5068 n5183 0.013671875
r8975 n5182 n5183 0.70833333333333337
r8976 n5069 n5184 0.21875
r8977 n5183 n5184 0.70833333333333337
r8978 n5070 n5185 0.012152777777777778
r8979 n5184 n5185 0.79166666666666663
r8980 n5071 n5186 0.21875
r8981 n5185 n5186 0.79166666666666663
r8982 n5072 n5187 0.013671875
r8983 n5186 n5187 0.70833333333333337
r8984 n5073 n5188 0.21875
r8985 n5187 n5188 0.70833333333333337
r8986 n5074 n5189 0.012152777777777778
r8987 n5188 n5189 0.79166666666666663
r8988 n5075 n5190 0.21875
r8989 n5189 n5190 0.79166666666666663
r8990 n5076 n5191 0.013671875
r8991 n5190 n5191 0.70833333333333337
r8992 n5077 n5192 0.21875
r8993 n5191 n5192 0.70833333333333337
r8994 n5078 n5193 0.012152777777777778
r8995 n5192 n5193 0.79166666666666663
r8996 n5079 n5194 0.21875
r8997 n5193 n5194 0.79166666666666663
r8998 n5080 n5195 0.013671875
r8999 n5194 n5195 0.70833333333333337
r9000 n5081 n5196 0.21875
r9001 n5195 n5196 0.70833333333333337
r9002 n5082 n5197 0.012152777777777778
r9003 n5196 n5197 0.79166666666666663
r9004 n5083 n5198 0.21875
r9005 n5197 n5198 0.79166666666666663
r9006 n5084 n5199 0.013671875
r9007 n5198 n5199 0.70833333333333337
r9008 n5085 n5200 0.21875
r9009 n5199 n5200 0.70833333333333337
r9010 n5086 n5201 0.012152777777777778
r9011 n5200 n5201 0.79166666666666663
r9012 n5087 n5202 0.21875
r9013 n5201 n5202 0.79166666666666663
r9014 n5088 n5203 0.013671875
r9015 n5202 n5203 0.70833333333333337
r9016 n5089 n5204 0.21875
r9017 n5203 n5204 0.70833333333333337
r9018 n5090 n5205 0.012152777777777778
r9019 n5204 n5205 0.79166666666666663
r9020 n5091 n5206 0.21875
r9021 n5205 n5206 0.79166666666666663
r9022 n5092 n5207 0.013671875
r9023 n5206 n5207 0.70833333333333337
r9024 n5093 n5208 0.21875
r9025 n5207 n5208 0.70833333333333337
r9026 n5094 n5209 0.029166666666666667
r9027 n5208 n5209 0.35416666666666669
r9028 n5095 n5210 0.036458333333333336
r9029 n5209 n5210 0.5625
r9030 n5096 n5211 0.048611111111111112
r9031 n5210 n5211 0.4375
r9032 n5097 n5212 0.21875
r9033 n5211 n5212 0.22916666666666666
r9034 n5098 n5213 0.21875
r9035 n5212 n5213 0.083333333333333329
r9036 n5099 n5214 0.0546875
r9037 n5213 n5214 0.20833333333333334
r9038 n5100 n5215 0.019886363636363636
r9039 n5214 n5215 0.625
r9040 n5101 n5216 0.4375
r9041 n5215 n5216 0.47916666666666669
r9042 n5102 n5217 0.4375
r9043 n5216 n5217 0.041666666666666664
r9044 n5103 n5218 0.4375
r9045 n5217 n5218 0.041666666666666664
r9046 n5104 n5219 0.043749999999999997
r9047 n5218 n5219 0.22916666666666666
r9048 n5105 n5220 0.036458333333333336
r9049 n5219 n5220 0.45833333333333331
r9050 n5106 n5221 0.0546875
r9051 n5220 n5221 0.41666666666666669
r9052 n5107 n5222 0.21875
r9053 n5221 n5222 0.20833333333333334
r9054 n5108 n5223 0.14583333333333334
r9055 n5222 n5223 0.10416666666666667
r9056 n5109 n5224 0.21875
r9057 n5223 n5224 0.10416666666666667
r9058 n5110 n5225 0.072916666666666671
r9059 n5224 n5225 0.16666666666666666
r9060 n5111 n5226 0.036458333333333336
r9061 n5225 n5226 0.375
r9062 n5112 n5227 0.03125
r9063 n5226 n5227 0.54166666666666663
r9064 n5113 n5228 0.21875
r9065 n5227 n5228 0.33333333333333331
r9066 n5114 n5229 0.012152777777777778
r9067 n5228 n5229 0.79166666666666663
r9068 n5115 n5230 0.21875
r9069 n5229 n5230 0.79166666666666663
r9070 n5116 n5231 0.013671875
r9071 n5230 n5231 0.70833333333333337
r9072 n5117 n5232 0.21875
r9073 n5231 n5232 0.70833333333333337
r9074 n5118 n5233 0.012152777777777778
r9075 n5232 n5233 0.79166666666666663
r9076 n5119 n5234 0.21875
r9077 n5233 n5234 0.79166666666666663
r9078 n5120 n5235 0.013671875
r9079 n5234 n5235 0.70833333333333337
r9080 n5121 n5236 0.21875
r9081 n5235 n5236 0.70833333333333337
r9082 n5122 n5237 0.012152777777777778
r9083 n5236 n5237 0.79166666666666663
r9084 n5123 n5238 0.21875
r9085 n5237 n5238 0.79166666666666663
r9086 n5124 n5239 0.013671875
r9087 n5238 n5239 0.70833333333333337
r9088 n5125 n5240 0.21875
r9089 n5239 n5240 0.70833333333333337
r9090 n5126 n5241 0.012152777777777778
r9091 n5240 n5241 0.79166666666666663
r9092 n5127 n5242 0.21875
r9093 n5241 n5242 0.79166666666666663
r9094 n5128 n5243 0.013671875
r9095 n5242 n5243 0.70833333333333337
r9096 n5129 n5244 0.21875
r9097 n5243 n5244 0.70833333333333337
r9098 n5130 n5245 0.012152777777777778
r9099 n5244 n5245 0.79166666666666663
r9100 n5131 n5246 0.21875
r9101 n5245 n5246 0.79166666666666663
r9102 n5132 n5247 0.013671875
r9103 n5246 n5247 0.70833333333333337
r9104 n5133 n5248 0.21875
r9105 n5247 n5248 0.70833333333333337
r9106 n5134 n5249 0.012152777777777778
r9107 n5248 n5249 0.79166666666666663
r9108 n5135 n5250 0.21875
r9109 n5249 n5250 0.79166666666666663
r9110 n5136 n5251 0.013671875
r9111 n5250 n5251 0.70833333333333337
r9112 n5137 n5252 0.21875
r9113 n5251 n5252 0.70833333333333337
r9114 n5138 n5253 0.012152777777777778
r9115 n5252 n5253 0.79166666666666663
r9116 n5139 n5254 0.21875
r9117 n5253 n5254 0.79166666666666663
r9118 n5140 n5255 0.013671875
r9119 n5254 n5255 0.70833333333333337
r9120 n5141 n5256 0.21875
r9121 n5255 n5256 0.70833333333333337
r9122 n5142 n5257 0.036458333333333336
r9123 n5256 n5257 0.29166666666666669
r9124 n5151 n5258 0.1125
r9125 n5152 n5259 0.5625
r9126 n5258 n5259 0.050000000000000003
r9127 n5153 n5260 0.03515625
r9128 n5259 n5260 0.14166666666666666
r9129 n5154 n5261 0.5625
r9130 n5260 n5261 0.14166666666666666
r9131 n5155 n5262 0.03125
r9132 n5261 n5262 0.15833333333333333
r9133 n5156 n5263 0.5625
r9134 n5262 n5263 0.15833333333333333
r9135 n5157 n5264 0.086538461538461536
r9136 n5263 n5264 0.0625
r9137 n5158 n5265 0.09375
r9138 n5264 n5265 0.10416666666666667
r9139 n5159 n5266 0.16071428571428573
r9140 n5265 n5266 0.079166666666666663
r9141 n5160 n5267 0.5625
r9142 n5266 n5267 0.037499999999999999
r9143 n5161 n5268 0.28125
r9144 n5267 n5268 0.025000000000000001
r9145 n5162 n5269 0.125
r9146 n5268 n5269 0.054166666666666669
r9147 n5163 n5270 0.053571428571428568
r9148 n5269 n5270 0.125
r9149 n5164 n5271 0.5625
r9150 n5270 n5271 0.09583333333333334
r9151 n5165 n5272 0.5625
r9152 n5271 n5272 0.016666666666666666
r9153 n5166 n5273 0.125
r9154 n5272 n5273 0.04583333333333333
r9155 n5167 n5274 0.09375
r9156 n5273 n5274 0.087499999999999994
r9157 n5168 n5275 0.125
r9158 n5274 n5275 0.087499999999999994
r9159 n5169 n5276 0.5625
r9160 n5275 n5276 0.04583333333333333
r9161 n5170 n5277 0.5625
r9162 n5276 n5277 0.016666666666666666
r9163 n5171 n5278 0.053571428571428568
r9164 n5277 n5278 0.09583333333333334
r9165 n5172 n5279 0.074999999999999997
r9166 n5278 n5279 0.14999999999999999
r9167 n5173 n5280 0.5625
r9168 n5279 n5280 0.070833333333333331
r9169 n5174 n5281 0.03515625
r9170 n5280 n5281 0.14166666666666666
r9171 n5175 n5282 0.5625
r9172 n5281 n5282 0.14166666666666666
r9173 n5176 n5283 0.09375
r9174 n5282 n5283 0.058333333333333334
r9175 n5177 n5284 0.1125
r9176 n5178 n5285 0.5625
r9177 n5284 n5285 0.050000000000000003
r9178 n5179 n5286 0.03515625
r9179 n5285 n5286 0.14166666666666666
r9180 n5180 n5287 0.5625
r9181 n5286 n5287 0.14166666666666666
r9182 n5181 n5288 0.03125
r9183 n5287 n5288 0.15833333333333333
r9184 n5182 n5289 0.5625
r9185 n5288 n5289 0.15833333333333333
r9186 n5183 n5290 0.03515625
r9187 n5289 n5290 0.14166666666666666
r9188 n5184 n5291 0.5625
r9189 n5290 n5291 0.14166666666666666
r9190 n5185 n5292 0.03125
r9191 n5291 n5292 0.15833333333333333
r9192 n5186 n5293 0.5625
r9193 n5292 n5293 0.15833333333333333
r9194 n5187 n5294 0.03515625
r9195 n5293 n5294 0.14166666666666666
r9196 n5188 n5295 0.5625
r9197 n5294 n5295 0.14166666666666666
r9198 n5189 n5296 0.03125
r9199 n5295 n5296 0.15833333333333333
r9200 n5190 n5297 0.5625
r9201 n5296 n5297 0.15833333333333333
r9202 n5191 n5298 0.03515625
r9203 n5297 n5298 0.14166666666666666
r9204 n5192 n5299 0.5625
r9205 n5298 n5299 0.14166666666666666
r9206 n5193 n5300 0.03125
r9207 n5299 n5300 0.15833333333333333
r9208 n5194 n5301 0.5625
r9209 n5300 n5301 0.15833333333333333
r9210 n5195 n5302 0.03515625
r9211 n5301 n5302 0.14166666666666666
r9212 n5196 n5303 0.5625
r9213 n5302 n5303 0.14166666666666666
r9214 n5197 n5304 0.03125
r9215 n5303 n5304 0.15833333333333333
r9216 n5198 n5305 0.5625
r9217 n5304 n5305 0.15833333333333333
r9218 n5199 n5306 0.03515625
r9219 n5305 n5306 0.14166666666666666
r9220 n5200 n5307 0.5625
r9221 n5306 n5307 0.14166666666666666
r9222 n5201 n5308 0.03125
r9223 n5307 n5308 0.15833333333333333
r9224 n5202 n5309 0.5625
r9225 n5308 n5309 0.15833333333333333
r9226 n5203 n5310 0.03515625
r9227 n5309 n5310 0.14166666666666666
r9228 n5204 n5311 0.5625
r9229 n5310 n5311 0.14166666666666666
r9230 n5205 n5312 0.03125
r9231 n5311 n5312 0.15833333333333333
r9232 n5206 n5313 0.5625
r9233 n5312 n5313 0.15833333333333333
r9234 n5207 n5314 0.03515625
r9235 n5313 n5314 0.14166666666666666
r9236 n5208 n5315 0.5625
r9237 n5314 n5315 0.14166666666666666
r9238 n5209 n5316 0.074999999999999997
r9239 n5315 n5316 0.070833333333333331
r9240 n5210 n5317 0.09375
r9241 n5316 n5317 0.1125
r9242 n5211 n5318 0.125
r9243 n5317 n5318 0.087499999999999994
r9244 n5212 n5319 0.5625
r9245 n5318 n5319 0.04583333333333333
r9246 n5213 n5320 0.5625
r9247 n5319 n5320 0.016666666666666666
r9248 n5214 n5321 0.140625
r9249 n5320 n5321 0.041666666666666664
r9250 n5215 n5322 0.05113636363636364
r9251 n5321 n5322 0.125
r9252 n5216 n5323 1.125
r9253 n5322 n5323 0.09583333333333334
r9254 n5217 n5324 1.125
r9255 n5323 n5324 0.0083333333333333332
r9256 n5218 n5325 1.125
r9257 n5324 n5325 0.0083333333333333332
r9258 n5219 n5326 0.1125
r9259 n5325 n5326 0.04583333333333333
r9260 n5220 n5327 0.09375
r9261 n5326 n5327 0.09166666666666666
r9262 n5221 n5328 0.140625
r9263 n5327 n5328 0.083333333333333329
r9264 n5222 n5329 0.5625
r9265 n5328 n5329 0.041666666666666664
r9266 n5223 n5330 0.375
r9267 n5329 n5330 0.020833333333333332
r9268 n5224 n5331 0.5625
r9269 n5330 n5331 0.020833333333333332
r9270 n5225 n5332 0.1875
r9271 n5331 n5332 0.033333333333333333
r9272 n5226 n5333 0.09375
r9273 n5332 n5333 0.074999999999999997
r9274 n5227 n5334 0.080357142857142863
r9275 n5333 n5334 0.10833333333333334
r9276 n5228 n5335 0.5625
r9277 n5334 n5335 0.066666666666666666
r9278 n5229 n5336 0.03125
r9279 n5335 n5336 0.15833333333333333
r9280 n5230 n5337 0.5625
r9281 n5336 n5337 0.15833333333333333
r9282 n5231 n5338 0.03515625
r9283 n5337 n5338 0.14166666666666666
r9284 n5232 n5339 0.5625
r9285 n5338 n5339 0.14166666666666666
r9286 n5233 n5340 0.03125
r9287 n5339 n5340 0.15833333333333333
r9288 n5234 n5341 0.5625
r9289 n5340 n5341 0.15833333333333333
r9290 n5235 n5342 0.03515625
r9291 n5341 n5342 0.14166666666666666
r9292 n5236 n5343 0.5625
r9293 n5342 n5343 0.14166666666666666
r9294 n5237 n5344 0.03125
r9295 n5343 n5344 0.15833333333333333
r9296 n5238 n5345 0.5625
r9297 n5344 n5345 0.15833333333333333
r9298 n5239 n5346 0.03515625
r9299 n5345 n5346 0.14166666666666666
r9300 n5240 n5347 0.5625
r9301 n5346 n5347 0.14166666666666666
r9302 n5241 n5348 0.03125
r9303 n5347 n5348 0.15833333333333333
r9304 n5242 n5349 0.5625
r9305 n5348 n5349 0.15833333333333333
r9306 n5243 n5350 0.03515625
r9307 n5349 n5350 0.14166666666666666
r9308 n5244 n5351 0.5625
r9309 n5350 n5351 0.14166666666666666
r9310 n5245 n5352 0.03125
r9311 n5351 n5352 0.15833333333333333
r9312 n5246 n5353 0.5625
r9313 n5352 n5353 0.15833333333333333
r9314 n5247 n5354 0.03515625
r9315 n5353 n5354 0.14166666666666666
r9316 n5248 n5355 0.5625
r9317 n5354 n5355 0.14166666666666666
r9318 n5249 n5356 0.03125
r9319 n5355 n5356 0.15833333333333333
r9320 n5250 n5357 0.5625
r9321 n5356 n5357 0.15833333333333333
r9322 n5251 n5358 0.03515625
r9323 n5357 n5358 0.14166666666666666
r9324 n5252 n5359 0.5625
r9325 n5358 n5359 0.14166666666666666
r9326 n5253 n5360 0.03125
r9327 n5359 n5360 0.15833333333333333
r9328 n5254 n5361 0.5625
r9329 n5360 n5361 0.15833333333333333
r9330 n5255 n5362 0.03515625
r9331 n5361 n5362 0.14166666666666666
r9332 n5256 n5363 0.5625
r9333 n5362 n5363 0.14166666666666666
r9334 n5257 n5364 0.09375
r9335 n5363 n5364 0.058333333333333334
r9336 n5258 n5365 0.125
r9337 n5259 n5366 0.625
r9338 n5365 n5366 0.14999999999999999
r9339 n5260 n5367 0.0390625
r9340 n5366 n5367 0.42499999999999999
r9341 n5261 n5368 0.625
r9342 n5367 n5368 0.42499999999999999
r9343 n5262 n5369 0.034722222222222224
r9344 n5368 n5369 0.47499999999999998
r9345 n5263 n5370 0.625
r9346 n5369 n5370 0.47499999999999998
r9347 n5264 n5371 0.096153846153846159
r9348 n5370 n5371 0.1875
r9349 n5265 n5372 0.10416666666666667
r9350 n5371 n5372 0.3125
r9351 n5266 n5373 0.17857142857142858
r9352 n5372 n5373 0.23749999999999999
r9353 n5267 n5374 0.625
r9354 n5373 n5374 0.1125
r9355 n5268 n5375 0.3125
r9356 n5374 n5375 0.074999999999999997
r9357 n5269 n5376 0.1388888888888889
r9358 n5375 n5376 0.16250000000000001
r9359 n5270 n5377 0.059523809523809521
r9360 n5376 n5377 0.375
r9361 n5271 n5378 0.625
r9362 n5377 n5378 0.28749999999999998
r9363 n5272 n5379 0.625
r9364 n5378 n5379 0.050000000000000003
r9365 n5273 n5380 0.1388888888888889
r9366 n5379 n5380 0.13750000000000001
r9367 n5274 n5381 0.10416666666666667
r9368 n5380 n5381 0.26250000000000001
r9369 n5275 n5382 0.1388888888888889
r9370 n5381 n5382 0.26250000000000001
r9371 n5276 n5383 0.625
r9372 n5382 n5383 0.13750000000000001
r9373 n5277 n5384 0.625
r9374 n5383 n5384 0.050000000000000003
r9375 n5278 n5385 0.059523809523809521
r9376 n5384 n5385 0.28749999999999998
r9377 n5279 n5386 0.083333333333333329
r9378 n5385 n5386 0.45000000000000001
r9379 n5280 n5387 0.625
r9380 n5386 n5387 0.21249999999999999
r9381 n5281 n5388 0.0390625
r9382 n5387 n5388 0.42499999999999999
r9383 n5282 n5389 0.625
r9384 n5388 n5389 0.42499999999999999
r9385 n5283 n5390 0.10416666666666667
r9386 n5389 n5390 0.17499999999999999
r9387 n5284 n5391 0.125
r9388 n5285 n5392 0.625
r9389 n5391 n5392 0.14999999999999999
r9390 n5286 n5393 0.0390625
r9391 n5392 n5393 0.42499999999999999
r9392 n5287 n5394 0.625
r9393 n5393 n5394 0.42499999999999999
r9394 n5288 n5395 0.034722222222222224
r9395 n5394 n5395 0.47499999999999998
r9396 n5289 n5396 0.625
r9397 n5395 n5396 0.47499999999999998
r9398 n5290 n5397 0.0390625
r9399 n5396 n5397 0.42499999999999999
r9400 n5291 n5398 0.625
r9401 n5397 n5398 0.42499999999999999
r9402 n5292 n5399 0.034722222222222224
r9403 n5398 n5399 0.47499999999999998
r9404 n5293 n5400 0.625
r9405 n5399 n5400 0.47499999999999998
r9406 n5294 n5401 0.0390625
r9407 n5400 n5401 0.42499999999999999
r9408 n5295 n5402 0.625
r9409 n5401 n5402 0.42499999999999999
r9410 n5296 n5403 0.034722222222222224
r9411 n5402 n5403 0.47499999999999998
r9412 n5297 n5404 0.625
r9413 n5403 n5404 0.47499999999999998
r9414 n5298 n5405 0.0390625
r9415 n5404 n5405 0.42499999999999999
r9416 n5299 n5406 0.625
r9417 n5405 n5406 0.42499999999999999
r9418 n5300 n5407 0.034722222222222224
r9419 n5406 n5407 0.47499999999999998
r9420 n5301 n5408 0.625
r9421 n5407 n5408 0.47499999999999998
r9422 n5302 n5409 0.0390625
r9423 n5408 n5409 0.42499999999999999
r9424 n5303 n5410 0.625
r9425 n5409 n5410 0.42499999999999999
r9426 n5304 n5411 0.034722222222222224
r9427 n5410 n5411 0.47499999999999998
r9428 n5305 n5412 0.625
r9429 n5411 n5412 0.47499999999999998
r9430 n5306 n5413 0.0390625
r9431 n5412 n5413 0.42499999999999999
r9432 n5307 n5414 0.625
r9433 n5413 n5414 0.42499999999999999
r9434 n5308 n5415 0.034722222222222224
r9435 n5414 n5415 0.47499999999999998
r9436 n5309 n5416 0.625
r9437 n5415 n5416 0.47499999999999998
r9438 n5310 n5417 0.0390625
r9439 n5416 n5417 0.42499999999999999
r9440 n5311 n5418 0.625
r9441 n5417 n5418 0.42499999999999999
r9442 n5312 n5419 0.034722222222222224
r9443 n5418 n5419 0.47499999999999998
r9444 n5313 n5420 0.625
r9445 n5419 n5420 0.47499999999999998
r9446 n5314 n5421 0.0390625
r9447 n5420 n5421 0.42499999999999999
r9448 n5315 n5422 0.625
r9449 n5421 n5422 0.42499999999999999
r9450 n5316 n5423 0.083333333333333329
r9451 n5422 n5423 0.21249999999999999
r9452 n5317 n5424 0.10416666666666667
r9453 n5423 n5424 0.33750000000000002
r9454 n5318 n5425 0.1388888888888889
r9455 n5424 n5425 0.26250000000000001
r9456 n5319 n5426 0.625
r9457 n5425 n5426 0.13750000000000001
r9458 n5320 n5427 0.625
r9459 n5426 n5427 0.050000000000000003
r9460 n5321 n5428 0.15625
r9461 n5427 n5428 0.125
r9462 n5322 n5429 0.056818181818181816
r9463 n5428 n5429 0.375
r9464 n5323 n5430 1.25
r9465 n5429 n5430 0.28749999999999998
r9466 n5324 n5431 1.25
r9467 n5430 n5431 0.025000000000000001
r9468 n5325 n5432 1.25
r9469 n5431 n5432 0.025000000000000001
r9470 n5326 n5433 0.125
r9471 n5432 n5433 0.13750000000000001
r9472 n5327 n5434 0.10416666666666667
r9473 n5433 n5434 0.27500000000000002
r9474 n5328 n5435 0.15625
r9475 n5434 n5435 0.25
r9476 n5329 n5436 0.625
r9477 n5435 n5436 0.125
r9478 n5330 n5437 0.41666666666666669
r9479 n5436 n5437 0.0625
r9480 n5331 n5438 0.625
r9481 n5437 n5438 0.0625
r9482 n5332 n5439 0.20833333333333334
r9483 n5438 n5439 0.10000000000000001
r9484 n5333 n5440 0.10416666666666667
r9485 n5439 n5440 0.22500000000000001
r9486 n5334 n5441 0.089285714285714288
r9487 n5440 n5441 0.32500000000000001
r9488 n5335 n5442 0.625
r9489 n5441 n5442 0.20000000000000001
r9490 n5336 n5443 0.034722222222222224
r9491 n5442 n5443 0.47499999999999998
r9492 n5337 n5444 0.625
r9493 n5443 n5444 0.47499999999999998
r9494 n5338 n5445 0.0390625
r9495 n5444 n5445 0.42499999999999999
r9496 n5339 n5446 0.625
r9497 n5445 n5446 0.42499999999999999
r9498 n5340 n5447 0.034722222222222224
r9499 n5446 n5447 0.47499999999999998
r9500 n5341 n5448 0.625
r9501 n5447 n5448 0.47499999999999998
r9502 n5342 n5449 0.0390625
r9503 n5448 n5449 0.42499999999999999
r9504 n5343 n5450 0.625
r9505 n5449 n5450 0.42499999999999999
r9506 n5344 n5451 0.034722222222222224
r9507 n5450 n5451 0.47499999999999998
r9508 n5345 n5452 0.625
r9509 n5451 n5452 0.47499999999999998
r9510 n5346 n5453 0.0390625
r9511 n5452 n5453 0.42499999999999999
r9512 n5347 n5454 0.625
r9513 n5453 n5454 0.42499999999999999
r9514 n5348 n5455 0.034722222222222224
r9515 n5454 n5455 0.47499999999999998
r9516 n5349 n5456 0.625
r9517 n5455 n5456 0.47499999999999998
r9518 n5350 n5457 0.0390625
r9519 n5456 n5457 0.42499999999999999
r9520 n5351 n5458 0.625
r9521 n5457 n5458 0.42499999999999999
r9522 n5352 n5459 0.034722222222222224
r9523 n5458 n5459 0.47499999999999998
r9524 n5353 n5460 0.625
r9525 n5459 n5460 0.47499999999999998
r9526 n5354 n5461 0.0390625
r9527 n5460 n5461 0.42499999999999999
r9528 n5355 n5462 0.625
r9529 n5461 n5462 0.42499999999999999
r9530 n5356 n5463 0.034722222222222224
r9531 n5462 n5463 0.47499999999999998
r9532 n5357 n5464 0.625
r9533 n5463 n5464 0.47499999999999998
r9534 n5358 n5465 0.0390625
r9535 n5464 n5465 0.42499999999999999
r9536 n5359 n5466 0.625
r9537 n5465 n5466 0.42499999999999999
r9538 n5360 n5467 0.034722222222222224
r9539 n5466 n5467 0.47499999999999998
r9540 n5361 n5468 0.625
r9541 n5467 n5468 0.47499999999999998
r9542 n5362 n5469 0.0390625
r9543 n5468 n5469 0.42499999999999999
r9544 n5363 n5470 0.625
r9545 n5469 n5470 0.42499999999999999
r9546 n5364 n5471 0.10416666666666667
r9547 n5470 n5471 0.17499999999999999
r9548 n5365 n5472 0.043749999999999997
r9549 n5366 n5473 0.21875
r9550 n5472 n5473 0.375
r9551 n5367 n5474 0.013671875
r9552 n5473 n5474 1.0625
r9553 n5368 n5475 0.21875
r9554 n5474 n5475 1.0625
r9555 n5369 n5476 0.012152777777777778
r9556 n5475 n5476 1.1875
r9557 n5370 n5477 0.21875
r9558 n5476 n5477 1.1875
r9559 n5371 n5478 0.033653846153846152
r9560 n5477 n5478 0.46875
r9561 n5372 n5479 0.036458333333333336
r9562 n5478 n5479 0.78125
r9563 n5373 n5480 0.0625
r9564 n5479 n5480 0.59375
r9565 n5374 n5481 0.21875
r9566 n5480 n5481 0.28125
r9567 n5375 n5482 0.109375
r9568 n5481 n5482 0.1875
r9569 n5376 n5483 0.048611111111111112
r9570 n5482 n5483 0.40625
r9571 n5377 n5484 0.020833333333333332
r9572 n5483 n5484 0.9375
r9573 n5378 n5485 0.21875
r9574 n5484 n5485 0.71875
r9575 n5379 n5486 0.21875
r9576 n5485 n5486 0.125
r9577 n5380 n5487 0.048611111111111112
r9578 n5486 n5487 0.34375
r9579 n5381 n5488 0.036458333333333336
r9580 n5487 n5488 0.65625
r9581 n5382 n5489 0.048611111111111112
r9582 n5488 n5489 0.65625
r9583 n5383 n5490 0.21875
r9584 n5489 n5490 0.34375
r9585 n5384 n5491 0.21875
r9586 n5490 n5491 0.125
r9587 n5385 n5492 0.020833333333333332
r9588 n5491 n5492 0.71875
r9589 n5386 n5493 0.029166666666666667
r9590 n5492 n5493 1.125
r9591 n5387 n5494 0.21875
r9592 n5493 n5494 0.53125
r9593 n5388 n5495 0.013671875
r9594 n5494 n5495 1.0625
r9595 n5389 n5496 0.21875
r9596 n5495 n5496 1.0625
r9597 n5390 n5497 0.036458333333333336
r9598 n5496 n5497 0.4375
r9599 n5391 n5498 0.043749999999999997
r9600 n5392 n5499 0.21875
r9601 n5498 n5499 0.375
r9602 n5393 n5500 0.013671875
r9603 n5499 n5500 1.0625
r9604 n5394 n5501 0.21875
r9605 n5500 n5501 1.0625
r9606 n5395 n5502 0.012152777777777778
r9607 n5501 n5502 1.1875
r9608 n5396 n5503 0.21875
r9609 n5502 n5503 1.1875
r9610 n5397 n5504 0.013671875
r9611 n5503 n5504 1.0625
r9612 n5398 n5505 0.21875
r9613 n5504 n5505 1.0625
r9614 n5399 n5506 0.012152777777777778
r9615 n5505 n5506 1.1875
r9616 n5400 n5507 0.21875
r9617 n5506 n5507 1.1875
r9618 n5401 n5508 0.013671875
r9619 n5507 n5508 1.0625
r9620 n5402 n5509 0.21875
r9621 n5508 n5509 1.0625
r9622 n5403 n5510 0.012152777777777778
r9623 n5509 n5510 1.1875
r9624 n5404 n5511 0.21875
r9625 n5510 n5511 1.1875
r9626 n5405 n5512 0.013671875
r9627 n5511 n5512 1.0625
r9628 n5406 n5513 0.21875
r9629 n5512 n5513 1.0625
r9630 n5407 n5514 0.012152777777777778
r9631 n5513 n5514 1.1875
r9632 n5408 n5515 0.21875
r9633 n5514 n5515 1.1875
r9634 n5409 n5516 0.013671875
r9635 n5515 n5516 1.0625
r9636 n5410 n5517 0.21875
r9637 n5516 n5517 1.0625
r9638 n5411 n5518 0.012152777777777778
r9639 n5517 n5518 1.1875
r9640 n5412 n5519 0.21875
r9641 n5518 n5519 1.1875
r9642 n5413 n5520 0.013671875
r9643 n5519 n5520 1.0625
r9644 n5414 n5521 0.21875
r9645 n5520 n5521 1.0625
r9646 n5415 n5522 0.012152777777777778
r9647 n5521 n5522 1.1875
r9648 n5416 n5523 0.21875
r9649 n5522 n5523 1.1875
r9650 n5417 n5524 0.013671875
r9651 n5523 n5524 1.0625
r9652 n5418 n5525 0.21875
r9653 n5524 n5525 1.0625
r9654 n5419 n5526 0.012152777777777778
r9655 n5525 n5526 1.1875
r9656 n5420 n5527 0.21875
r9657 n5526 n5527 1.1875
r9658 n5421 n5528 0.013671875
r9659 n5527 n5528 1.0625
r9660 n5422 n5529 0.21875
r9661 n5528 n5529 1.0625
r9662 n5423 n5530 0.029166666666666667
r9663 n5529 n5530 0.53125
r9664 n5424 n5531 0.036458333333333336
r9665 n5530 n5531 0.84375
r9666 n5425 n5532 0.048611111111111112
r9667 n5531 n5532 0.65625
r9668 n5426 n5533 0.21875
r9669 n5532 n5533 0.34375
r9670 n5427 n5534 0.21875
r9671 n5533 n5534 0.125
r9672 n5428 n5535 0.0546875
r9673 n5534 n5535 0.3125
r9674 n5429 n5536 0.019886363636363636
r9675 n5535 n5536 0.9375
r9676 n5430 n5537 0.4375
r9677 n5536 n5537 0.71875
r9678 n5431 n5538 0.4375
r9679 n5537 n5538 0.0625
r9680 n5432 n5539 0.4375
r9681 n5538 n5539 0.0625
r9682 n5433 n5540 0.043749999999999997
r9683 n5539 n5540 0.34375
r9684 n5434 n5541 0.036458333333333336
r9685 n5540 n5541 0.6875
r9686 n5435 n5542 0.0546875
r9687 n5541 n5542 0.625
r9688 n5436 n5543 0.21875
r9689 n5542 n5543 0.3125
r9690 n5437 n5544 0.14583333333333334
r9691 n5543 n5544 0.15625
r9692 n5438 n5545 0.21875
r9693 n5544 n5545 0.15625
r9694 n5439 n5546 0.072916666666666671
r9695 n5545 n5546 0.25
r9696 n5440 n5547 0.036458333333333336
r9697 n5546 n5547 0.5625
r9698 n5441 n5548 0.03125
r9699 n5547 n5548 0.8125
r9700 n5442 n5549 0.21875
r9701 n5548 n5549 0.5
r9702 n5443 n5550 0.012152777777777778
r9703 n5549 n5550 1.1875
r9704 n5444 n5551 0.21875
r9705 n5550 n5551 1.1875
r9706 n5445 n5552 0.013671875
r9707 n5551 n5552 1.0625
r9708 n5446 n5553 0.21875
r9709 n5552 n5553 1.0625
r9710 n5447 n5554 0.012152777777777778
r9711 n5553 n5554 1.1875
r9712 n5448 n5555 0.21875
r9713 n5554 n5555 1.1875
r9714 n5449 n5556 0.013671875
r9715 n5555 n5556 1.0625
r9716 n5450 n5557 0.21875
r9717 n5556 n5557 1.0625
r9718 n5451 n5558 0.012152777777777778
r9719 n5557 n5558 1.1875
r9720 n5452 n5559 0.21875
r9721 n5558 n5559 1.1875
r9722 n5453 n5560 0.013671875
r9723 n5559 n5560 1.0625
r9724 n5454 n5561 0.21875
r9725 n5560 n5561 1.0625
r9726 n5455 n5562 0.012152777777777778
r9727 n5561 n5562 1.1875
r9728 n5456 n5563 0.21875
r9729 n5562 n5563 1.1875
r9730 n5457 n5564 0.013671875
r9731 n5563 n5564 1.0625
r9732 n5458 n5565 0.21875
r9733 n5564 n5565 1.0625
r9734 n5459 n5566 0.012152777777777778
r9735 n5565 n5566 1.1875
r9736 n5460 n5567 0.21875
r9737 n5566 n5567 1.1875
r9738 n5461 n5568 0.013671875
r9739 n5567 n5568 1.0625
r9740 n5462 n5569 0.21875
r9741 n5568 n5569 1.0625
r9742 n5463 n5570 0.012152777777777778
r9743 n5569 n5570 1.1875
r9744 n5464 n5571 0.21875
r9745 n5570 n5571 1.1875
r9746 n5465 n5572 0.013671875
r9747 n5571 n5572 1.0625
r9748 n5466 n5573 0.21875
r9749 n5572 n5573 1.0625
r9750 n5467 n5574 0.012152777777777778
r9751 n5573 n5574 1.1875
r9752 n5468 n5575 0.21875
r9753 n5574 n5575 1.1875
r9754 n5469 n5576 0.013671875
r9755 n5575 n5576 1.0625
r9756 n5470 n5577 0.21875
r9757 n5576 n5577 1.0625
r9758 n5471 n5578 0.036458333333333336
r9759 n5577 n5578 0.4375
r9760 n5472 n5579 0.050000000000000003
r9761 n5473 n5580 0.25
r9762 n5579 n5580 0.125
r9763 n5474 n5581 0.015625
r9764 n5580 n5581 0.35416666666666669
r9765 n5475 n5582 0.25
r9766 n5581 n5582 0.35416666666666669
r9767 n5476 n5583 0.013888888888888888
r9768 n5582 n5583 0.39583333333333331
r9769 n5477 n5584 0.25
r9770 n5583 n5584 0.39583333333333331
r9771 n5478 n5585 0.038461538461538464
r9772 n5584 n5585 0.15625
r9773 n5479 n5586 0.041666666666666664
r9774 n5585 n5586 0.26041666666666669
r9775 n5480 n5587 0.071428571428571425
r9776 n5586 n5587 0.19791666666666666
r9777 n5481 n5588 0.25
r9778 n5587 n5588 0.09375
r9779 n5482 n5589 0.125
r9780 n5588 n5589 0.0625
r9781 n5483 n5590 0.055555555555555552
r9782 n5589 n5590 0.13541666666666666
r9783 n5484 n5591 0.023809523809523808
r9784 n5590 n5591 0.3125
r9785 n5485 n5592 0.25
r9786 n5591 n5592 0.23958333333333334
r9787 n5486 n5593 0.25
r9788 n5592 n5593 0.041666666666666664
r9789 n5487 n5594 0.055555555555555552
r9790 n5593 n5594 0.11458333333333333
r9791 n5488 n5595 0.041666666666666664
r9792 n5594 n5595 0.21875
r9793 n5489 n5596 0.055555555555555552
r9794 n5595 n5596 0.21875
r9795 n5490 n5597 0.25
r9796 n5596 n5597 0.11458333333333333
r9797 n5491 n5598 0.25
r9798 n5597 n5598 0.041666666666666664
r9799 n5492 n5599 0.023809523809523808
r9800 n5598 n5599 0.23958333333333334
r9801 n5493 n5600 0.033333333333333333
r9802 n5599 n5600 0.375
r9803 n5494 n5601 0.25
r9804 n5600 n5601 0.17708333333333334
r9805 n5495 n5602 0.015625
r9806 n5601 n5602 0.35416666666666669
r9807 n5496 n5603 0.25
r9808 n5602 n5603 0.35416666666666669
r9809 n5497 n5604 0.041666666666666664
r9810 n5603 n5604 0.14583333333333334
r9811 n5498 n5605 0.050000000000000003
r9812 n5499 n5606 0.25
r9813 n5605 n5606 0.125
r9814 n5500 n5607 0.015625
r9815 n5606 n5607 0.35416666666666669
r9816 n5501 n5608 0.25
r9817 n5607 n5608 0.35416666666666669
r9818 n5502 n5609 0.013888888888888888
r9819 n5608 n5609 0.39583333333333331
r9820 n5503 n5610 0.25
r9821 n5609 n5610 0.39583333333333331
r9822 n5504 n5611 0.015625
r9823 n5610 n5611 0.35416666666666669
r9824 n5505 n5612 0.25
r9825 n5611 n5612 0.35416666666666669
r9826 n5506 n5613 0.013888888888888888
r9827 n5612 n5613 0.39583333333333331
r9828 n5507 n5614 0.25
r9829 n5613 n5614 0.39583333333333331
r9830 n5508 n5615 0.015625
r9831 n5614 n5615 0.35416666666666669
r9832 n5509 n5616 0.25
r9833 n5615 n5616 0.35416666666666669
r9834 n5510 n5617 0.013888888888888888
r9835 n5616 n5617 0.39583333333333331
r9836 n5511 n5618 0.25
r9837 n5617 n5618 0.39583333333333331
r9838 n5512 n5619 0.015625
r9839 n5618 n5619 0.35416666666666669
r9840 n5513 n5620 0.25
r9841 n5619 n5620 0.35416666666666669
r9842 n5514 n5621 0.013888888888888888
r9843 n5620 n5621 0.39583333333333331
r9844 n5515 n5622 0.25
r9845 n5621 n5622 0.39583333333333331
r9846 n5516 n5623 0.015625
r9847 n5622 n5623 0.35416666666666669
r9848 n5517 n5624 0.25
r9849 n5623 n5624 0.35416666666666669
r9850 n5518 n5625 0.013888888888888888
r9851 n5624 n5625 0.39583333333333331
r9852 n5519 n5626 0.25
r9853 n5625 n5626 0.39583333333333331
r9854 n5520 n5627 0.015625
r9855 n5626 n5627 0.35416666666666669
r9856 n5521 n5628 0.25
r9857 n5627 n5628 0.35416666666666669
r9858 n5522 n5629 0.013888888888888888
r9859 n5628 n5629 0.39583333333333331
r9860 n5523 n5630 0.25
r9861 n5629 n5630 0.39583333333333331
r9862 n5524 n5631 0.015625
r9863 n5630 n5631 0.35416666666666669
r9864 n5525 n5632 0.25
r9865 n5631 n5632 0.35416666666666669
r9866 n5526 n5633 0.013888888888888888
r9867 n5632 n5633 0.39583333333333331
r9868 n5527 n5634 0.25
r9869 n5633 n5634 0.39583333333333331
r9870 n5528 n5635 0.015625
r9871 n5634 n5635 0.35416666666666669
r9872 n5529 n5636 0.25
r9873 n5635 n5636 0.35416666666666669
r9874 n5530 n5637 0.033333333333333333
r9875 n5636 n5637 0.17708333333333334
r9876 n5531 n5638 0.041666666666666664
r9877 n5637 n5638 0.28125
r9878 n5532 n5639 0.055555555555555552
r9879 n5638 n5639 0.21875
r9880 n5533 n5640 0.25
r9881 n5639 n5640 0.11458333333333333
r9882 n5534 n5641 0.25
r9883 n5640 n5641 0.041666666666666664
r9884 n5535 n5642 0.0625
r9885 n5641 n5642 0.10416666666666667
r9886 n5536 n5643 0.022727272727272728
r9887 n5642 n5643 0.3125
r9888 n5537 n5644 0.5
r9889 n5643 n5644 0.23958333333333334
r9890 n5538 n5645 0.5
r9891 n5644 n5645 0.020833333333333332
r9892 n5539 n5646 0.5
r9893 n5645 n5646 0.020833333333333332
r9894 n5540 n5647 0.050000000000000003
r9895 n5646 n5647 0.11458333333333333
r9896 n5541 n5648 0.041666666666666664
r9897 n5647 n5648 0.22916666666666666
r9898 n5542 n5649 0.0625
r9899 n5648 n5649 0.20833333333333334
r9900 n5543 n5650 0.25
r9901 n5649 n5650 0.10416666666666667
r9902 n5544 n5651 0.16666666666666666
r9903 n5650 n5651 0.052083333333333336
r9904 n5545 n5652 0.25
r9905 n5651 n5652 0.052083333333333336
r9906 n5546 n5653 0.083333333333333329
r9907 n5652 n5653 0.083333333333333329
r9908 n5547 n5654 0.041666666666666664
r9909 n5653 n5654 0.1875
r9910 n5548 n5655 0.035714285714285712
r9911 n5654 n5655 0.27083333333333331
r9912 n5549 n5656 0.25
r9913 n5655 n5656 0.16666666666666666
r9914 n5550 n5657 0.013888888888888888
r9915 n5656 n5657 0.39583333333333331
r9916 n5551 n5658 0.25
r9917 n5657 n5658 0.39583333333333331
r9918 n5552 n5659 0.015625
r9919 n5658 n5659 0.35416666666666669
r9920 n5553 n5660 0.25
r9921 n5659 n5660 0.35416666666666669
r9922 n5554 n5661 0.013888888888888888
r9923 n5660 n5661 0.39583333333333331
r9924 n5555 n5662 0.25
r9925 n5661 n5662 0.39583333333333331
r9926 n5556 n5663 0.015625
r9927 n5662 n5663 0.35416666666666669
r9928 n5557 n5664 0.25
r9929 n5663 n5664 0.35416666666666669
r9930 n5558 n5665 0.013888888888888888
r9931 n5664 n5665 0.39583333333333331
r9932 n5559 n5666 0.25
r9933 n5665 n5666 0.39583333333333331
r9934 n5560 n5667 0.015625
r9935 n5666 n5667 0.35416666666666669
r9936 n5561 n5668 0.25
r9937 n5667 n5668 0.35416666666666669
r9938 n5562 n5669 0.013888888888888888
r9939 n5668 n5669 0.39583333333333331
r9940 n5563 n5670 0.25
r9941 n5669 n5670 0.39583333333333331
r9942 n5564 n5671 0.015625
r9943 n5670 n5671 0.35416666666666669
r9944 n5565 n5672 0.25
r9945 n5671 n5672 0.35416666666666669
r9946 n5566 n5673 0.013888888888888888
r9947 n5672 n5673 0.39583333333333331
r9948 n5567 n5674 0.25
r9949 n5673 n5674 0.39583333333333331
r9950 n5568 n5675 0.015625
r9951 n5674 n5675 0.35416666666666669
r9952 n5569 n5676 0.25
r9953 n5675 n5676 0.35416666666666669
r9954 n5570 n5677 0.013888888888888888
r9955 n5676 n5677 0.39583333333333331
r9956 n5571 n5678 0.25
r9957 n5677 n5678 0.39583333333333331
r9958 n5572 n5679 0.015625
r9959 n5678 n5679 0.35416666666666669
r9960 n5573 n5680 0.25
r9961 n5679 n5680 0.35416666666666669
r9962 n5574 n5681 0.013888888888888888
r9963 n5680 n5681 0.39583333333333331
r9964 n5575 n5682 0.25
r9965 n5681 n5682 0.39583333333333331
r9966 n5576 n5683 0.015625
r9967 n5682 n5683 0.35416666666666669
r9968 n5577 n5684 0.25
r9969 n5683 n5684 0.35416666666666669
r9970 n5578 n5685 0.041666666666666664
r9971 n5684 n5685 0.14583333333333334
r9972 n5586 n5686 0.067708333333333329
r9973 n5587 n5687 0.11607142857142858
r9974 n5686 n5687 0.16964285714285715
r9975 n5588 n5688 0.40625
r9976 n5687 n5688 0.080357142857142863
r9977 n5589 n5689 0.203125
r9978 n5688 n5689 0.053571428571428568
r9979 n5590 n5690 0.090277777777777776
r9980 n5689 n5690 0.11607142857142858
r9981 n5591 n5691 0.038690476190476192
r9982 n5690 n5691 0.26785714285714285
r9983 n5592 n5692 0.40625
r9984 n5691 n5692 0.20535714285714285
r9985 n5593 n5693 0.40625
r9986 n5692 n5693 0.035714285714285712
r9987 n5594 n5694 0.090277777777777776
r9988 n5693 n5694 0.098214285714285712
r9989 n5595 n5695 0.067708333333333329
r9990 n5694 n5695 0.1875
r9991 n5638 n5696 0.067708333333333329
r9992 n5639 n5697 0.090277777777777776
r9993 n5696 n5697 0.1875
r9994 n5640 n5698 0.40625
r9995 n5697 n5698 0.098214285714285712
r9996 n5641 n5699 0.40625
r9997 n5698 n5699 0.035714285714285712
r9998 n5642 n5700 0.1015625
r9999 n5699 n5700 0.089285714285714288
r10000 n5643 n5701 0.036931818181818184
r10001 n5700 n5701 0.26785714285714285
r10002 n5644 n5702 0.8125
r10003 n5701 n5702 0.20535714285714285
r10004 n5645 n5703 0.8125
r10005 n5702 n5703 0.017857142857142856
r10006 n5646 n5704 0.8125
r10007 n5703 n5704 0.017857142857142856
r10008 n5647 n5705 0.081250000000000003
r10009 n5704 n5705 0.098214285714285712
r10010 n5648 n5706 0.067708333333333329
r10011 n5705 n5706 0.19642857142857142
r10012 n5707 n5708 0.027777777777777776
r10013 n5708 n5709 0.04583333333333333
r10014 n5709 n5710 0.034722222222222224
r10015 n5710 n5711 0.044444444444444446
r10016 n5711 n5712 0.044444444444444446
r10017 n5712 n5713 0.034722222222222224
r10018 n5713 n5714 0.04583333333333333
r10019 n5714 n5715 0.027777777777777776
r10020 n5716 n5717 0.027777777777777776
r10021 n5717 n5718 0.04027777777777778
r10022 n5718 n5719 0.031944444444444442
r10023 n5719 n5720 0.0083333333333333332
r10024 n5720 n5721 0.044444444444444446
r10025 n5721 n5722 0.044444444444444446
r10026 n5722 n5723 0.0083333333333333332
r10027 n5723 n5724 0.031944444444444442
r10028 n5724 n5725 0.04027777777777778
r10029 n5725 n5726 0.027777777777777776
r10030 n5707 n5727 0.46875
r10031 n5708 n5728 0.46875
r10032 n5727 n5728 0.041666666666666664
r10033 n5709 n5729 0.20380434782608695
r10034 n5728 n5729 0.068750000000000006
r10035 n5710 n5730 2.34375
r10036 n5729 n5730 0.052083333333333336
r10037 n5711 n5731 0.15625
r10038 n5730 n5731 0.066666666666666666
r10039 n5712 n5732 2.34375
r10040 n5731 n5732 0.066666666666666666
r10041 n5713 n5733 0.20380434782608695
r10042 n5732 n5733 0.052083333333333336
r10043 n5714 n5734 0.46875
r10044 n5733 n5734 0.068750000000000006
r10045 n5715 n5735 0.46875
r10046 n5734 n5735 0.041666666666666664
r10047 n5716 n5736 0.46875
r10048 n5717 n5737 0.46875
r10049 n5736 n5737 0.041666666666666664
r10050 n5718 n5738 0.24671052631578946
r10051 n5737 n5738 0.060416666666666667
r10052 n5719 n5739 1.171875
r10053 n5738 n5739 0.04791666666666667
r10054 n5720 n5740 2.34375
r10055 n5739 n5740 0.012500000000000001
r10056 n5721 n5741 0.15625
r10057 n5740 n5741 0.066666666666666666
r10058 n5722 n5742 2.34375
r10059 n5741 n5742 0.066666666666666666
r10060 n5723 n5743 1.171875
r10061 n5742 n5743 0.012500000000000001
r10062 n5724 n5744 0.24671052631578946
r10063 n5743 n5744 0.04791666666666667
r10064 n5725 n5745 0.46875
r10065 n5744 n5745 0.060416666666666667
r10066 n5726 n5746 0.46875
r10067 n5745 n5746 0.041666666666666664
r10068 n5727 n5747 0.34375
r10069 n5728 n5748 0.34375
r10070 n5747 n5748 0.050000000000000003
r10071 n5729 n5749 0.14945652173913043
r10072 n5748 n5749 0.082500000000000004
r10073 n5730 n5750 1.71875
r10074 n5749 n5750 0.0625
r10075 n5731 n5751 0.11458333333333333
r10076 n5750 n5751 0.080000000000000002
r10077 n5732 n5752 1.71875
r10078 n5751 n5752 0.080000000000000002
r10079 n5733 n5753 0.14945652173913043
r10080 n5752 n5753 0.0625
r10081 n5734 n5754 0.34375
r10082 n5753 n5754 0.082500000000000004
r10083 n5735 n5755 0.34375
r10084 n5754 n5755 0.050000000000000003
r10085 n5736 n5756 0.34375
r10086 n5737 n5757 0.34375
r10087 n5756 n5757 0.050000000000000003
r10088 n5738 n5758 0.18092105263157895
r10089 n5757 n5758 0.072499999999999995
r10090 n5739 n5759 0.859375
r10091 n5758 n5759 0.057500000000000002
r10092 n5740 n5760 1.71875
r10093 n5759 n5760 0.014999999999999999
r10094 n5741 n5761 0.11458333333333333
r10095 n5760 n5761 0.080000000000000002
r10096 n5742 n5762 1.71875
r10097 n5761 n5762 0.080000000000000002
r10098 n5743 n5763 0.859375
r10099 n5762 n5763 0.014999999999999999
r10100 n5744 n5764 0.18092105263157895
r10101 n5763 n5764 0.057500000000000002
r10102 n5745 n5765 0.34375
r10103 n5764 n5765 0.072499999999999995
r10104 n5746 n5766 0.34375
r10105 n5765 n5766 0.050000000000000003
r10106 n5747 n5767 0.28125
r10107 n5748 n5768 0.28125
r10108 n5767 n5768 0.0625
r10109 n5749 n5769 0.12228260869565218
r10110 n5768 n5769 0.10312499999999999
r10111 n5750 n5770 1.40625
r10112 n5769 n5770 0.078125
r10113 n5751 n5771 0.09375
r10114 n5770 n5771 0.10000000000000001
r10115 n5752 n5772 1.40625
r10116 n5771 n5772 0.10000000000000001
r10117 n5753 n5773 0.12228260869565218
r10118 n5772 n5773 0.078125
r10119 n5754 n5774 0.28125
r10120 n5773 n5774 0.10312499999999999
r10121 n5755 n5775 0.28125
r10122 n5774 n5775 0.0625
r10123 n5756 n5776 0.28125
r10124 n5757 n5777 0.28125
r10125 n5776 n5777 0.0625
r10126 n5758 n5778 0.14802631578947367
r10127 n5777 n5778 0.090624999999999997
r10128 n5759 n5779 0.703125
r10129 n5778 n5779 0.071874999999999994
r10130 n5760 n5780 1.40625
r10131 n5779 n5780 0.018749999999999999
r10132 n5761 n5781 0.09375
r10133 n5780 n5781 0.10000000000000001
r10134 n5762 n5782 1.40625
r10135 n5781 n5782 0.10000000000000001
r10136 n5763 n5783 0.703125
r10137 n5782 n5783 0.018749999999999999
r10138 n5764 n5784 0.14802631578947367
r10139 n5783 n5784 0.071874999999999994
r10140 n5765 n5785 0.28125
r10141 n5784 n5785 0.090624999999999997
r10142 n5766 n5786 0.28125
r10143 n5785 n5786 0.0625
r10144 n5768 n5787 0.34375
r10145 n5769 n5788 0.14945652173913043
r10146 n5787 n5788 0.058928571428571427
r10147 n5770 n5789 1.71875
r10148 n5788 n5789 0.044642857142857144
r10149 n5771 n5790 0.11458333333333333
r10150 n5789 n5790 0.057142857142857141
r10151 n5772 n5791 1.71875
r10152 n5790 n5791 0.057142857142857141
r10153 n5773 n5792 0.14945652173913043
r10154 n5791 n5792 0.044642857142857144
r10155 n5774 n5793 0.34375
r10156 n5792 n5793 0.058928571428571427
r10157 n5777 n5794 0.34375
r10158 n5778 n5795 0.18092105263157895
r10159 n5794 n5795 0.051785714285714289
r10160 n5779 n5796 0.859375
r10161 n5795 n5796 0.041071428571428571
r10162 n5780 n5797 1.71875
r10163 n5796 n5797 0.010714285714285714
r10164 n5781 n5798 0.11458333333333333
r10165 n5797 n5798 0.057142857142857141
r10166 n5782 n5799 1.71875
r10167 n5798 n5799 0.057142857142857141
r10168 n5783 n5800 0.859375
r10169 n5799 n5800 0.010714285714285714
r10170 n5784 n5801 0.18092105263157895
r10171 n5800 n5801 0.041071428571428571
r10172 n5785 n5802 0.34375
r10173 n5801 n5802 0.051785714285714289
r10174 n5787 n5803 0.4375
r10175 n5788 n5804 0.19021739130434784
r10176 n5803 n5804 0.058928571428571427
r10177 n5789 n5805 2.1875
r10178 n5804 n5805 0.044642857142857144
r10179 n5790 n5806 0.14583333333333334
r10180 n5805 n5806 0.057142857142857141
r10181 n5791 n5807 2.1875
r10182 n5806 n5807 0.057142857142857141
r10183 n5792 n5808 0.19021739130434784
r10184 n5807 n5808 0.044642857142857144
r10185 n5793 n5809 0.4375
r10186 n5808 n5809 0.058928571428571427
r10187 n5794 n5810 0.4375
r10188 n5795 n5811 0.23026315789473684
r10189 n5810 n5811 0.051785714285714289
r10190 n5796 n5812 1.09375
r10191 n5811 n5812 0.041071428571428571
r10192 n5797 n5813 2.1875
r10193 n5812 n5813 0.010714285714285714
r10194 n5798 n5814 0.14583333333333334
r10195 n5813 n5814 0.057142857142857141
r10196 n5799 n5815 2.1875
r10197 n5814 n5815 0.057142857142857141
r10198 n5800 n5816 1.09375
r10199 n5815 n5816 0.010714285714285714
r10200 n5801 n5817 0.23026315789473684
r10201 n5816 n5817 0.041071428571428571
r10202 n5802 n5818 0.4375
r10203 n5817 n5818 0.051785714285714289
r10204 n5803 n5819 0.40625
r10205 n5804 n5820 0.1766304347826087
r10206 n5819 n5820 0.068750000000000006
r10207 n5805 n5821 2.03125
r10208 n5820 n5821 0.052083333333333336
r10209 n5806 n5822 0.13541666666666666
r10210 n5821 n5822 0.066666666666666666
r10211 n5807 n5823 2.03125
r10212 n5822 n5823 0.066666666666666666
r10213 n5808 n5824 0.1766304347826087
r10214 n5823 n5824 0.052083333333333336
r10215 n5809 n5825 0.40625
r10216 n5824 n5825 0.068750000000000006
r10217 n5810 n5826 0.40625
r10218 n5811 n5827 0.21381578947368421
r10219 n5826 n5827 0.060416666666666667
r10220 n5812 n5828 1.015625
r10221 n5827 n5828 0.04791666666666667
r10222 n5813 n5829 2.03125
r10223 n5828 n5829 0.012500000000000001
r10224 n5814 n5830 0.13541666666666666
r10225 n5829 n5830 0.066666666666666666
r10226 n5815 n5831 2.03125
r10227 n5830 n5831 0.066666666666666666
r10228 n5816 n5832 1.015625
r10229 n5831 n5832 0.012500000000000001
r10230 n5817 n5833 0.21381578947368421
r10231 n5832 n5833 0.04791666666666667
r10232 n5818 n5834 0.40625
r10233 n5833 n5834 0.060416666666666667
r10234 n5819 n5835 0.375
r10235 n5820 n5836 0.16304347826086957
r10236 n5835 n5836 0.068750000000000006
r10237 n5821 n5837 1.875
r10238 n5836 n5837 0.052083333333333336
r10239 n5822 n5838 0.125
r10240 n5837 n5838 0.066666666666666666
r10241 n5823 n5839 1.875
r10242 n5838 n5839 0.066666666666666666
r10243 n5824 n5840 0.16304347826086957
r10244 n5839 n5840 0.052083333333333336
r10245 n5825 n5841 0.375
r10246 n5840 n5841 0.068750000000000006
r10247 n5826 n5842 0.375
r10248 n5827 n5843 0.19736842105263158
r10249 n5842 n5843 0.060416666666666667
r10250 n5828 n5844 0.9375
r10251 n5843 n5844 0.04791666666666667
r10252 n5829 n5845 1.875
r10253 n5844 n5845 0.012500000000000001
r10254 n5830 n5846 0.125
r10255 n5845 n5846 0.066666666666666666
r10256 n5831 n5847 1.875
r10257 n5846 n5847 0.066666666666666666
r10258 n5832 n5848 0.9375
r10259 n5847 n5848 0.012500000000000001
r10260 n5833 n5849 0.19736842105263158
r10261 n5848 n5849 0.04791666666666667
r10262 n5834 n5850 0.375
r10263 n5849 n5850 0.060416666666666667
r10264 n5835 n5851 0.41249999999999998
r10265 n5836 n5852 0.17934782608695651
r10266 n5851 n5852 0.057291666666666664
r10267 n5837 n5853 2.0625
r10268 n5852 n5853 0.043402777777777776
r10269 n5838 n5854 0.13750000000000001
r10270 n5853 n5854 0.055555555555555552
r10271 n5839 n5855 2.0625
r10272 n5854 n5855 0.055555555555555552
r10273 n5840 n5856 0.17934782608695651
r10274 n5855 n5856 0.043402777777777776
r10275 n5841 n5857 0.41249999999999998
r10276 n5856 n5857 0.057291666666666664
r10277 n5842 n5858 0.41249999999999998
r10278 n5843 n5859 0.21710526315789475
r10279 n5858 n5859 0.050347222222222224
r10280 n5844 n5860 1.03125
r10281 n5859 n5860 0.039930555555555552
r10282 n5845 n5861 2.0625
r10283 n5860 n5861 0.010416666666666666
r10284 n5846 n5862 0.13750000000000001
r10285 n5861 n5862 0.055555555555555552
r10286 n5847 n5863 2.0625
r10287 n5862 n5863 0.055555555555555552
r10288 n5848 n5864 1.03125
r10289 n5863 n5864 0.010416666666666666
r10290 n5849 n5865 0.21710526315789475
r10291 n5864 n5865 0.039930555555555552
r10292 n5850 n5866 0.41249999999999998
r10293 n5865 n5866 0.050347222222222224
r10294 n5851 n5867 0.45000000000000001
r10295 n5852 n5868 0.19565217391304349
r10296 n5867 n5868 0.057291666666666664
r10297 n5853 n5869 2.25
r10298 n5868 n5869 0.043402777777777776
r10299 n5854 n5870 0.14999999999999999
r10300 n5869 n5870 0.055555555555555552
r10301 n5855 n5871 2.25
r10302 n5870 n5871 0.055555555555555552
r10303 n5856 n5872 0.19565217391304349
r10304 n5871 n5872 0.043402777777777776
r10305 n5857 n5873 0.45000000000000001
r10306 n5872 n5873 0.057291666666666664
r10307 n5858 n5874 0.45000000000000001
r10308 n5859 n5875 0.23684210526315788
r10309 n5874 n5875 0.050347222222222224
r10310 n5860 n5876 1.125
r10311 n5875 n5876 0.039930555555555552
r10312 n5861 n5877 2.25
r10313 n5876 n5877 0.010416666666666666
r10314 n5862 n5878 0.14999999999999999
r10315 n5877 n5878 0.055555555555555552
r10316 n5863 n5879 2.25
r10317 n5878 n5879 0.055555555555555552
r10318 n5864 n5880 1.125
r10319 n5879 n5880 0.010416666666666666
r10320 n5865 n5881 0.23684210526315788
r10321 n5880 n5881 0.039930555555555552
r10322 n5866 n5882 0.45000000000000001
r10323 n5881 n5882 0.050347222222222224
r10324 n5867 n5883 0.40000000000000002
r10325 n5868 n5884 0.17391304347826086
r10326 n5883 n5884 0.073660714285714288
r10327 n5869 n5885 2
r10328 n5884 n5885 0.055803571428571432
r10329 n5870 n5886 0.13333333333333333
r10330 n5885 n5886 0.071428571428571425
r10331 n5871 n5887 2
r10332 n5886 n5887 0.071428571428571425
r10333 n5872 n5888 0.17391304347826086
r10334 n5887 n5888 0.055803571428571432
r10335 n5873 n5889 0.40000000000000002
r10336 n5888 n5889 0.073660714285714288
r10337 n5890 n5891 0.024553571428571428
r10338 n5891 n5892 0.0089285714285714281
r10339 n5892 n5893 0.022321428571428572
r10340 n5893 n5894 0.066964285714285712
r10341 n5894 n5895 0.051339285714285712
r10342 n5895 n5896 0.004464285714285714
r10343 n5896 n5897 0.004464285714285714
r10344 n5897 n5898 0.024553571428571428
r10345 n5898 n5899 0.049107142857142856
r10346 n5899 n5900 0.044642857142857144
r10347 n5900 n5901 0.022321428571428572
r10348 n5901 n5902 0.011160714285714286
r10349 n5902 n5903 0.011160714285714286
r10350 n5903 n5904 0.017857142857142856
r10351 n5904 n5905 0.040178571428571432
r10352 n5905 n5906 0.058035714285714288
r10353 n5906 n5907 0.035714285714285712
r10354 n5907 n5908 0.084821428571428575
r10355 n5908 n5909 0.084821428571428575
r10356 n5909 n5910 0.075892857142857137
r10357 n5910 n5911 0.075892857142857137
r10358 n5911 n5912 0.084821428571428575
r10359 n5912 n5913 0.084821428571428575
r10360 n5913 n5914 0.075892857142857137
r10361 n5914 n5915 0.075892857142857137
r10362 n5915 n5916 0.084821428571428575
r10363 n5916 n5917 0.084821428571428575
r10364 n5917 n5918 0.075892857142857137
r10365 n5918 n5919 0.075892857142857137
r10366 n5919 n5920 0.084821428571428575
r10367 n5920 n5921 0.084821428571428575
r10368 n5921 n5922 0.075892857142857137
r10369 n5922 n5923 0.075892857142857137
r10370 n5923 n5924 0.084821428571428575
r10371 n5924 n5925 0.084821428571428575
r10372 n5925 n5926 0.075892857142857137
r10373 n5926 n5927 0.075892857142857137
r10374 n5927 n5928 0.084821428571428575
r10375 n5928 n5929 0.084821428571428575
r10376 n5929 n5930 0.075892857142857137
r10377 n5930 n5931 0.075892857142857137
r10378 n5931 n5932 0.084821428571428575
r10379 n5932 n5933 0.084821428571428575
r10380 n5933 n5934 0.075892857142857137
r10381 n5934 n5935 0.075892857142857137
r10382 n5935 n5936 0.03125
r10383 n5936 n5937 0.035714285714285712
r10384 n5937 n5938 0.053571428571428568
r10385 n5938 n5939 0.12053571428571429
r10386 n5939 n5940 0.080357142857142863
r10387 n5940 n5941 0.026785714285714284
r10388 n5941 n5942 0.037946428571428568
r10389 n5942 n5943 0.022321428571428572
r10390 n5943 n5944 0.013392857142857142
r10391 n5944 n5945 0.011160714285714286
r10392 n5945 n5946 0.029017857142857144
r10393 n5946 n5947 0.066964285714285712
r10394 n5947 n5948 0.046875
r10395 n5948 n5949 0.011160714285714286
r10396 n5949 n5950 0.013392857142857142
r10397 n5950 n5951 0.022321428571428572
r10398 n5951 n5952 0.037946428571428568
r10399 n5952 n5953 0.13169642857142858
r10400 n5953 n5954 0.18526785714285715
r10401 n5954 n5955 0.18705357142857143
r10402 n5955 n5956 0.22187499999999999
r10403 n5956 n5957 0.22187499999999999
r10404 n5957 n5958 0.22232142857142856
r10405 n5958 n5959 0.13348214285714285
r10406 n5874 n5960 0.40000000000000002
r10407 n5959 n5960 0.044642857142857144
r10408 n5875 n5961 0.21052631578947367
r10409 n5960 n5961 0.064732142857142863
r10410 n5876 n5962 1
r10411 n5961 n5962 0.051339285714285712
r10412 n5877 n5963 2
r10413 n5962 n5963 0.013392857142857142
r10414 n5878 n5964 0.13333333333333333
r10415 n5963 n5964 0.071428571428571425
r10416 n5879 n5965 2
r10417 n5964 n5965 0.071428571428571425
r10418 n5880 n5966 1
r10419 n5965 n5966 0.013392857142857142
r10420 n5881 n5967 0.21052631578947367
r10421 n5966 n5967 0.051339285714285712
r10422 n5882 n5968 0.40000000000000002
r10423 n5967 n5968 0.064732142857142863
r10424 n5883 n5969 0.34999999999999998
r10425 n5884 n5970 0.15217391304347827
r10426 n5969 n5970 0.073660714285714288
r10427 n5885 n5971 1.75
r10428 n5970 n5971 0.055803571428571432
r10429 n5886 n5972 0.11666666666666667
r10430 n5971 n5972 0.071428571428571425
r10431 n5887 n5973 1.75
r10432 n5972 n5973 0.071428571428571425
r10433 n5888 n5974 0.15217391304347827
r10434 n5973 n5974 0.055803571428571432
r10435 n5889 n5975 0.34999999999999998
r10436 n5974 n5975 0.073660714285714288
r10437 n5890 n5976 0.3888888888888889
r10438 n5891 n5977 1.75
r10439 n5976 n5977 0.024553571428571428
r10440 n5892 n5978 1.75
r10441 n5977 n5978 0.0089285714285714281
r10442 n5893 n5979 0.4375
r10443 n5978 n5979 0.022321428571428572
r10444 n5894 n5980 0.15909090909090909
r10445 n5979 n5980 0.066964285714285712
r10446 n5895 n5981 3.5
r10447 n5980 n5981 0.051339285714285712
r10448 n5896 n5982 3.5
r10449 n5981 n5982 0.004464285714285714
r10450 n5897 n5983 3.5
r10451 n5982 n5983 0.004464285714285714
r10452 n5898 n5984 0.34999999999999998
r10453 n5983 n5984 0.024553571428571428
r10454 n5899 n5985 0.29166666666666669
r10455 n5984 n5985 0.049107142857142856
r10456 n5900 n5986 0.4375
r10457 n5985 n5986 0.044642857142857144
r10458 n5901 n5987 1.75
r10459 n5986 n5987 0.022321428571428572
r10460 n5902 n5988 1.1666666666666667
r10461 n5987 n5988 0.011160714285714286
r10462 n5903 n5989 1.75
r10463 n5988 n5989 0.011160714285714286
r10464 n5904 n5990 0.58333333333333337
r10465 n5989 n5990 0.017857142857142856
r10466 n5905 n5991 0.29166666666666669
r10467 n5990 n5991 0.040178571428571432
r10468 n5906 n5992 0.25
r10469 n5991 n5992 0.058035714285714288
r10470 n5907 n5993 1.75
r10471 n5992 n5993 0.035714285714285712
r10472 n5908 n5994 0.097222222222222224
r10473 n5993 n5994 0.084821428571428575
r10474 n5909 n5995 1.75
r10475 n5994 n5995 0.084821428571428575
r10476 n5910 n5996 0.109375
r10477 n5995 n5996 0.075892857142857137
r10478 n5911 n5997 1.75
r10479 n5996 n5997 0.075892857142857137
r10480 n5912 n5998 0.097222222222222224
r10481 n5997 n5998 0.084821428571428575
r10482 n5913 n5999 1.75
r10483 n5998 n5999 0.084821428571428575
r10484 n5914 n6000 0.109375
r10485 n5999 n6000 0.075892857142857137
r10486 n5915 n6001 1.75
r10487 n6000 n6001 0.075892857142857137
r10488 n5916 n6002 0.097222222222222224
r10489 n6001 n6002 0.084821428571428575
r10490 n5917 n6003 1.75
r10491 n6002 n6003 0.084821428571428575
r10492 n5918 n6004 0.109375
r10493 n6003 n6004 0.075892857142857137
r10494 n5919 n6005 1.75
r10495 n6004 n6005 0.075892857142857137
r10496 n5920 n6006 0.097222222222222224
r10497 n6005 n6006 0.084821428571428575
r10498 n5921 n6007 1.75
r10499 n6006 n6007 0.084821428571428575
r10500 n5922 n6008 0.109375
r10501 n6007 n6008 0.075892857142857137
r10502 n5923 n6009 1.75
r10503 n6008 n6009 0.075892857142857137
r10504 n5924 n6010 0.097222222222222224
r10505 n6009 n6010 0.084821428571428575
r10506 n5925 n6011 1.75
r10507 n6010 n6011 0.084821428571428575
r10508 n5926 n6012 0.109375
r10509 n6011 n6012 0.075892857142857137
r10510 n5927 n6013 1.75
r10511 n6012 n6013 0.075892857142857137
r10512 n5928 n6014 0.097222222222222224
r10513 n6013 n6014 0.084821428571428575
r10514 n5929 n6015 1.75
r10515 n6014 n6015 0.084821428571428575
r10516 n5930 n6016 0.109375
r10517 n6015 n6016 0.075892857142857137
r10518 n5931 n6017 1.75
r10519 n6016 n6017 0.075892857142857137
r10520 n5932 n6018 0.097222222222222224
r10521 n6017 n6018 0.084821428571428575
r10522 n5933 n6019 1.75
r10523 n6018 n6019 0.084821428571428575
r10524 n5934 n6020 0.109375
r10525 n6019 n6020 0.075892857142857137
r10526 n5935 n6021 1.75
r10527 n6020 n6021 0.075892857142857137
r10528 n5936 n6022 0.29166666666666669
r10529 n6021 n6022 0.03125
r10530 n5937 n6023 0.875
r10531 n6022 n6023 0.035714285714285712
r10532 n5938 n6024 0.17499999999999999
r10533 n6023 n6024 0.053571428571428568
r10534 n5939 n6025 0.10294117647058823
r10535 n6024 n6025 0.12053571428571429
r10536 n5940 n6026 1.75
r10537 n6025 n6026 0.080357142857142863
r10538 n5941 n6027 0.34999999999999998
r10539 n6026 n6027 0.026785714285714284
r10540 n5942 n6028 0.5
r10541 n6027 n6028 0.037946428571428568
r10542 n5943 n6029 1.1666666666666667
r10543 n6028 n6029 0.022321428571428572
r10544 n5944 n6030 1.1666666666666667
r10545 n6029 n6030 0.013392857142857142
r10546 n5945 n6031 1.75
r10547 n6030 n6031 0.011160714285714286
r10548 n5946 n6032 0.31818181818181818
r10549 n6031 n6032 0.029017857142857144
r10550 n5947 n6033 0.18421052631578946
r10551 n6032 n6033 0.066964285714285712
r10552 n5948 n6034 1.75
r10553 n6033 n6034 0.046875
r10554 n5949 n6035 1.1666666666666667
r10555 n6034 n6035 0.011160714285714286
r10556 n5950 n6036 1.1666666666666667
r10557 n6035 n6036 0.013392857142857142
r10558 n5951 n6037 0.5
r10559 n6036 n6037 0.022321428571428572
r10560 n5952 n6038 0.34999999999999998
r10561 n6037 n6038 0.037946428571428568
r10562 n5953 n6039 0.071428571428571425
r10563 n6038 n6039 0.13169642857142858
r10564 n5954 n6040 0.10294117647058823
r10565 n6039 n6040 0.18526785714285715
r10566 n5955 n6041 0.070281124497991967
r10567 n6040 n6041 0.18705357142857143
r10568 n5956 n6042 0.070564516129032265
r10569 n6041 n6042 0.22187499999999999
r10570 n5957 n6043 0.070281124497991967
r10571 n6042 n6043 0.22187499999999999
r10572 n5958 n6044 0.070281124497991967
r10573 n6043 n6044 0.22232142857142856
r10574 n5959 n6045 0.34999999999999998
r10575 n6044 n6045 0.13348214285714285
r10576 n5960 n6046 0.34999999999999998
r10577 n6045 n6046 0.044642857142857144
r10578 n5961 n6047 0.18421052631578946
r10579 n6046 n6047 0.064732142857142863
r10580 n5962 n6048 0.875
r10581 n6047 n6048 0.051339285714285712
r10582 n5963 n6049 1.75
r10583 n6048 n6049 0.013392857142857142
r10584 n5964 n6050 0.11666666666666667
r10585 n6049 n6050 0.071428571428571425
r10586 n5965 n6051 1.75
r10587 n6050 n6051 0.071428571428571425
r10588 n5966 n6052 0.875
r10589 n6051 n6052 0.013392857142857142
r10590 n5967 n6053 0.18421052631578946
r10591 n6052 n6053 0.051339285714285712
r10592 n5968 n6054 0.34999999999999998
r10593 n6053 n6054 0.064732142857142863
r10594 n5969 n6055 0.46250000000000002
r10595 n5970 n6056 0.20108695652173914
r10596 n6055 n6056 0.044836956521739128
r10597 n5971 n6057 2.3125
r10598 n6056 n6057 0.033967391304347824
r10599 n5972 n6058 0.15416666666666667
r10600 n6057 n6058 0.043478260869565216
r10601 n5973 n6059 2.3125
r10602 n6058 n6059 0.043478260869565216
r10603 n5974 n6060 0.20108695652173914
r10604 n6059 n6060 0.033967391304347824
r10605 n5975 n6061 0.46250000000000002
r10606 n6060 n6061 0.044836956521739128
r10607 n5976 n6062 0.51388888888888884
r10608 n5977 n6063 2.3125
r10609 n6062 n6063 0.014945652173913044
r10610 n5978 n6064 2.3125
r10611 n6063 n6064 0.005434782608695652
r10612 n5979 n6065 0.578125
r10613 n6064 n6065 0.01358695652173913
r10614 n5980 n6066 0.21022727272727273
r10615 n6065 n6066 0.040760869565217392
r10616 n5981 n6067 4.625
r10617 n6066 n6067 0.03125
r10618 n5982 n6068 4.625
r10619 n6067 n6068 0.002717391304347826
r10620 n5983 n6069 4.625
r10621 n6068 n6069 0.002717391304347826
r10622 n5984 n6070 0.46250000000000002
r10623 n6069 n6070 0.014945652173913044
r10624 n5985 n6071 0.38541666666666669
r10625 n6070 n6071 0.029891304347826088
r10626 n5986 n6072 0.578125
r10627 n6071 n6072 0.02717391304347826
r10628 n5987 n6073 2.3125
r10629 n6072 n6073 0.01358695652173913
r10630 n5988 n6074 1.5416666666666667
r10631 n6073 n6074 0.006793478260869565
r10632 n5989 n6075 2.3125
r10633 n6074 n6075 0.006793478260869565
r10634 n5990 n6076 0.77083333333333337
r10635 n6075 n6076 0.010869565217391304
r10636 n6046 n6077 0.46250000000000002
r10637 n6047 n6078 0.24342105263157895
r10638 n6077 n6078 0.03940217391304348
r10639 n6048 n6079 1.15625
r10640 n6078 n6079 0.03125
r10641 n6049 n6080 2.3125
r10642 n6079 n6080 0.008152173913043478
r10643 n6050 n6081 0.15416666666666667
r10644 n6080 n6081 0.043478260869565216
r10645 n6051 n6082 2.3125
r10646 n6081 n6082 0.043478260869565216
r10647 n6052 n6083 1.15625
r10648 n6082 n6083 0.008152173913043478
r10649 n6053 n6084 0.24342105263157895
r10650 n6083 n6084 0.03125
r10651 n6054 n6085 0.46250000000000002
r10652 n6084 n6085 0.03940217391304348
r10653 n6055 n6086 0.29999999999999999
r10654 n6056 n6087 0.13043478260869565
r10655 n6086 n6087 1.03125
r10656 n6057 n6088 1.5
r10657 n6087 n6088 0.78125
r10658 n6058 n6089 0.10000000000000001
r10659 n6088 n6089 1
r10660 n6059 n6090 1.5
r10661 n6089 n6090 1
r10662 n6060 n6091 0.13043478260869565
r10663 n6090 n6091 0.78125
r10664 n6061 n6092 0.29999999999999999
r10665 n6091 n6092 1.03125
r10666 n6093 n6094 0.71875
r10667 n6094 n6095 0.125
r10668 n6095 n6096 0.34375
r10669 n6096 n6097 0.65625
r10670 n6097 n6098 0.65625
r10671 n6098 n6099 0.34375
r10672 n6099 n6100 0.125
r10673 n6100 n6101 0.71875
r10674 n6062 n6102 0.33333333333333331
r10675 n6063 n6103 1.5
r10676 n6102 n6103 0.34375
r10677 n6064 n6104 1.5
r10678 n6103 n6104 0.125
r10679 n6065 n6105 0.375
r10680 n6104 n6105 0.3125
r10681 n6066 n6106 0.13636363636363635
r10682 n6105 n6106 0.9375
r10683 n6067 n6107 3
r10684 n6106 n6107 0.71875
r10685 n6068 n6108 3
r10686 n6107 n6108 0.0625
r10687 n6069 n6109 3
r10688 n6108 n6109 0.0625
r10689 n6070 n6110 0.29999999999999999
r10690 n6109 n6110 0.34375
r10691 n6071 n6111 0.25
r10692 n6110 n6111 0.6875
r10693 n6072 n6112 0.375
r10694 n6111 n6112 0.625
r10695 n6073 n6113 1.5
r10696 n6112 n6113 0.3125
r10697 n6074 n6114 1
r10698 n6113 n6114 0.15625
r10699 n6075 n6115 1.5
r10700 n6114 n6115 0.15625
r10701 n6076 n6116 0.5
r10702 n6115 n6116 0.25
r10703 n6116 n6117 0.5625
r10704 n6077 n6118 0.29999999999999999
r10705 n6078 n6119 0.15789473684210525
r10706 n6118 n6119 0.90625
r10707 n6079 n6120 0.75
r10708 n6119 n6120 0.71875
r10709 n6080 n6121 1.5
r10710 n6120 n6121 0.1875
r10711 n6081 n6122 0.10000000000000001
r10712 n6121 n6122 1
r10713 n6082 n6123 1.5
r10714 n6122 n6123 1
r10715 n6083 n6124 0.75
r10716 n6123 n6124 0.1875
r10717 n6084 n6125 0.15789473684210525
r10718 n6124 n6125 0.71875
r10719 n6085 n6126 0.29999999999999999
r10720 n6125 n6126 0.90625
r10721 n6086 n6127 0.081250000000000003
r10722 n6087 n6128 0.035326086956521736
r10723 n6127 n6128 0.1875
r10724 n6088 n6129 0.40625
r10725 n6128 n6129 0.14204545454545456
r10726 n6089 n6130 0.027083333333333334
r10727 n6129 n6130 0.18181818181818182
r10728 n6090 n6131 0.40625
r10729 n6130 n6131 0.18181818181818182
r10730 n6091 n6132 0.035326086956521736
r10731 n6131 n6132 0.14204545454545456
r10732 n6092 n6133 0.081250000000000003
r10733 n6132 n6133 0.1875
r10734 n6133 n6134 0.11363636363636363
r10735 n6134 n6135 0.27272727272727271
r10736 n6135 n6136 0.43181818181818182
r10737 n6136 n6137 0.43181818181818182
r10738 n6137 n6138 0.43181818181818182
r10739 n6138 n6139 0.40909090909090912
r10740 n6139 n6140 0.36931818181818182
r10741 n6140 n6141 0.35227272727272729
r10742 n6141 n6142 0.36931818181818182
r10743 n6142 n6143 0.32954545454545453
r10744 n6143 n6144 0.15909090909090909
r10745 n6144 n6145 0.079545454545454544
r10746 n6145 n6146 0.068181818181818177
r10747 n6146 n6147 0.19318181818181818
r10748 n6147 n6148 0.19318181818181818
r10749 n6148 n6149 0.21590909090909091
r10750 n6149 n6150 0.21590909090909091
r10751 n6150 n6151 0.085227272727272721
r10752 n6151 n6152 0.14204545454545456
r10753 n6152 n6153 0.10795454545454546
r10754 n6153 n6154 0.05113636363636364
r10755 n6154 n6155 0.034090909090909088
r10756 n6155 n6156 0.073863636363636367
r10757 n6093 n6157 0.038690476190476192
r10758 n6156 n6157 0.17045454545454544
r10759 n6094 n6158 0.40625
r10760 n6157 n6158 0.13068181818181818
r10761 n6095 n6159 0.40625
r10762 n6158 n6159 0.022727272727272728
r10763 n6096 n6160 0.090277777777777776
r10764 n6159 n6160 0.0625
r10765 n6097 n6161 0.067708333333333329
r10766 n6160 n6161 0.11931818181818182
r10767 n6098 n6162 0.090277777777777776
r10768 n6161 n6162 0.11931818181818182
r10769 n6099 n6163 0.40625
r10770 n6162 n6163 0.0625
r10771 n6100 n6164 0.40625
r10772 n6163 n6164 0.022727272727272728
r10773 n6101 n6165 0.038690476190476192
r10774 n6164 n6165 0.13068181818181818
r10775 n6102 n6166 0.090277777777777776
r10776 n6103 n6167 0.40625
r10777 n6166 n6167 0.0625
r10778 n6104 n6168 0.40625
r10779 n6167 n6168 0.022727272727272728
r10780 n6105 n6169 0.1015625
r10781 n6168 n6169 0.056818181818181816
r10782 n6106 n6170 0.036931818181818184
r10783 n6169 n6170 0.17045454545454544
r10784 n6107 n6171 0.8125
r10785 n6170 n6171 0.13068181818181818
r10786 n6108 n6172 0.8125
r10787 n6171 n6172 0.011363636363636364
r10788 n6109 n6173 0.8125
r10789 n6172 n6173 0.011363636363636364
r10790 n6110 n6174 0.081250000000000003
r10791 n6173 n6174 0.0625
r10792 n6111 n6175 0.067708333333333329
r10793 n6174 n6175 0.125
r10794 n6112 n6176 0.1015625
r10795 n6175 n6176 0.11363636363636363
r10796 n6113 n6177 0.40625
r10797 n6176 n6177 0.056818181818181816
r10798 n6114 n6178 0.27083333333333331
r10799 n6177 n6178 0.028409090909090908
r10800 n6115 n6179 0.40625
r10801 n6178 n6179 0.028409090909090908
r10802 n6116 n6180 0.13541666666666666
r10803 n6179 n6180 0.045454545454545456
r10804 n6117 n6181 0.067708333333333329
r10805 n6180 n6181 0.10227272727272728
r10806 n6118 n6182 0.081250000000000003
r10807 n6119 n6183 0.042763157894736843
r10808 n6182 n6183 0.16477272727272727
r10809 n6120 n6184 0.203125
r10810 n6183 n6184 0.13068181818181818
r10811 n6121 n6185 0.40625
r10812 n6184 n6185 0.034090909090909088
r10813 n6122 n6186 0.027083333333333334
r10814 n6185 n6186 0.18181818181818182
r10815 n6123 n6187 0.40625
r10816 n6186 n6187 0.18181818181818182
r10817 n6124 n6188 0.203125
r10818 n6187 n6188 0.034090909090909088
r10819 n6125 n6189 0.042763157894736843
r10820 n6188 n6189 0.13068181818181818
r10821 n6126 n6190 0.081250000000000003
r10822 n6189 n6190 0.16477272727272727
r10823 n6127 n6191 0.081250000000000003
r10824 n6128 n6192 0.035326086956521736
r10825 n6191 n6192 1.03125
r10826 n6129 n6193 0.40625
r10827 n6192 n6193 0.78125
r10828 n6130 n6194 0.027083333333333334
r10829 n6193 n6194 1
r10830 n6131 n6195 0.40625
r10831 n6194 n6195 1
r10832 n6132 n6196 0.035326086956521736
r10833 n6195 n6196 0.78125
r10834 n6133 n6197 0.081250000000000003
r10835 n6196 n6197 1.03125
r10836 n6134 n6198 0.081250000000000003
r10837 n6197 n6198 0.625
r10838 n6135 n6199 0.021381578947368422
r10839 n6198 n6199 1.5
r10840 n6136 n6200 0.021381578947368422
r10841 n6199 n6200 2.375
r10842 n6137 n6201 0.021381578947368422
r10843 n6200 n6201 2.375
r10844 n6138 n6202 0.021381578947368422
r10845 n6201 n6202 2.375
r10846 n6139 n6203 0.02389705882352941
r10847 n6202 n6203 2.25
r10848 n6140 n6204 0.02620967741935484
r10849 n6203 n6204 2.03125
r10850 n6141 n6205 0.02620967741935484
r10851 n6204 n6205 1.9375
r10852 n6142 n6206 0.02389705882352941
r10853 n6205 n6206 2.03125
r10854 n6143 n6207 0.033854166666666664
r10855 n6206 n6207 1.8125
r10856 n6144 n6208 0.203125
r10857 n6207 n6208 0.875
r10858 n6145 n6209 0.081250000000000003
r10859 n6208 n6209 0.4375
r10860 n6146 n6210 0.40625
r10861 n6209 n6210 0.375
r10862 n6147 n6211 0.025390625
r10863 n6210 n6211 1.0625
r10864 n6148 n6212 0.40625
r10865 n6211 n6212 1.0625
r10866 n6149 n6213 0.022569444444444444
r10867 n6212 n6213 1.1875
r10868 n6150 n6214 0.40625
r10869 n6213 n6214 1.1875
r10870 n6151 n6215 0.0625
r10871 n6214 n6215 0.46875
r10872 n6152 n6216 0.067708333333333329
r10873 n6215 n6216 0.78125
r10874 n6153 n6217 0.11607142857142858
r10875 n6216 n6217 0.59375
r10876 n6154 n6218 0.40625
r10877 n6217 n6218 0.28125
r10878 n6155 n6219 0.203125
r10879 n6218 n6219 0.1875
r10880 n6156 n6220 0.090277777777777776
r10881 n6219 n6220 0.40625
r10882 n6157 n6221 0.038690476190476192
r10883 n6220 n6221 0.9375
r10884 n6158 n6222 0.40625
r10885 n6221 n6222 0.71875
r10886 n6159 n6223 0.40625
r10887 n6222 n6223 0.125
r10888 n6160 n6224 0.090277777777777776
r10889 n6223 n6224 0.34375
r10890 n6161 n6225 0.067708333333333329
r10891 n6224 n6225 0.65625
r10892 n6162 n6226 0.090277777777777776
r10893 n6225 n6226 0.65625
r10894 n6163 n6227 0.40625
r10895 n6226 n6227 0.34375
r10896 n6164 n6228 0.40625
r10897 n6227 n6228 0.125
r10898 n6165 n6229 0.038690476190476192
r10899 n6228 n6229 0.71875
r10900 n6166 n6230 0.090277777777777776
r10901 n6167 n6231 0.40625
r10902 n6230 n6231 0.34375
r10903 n6168 n6232 0.40625
r10904 n6231 n6232 0.125
r10905 n6169 n6233 0.1015625
r10906 n6232 n6233 0.3125
r10907 n6170 n6234 0.036931818181818184
r10908 n6233 n6234 0.9375
r10909 n6171 n6235 0.8125
r10910 n6234 n6235 0.71875
r10911 n6172 n6236 0.8125
r10912 n6235 n6236 0.0625
r10913 n6173 n6237 0.8125
r10914 n6236 n6237 0.0625
r10915 n6174 n6238 0.081250000000000003
r10916 n6237 n6238 0.34375
r10917 n6175 n6239 0.067708333333333329
r10918 n6238 n6239 0.6875
r10919 n6176 n6240 0.1015625
r10920 n6239 n6240 0.625
r10921 n6177 n6241 0.40625
r10922 n6240 n6241 0.3125
r10923 n6178 n6242 0.27083333333333331
r10924 n6241 n6242 0.15625
r10925 n6179 n6243 0.40625
r10926 n6242 n6243 0.15625
r10927 n6180 n6244 0.13541666666666666
r10928 n6243 n6244 0.25
r10929 n6181 n6245 0.067708333333333329
r10930 n6244 n6245 0.5625
r10931 n6182 n6246 0.081250000000000003
r10932 n6183 n6247 0.042763157894736843
r10933 n6246 n6247 0.90625
r10934 n6184 n6248 0.203125
r10935 n6247 n6248 0.71875
r10936 n6185 n6249 0.40625
r10937 n6248 n6249 0.1875
r10938 n6186 n6250 0.027083333333333334
r10939 n6249 n6250 1
r10940 n6187 n6251 0.40625
r10941 n6250 n6251 1
r10942 n6188 n6252 0.203125
r10943 n6251 n6252 0.1875
r10944 n6189 n6253 0.042763157894736843
r10945 n6252 n6253 0.71875
r10946 n6190 n6254 0.081250000000000003
r10947 n6253 n6254 0.90625
r10948 n6191 n6255 0.20000000000000001
r10949 n6192 n6256 0.086956521739130432
r10950 n6255 n6256 0.068750000000000006
r10951 n6193 n6257 1
r10952 n6256 n6257 0.052083333333333336
r10953 n6194 n6258 0.066666666666666666
r10954 n6257 n6258 0.066666666666666666
r10955 n6195 n6259 1
r10956 n6258 n6259 0.066666666666666666
r10957 n6196 n6260 0.086956521739130432
r10958 n6259 n6260 0.052083333333333336
r10959 n6197 n6261 0.20000000000000001
r10960 n6260 n6261 0.068750000000000006
r10961 n6198 n6262 0.20000000000000001
r10962 n6261 n6262 0.041666666666666664
r10963 n6199 n6263 0.052631578947368418
r10964 n6262 n6263 0.10000000000000001
r10965 n6200 n6264 0.052631578947368418
r10966 n6263 n6264 0.15833333333333333
r10967 n6201 n6265 0.052631578947368418
r10968 n6264 n6265 0.15833333333333333
r10969 n6202 n6266 0.052631578947368418
r10970 n6265 n6266 0.15833333333333333
r10971 n6203 n6267 0.058823529411764705
r10972 n6266 n6267 0.14999999999999999
r10973 n6204 n6268 0.064516129032258063
r10974 n6267 n6268 0.13541666666666666
r10975 n6205 n6269 0.064516129032258063
r10976 n6268 n6269 0.12916666666666668
r10977 n6206 n6270 0.058823529411764705
r10978 n6269 n6270 0.13541666666666666
r10979 n6207 n6271 0.083333333333333329
r10980 n6270 n6271 0.12083333333333333
r10981 n6208 n6272 0.5
r10982 n6271 n6272 0.058333333333333334
r10983 n6209 n6273 0.20000000000000001
r10984 n6272 n6273 0.029166666666666667
r10985 n6210 n6274 1
r10986 n6273 n6274 0.025000000000000001
r10987 n6211 n6275 0.0625
r10988 n6274 n6275 0.070833333333333331
r10989 n6212 n6276 1
r10990 n6275 n6276 0.070833333333333331
r10991 n6213 n6277 0.055555555555555552
r10992 n6276 n6277 0.079166666666666663
r10993 n6214 n6278 1
r10994 n6277 n6278 0.079166666666666663
r10995 n6215 n6279 0.15384615384615385
r10996 n6278 n6279 0.03125
r10997 n6216 n6280 0.16666666666666666
r10998 n6279 n6280 0.052083333333333336
r10999 n6217 n6281 0.2857142857142857
r11000 n6280 n6281 0.039583333333333331
r11001 n6218 n6282 1
r11002 n6281 n6282 0.018749999999999999
r11003 n6219 n6283 0.5
r11004 n6282 n6283 0.012500000000000001
r11005 n6220 n6284 0.22222222222222221
r11006 n6283 n6284 0.027083333333333334
r11007 n6221 n6285 0.095238095238095233
r11008 n6284 n6285 0.0625
r11009 n6222 n6286 1
r11010 n6285 n6286 0.04791666666666667
r11011 n6223 n6287 1
r11012 n6286 n6287 0.0083333333333333332
r11013 n6224 n6288 0.22222222222222221
r11014 n6287 n6288 0.022916666666666665
r11015 n6225 n6289 0.16666666666666666
r11016 n6288 n6289 0.043749999999999997
r11017 n6226 n6290 0.22222222222222221
r11018 n6289 n6290 0.043749999999999997
r11019 n6227 n6291 1
r11020 n6290 n6291 0.022916666666666665
r11021 n6228 n6292 1
r11022 n6291 n6292 0.0083333333333333332
r11023 n6229 n6293 0.095238095238095233
r11024 n6292 n6293 0.04791666666666667
r11025 n6230 n6294 0.22222222222222221
r11026 n6231 n6295 1
r11027 n6294 n6295 0.022916666666666665
r11028 n6232 n6296 1
r11029 n6295 n6296 0.0083333333333333332
r11030 n6233 n6297 0.25
r11031 n6296 n6297 0.020833333333333332
r11032 n6234 n6298 0.090909090909090912
r11033 n6297 n6298 0.0625
r11034 n6235 n6299 2
r11035 n6298 n6299 0.04791666666666667
r11036 n6236 n6300 2
r11037 n6299 n6300 0.0041666666666666666
r11038 n6237 n6301 2
r11039 n6300 n6301 0.0041666666666666666
r11040 n6238 n6302 0.20000000000000001
r11041 n6301 n6302 0.022916666666666665
r11042 n6239 n6303 0.16666666666666666
r11043 n6302 n6303 0.04583333333333333
r11044 n6240 n6304 0.25
r11045 n6303 n6304 0.041666666666666664
r11046 n6241 n6305 1
r11047 n6304 n6305 0.020833333333333332
r11048 n6242 n6306 0.66666666666666663
r11049 n6305 n6306 0.010416666666666666
r11050 n6243 n6307 1
r11051 n6306 n6307 0.010416666666666666
r11052 n6244 n6308 0.33333333333333331
r11053 n6307 n6308 0.016666666666666666
r11054 n6245 n6309 0.16666666666666666
r11055 n6308 n6309 0.037499999999999999
r11056 n6246 n6310 0.20000000000000001
r11057 n6247 n6311 0.10526315789473684
r11058 n6310 n6311 0.060416666666666667
r11059 n6248 n6312 0.5
r11060 n6311 n6312 0.04791666666666667
r11061 n6249 n6313 1
r11062 n6312 n6313 0.012500000000000001
r11063 n6250 n6314 0.066666666666666666
r11064 n6313 n6314 0.066666666666666666
r11065 n6251 n6315 1
r11066 n6314 n6315 0.066666666666666666
r11067 n6252 n6316 0.5
r11068 n6315 n6316 0.012500000000000001
r11069 n6253 n6317 0.10526315789473684
r11070 n6316 n6317 0.04791666666666667
r11071 n6254 n6318 0.20000000000000001
r11072 n6317 n6318 0.060416666666666667
r11073 n6255 n6319 0.20000000000000001
r11074 n6256 n6320 0.086956521739130432
r11075 n6319 n6320 1.03125
r11076 n6257 n6321 1
r11077 n6320 n6321 0.78125
r11078 n6258 n6322 0.066666666666666666
r11079 n6321 n6322 1
r11080 n6259 n6323 1
r11081 n6322 n6323 1
r11082 n6260 n6324 0.086956521739130432
r11083 n6323 n6324 0.78125
r11084 n6261 n6325 0.20000000000000001
r11085 n6324 n6325 1.03125
r11086 n6262 n6326 0.20000000000000001
r11087 n6325 n6326 0.625
r11088 n6263 n6327 0.052631578947368418
r11089 n6326 n6327 1.5
r11090 n6264 n6328 0.052631578947368418
r11091 n6327 n6328 2.375
r11092 n6265 n6329 0.052631578947368418
r11093 n6328 n6329 2.375
r11094 n6266 n6330 0.052631578947368418
r11095 n6329 n6330 2.375
r11096 n6267 n6331 0.058823529411764705
r11097 n6330 n6331 2.25
r11098 n6268 n6332 0.064516129032258063
r11099 n6331 n6332 2.03125
r11100 n6269 n6333 0.064516129032258063
r11101 n6332 n6333 1.9375
r11102 n6270 n6334 0.058823529411764705
r11103 n6333 n6334 2.03125
r11104 n6271 n6335 0.083333333333333329
r11105 n6334 n6335 1.8125
r11106 n6272 n6336 0.5
r11107 n6335 n6336 0.875
r11108 n6273 n6337 0.20000000000000001
r11109 n6336 n6337 0.4375
r11110 n6274 n6338 1
r11111 n6337 n6338 0.375
r11112 n6275 n6339 0.0625
r11113 n6338 n6339 1.0625
r11114 n6276 n6340 1
r11115 n6339 n6340 1.0625
r11116 n6277 n6341 0.055555555555555552
r11117 n6340 n6341 1.1875
r11118 n6278 n6342 1
r11119 n6341 n6342 1.1875
r11120 n6279 n6343 0.15384615384615385
r11121 n6342 n6343 0.46875
r11122 n6280 n6344 0.16666666666666666
r11123 n6343 n6344 0.78125
r11124 n6281 n6345 0.2857142857142857
r11125 n6344 n6345 0.59375
r11126 n6282 n6346 1
r11127 n6345 n6346 0.28125
r11128 n6283 n6347 0.5
r11129 n6346 n6347 0.1875
r11130 n6284 n6348 0.22222222222222221
r11131 n6347 n6348 0.40625
r11132 n6285 n6349 0.095238095238095233
r11133 n6348 n6349 0.9375
r11134 n6286 n6350 1
r11135 n6349 n6350 0.71875
r11136 n6287 n6351 1
r11137 n6350 n6351 0.125
r11138 n6288 n6352 0.22222222222222221
r11139 n6351 n6352 0.34375
r11140 n6289 n6353 0.16666666666666666
r11141 n6352 n6353 0.65625
r11142 n6290 n6354 0.22222222222222221
r11143 n6353 n6354 0.65625
r11144 n6291 n6355 1
r11145 n6354 n6355 0.34375
r11146 n6292 n6356 1
r11147 n6355 n6356 0.125
r11148 n6293 n6357 0.095238095238095233
r11149 n6356 n6357 0.71875
r11150 n6294 n6358 0.22222222222222221
r11151 n6295 n6359 1
r11152 n6358 n6359 0.34375
r11153 n6296 n6360 1
r11154 n6359 n6360 0.125
r11155 n6297 n6361 0.25
r11156 n6360 n6361 0.3125
r11157 n6298 n6362 0.090909090909090912
r11158 n6361 n6362 0.9375
r11159 n6299 n6363 2
r11160 n6362 n6363 0.71875
r11161 n6300 n6364 2
r11162 n6363 n6364 0.0625
r11163 n6301 n6365 2
r11164 n6364 n6365 0.0625
r11165 n6302 n6366 0.20000000000000001
r11166 n6365 n6366 0.34375
r11167 n6303 n6367 0.16666666666666666
r11168 n6366 n6367 0.6875
r11169 n6304 n6368 0.25
r11170 n6367 n6368 0.625
r11171 n6305 n6369 1
r11172 n6368 n6369 0.3125
r11173 n6306 n6370 0.66666666666666663
r11174 n6369 n6370 0.15625
r11175 n6307 n6371 1
r11176 n6370 n6371 0.15625
r11177 n6308 n6372 0.33333333333333331
r11178 n6371 n6372 0.25
r11179 n6309 n6373 0.16666666666666666
r11180 n6372 n6373 0.5625
r11181 n6310 n6374 0.20000000000000001
r11182 n6311 n6375 0.10526315789473684
r11183 n6374 n6375 0.90625
r11184 n6312 n6376 0.5
r11185 n6375 n6376 0.71875
r11186 n6313 n6377 1
r11187 n6376 n6377 0.1875
r11188 n6314 n6378 0.066666666666666666
r11189 n6377 n6378 1
r11190 n6315 n6379 1
r11191 n6378 n6379 1
r11192 n6316 n6380 0.5
r11193 n6379 n6380 0.1875
r11194 n6317 n6381 0.10526315789473684
r11195 n6380 n6381 0.71875
r11196 n6318 n6382 0.20000000000000001
r11197 n6381 n6382 0.90625
r11198 n6319 n6383 0.081250000000000003
r11199 n6320 n6384 0.035326086956521736
r11200 n6383 n6384 0.1875
r11201 n6321 n6385 0.40625
r11202 n6384 n6385 0.14204545454545456
r11203 n6322 n6386 0.027083333333333334
r11204 n6385 n6386 0.18181818181818182
r11205 n6323 n6387 0.40625
r11206 n6386 n6387 0.18181818181818182
r11207 n6324 n6388 0.035326086956521736
r11208 n6387 n6388 0.14204545454545456
r11209 n6325 n6389 0.081250000000000003
r11210 n6388 n6389 0.1875
r11211 n6326 n6390 0.081250000000000003
r11212 n6389 n6390 0.11363636363636363
r11213 n6327 n6391 0.021381578947368422
r11214 n6390 n6391 0.27272727272727271
r11215 n6328 n6392 0.021381578947368422
r11216 n6391 n6392 0.43181818181818182
r11217 n6329 n6393 0.021381578947368422
r11218 n6392 n6393 0.43181818181818182
r11219 n6330 n6394 0.021381578947368422
r11220 n6393 n6394 0.43181818181818182
r11221 n6331 n6395 0.02389705882352941
r11222 n6394 n6395 0.40909090909090912
r11223 n6332 n6396 0.02620967741935484
r11224 n6395 n6396 0.36931818181818182
r11225 n6333 n6397 0.02620967741935484
r11226 n6396 n6397 0.35227272727272729
r11227 n6334 n6398 0.02389705882352941
r11228 n6397 n6398 0.36931818181818182
r11229 n6335 n6399 0.033854166666666664
r11230 n6398 n6399 0.32954545454545453
r11231 n6336 n6400 0.203125
r11232 n6399 n6400 0.15909090909090909
r11233 n6337 n6401 0.081250000000000003
r11234 n6400 n6401 0.079545454545454544
r11235 n6338 n6402 0.40625
r11236 n6401 n6402 0.068181818181818177
r11237 n6339 n6403 0.025390625
r11238 n6402 n6403 0.19318181818181818
r11239 n6340 n6404 0.40625
r11240 n6403 n6404 0.19318181818181818
r11241 n6341 n6405 0.022569444444444444
r11242 n6404 n6405 0.21590909090909091
r11243 n6342 n6406 0.40625
r11244 n6405 n6406 0.21590909090909091
r11245 n6343 n6407 0.0625
r11246 n6406 n6407 0.085227272727272721
r11247 n6344 n6408 0.067708333333333329
r11248 n6407 n6408 0.14204545454545456
r11249 n6345 n6409 0.11607142857142858
r11250 n6408 n6409 0.10795454545454546
r11251 n6346 n6410 0.40625
r11252 n6409 n6410 0.05113636363636364
r11253 n6347 n6411 0.203125
r11254 n6410 n6411 0.034090909090909088
r11255 n6348 n6412 0.090277777777777776
r11256 n6411 n6412 0.073863636363636367
r11257 n6349 n6413 0.038690476190476192
r11258 n6412 n6413 0.17045454545454544
r11259 n6350 n6414 0.40625
r11260 n6413 n6414 0.13068181818181818
r11261 n6351 n6415 0.40625
r11262 n6414 n6415 0.022727272727272728
r11263 n6352 n6416 0.090277777777777776
r11264 n6415 n6416 0.0625
r11265 n6353 n6417 0.067708333333333329
r11266 n6416 n6417 0.11931818181818182
r11267 n6354 n6418 0.090277777777777776
r11268 n6417 n6418 0.11931818181818182
r11269 n6355 n6419 0.40625
r11270 n6418 n6419 0.0625
r11271 n6356 n6420 0.40625
r11272 n6419 n6420 0.022727272727272728
r11273 n6357 n6421 0.038690476190476192
r11274 n6420 n6421 0.13068181818181818
r11275 n6358 n6422 0.090277777777777776
r11276 n6359 n6423 0.40625
r11277 n6422 n6423 0.0625
r11278 n6360 n6424 0.40625
r11279 n6423 n6424 0.022727272727272728
r11280 n6361 n6425 0.1015625
r11281 n6424 n6425 0.056818181818181816
r11282 n6362 n6426 0.036931818181818184
r11283 n6425 n6426 0.17045454545454544
r11284 n6363 n6427 0.8125
r11285 n6426 n6427 0.13068181818181818
r11286 n6364 n6428 0.8125
r11287 n6427 n6428 0.011363636363636364
r11288 n6365 n6429 0.8125
r11289 n6428 n6429 0.011363636363636364
r11290 n6366 n6430 0.081250000000000003
r11291 n6429 n6430 0.0625
r11292 n6367 n6431 0.067708333333333329
r11293 n6430 n6431 0.125
r11294 n6368 n6432 0.1015625
r11295 n6431 n6432 0.11363636363636363
r11296 n6369 n6433 0.40625
r11297 n6432 n6433 0.056818181818181816
r11298 n6370 n6434 0.27083333333333331
r11299 n6433 n6434 0.028409090909090908
r11300 n6371 n6435 0.40625
r11301 n6434 n6435 0.028409090909090908
r11302 n6372 n6436 0.13541666666666666
r11303 n6435 n6436 0.045454545454545456
r11304 n6373 n6437 0.067708333333333329
r11305 n6436 n6437 0.10227272727272728
r11306 n6374 n6438 0.081250000000000003
r11307 n6375 n6439 0.042763157894736843
r11308 n6438 n6439 0.16477272727272727
r11309 n6376 n6440 0.203125
r11310 n6439 n6440 0.13068181818181818
r11311 n6377 n6441 0.40625
r11312 n6440 n6441 0.034090909090909088
r11313 n6378 n6442 0.027083333333333334
r11314 n6441 n6442 0.18181818181818182
r11315 n6379 n6443 0.40625
r11316 n6442 n6443 0.18181818181818182
r11317 n6380 n6444 0.203125
r11318 n6443 n6444 0.034090909090909088
r11319 n6381 n6445 0.042763157894736843
r11320 n6444 n6445 0.13068181818181818
r11321 n6382 n6446 0.081250000000000003
r11322 n6445 n6446 0.16477272727272727
r11323 n6383 n6447 0.081250000000000003
r11324 n6384 n6448 0.035326086956521736
r11325 n6447 n6448 1.03125
r11326 n6385 n6449 0.40625
r11327 n6448 n6449 0.78125
r11328 n6386 n6450 0.027083333333333334
r11329 n6449 n6450 1
r11330 n6387 n6451 0.40625
r11331 n6450 n6451 1
r11332 n6388 n6452 0.035326086956521736
r11333 n6451 n6452 0.78125
r11334 n6389 n6453 0.081250000000000003
r11335 n6452 n6453 1.03125
r11336 n6413 n6454 0.038690476190476192
r11337 n6414 n6455 0.40625
r11338 n6454 n6455 0.71875
r11339 n6415 n6456 0.40625
r11340 n6455 n6456 0.125
r11341 n6416 n6457 0.090277777777777776
r11342 n6456 n6457 0.34375
r11343 n6417 n6458 0.067708333333333329
r11344 n6457 n6458 0.65625
r11345 n6418 n6459 0.090277777777777776
r11346 n6458 n6459 0.65625
r11347 n6419 n6460 0.40625
r11348 n6459 n6460 0.34375
r11349 n6420 n6461 0.40625
r11350 n6460 n6461 0.125
r11351 n6421 n6462 0.038690476190476192
r11352 n6461 n6462 0.71875
r11353 n6422 n6463 0.090277777777777776
r11354 n6423 n6464 0.40625
r11355 n6463 n6464 0.34375
r11356 n6424 n6465 0.40625
r11357 n6464 n6465 0.125
r11358 n6425 n6466 0.1015625
r11359 n6465 n6466 0.3125
r11360 n6426 n6467 0.036931818181818184
r11361 n6466 n6467 0.9375
r11362 n6427 n6468 0.8125
r11363 n6467 n6468 0.71875
r11364 n6428 n6469 0.8125
r11365 n6468 n6469 0.0625
r11366 n6429 n6470 0.8125
r11367 n6469 n6470 0.0625
r11368 n6430 n6471 0.081250000000000003
r11369 n6470 n6471 0.34375
r11370 n6431 n6472 0.067708333333333329
r11371 n6471 n6472 0.6875
r11372 n6432 n6473 0.1015625
r11373 n6472 n6473 0.625
r11374 n6433 n6474 0.40625
r11375 n6473 n6474 0.3125
r11376 n6434 n6475 0.27083333333333331
r11377 n6474 n6475 0.15625
r11378 n6435 n6476 0.40625
r11379 n6475 n6476 0.15625
r11380 n6436 n6477 0.13541666666666666
r11381 n6476 n6477 0.25
r11382 n6437 n6478 0.067708333333333329
r11383 n6477 n6478 0.5625
r11384 n6438 n6479 0.081250000000000003
r11385 n6439 n6480 0.042763157894736843
r11386 n6479 n6480 0.90625
r11387 n6440 n6481 0.203125
r11388 n6480 n6481 0.71875
r11389 n6441 n6482 0.40625
r11390 n6481 n6482 0.1875
r11391 n6442 n6483 0.027083333333333334
r11392 n6482 n6483 1
r11393 n6443 n6484 0.40625
r11394 n6483 n6484 1
r11395 n6444 n6485 0.203125
r11396 n6484 n6485 0.1875
r11397 n6445 n6486 0.042763157894736843
r11398 n6485 n6486 0.71875
r11399 n6446 n6487 0.081250000000000003
r11400 n6486 n6487 0.90625
r11401 n6447 n6488 0.20624999999999999
r11402 n6448 n6489 0.089673913043478257
r11403 n6488 n6489 0.066532258064516125
r11404 n6449 n6490 1.03125
r11405 n6489 n6490 0.05040322580645161
r11406 n6450 n6491 0.068750000000000006
r11407 n6490 n6491 0.064516129032258063
r11408 n6451 n6492 1.03125
r11409 n6491 n6492 0.064516129032258063
r11410 n6452 n6493 0.089673913043478257
r11411 n6492 n6493 0.05040322580645161
r11412 n6453 n6494 0.20624999999999999
r11413 n6493 n6494 0.066532258064516125
r11414 n6463 n6495 0.22916666666666666
r11415 n6464 n6496 1.03125
r11416 n6495 n6496 0.022177419354838711
r11417 n6465 n6497 1.03125
r11418 n6496 n6497 0.0080645161290322578
r11419 n6466 n6498 0.2578125
r11420 n6497 n6498 0.020161290322580645
r11421 n6467 n6499 0.09375
r11422 n6498 n6499 0.060483870967741937
r11423 n6468 n6500 2.0625
r11424 n6499 n6500 0.046370967741935484
r11425 n6469 n6501 2.0625
r11426 n6500 n6501 0.0040322580645161289
r11427 n6470 n6502 2.0625
r11428 n6501 n6502 0.0040322580645161289
r11429 n6471 n6503 0.20624999999999999
r11430 n6502 n6503 0.022177419354838711
r11431 n6479 n6504 0.20624999999999999
r11432 n6480 n6505 0.10855263157894737
r11433 n6504 n6505 0.058467741935483868
r11434 n6481 n6506 0.515625
r11435 n6505 n6506 0.046370967741935484
r11436 n6482 n6507 1.03125
r11437 n6506 n6507 0.012096774193548387
r11438 n6483 n6508 0.068750000000000006
r11439 n6507 n6508 0.064516129032258063
r11440 n6484 n6509 1.03125
r11441 n6508 n6509 0.064516129032258063
r11442 n6485 n6510 0.515625
r11443 n6509 n6510 0.012096774193548387
r11444 n6486 n6511 0.10855263157894737
r11445 n6510 n6511 0.046370967741935484
r11446 n6487 n6512 0.20624999999999999
r11447 n6511 n6512 0.058467741935483868
r11448 n6488 n6513 0.38750000000000001
r11449 n6489 n6514 0.16847826086956522
r11450 n6513 n6514 0.066532258064516125
r11451 n6490 n6515 1.9375
r11452 n6514 n6515 0.05040322580645161
r11453 n6491 n6516 0.12916666666666668
r11454 n6515 n6516 0.064516129032258063
r11455 n6492 n6517 1.9375
r11456 n6516 n6517 0.064516129032258063
r11457 n6493 n6518 0.16847826086956522
r11458 n6517 n6518 0.05040322580645161
r11459 n6494 n6519 0.38750000000000001
r11460 n6518 n6519 0.066532258064516125
r11461 n6495 n6520 0.43055555555555558
r11462 n6496 n6521 1.9375
r11463 n6520 n6521 0.022177419354838711
r11464 n6497 n6522 1.9375
r11465 n6521 n6522 0.0080645161290322578
r11466 n6498 n6523 0.484375
r11467 n6522 n6523 0.020161290322580645
r11468 n6499 n6524 0.17613636363636365
r11469 n6523 n6524 0.060483870967741937
r11470 n6500 n6525 3.875
r11471 n6524 n6525 0.046370967741935484
r11472 n6501 n6526 3.875
r11473 n6525 n6526 0.0040322580645161289
r11474 n6502 n6527 3.875
r11475 n6526 n6527 0.0040322580645161289
r11476 n6503 n6528 0.38750000000000001
r11477 n6527 n6528 0.022177419354838711
r11478 n6504 n6529 0.38750000000000001
r11479 n6505 n6530 0.20394736842105263
r11480 n6529 n6530 0.058467741935483868
r11481 n6506 n6531 0.96875
r11482 n6530 n6531 0.046370967741935484
r11483 n6507 n6532 1.9375
r11484 n6531 n6532 0.012096774193548387
r11485 n6508 n6533 0.12916666666666668
r11486 n6532 n6533 0.064516129032258063
r11487 n6509 n6534 1.9375
r11488 n6533 n6534 0.064516129032258063
r11489 n6510 n6535 0.96875
r11490 n6534 n6535 0.012096774193548387
r11491 n6511 n6536 0.20394736842105263
r11492 n6535 n6536 0.046370967741935484
r11493 n6512 n6537 0.38750000000000001
r11494 n6536 n6537 0.058467741935483868
r11495 n6513 n6538 0.28125
r11496 n6514 n6539 0.12228260869565218
r11497 n6538 n6539 0.14732142857142858
r11498 n6515 n6540 1.40625
r11499 n6539 n6540 0.11160714285714286
r11500 n6516 n6541 0.09375
r11501 n6540 n6541 0.14285714285714285
r11502 n6517 n6542 1.40625
r11503 n6541 n6542 0.14285714285714285
r11504 n6518 n6543 0.12228260869565218
r11505 n6542 n6543 0.11160714285714286
r11506 n6519 n6544 0.28125
r11507 n6543 n6544 0.14732142857142858
r11508 n6520 n6545 0.3125
r11509 n6521 n6546 1.40625
r11510 n6545 n6546 0.049107142857142856
r11511 n6522 n6547 1.40625
r11512 n6546 n6547 0.017857142857142856
r11513 n6523 n6548 0.3515625
r11514 n6547 n6548 0.044642857142857144
r11515 n6524 n6549 0.12784090909090909
r11516 n6548 n6549 0.13392857142857142
r11517 n6525 n6550 2.8125
r11518 n6549 n6550 0.10267857142857142
r11519 n6526 n6551 2.8125
r11520 n6550 n6551 0.0089285714285714281
r11521 n6527 n6552 2.8125
r11522 n6551 n6552 0.0089285714285714281
r11523 n6528 n6553 0.28125
r11524 n6552 n6553 0.049107142857142856
r11525 n6529 n6554 0.28125
r11526 n6530 n6555 0.14802631578947367
r11527 n6554 n6555 0.12946428571428573
r11528 n6531 n6556 0.703125
r11529 n6555 n6556 0.10267857142857142
r11530 n6532 n6557 1.40625
r11531 n6556 n6557 0.026785714285714284
r11532 n6533 n6558 0.09375
r11533 n6557 n6558 0.14285714285714285
r11534 n6534 n6559 1.40625
r11535 n6558 n6559 0.14285714285714285
r11536 n6535 n6560 0.703125
r11537 n6559 n6560 0.026785714285714284
r11538 n6536 n6561 0.14802631578947367
r11539 n6560 n6561 0.10267857142857142
r11540 n6537 n6562 0.28125
r11541 n6561 n6562 0.12946428571428573
r11542 n6538 n6563 0.10000000000000001
r11543 n6539 n6564 0.043478260869565216
r11544 n6563 n6564 1.03125
r11545 n6540 n6565 0.5
r11546 n6564 n6565 0.78125
r11547 n6541 n6566 0.033333333333333333
r11548 n6565 n6566 1
r11549 n6542 n6567 0.5
r11550 n6566 n6567 1
r11551 n6543 n6568 0.043478260869565216
r11552 n6567 n6568 0.78125
r11553 n6544 n6569 0.10000000000000001
r11554 n6568 n6569 1.03125
r11555 n6570 n6571 0.59375
r11556 n6571 n6572 0.28125
r11557 n6572 n6573 0.1875
r11558 n6573 n6574 0.40625
r11559 n6574 n6575 0.9375
r11560 n6575 n6576 0.71875
r11561 n6576 n6577 0.125
r11562 n6577 n6578 0.34375
r11563 n6578 n6579 0.65625
r11564 n6545 n6581 0.1111111111111111
r11565 n6580 n6581 0.65625
r11566 n6546 n6582 0.5
r11567 n6581 n6582 0.34375
r11568 n6547 n6583 0.5
r11569 n6582 n6583 0.125
r11570 n6548 n6584 0.125
r11571 n6583 n6584 0.3125
r11572 n6549 n6585 0.045454545454545456
r11573 n6584 n6585 0.9375
r11574 n6550 n6586 1
r11575 n6585 n6586 0.71875
r11576 n6551 n6587 1
r11577 n6586 n6587 0.0625
r11578 n6552 n6588 1
r11579 n6587 n6588 0.0625
r11580 n6553 n6589 0.10000000000000001
r11581 n6588 n6589 0.34375
r11582 n6589 n6590 0.6875
r11583 n6554 n6591 0.10000000000000001
r11584 n6555 n6592 0.052631578947368418
r11585 n6591 n6592 0.90625
r11586 n6556 n6593 0.25
r11587 n6592 n6593 0.71875
r11588 n6557 n6594 0.5
r11589 n6593 n6594 0.1875
r11590 n6558 n6595 0.033333333333333333
r11591 n6594 n6595 1
r11592 n6559 n6596 0.5
r11593 n6595 n6596 1
r11594 n6560 n6597 0.25
r11595 n6596 n6597 0.1875
r11596 n6561 n6598 0.052631578947368418
r11597 n6597 n6598 0.71875
r11598 n6562 n6599 0.10000000000000001
r11599 n6598 n6599 0.90625
r11600 n6563 n6600 0.043749999999999997
r11601 n6564 n6601 0.019021739130434784
r11602 n6600 n6601 0.41249999999999998
r11603 n6565 n6602 0.21875
r11604 n6601 n6602 0.3125
r11605 n6566 n6603 0.014583333333333334
r11606 n6602 n6603 0.40000000000000002
r11607 n6567 n6604 0.21875
r11608 n6603 n6604 0.40000000000000002
r11609 n6568 n6605 0.019021739130434784
r11610 n6604 n6605 0.3125
r11611 n6569 n6606 0.043749999999999997
r11612 n6605 n6606 0.41249999999999998
r11613 n6606 n6607 0.25
r11614 n6607 n6608 0.59999999999999998
r11615 n6608 n6609 0.94999999999999996
r11616 n6609 n6610 0.94999999999999996
r11617 n6610 n6611 0.94999999999999996
r11618 n6611 n6612 0.90000000000000002
r11619 n6612 n6613 0.8125
r11620 n6613 n6614 0.77500000000000002
r11621 n6614 n6615 0.8125
r11622 n6615 n6616 0.72499999999999998
r11623 n6616 n6617 0.34999999999999998
r11624 n6617 n6618 0.17499999999999999
r11625 n6618 n6619 0.14999999999999999
r11626 n6619 n6620 0.42499999999999999
r11627 n6620 n6621 0.42499999999999999
r11628 n6621 n6622 0.47499999999999998
r11629 n6622 n6623 0.47499999999999998
r11630 n6623 n6624 0.1875
r11631 n6570 n6625 0.036458333333333336
r11632 n6624 n6625 0.3125
r11633 n6571 n6626 0.0625
r11634 n6625 n6626 0.23749999999999999
r11635 n6572 n6627 0.21875
r11636 n6626 n6627 0.1125
r11637 n6573 n6628 0.109375
r11638 n6627 n6628 0.074999999999999997
r11639 n6574 n6629 0.048611111111111112
r11640 n6628 n6629 0.16250000000000001
r11641 n6575 n6630 0.020833333333333332
r11642 n6629 n6630 0.375
r11643 n6576 n6631 0.21875
r11644 n6630 n6631 0.28749999999999998
r11645 n6577 n6632 0.21875
r11646 n6631 n6632 0.050000000000000003
r11647 n6578 n6633 0.048611111111111112
r11648 n6632 n6633 0.13750000000000001
r11649 n6579 n6634 0.036458333333333336
r11650 n6633 n6634 0.26250000000000001
r11651 n6580 n6635 0.036458333333333336
r11652 n6581 n6636 0.048611111111111112
r11653 n6635 n6636 0.26250000000000001
r11654 n6582 n6637 0.21875
r11655 n6636 n6637 0.13750000000000001
r11656 n6583 n6638 0.21875
r11657 n6637 n6638 0.050000000000000003
r11658 n6584 n6639 0.0546875
r11659 n6638 n6639 0.125
r11660 n6585 n6640 0.019886363636363636
r11661 n6639 n6640 0.375
r11662 n6586 n6641 0.4375
r11663 n6640 n6641 0.28749999999999998
r11664 n6587 n6642 0.4375
r11665 n6641 n6642 0.025000000000000001
r11666 n6588 n6643 0.4375
r11667 n6642 n6643 0.025000000000000001
r11668 n6589 n6644 0.043749999999999997
r11669 n6643 n6644 0.13750000000000001
r11670 n6590 n6645 0.036458333333333336
r11671 n6644 n6645 0.27500000000000002
r11672 n6591 n6646 0.043749999999999997
r11673 n6592 n6647 0.023026315789473683
r11674 n6646 n6647 0.36249999999999999
r11675 n6593 n6648 0.109375
r11676 n6647 n6648 0.28749999999999998
r11677 n6594 n6649 0.21875
r11678 n6648 n6649 0.074999999999999997
r11679 n6595 n6650 0.014583333333333334
r11680 n6649 n6650 0.40000000000000002
r11681 n6596 n6651 0.21875
r11682 n6650 n6651 0.40000000000000002
r11683 n6597 n6652 0.109375
r11684 n6651 n6652 0.074999999999999997
r11685 n6598 n6653 0.023026315789473683
r11686 n6652 n6653 0.28749999999999998
r11687 n6599 n6654 0.043749999999999997
r11688 n6653 n6654 0.36249999999999999
r11689 n6600 n6655 0.068750000000000006
r11690 n6601 n6656 0.029891304347826088
r11691 n6655 n6656 0.34375
r11692 n6602 n6657 0.34375
r11693 n6656 n6657 0.26041666666666669
r11694 n6603 n6658 0.022916666666666665
r11695 n6657 n6658 0.33333333333333331
r11696 n6604 n6659 0.34375
r11697 n6658 n6659 0.33333333333333331
r11698 n6605 n6660 0.029891304347826088
r11699 n6659 n6660 0.26041666666666669
r11700 n6606 n6661 0.068750000000000006
r11701 n6660 n6661 0.34375
r11702 n6607 n6662 0.068750000000000006
r11703 n6661 n6662 0.20833333333333334
r11704 n6608 n6663 0.018092105263157895
r11705 n6662 n6663 0.5
r11706 n6609 n6664 0.018092105263157895
r11707 n6663 n6664 0.79166666666666663
r11708 n6610 n6665 0.018092105263157895
r11709 n6664 n6665 0.79166666666666663
r11710 n6611 n6666 0.018092105263157895
r11711 n6665 n6666 0.79166666666666663
r11712 n6612 n6667 0.020220588235294119
r11713 n6666 n6667 0.75
r11714 n6613 n6668 0.022177419354838711
r11715 n6667 n6668 0.67708333333333337
r11716 n6614 n6669 0.022177419354838711
r11717 n6668 n6669 0.64583333333333337
r11718 n6615 n6670 0.020220588235294119
r11719 n6669 n6670 0.67708333333333337
r11720 n6616 n6671 0.028645833333333332
r11721 n6670 n6671 0.60416666666666663
r11722 n6617 n6672 0.171875
r11723 n6671 n6672 0.29166666666666669
r11724 n6618 n6673 0.068750000000000006
r11725 n6672 n6673 0.14583333333333334
r11726 n6619 n6674 0.34375
r11727 n6673 n6674 0.125
r11728 n6620 n6675 0.021484375
r11729 n6674 n6675 0.35416666666666669
r11730 n6621 n6676 0.34375
r11731 n6675 n6676 0.35416666666666669
r11732 n6622 n6677 0.019097222222222224
r11733 n6676 n6677 0.39583333333333331
r11734 n6623 n6678 0.34375
r11735 n6677 n6678 0.39583333333333331
r11736 n6624 n6679 0.052884615384615384
r11737 n6678 n6679 0.15625
r11738 n6625 n6680 0.057291666666666664
r11739 n6679 n6680 0.26041666666666669
r11740 n6626 n6681 0.098214285714285712
r11741 n6680 n6681 0.19791666666666666
r11742 n6627 n6682 0.34375
r11743 n6681 n6682 0.09375
r11744 n6628 n6683 0.171875
r11745 n6682 n6683 0.0625
r11746 n6629 n6684 0.076388888888888895
r11747 n6683 n6684 0.13541666666666666
r11748 n6630 n6685 0.03273809523809524
r11749 n6684 n6685 0.3125
r11750 n6631 n6686 0.34375
r11751 n6685 n6686 0.23958333333333334
r11752 n6632 n6687 0.34375
r11753 n6686 n6687 0.041666666666666664
r11754 n6633 n6688 0.076388888888888895
r11755 n6687 n6688 0.11458333333333333
r11756 n6634 n6689 0.057291666666666664
r11757 n6688 n6689 0.21875
r11758 n6635 n6690 0.057291666666666664
r11759 n6636 n6691 0.076388888888888895
r11760 n6690 n6691 0.21875
r11761 n6637 n6692 0.34375
r11762 n6691 n6692 0.11458333333333333
r11763 n6638 n6693 0.34375
r11764 n6692 n6693 0.041666666666666664
r11765 n6639 n6694 0.0859375
r11766 n6693 n6694 0.10416666666666667
r11767 n6640 n6695 0.03125
r11768 n6694 n6695 0.3125
r11769 n6641 n6696 0.6875
r11770 n6695 n6696 0.23958333333333334
r11771 n6642 n6697 0.6875
r11772 n6696 n6697 0.020833333333333332
r11773 n6643 n6698 0.6875
r11774 n6697 n6698 0.020833333333333332
r11775 n6644 n6699 0.068750000000000006
r11776 n6698 n6699 0.11458333333333333
r11777 n6645 n6700 0.057291666666666664
r11778 n6699 n6700 0.22916666666666666
r11779 n6646 n6701 0.068750000000000006
r11780 n6647 n6702 0.036184210526315791
r11781 n6701 n6702 0.30208333333333331
r11782 n6648 n6703 0.171875
r11783 n6702 n6703 0.23958333333333334
r11784 n6649 n6704 0.34375
r11785 n6703 n6704 0.0625
r11786 n6650 n6705 0.022916666666666665
r11787 n6704 n6705 0.33333333333333331
r11788 n6651 n6706 0.34375
r11789 n6705 n6706 0.33333333333333331
r11790 n6652 n6707 0.171875
r11791 n6706 n6707 0.0625
r11792 n6653 n6708 0.036184210526315791
r11793 n6707 n6708 0.23958333333333334
r11794 n6654 n6709 0.068750000000000006
r11795 n6708 n6709 0.30208333333333331
r11796 n6655 n6710 0.050000000000000003
r11797 n6656 n6711 0.021739130434782608
r11798 n6710 n6711 1.03125
r11799 n6657 n6712 0.25
r11800 n6711 n6712 0.78125
r11801 n6658 n6713 0.016666666666666666
r11802 n6712 n6713 1
r11803 n6659 n6714 0.25
r11804 n6713 n6714 1
r11805 n6660 n6715 0.021739130434782608
r11806 n6714 n6715 0.78125
r11807 n6661 n6716 0.050000000000000003
r11808 n6715 n6716 1.03125
r11809 n6662 n6717 0.050000000000000003
r11810 n6716 n6717 0.625
r11811 n6663 n6718 0.013157894736842105
r11812 n6717 n6718 1.5
r11813 n6664 n6719 0.013157894736842105
r11814 n6718 n6719 2.375
r11815 n6665 n6720 0.013157894736842105
r11816 n6719 n6720 2.375
r11817 n6666 n6721 0.013157894736842105
r11818 n6720 n6721 2.375
r11819 n6667 n6722 0.014705882352941176
r11820 n6721 n6722 2.25
r11821 n6668 n6723 0.016129032258064516
r11822 n6722 n6723 2.03125
r11823 n6669 n6724 0.016129032258064516
r11824 n6723 n6724 1.9375
r11825 n6670 n6725 0.014705882352941176
r11826 n6724 n6725 2.03125
r11827 n6671 n6726 0.020833333333333332
r11828 n6725 n6726 1.8125
r11829 n6672 n6727 0.125
r11830 n6726 n6727 0.875
r11831 n6673 n6728 0.050000000000000003
r11832 n6727 n6728 0.4375
r11833 n6674 n6729 0.25
r11834 n6728 n6729 0.375
r11835 n6675 n6730 0.015625
r11836 n6729 n6730 1.0625
r11837 n6676 n6731 0.25
r11838 n6730 n6731 1.0625
r11839 n6677 n6732 0.013888888888888888
r11840 n6731 n6732 1.1875
r11841 n6678 n6733 0.25
r11842 n6732 n6733 1.1875
r11843 n6679 n6734 0.038461538461538464
r11844 n6733 n6734 0.46875
r11845 n6680 n6735 0.041666666666666664
r11846 n6734 n6735 0.78125
r11847 n6681 n6736 0.071428571428571425
r11848 n6735 n6736 0.59375
r11849 n6682 n6737 0.25
r11850 n6736 n6737 0.28125
r11851 n6683 n6738 0.125
r11852 n6737 n6738 0.1875
r11853 n6684 n6739 0.055555555555555552
r11854 n6738 n6739 0.40625
r11855 n6685 n6740 0.023809523809523808
r11856 n6739 n6740 0.9375
r11857 n6686 n6741 0.25
r11858 n6740 n6741 0.71875
r11859 n6687 n6742 0.25
r11860 n6741 n6742 0.125
r11861 n6688 n6743 0.055555555555555552
r11862 n6742 n6743 0.34375
r11863 n6689 n6744 0.041666666666666664
r11864 n6743 n6744 0.65625
r11865 n6690 n6745 0.041666666666666664
r11866 n6691 n6746 0.055555555555555552
r11867 n6745 n6746 0.65625
r11868 n6692 n6747 0.25
r11869 n6746 n6747 0.34375
r11870 n6693 n6748 0.25
r11871 n6747 n6748 0.125
r11872 n6694 n6749 0.0625
r11873 n6748 n6749 0.3125
r11874 n6695 n6750 0.022727272727272728
r11875 n6749 n6750 0.9375
r11876 n6696 n6751 0.5
r11877 n6750 n6751 0.71875
r11878 n6697 n6752 0.5
r11879 n6751 n6752 0.0625
r11880 n6698 n6753 0.5
r11881 n6752 n6753 0.0625
r11882 n6699 n6754 0.050000000000000003
r11883 n6753 n6754 0.34375
r11884 n6700 n6755 0.041666666666666664
r11885 n6754 n6755 0.6875
r11886 n6701 n6756 0.050000000000000003
r11887 n6702 n6757 0.026315789473684209
r11888 n6756 n6757 0.90625
r11889 n6703 n6758 0.125
r11890 n6757 n6758 0.71875
r11891 n6704 n6759 0.25
r11892 n6758 n6759 0.1875
r11893 n6705 n6760 0.016666666666666666
r11894 n6759 n6760 1
r11895 n6706 n6761 0.25
r11896 n6760 n6761 1
r11897 n6707 n6762 0.125
r11898 n6761 n6762 0.1875
r11899 n6708 n6763 0.026315789473684209
r11900 n6762 n6763 0.71875
r11901 n6709 n6764 0.050000000000000003
r11902 n6763 n6764 0.90625
r11903 n6710 n6765 0.043749999999999997
r11904 n6711 n6766 0.019021739130434784
r11905 n6765 n6766 0.41249999999999998
r11906 n6712 n6767 0.21875
r11907 n6766 n6767 0.3125
r11908 n6713 n6768 0.014583333333333334
r11909 n6767 n6768 0.40000000000000002
r11910 n6714 n6769 0.21875
r11911 n6768 n6769 0.40000000000000002
r11912 n6715 n6770 0.019021739130434784
r11913 n6769 n6770 0.3125
r11914 n6716 n6771 0.043749999999999997
r11915 n6770 n6771 0.41249999999999998
r11916 n6717 n6772 0.043749999999999997
r11917 n6771 n6772 0.25
r11918 n6718 n6773 0.011513157894736841
r11919 n6772 n6773 0.59999999999999998
r11920 n6719 n6774 0.011513157894736841
r11921 n6773 n6774 0.94999999999999996
r11922 n6720 n6775 0.011513157894736841
r11923 n6774 n6775 0.94999999999999996
r11924 n6721 n6776 0.011513157894736841
r11925 n6775 n6776 0.94999999999999996
r11926 n6722 n6777 0.012867647058823529
r11927 n6776 n6777 0.90000000000000002
r11928 n6723 n6778 0.014112903225806451
r11929 n6777 n6778 0.8125
r11930 n6724 n6779 0.014112903225806451
r11931 n6778 n6779 0.77500000000000002
r11932 n6725 n6780 0.012867647058823529
r11933 n6779 n6780 0.8125
r11934 n6726 n6781 0.018229166666666668
r11935 n6780 n6781 0.72499999999999998
r11936 n6727 n6782 0.109375
r11937 n6781 n6782 0.34999999999999998
r11938 n6728 n6783 0.043749999999999997
r11939 n6782 n6783 0.17499999999999999
r11940 n6729 n6784 0.21875
r11941 n6783 n6784 0.14999999999999999
r11942 n6730 n6785 0.013671875
r11943 n6784 n6785 0.42499999999999999
r11944 n6731 n6786 0.21875
r11945 n6785 n6786 0.42499999999999999
r11946 n6732 n6787 0.012152777777777778
r11947 n6786 n6787 0.47499999999999998
r11948 n6733 n6788 0.21875
r11949 n6787 n6788 0.47499999999999998
r11950 n6734 n6789 0.033653846153846152
r11951 n6788 n6789 0.1875
r11952 n6735 n6790 0.036458333333333336
r11953 n6789 n6790 0.3125
r11954 n6736 n6791 0.0625
r11955 n6790 n6791 0.23749999999999999
r11956 n6737 n6792 0.21875
r11957 n6791 n6792 0.1125
r11958 n6738 n6793 0.109375
r11959 n6792 n6793 0.074999999999999997
r11960 n6739 n6794 0.048611111111111112
r11961 n6793 n6794 0.16250000000000001
r11962 n6740 n6795 0.020833333333333332
r11963 n6794 n6795 0.375
r11964 n6741 n6796 0.21875
r11965 n6795 n6796 0.28749999999999998
r11966 n6742 n6797 0.21875
r11967 n6796 n6797 0.050000000000000003
r11968 n6743 n6798 0.048611111111111112
r11969 n6797 n6798 0.13750000000000001
r11970 n6744 n6799 0.036458333333333336
r11971 n6798 n6799 0.26250000000000001
r11972 n6745 n6800 0.036458333333333336
r11973 n6746 n6801 0.048611111111111112
r11974 n6800 n6801 0.26250000000000001
r11975 n6747 n6802 0.21875
r11976 n6801 n6802 0.13750000000000001
r11977 n6748 n6803 0.21875
r11978 n6802 n6803 0.050000000000000003
r11979 n6749 n6804 0.0546875
r11980 n6803 n6804 0.125
r11981 n6750 n6805 0.019886363636363636
r11982 n6804 n6805 0.375
r11983 n6751 n6806 0.4375
r11984 n6805 n6806 0.28749999999999998
r11985 n6752 n6807 0.4375
r11986 n6806 n6807 0.025000000000000001
r11987 n6753 n6808 0.4375
r11988 n6807 n6808 0.025000000000000001
r11989 n6754 n6809 0.043749999999999997
r11990 n6808 n6809 0.13750000000000001
r11991 n6755 n6810 0.036458333333333336
r11992 n6809 n6810 0.27500000000000002
r11993 n6756 n6811 0.043749999999999997
r11994 n6757 n6812 0.023026315789473683
r11995 n6811 n6812 0.36249999999999999
r11996 n6758 n6813 0.109375
r11997 n6812 n6813 0.28749999999999998
r11998 n6759 n6814 0.21875
r11999 n6813 n6814 0.074999999999999997
r12000 n6760 n6815 0.014583333333333334
r12001 n6814 n6815 0.40000000000000002
r12002 n6761 n6816 0.21875
r12003 n6815 n6816 0.40000000000000002
r12004 n6762 n6817 0.109375
r12005 n6816 n6817 0.074999999999999997
r12006 n6763 n6818 0.023026315789473683
r12007 n6817 n6818 0.28749999999999998
r12008 n6764 n6819 0.043749999999999997
r12009 n6818 n6819 0.36249999999999999
r12010 n6765 n6820 0.125
r12011 n6766 n6821 0.05434782608695652
r12012 n6820 n6821 0.13750000000000001
r12013 n6767 n6822 0.625
r12014 n6821 n6822 0.10416666666666667
r12015 n6768 n6823 0.041666666666666664
r12016 n6822 n6823 0.13333333333333333
r12017 n6769 n6824 0.625
r12018 n6823 n6824 0.13333333333333333
r12019 n6770 n6825 0.05434782608695652
r12020 n6824 n6825 0.10416666666666667
r12021 n6771 n6826 0.125
r12022 n6825 n6826 0.13750000000000001
r12023 n6772 n6827 0.125
r12024 n6826 n6827 0.083333333333333329
r12025 n6773 n6828 0.032894736842105261
r12026 n6827 n6828 0.20000000000000001
r12027 n6774 n6829 0.032894736842105261
r12028 n6828 n6829 0.31666666666666665
r12029 n6775 n6830 0.032894736842105261
r12030 n6829 n6830 0.31666666666666665
r12031 n6776 n6831 0.032894736842105261
r12032 n6830 n6831 0.31666666666666665
r12033 n6777 n6832 0.036764705882352942
r12034 n6831 n6832 0.29999999999999999
r12035 n6778 n6833 0.040322580645161289
r12036 n6832 n6833 0.27083333333333331
r12037 n6779 n6834 0.040322580645161289
r12038 n6833 n6834 0.25833333333333336
r12039 n6780 n6835 0.036764705882352942
r12040 n6834 n6835 0.27083333333333331
r12041 n6781 n6836 0.052083333333333336
r12042 n6835 n6836 0.24166666666666667
r12043 n6782 n6837 0.3125
r12044 n6836 n6837 0.11666666666666667
r12045 n6783 n6838 0.125
r12046 n6837 n6838 0.058333333333333334
r12047 n6784 n6839 0.625
r12048 n6838 n6839 0.050000000000000003
r12049 n6785 n6840 0.0390625
r12050 n6839 n6840 0.14166666666666666
r12051 n6786 n6841 0.625
r12052 n6840 n6841 0.14166666666666666
r12053 n6787 n6842 0.034722222222222224
r12054 n6841 n6842 0.15833333333333333
r12055 n6788 n6843 0.625
r12056 n6842 n6843 0.15833333333333333
r12057 n6789 n6844 0.096153846153846159
r12058 n6843 n6844 0.0625
r12059 n6790 n6845 0.10416666666666667
r12060 n6844 n6845 0.10416666666666667
r12061 n6791 n6846 0.17857142857142858
r12062 n6845 n6846 0.079166666666666663
r12063 n6792 n6847 0.625
r12064 n6846 n6847 0.037499999999999999
r12065 n6793 n6848 0.3125
r12066 n6847 n6848 0.025000000000000001
r12067 n6794 n6849 0.1388888888888889
r12068 n6848 n6849 0.054166666666666669
r12069 n6795 n6850 0.059523809523809521
r12070 n6849 n6850 0.125
r12071 n6796 n6851 0.625
r12072 n6850 n6851 0.09583333333333334
r12073 n6797 n6852 0.625
r12074 n6851 n6852 0.016666666666666666
r12075 n6798 n6853 0.1388888888888889
r12076 n6852 n6853 0.04583333333333333
r12077 n6799 n6854 0.10416666666666667
r12078 n6853 n6854 0.087499999999999994
r12079 n6800 n6855 0.10416666666666667
r12080 n6801 n6856 0.1388888888888889
r12081 n6855 n6856 0.087499999999999994
r12082 n6802 n6857 0.625
r12083 n6856 n6857 0.04583333333333333
r12084 n6803 n6858 0.625
r12085 n6857 n6858 0.016666666666666666
r12086 n6804 n6859 0.15625
r12087 n6858 n6859 0.041666666666666664
r12088 n6805 n6860 0.056818181818181816
r12089 n6859 n6860 0.125
r12090 n6806 n6861 1.25
r12091 n6860 n6861 0.09583333333333334
r12092 n6807 n6862 1.25
r12093 n6861 n6862 0.0083333333333333332
r12094 n6808 n6863 1.25
r12095 n6862 n6863 0.0083333333333333332
r12096 n6809 n6864 0.125
r12097 n6863 n6864 0.04583333333333333
r12098 n6810 n6865 0.10416666666666667
r12099 n6864 n6865 0.09166666666666666
r12100 n6811 n6866 0.125
r12101 n6812 n6867 0.065789473684210523
r12102 n6866 n6867 0.12083333333333333
r12103 n6813 n6868 0.3125
r12104 n6867 n6868 0.09583333333333334
r12105 n6814 n6869 0.625
r12106 n6868 n6869 0.025000000000000001
r12107 n6815 n6870 0.041666666666666664
r12108 n6869 n6870 0.13333333333333333
r12109 n6816 n6871 0.625
r12110 n6870 n6871 0.13333333333333333
r12111 n6817 n6872 0.3125
r12112 n6871 n6872 0.025000000000000001
r12113 n6818 n6873 0.065789473684210523
r12114 n6872 n6873 0.09583333333333334
r12115 n6819 n6874 0.125
r12116 n6873 n6874 0.12083333333333333
r12117 n6820 n6875 0.1125
r12118 n6821 n6876 0.048913043478260872
r12119 n6875 n6876 0.6875
r12120 n6822 n6877 0.5625
r12121 n6876 n6877 0.52083333333333337
r12122 n6823 n6878 0.037499999999999999
r12123 n6877 n6878 0.66666666666666663
r12124 n6824 n6879 0.5625
r12125 n6878 n6879 0.66666666666666663
r12126 n6825 n6880 0.048913043478260872
r12127 n6879 n6880 0.52083333333333337
r12128 n6826 n6881 0.1125
r12129 n6880 n6881 0.6875
r12130 n6827 n6882 0.1125
r12131 n6881 n6882 0.41666666666666669
r12132 n6828 n6883 0.029605263157894735
r12133 n6882 n6883 1
r12134 n6829 n6884 0.029605263157894735
r12135 n6883 n6884 1.5833333333333333
r12136 n6830 n6885 0.029605263157894735
r12137 n6884 n6885 1.5833333333333333
r12138 n6831 n6886 0.029605263157894735
r12139 n6885 n6886 1.5833333333333333
r12140 n6832 n6887 0.033088235294117647
r12141 n6886 n6887 1.5
r12142 n6833 n6888 0.036290322580645164
r12143 n6887 n6888 1.3541666666666667
r12144 n6834 n6889 0.036290322580645164
r12145 n6888 n6889 1.2916666666666667
r12146 n6835 n6890 0.033088235294117647
r12147 n6889 n6890 1.3541666666666667
r12148 n6836 n6891 0.046875
r12149 n6890 n6891 1.2083333333333333
r12150 n6837 n6892 0.28125
r12151 n6891 n6892 0.58333333333333337
r12152 n6838 n6893 0.1125
r12153 n6892 n6893 0.29166666666666669
r12154 n6839 n6894 0.5625
r12155 n6893 n6894 0.25
r12156 n6840 n6895 0.03515625
r12157 n6894 n6895 0.70833333333333337
r12158 n6841 n6896 0.5625
r12159 n6895 n6896 0.70833333333333337
r12160 n6842 n6897 0.03125
r12161 n6896 n6897 0.79166666666666663
r12162 n6843 n6898 0.5625
r12163 n6897 n6898 0.79166666666666663
r12164 n6844 n6899 0.086538461538461536
r12165 n6898 n6899 0.3125
r12166 n6845 n6900 0.09375
r12167 n6899 n6900 0.52083333333333337
r12168 n6846 n6901 0.16071428571428573
r12169 n6900 n6901 0.39583333333333331
r12170 n6847 n6902 0.5625
r12171 n6901 n6902 0.1875
r12172 n6848 n6903 0.28125
r12173 n6902 n6903 0.125
r12174 n6849 n6904 0.125
r12175 n6903 n6904 0.27083333333333331
r12176 n6850 n6905 0.053571428571428568
r12177 n6904 n6905 0.625
r12178 n6851 n6906 0.5625
r12179 n6905 n6906 0.47916666666666669
r12180 n6852 n6907 0.5625
r12181 n6906 n6907 0.083333333333333329
r12182 n6853 n6908 0.125
r12183 n6907 n6908 0.22916666666666666
r12184 n6854 n6909 0.09375
r12185 n6908 n6909 0.4375
r12186 n6910 n6911 0.35416666666666669
r12187 n6911 n6912 0.20833333333333334
r12188 n6912 n6913 0.125
r12189 n6913 n6914 0.10416666666666667
r12190 n6914 n6915 0.20833333333333334
r12191 n6915 n6916 0.625
r12192 n6916 n6917 0.5
r12193 n6917 n6918 0.10416666666666667
r12194 n6918 n6919 0.125
r12195 n6919 n6920 0.14583333333333334
r12196 n6920 n6921 0.14583333333333334
r12197 n6921 n6922 0.27083333333333331
r12198 n6855 n6923 0.09375
r12199 n6856 n6924 0.125
r12200 n6923 n6924 0.4375
r12201 n6857 n6925 0.5625
r12202 n6924 n6925 0.22916666666666666
r12203 n6858 n6926 0.5625
r12204 n6925 n6926 0.083333333333333329
r12205 n6859 n6927 0.140625
r12206 n6926 n6927 0.20833333333333334
r12207 n6860 n6928 0.05113636363636364
r12208 n6927 n6928 0.625
r12209 n6861 n6929 1.125
r12210 n6928 n6929 0.47916666666666669
r12211 n6862 n6930 1.125
r12212 n6929 n6930 0.041666666666666664
r12213 n6863 n6931 1.125
r12214 n6930 n6931 0.041666666666666664
r12215 n6864 n6932 0.1125
r12216 n6931 n6932 0.22916666666666666
r12217 n6865 n6933 0.09375
r12218 n6932 n6933 0.45833333333333331
r12219 n6934 n6935 0.35416666666666669
r12220 n6935 n6936 0.20833333333333334
r12221 n6936 n6937 0.125
r12222 n6937 n6938 0.10416666666666667
r12223 n6938 n6939 0.27083333333333331
r12224 n6939 n6940 0.625
r12225 n6940 n6941 0.4375
r12226 n6941 n6942 0.10416666666666667
r12227 n6942 n6943 0.125
r12228 n6943 n6944 0.20833333333333334
r12229 n6944 n6945 0.35416666666666669
r12230 n6866 n6946 0.1125
r12231 n6867 n6947 0.05921052631578947
r12232 n6946 n6947 0.60416666666666663
r12233 n6868 n6948 0.28125
r12234 n6947 n6948 0.47916666666666669
r12235 n6869 n6949 0.5625
r12236 n6948 n6949 0.125
r12237 n6870 n6950 0.037499999999999999
r12238 n6949 n6950 0.66666666666666663
r12239 n6871 n6951 0.5625
r12240 n6950 n6951 0.66666666666666663
r12241 n6872 n6952 0.28125
r12242 n6951 n6952 0.125
r12243 n6873 n6953 0.05921052631578947
r12244 n6952 n6953 0.47916666666666669
r12245 n6874 n6954 0.1125
r12246 n6953 n6954 0.60416666666666663
r12247 n6875 n6955 0.043749999999999997
r12248 n6876 n6956 0.019021739130434784
r12249 n6955 n6956 0.515625
r12250 n6877 n6957 0.21875
r12251 n6956 n6957 0.390625
r12252 n6878 n6958 0.014583333333333334
r12253 n6957 n6958 0.5
r12254 n6879 n6959 0.21875
r12255 n6958 n6959 0.5
r12256 n6880 n6960 0.019021739130434784
r12257 n6959 n6960 0.390625
r12258 n6881 n6961 0.043749999999999997
r12259 n6960 n6961 0.515625
r12260 n6882 n6962 0.043749999999999997
r12261 n6961 n6962 0.3125
r12262 n6883 n6963 0.011513157894736841
r12263 n6962 n6963 0.75
r12264 n6884 n6964 0.011513157894736841
r12265 n6963 n6964 1.1875
r12266 n6885 n6965 0.011513157894736841
r12267 n6964 n6965 1.1875
r12268 n6886 n6966 0.011513157894736841
r12269 n6965 n6966 1.1875
r12270 n6887 n6967 0.012867647058823529
r12271 n6966 n6967 1.125
r12272 n6888 n6968 0.014112903225806451
r12273 n6967 n6968 1.015625
r12274 n6889 n6969 0.014112903225806451
r12275 n6968 n6969 0.96875
r12276 n6890 n6970 0.012867647058823529
r12277 n6969 n6970 1.015625
r12278 n6891 n6971 0.018229166666666668
r12279 n6970 n6971 0.90625
r12280 n6892 n6972 0.109375
r12281 n6971 n6972 0.4375
r12282 n6893 n6973 0.043749999999999997
r12283 n6972 n6973 0.21875
r12284 n6894 n6974 0.21875
r12285 n6973 n6974 0.1875
r12286 n6895 n6975 0.013671875
r12287 n6974 n6975 0.53125
r12288 n6896 n6976 0.21875
r12289 n6975 n6976 0.53125
r12290 n6897 n6977 0.012152777777777778
r12291 n6976 n6977 0.59375
r12292 n6898 n6978 0.21875
r12293 n6977 n6978 0.59375
r12294 n6899 n6979 0.033653846153846152
r12295 n6978 n6979 0.234375
r12296 n6900 n6980 0.036458333333333336
r12297 n6979 n6980 0.390625
r12298 n6901 n6981 0.0625
r12299 n6980 n6981 0.296875
r12300 n6902 n6982 0.21875
r12301 n6981 n6982 0.140625
r12302 n6903 n6983 0.109375
r12303 n6982 n6983 0.09375
r12304 n6904 n6984 0.048611111111111112
r12305 n6983 n6984 0.203125
r12306 n6905 n6985 0.020833333333333332
r12307 n6984 n6985 0.46875
r12308 n6906 n6986 0.21875
r12309 n6985 n6986 0.359375
r12310 n6907 n6987 0.21875
r12311 n6986 n6987 0.0625
r12312 n6908 n6988 0.048611111111111112
r12313 n6987 n6988 0.171875
r12314 n6909 n6989 0.036458333333333336
r12315 n6988 n6989 0.328125
r12316 n6910 n6990 0.043749999999999997
r12317 n6911 n6991 0.0625
r12318 n6990 n6991 0.265625
r12319 n6912 n6992 0.14583333333333334
r12320 n6991 n6992 0.15625
r12321 n6913 n6993 0.14583333333333334
r12322 n6992 n6993 0.09375
r12323 n6914 n6994 0.21875
r12324 n6993 n6994 0.078125
r12325 n6915 n6995 0.0546875
r12326 n6994 n6995 0.15625
r12327 n6916 n6996 0.019886363636363636
r12328 n6995 n6996 0.46875
r12329 n6917 n6997 0.21875
r12330 n6996 n6997 0.375
r12331 n6918 n6998 0.14583333333333334
r12332 n6997 n6998 0.078125
r12333 n6919 n6999 0.14583333333333334
r12334 n6998 n6999 0.09375
r12335 n6920 n7000 0.109375
r12336 n6999 n7000 0.109375
r12337 n6921 n7001 0.14583333333333334
r12338 n7000 n7001 0.109375
r12339 n6922 n7002 0.043749999999999997
r12340 n7001 n7002 0.203125
r12341 n6923 n7003 0.036458333333333336
r12342 n6924 n7004 0.048611111111111112
r12343 n7003 n7004 0.328125
r12344 n6925 n7005 0.21875
r12345 n7004 n7005 0.171875
r12346 n6926 n7006 0.21875
r12347 n7005 n7006 0.0625
r12348 n6927 n7007 0.0546875
r12349 n7006 n7007 0.15625
r12350 n6928 n7008 0.019886363636363636
r12351 n7007 n7008 0.46875
r12352 n6929 n7009 0.4375
r12353 n7008 n7009 0.359375
r12354 n6930 n7010 0.4375
r12355 n7009 n7010 0.03125
r12356 n6931 n7011 0.4375
r12357 n7010 n7011 0.03125
r12358 n6932 n7012 0.043749999999999997
r12359 n7011 n7012 0.171875
r12360 n6933 n7013 0.036458333333333336
r12361 n7012 n7013 0.34375
r12362 n6934 n7014 0.043749999999999997
r12363 n6935 n7015 0.0625
r12364 n7014 n7015 0.265625
r12365 n6936 n7016 0.14583333333333334
r12366 n7015 n7016 0.15625
r12367 n6937 n7017 0.14583333333333334
r12368 n7016 n7017 0.09375
r12369 n6938 n7018 0.21875
r12370 n7017 n7018 0.078125
r12371 n6939 n7019 0.039772727272727272
r12372 n7018 n7019 0.203125
r12373 n6940 n7020 0.023026315789473683
r12374 n7019 n7020 0.46875
r12375 n6941 n7021 0.21875
r12376 n7020 n7021 0.328125
r12377 n6942 n7022 0.14583333333333334
r12378 n7021 n7022 0.078125
r12379 n6943 n7023 0.14583333333333334
r12380 n7022 n7023 0.09375
r12381 n6944 n7024 0.0625
r12382 n7023 n7024 0.15625
r12383 n6945 n7025 0.043749999999999997
r12384 n7024 n7025 0.265625
r12385 n6946 n7026 0.043749999999999997
r12386 n6947 n7027 0.023026315789473683
r12387 n7026 n7027 0.453125
r12388 n6948 n7028 0.109375
r12389 n7027 n7028 0.359375
r12390 n6949 n7029 0.21875
r12391 n7028 n7029 0.09375
r12392 n6950 n7030 0.014583333333333334
r12393 n7029 n7030 0.5
r12394 n6951 n7031 0.21875
r12395 n7030 n7031 0.5
r12396 n6952 n7032 0.109375
r12397 n7031 n7032 0.09375
r12398 n6953 n7033 0.023026315789473683
r12399 n7032 n7033 0.359375
r12400 n6954 n7034 0.043749999999999997
r12401 n7033 n7034 0.453125
r12402 n6955 n7035 0.043749999999999997
r12403 n6956 n7036 0.019021739130434784
r12404 n7035 n7036 0.6875
r12405 n6957 n7037 0.21875
r12406 n7036 n7037 0.52083333333333337
r12407 n6958 n7038 0.014583333333333334
r12408 n7037 n7038 0.66666666666666663
r12409 n6959 n7039 0.21875
r12410 n7038 n7039 0.66666666666666663
r12411 n6960 n7040 0.019021739130434784
r12412 n7039 n7040 0.52083333333333337
r12413 n6961 n7041 0.043749999999999997
r12414 n7040 n7041 0.6875
r12415 n6962 n7042 0.043749999999999997
r12416 n7041 n7042 0.41666666666666669
r12417 n6963 n7043 0.011513157894736841
r12418 n7042 n7043 1
r12419 n6964 n7044 0.011513157894736841
r12420 n7043 n7044 1.5833333333333333
r12421 n6965 n7045 0.011513157894736841
r12422 n7044 n7045 1.5833333333333333
r12423 n6966 n7046 0.011513157894736841
r12424 n7045 n7046 1.5833333333333333
r12425 n6967 n7047 0.012867647058823529
r12426 n7046 n7047 1.5
r12427 n6968 n7048 0.014112903225806451
r12428 n7047 n7048 1.3541666666666667
r12429 n6969 n7049 0.014112903225806451
r12430 n7048 n7049 1.2916666666666667
r12431 n6970 n7050 0.012867647058823529
r12432 n7049 n7050 1.3541666666666667
r12433 n6971 n7051 0.018229166666666668
r12434 n7050 n7051 1.2083333333333333
r12435 n6972 n7052 0.109375
r12436 n7051 n7052 0.58333333333333337
r12437 n6973 n7053 0.043749999999999997
r12438 n7052 n7053 0.29166666666666669
r12439 n6974 n7054 0.21875
r12440 n7053 n7054 0.25
r12441 n6975 n7055 0.013671875
r12442 n7054 n7055 0.70833333333333337
r12443 n6976 n7056 0.21875
r12444 n7055 n7056 0.70833333333333337
r12445 n6977 n7057 0.012152777777777778
r12446 n7056 n7057 0.79166666666666663
r12447 n6978 n7058 0.21875
r12448 n7057 n7058 0.79166666666666663
r12449 n6979 n7059 0.033653846153846152
r12450 n7058 n7059 0.3125
r12451 n6980 n7060 0.036458333333333336
r12452 n7059 n7060 0.52083333333333337
r12453 n6981 n7061 0.0625
r12454 n7060 n7061 0.39583333333333331
r12455 n6982 n7062 0.21875
r12456 n7061 n7062 0.1875
r12457 n6983 n7063 0.109375
r12458 n7062 n7063 0.125
r12459 n6984 n7064 0.048611111111111112
r12460 n7063 n7064 0.27083333333333331
r12461 n6985 n7065 0.020833333333333332
r12462 n7064 n7065 0.625
r12463 n6986 n7066 0.21875
r12464 n7065 n7066 0.47916666666666669
r12465 n6987 n7067 0.21875
r12466 n7066 n7067 0.083333333333333329
r12467 n6988 n7068 0.048611111111111112
r12468 n7067 n7068 0.22916666666666666
r12469 n6989 n7069 0.036458333333333336
r12470 n7068 n7069 0.4375
r12471 n6990 n7070 0.043749999999999997
r12472 n6991 n7071 0.0625
r12473 n7070 n7071 0.35416666666666669
r12474 n6992 n7072 0.14583333333333334
r12475 n7071 n7072 0.20833333333333334
r12476 n6993 n7073 0.14583333333333334
r12477 n7072 n7073 0.125
r12478 n6994 n7074 0.21875
r12479 n7073 n7074 0.10416666666666667
r12480 n6995 n7075 0.0546875
r12481 n7074 n7075 0.20833333333333334
r12482 n6996 n7076 0.019886363636363636
r12483 n7075 n7076 0.625
r12484 n6997 n7077 0.21875
r12485 n7076 n7077 0.5
r12486 n6998 n7078 0.14583333333333334
r12487 n7077 n7078 0.10416666666666667
r12488 n6999 n7079 0.14583333333333334
r12489 n7078 n7079 0.125
r12490 n7000 n7080 0.109375
r12491 n7079 n7080 0.14583333333333334
r12492 n7001 n7081 0.14583333333333334
r12493 n7080 n7081 0.14583333333333334
r12494 n7002 n7082 0.043749999999999997
r12495 n7081 n7082 0.27083333333333331
r12496 n7003 n7083 0.036458333333333336
r12497 n7004 n7084 0.048611111111111112
r12498 n7083 n7084 0.4375
r12499 n7005 n7085 0.21875
r12500 n7084 n7085 0.22916666666666666
r12501 n7006 n7086 0.21875
r12502 n7085 n7086 0.083333333333333329
r12503 n7007 n7087 0.0546875
r12504 n7086 n7087 0.20833333333333334
r12505 n7008 n7088 0.019886363636363636
r12506 n7087 n7088 0.625
r12507 n7009 n7089 0.4375
r12508 n7088 n7089 0.47916666666666669
r12509 n7010 n7090 0.4375
r12510 n7089 n7090 0.041666666666666664
r12511 n7011 n7091 0.4375
r12512 n7090 n7091 0.041666666666666664
r12513 n7012 n7092 0.043749999999999997
r12514 n7091 n7092 0.22916666666666666
r12515 n7013 n7093 0.036458333333333336
r12516 n7092 n7093 0.45833333333333331
r12517 n7014 n7094 0.043749999999999997
r12518 n7015 n7095 0.0625
r12519 n7094 n7095 0.35416666666666669
r12520 n7016 n7096 0.14583333333333334
r12521 n7095 n7096 0.20833333333333334
r12522 n7017 n7097 0.14583333333333334
r12523 n7096 n7097 0.125
r12524 n7018 n7098 0.21875
r12525 n7097 n7098 0.10416666666666667
r12526 n7019 n7099 0.039772727272727272
r12527 n7098 n7099 0.27083333333333331
r12528 n7020 n7100 0.023026315789473683
r12529 n7099 n7100 0.625
r12530 n7021 n7101 0.21875
r12531 n7100 n7101 0.4375
r12532 n7022 n7102 0.14583333333333334
r12533 n7101 n7102 0.10416666666666667
r12534 n7023 n7103 0.14583333333333334
r12535 n7102 n7103 0.125
r12536 n7024 n7104 0.0625
r12537 n7103 n7104 0.20833333333333334
r12538 n7025 n7105 0.043749999999999997
r12539 n7104 n7105 0.35416666666666669
r12540 n7026 n7106 0.043749999999999997
r12541 n7027 n7107 0.023026315789473683
r12542 n7106 n7107 0.60416666666666663
r12543 n7028 n7108 0.109375
r12544 n7107 n7108 0.47916666666666669
r12545 n7029 n7109 0.21875
r12546 n7108 n7109 0.125
r12547 n7030 n7110 0.014583333333333334
r12548 n7109 n7110 0.66666666666666663
r12549 n7031 n7111 0.21875
r12550 n7110 n7111 0.66666666666666663
r12551 n7032 n7112 0.109375
r12552 n7111 n7112 0.125
r12553 n7033 n7113 0.023026315789473683
r12554 n7112 n7113 0.47916666666666669
r12555 n7034 n7114 0.043749999999999997
r12556 n7113 n7114 0.60416666666666663
r12557 n7035 n7115 0.03125
r12558 n7036 n7116 0.01358695652173913
r12559 n7115 n7116 1.03125
r12560 n7037 n7117 0.15625
r12561 n7116 n7117 0.78125
r12562 n7038 n7118 0.010416666666666666
r12563 n7117 n7118 1
r12564 n7039 n7119 0.15625
r12565 n7118 n7119 1
r12566 n7040 n7120 0.01358695652173913
r12567 n7119 n7120 0.78125
r12568 n7041 n7121 0.03125
r12569 n7120 n7121 1.03125
r12570 n7042 n7122 0.03125
r12571 n7121 n7122 0.625
r12572 n7043 n7123 0.0082236842105263153
r12573 n7122 n7123 1.5
r12574 n7044 n7124 0.0082236842105263153
r12575 n7123 n7124 2.375
r12576 n7045 n7125 0.0082236842105263153
r12577 n7124 n7125 2.375
r12578 n7046 n7126 0.0082236842105263153
r12579 n7125 n7126 2.375
r12580 n7047 n7127 0.0091911764705882356
r12581 n7126 n7127 2.25
r12582 n7048 n7128 0.010080645161290322
r12583 n7127 n7128 2.03125
r12584 n7049 n7129 0.010080645161290322
r12585 n7128 n7129 1.9375
r12586 n7050 n7130 0.0091911764705882356
r12587 n7129 n7130 2.03125
r12588 n7051 n7131 0.013020833333333334
r12589 n7130 n7131 1.8125
r12590 n7052 n7132 0.078125
r12591 n7131 n7132 0.875
r12592 n7053 n7133 0.03125
r12593 n7132 n7133 0.4375
r12594 n7054 n7134 0.15625
r12595 n7133 n7134 0.375
r12596 n7055 n7135 0.009765625
r12597 n7134 n7135 1.0625
r12598 n7056 n7136 0.15625
r12599 n7135 n7136 1.0625
r12600 n7057 n7137 0.0086805555555555559
r12601 n7136 n7137 1.1875
r12602 n7058 n7138 0.15625
r12603 n7137 n7138 1.1875
r12604 n7059 n7139 0.02403846153846154
r12605 n7138 n7139 0.46875
r12606 n7060 n7140 0.026041666666666668
r12607 n7139 n7140 0.78125
r12608 n7061 n7141 0.044642857142857144
r12609 n7140 n7141 0.59375
r12610 n7062 n7142 0.15625
r12611 n7141 n7142 0.28125
r12612 n7063 n7143 0.078125
r12613 n7142 n7143 0.1875
r12614 n7064 n7144 0.034722222222222224
r12615 n7143 n7144 0.40625
r12616 n7065 n7145 0.01488095238095238
r12617 n7144 n7145 0.9375
r12618 n7066 n7146 0.15625
r12619 n7145 n7146 0.71875
r12620 n7067 n7147 0.15625
r12621 n7146 n7147 0.125
r12622 n7068 n7148 0.034722222222222224
r12623 n7147 n7148 0.34375
r12624 n7069 n7149 0.026041666666666668
r12625 n7148 n7149 0.65625
r12626 n7070 n7150 0.03125
r12627 n7071 n7151 0.044642857142857144
r12628 n7150 n7151 0.53125
r12629 n7072 n7152 0.10416666666666667
r12630 n7151 n7152 0.3125
r12631 n7073 n7153 0.10416666666666667
r12632 n7152 n7153 0.1875
r12633 n7074 n7154 0.15625
r12634 n7153 n7154 0.15625
r12635 n7075 n7155 0.0390625
r12636 n7154 n7155 0.3125
r12637 n7076 n7156 0.014204545454545454
r12638 n7155 n7156 0.9375
r12639 n7077 n7157 0.15625
r12640 n7156 n7157 0.75
r12641 n7078 n7158 0.10416666666666667
r12642 n7157 n7158 0.15625
r12643 n7079 n7159 0.10416666666666667
r12644 n7158 n7159 0.1875
r12645 n7080 n7160 0.078125
r12646 n7159 n7160 0.21875
r12647 n7081 n7161 0.10416666666666667
r12648 n7160 n7161 0.21875
r12649 n7082 n7162 0.03125
r12650 n7161 n7162 0.40625
r12651 n7083 n7163 0.026041666666666668
r12652 n7084 n7164 0.034722222222222224
r12653 n7163 n7164 0.65625
r12654 n7085 n7165 0.15625
r12655 n7164 n7165 0.34375
r12656 n7086 n7166 0.15625
r12657 n7165 n7166 0.125
r12658 n7087 n7167 0.0390625
r12659 n7166 n7167 0.3125
r12660 n7088 n7168 0.014204545454545454
r12661 n7167 n7168 0.9375
r12662 n7089 n7169 0.3125
r12663 n7168 n7169 0.71875
r12664 n7090 n7170 0.3125
r12665 n7169 n7170 0.0625
r12666 n7091 n7171 0.3125
r12667 n7170 n7171 0.0625
r12668 n7092 n7172 0.03125
r12669 n7171 n7172 0.34375
r12670 n7093 n7173 0.026041666666666668
r12671 n7172 n7173 0.6875
r12672 n7094 n7174 0.03125
r12673 n7095 n7175 0.044642857142857144
r12674 n7174 n7175 0.53125
r12675 n7096 n7176 0.10416666666666667
r12676 n7175 n7176 0.3125
r12677 n7097 n7177 0.10416666666666667
r12678 n7176 n7177 0.1875
r12679 n7098 n7178 0.15625
r12680 n7177 n7178 0.15625
r12681 n7099 n7179 0.028409090909090908
r12682 n7178 n7179 0.40625
r12683 n7100 n7180 0.016447368421052631
r12684 n7179 n7180 0.9375
r12685 n7101 n7181 0.15625
r12686 n7180 n7181 0.65625
r12687 n7102 n7182 0.10416666666666667
r12688 n7181 n7182 0.15625
r12689 n7103 n7183 0.10416666666666667
r12690 n7182 n7183 0.1875
r12691 n7104 n7184 0.044642857142857144
r12692 n7183 n7184 0.3125
r12693 n7105 n7185 0.03125
r12694 n7184 n7185 0.53125
r12695 n7106 n7186 0.03125
r12696 n7107 n7187 0.016447368421052631
r12697 n7186 n7187 0.90625
r12698 n7108 n7188 0.078125
r12699 n7187 n7188 0.71875
r12700 n7109 n7189 0.15625
r12701 n7188 n7189 0.1875
r12702 n7110 n7190 0.010416666666666666
r12703 n7189 n7190 1
r12704 n7111 n7191 0.15625
r12705 n7190 n7191 1
r12706 n7112 n7192 0.078125
r12707 n7191 n7192 0.1875
r12708 n7113 n7193 0.016447368421052631
r12709 n7192 n7193 0.71875
r12710 n7114 n7194 0.03125
r12711 n7193 n7194 0.90625
r12712 n7115 n7195 0.050000000000000003
r12713 n7116 n7196 0.021739130434782608
r12714 n7195 n7196 0.34375
r12715 n7117 n7197 0.25
r12716 n7196 n7197 0.26041666666666669
r12717 n7118 n7198 0.016666666666666666
r12718 n7197 n7198 0.33333333333333331
r12719 n7119 n7199 0.25
r12720 n7198 n7199 0.33333333333333331
r12721 n7120 n7200 0.021739130434782608
r12722 n7199 n7200 0.26041666666666669
r12723 n7121 n7201 0.050000000000000003
r12724 n7200 n7201 0.34375
r12725 n7122 n7202 0.050000000000000003
r12726 n7201 n7202 0.20833333333333334
r12727 n7123 n7203 0.013157894736842105
r12728 n7202 n7203 0.5
r12729 n7124 n7204 0.013157894736842105
r12730 n7203 n7204 0.79166666666666663
r12731 n7125 n7205 0.013157894736842105
r12732 n7204 n7205 0.79166666666666663
r12733 n7126 n7206 0.013157894736842105
r12734 n7205 n7206 0.79166666666666663
r12735 n7127 n7207 0.014705882352941176
r12736 n7206 n7207 0.75
r12737 n7128 n7208 0.016129032258064516
r12738 n7207 n7208 0.67708333333333337
r12739 n7129 n7209 0.016129032258064516
r12740 n7208 n7209 0.64583333333333337
r12741 n7130 n7210 0.014705882352941176
r12742 n7209 n7210 0.67708333333333337
r12743 n7131 n7211 0.020833333333333332
r12744 n7210 n7211 0.60416666666666663
r12745 n7132 n7212 0.125
r12746 n7211 n7212 0.29166666666666669
r12747 n7133 n7213 0.050000000000000003
r12748 n7212 n7213 0.14583333333333334
r12749 n7134 n7214 0.25
r12750 n7213 n7214 0.125
r12751 n7135 n7215 0.015625
r12752 n7214 n7215 0.35416666666666669
r12753 n7136 n7216 0.25
r12754 n7215 n7216 0.35416666666666669
r12755 n7137 n7217 0.013888888888888888
r12756 n7216 n7217 0.39583333333333331
r12757 n7138 n7218 0.25
r12758 n7217 n7218 0.39583333333333331
r12759 n7139 n7219 0.038461538461538464
r12760 n7218 n7219 0.15625
r12761 n7140 n7220 0.041666666666666664
r12762 n7219 n7220 0.26041666666666669
r12763 n7141 n7221 0.071428571428571425
r12764 n7220 n7221 0.19791666666666666
r12765 n7142 n7222 0.25
r12766 n7221 n7222 0.09375
r12767 n7143 n7223 0.125
r12768 n7222 n7223 0.0625
r12769 n7144 n7224 0.055555555555555552
r12770 n7223 n7224 0.13541666666666666
r12771 n7145 n7225 0.023809523809523808
r12772 n7224 n7225 0.3125
r12773 n7146 n7226 0.25
r12774 n7225 n7226 0.23958333333333334
r12775 n7147 n7227 0.25
r12776 n7226 n7227 0.041666666666666664
r12777 n7148 n7228 0.055555555555555552
r12778 n7227 n7228 0.11458333333333333
r12779 n7149 n7229 0.041666666666666664
r12780 n7228 n7229 0.21875
r12781 n7150 n7230 0.050000000000000003
r12782 n7151 n7231 0.071428571428571425
r12783 n7230 n7231 0.17708333333333334
r12784 n7152 n7232 0.16666666666666666
r12785 n7231 n7232 0.10416666666666667
r12786 n7153 n7233 0.16666666666666666
r12787 n7232 n7233 0.0625
r12788 n7154 n7234 0.25
r12789 n7233 n7234 0.052083333333333336
r12790 n7155 n7235 0.0625
r12791 n7234 n7235 0.10416666666666667
r12792 n7156 n7236 0.022727272727272728
r12793 n7235 n7236 0.3125
r12794 n7157 n7237 0.25
r12795 n7236 n7237 0.25
r12796 n7158 n7238 0.16666666666666666
r12797 n7237 n7238 0.052083333333333336
r12798 n7159 n7239 0.16666666666666666
r12799 n7238 n7239 0.0625
r12800 n7160 n7240 0.125
r12801 n7239 n7240 0.072916666666666671
r12802 n7161 n7241 0.16666666666666666
r12803 n7240 n7241 0.072916666666666671
r12804 n7162 n7242 0.050000000000000003
r12805 n7241 n7242 0.13541666666666666
r12806 n7163 n7243 0.041666666666666664
r12807 n7164 n7244 0.055555555555555552
r12808 n7243 n7244 0.21875
r12809 n7165 n7245 0.25
r12810 n7244 n7245 0.11458333333333333
r12811 n7166 n7246 0.25
r12812 n7245 n7246 0.041666666666666664
r12813 n7167 n7247 0.0625
r12814 n7246 n7247 0.10416666666666667
r12815 n7168 n7248 0.022727272727272728
r12816 n7247 n7248 0.3125
r12817 n7169 n7249 0.5
r12818 n7248 n7249 0.23958333333333334
r12819 n7170 n7250 0.5
r12820 n7249 n7250 0.020833333333333332
r12821 n7171 n7251 0.5
r12822 n7250 n7251 0.020833333333333332
r12823 n7172 n7252 0.050000000000000003
r12824 n7251 n7252 0.11458333333333333
r12825 n7173 n7253 0.041666666666666664
r12826 n7252 n7253 0.22916666666666666
r12827 n7174 n7254 0.050000000000000003
r12828 n7175 n7255 0.071428571428571425
r12829 n7254 n7255 0.17708333333333334
r12830 n7176 n7256 0.16666666666666666
r12831 n7255 n7256 0.10416666666666667
r12832 n7177 n7257 0.16666666666666666
r12833 n7256 n7257 0.0625
r12834 n7178 n7258 0.25
r12835 n7257 n7258 0.052083333333333336
r12836 n7179 n7259 0.045454545454545456
r12837 n7258 n7259 0.13541666666666666
r12838 n7180 n7260 0.026315789473684209
r12839 n7259 n7260 0.3125
r12840 n7181 n7261 0.25
r12841 n7260 n7261 0.21875
r12842 n7182 n7262 0.16666666666666666
r12843 n7261 n7262 0.052083333333333336
r12844 n7183 n7263 0.16666666666666666
r12845 n7262 n7263 0.0625
r12846 n7184 n7264 0.071428571428571425
r12847 n7263 n7264 0.10416666666666667
r12848 n7185 n7265 0.050000000000000003
r12849 n7264 n7265 0.17708333333333334
r12850 n7186 n7266 0.050000000000000003
r12851 n7187 n7267 0.026315789473684209
r12852 n7266 n7267 0.30208333333333331
r12853 n7188 n7268 0.125
r12854 n7267 n7268 0.23958333333333334
r12855 n7189 n7269 0.25
r12856 n7268 n7269 0.0625
r12857 n7190 n7270 0.016666666666666666
r12858 n7269 n7270 0.33333333333333331
r12859 n7191 n7271 0.25
r12860 n7270 n7271 0.33333333333333331
r12861 n7192 n7272 0.125
r12862 n7271 n7272 0.0625
r12863 n7193 n7273 0.026315789473684209
r12864 n7272 n7273 0.23958333333333334
r12865 n7194 n7274 0.050000000000000003
r12866 n7273 n7274 0.30208333333333331
r12867 n7195 n7275 0.050000000000000003
r12868 n7196 n7276 0.021739130434782608
r12869 n7275 n7276 1.03125
r12870 n7197 n7277 0.25
r12871 n7276 n7277 0.78125
r12872 n7198 n7278 0.016666666666666666
r12873 n7277 n7278 1
r12874 n7199 n7279 0.25
r12875 n7278 n7279 1
r12876 n7200 n7280 0.021739130434782608
r12877 n7279 n7280 0.78125
r12878 n7201 n7281 0.050000000000000003
r12879 n7280 n7281 1.03125
r12880 n7202 n7282 0.050000000000000003
r12881 n7281 n7282 0.625
r12882 n7203 n7283 0.013157894736842105
r12883 n7282 n7283 1.5
r12884 n7204 n7284 0.013157894736842105
r12885 n7283 n7284 2.375
r12886 n7205 n7285 0.013157894736842105
r12887 n7284 n7285 2.375
r12888 n7206 n7286 0.013157894736842105
r12889 n7285 n7286 2.375
r12890 n7207 n7287 0.014705882352941176
r12891 n7286 n7287 2.25
r12892 n7208 n7288 0.016129032258064516
r12893 n7287 n7288 2.03125
r12894 n7209 n7289 0.016129032258064516
r12895 n7288 n7289 1.9375
r12896 n7210 n7290 0.014705882352941176
r12897 n7289 n7290 2.03125
r12898 n7211 n7291 0.020833333333333332
r12899 n7290 n7291 1.8125
r12900 n7212 n7292 0.125
r12901 n7291 n7292 0.875
r12902 n7213 n7293 0.050000000000000003
r12903 n7292 n7293 0.4375
r12904 n7214 n7294 0.25
r12905 n7293 n7294 0.375
r12906 n7215 n7295 0.015625
r12907 n7294 n7295 1.0625
r12908 n7216 n7296 0.25
r12909 n7295 n7296 1.0625
r12910 n7217 n7297 0.013888888888888888
r12911 n7296 n7297 1.1875
r12912 n7218 n7298 0.25
r12913 n7297 n7298 1.1875
r12914 n7219 n7299 0.038461538461538464
r12915 n7298 n7299 0.46875
r12916 n7220 n7300 0.041666666666666664
r12917 n7299 n7300 0.78125
r12918 n7221 n7301 0.071428571428571425
r12919 n7300 n7301 0.59375
r12920 n7222 n7302 0.25
r12921 n7301 n7302 0.28125
r12922 n7223 n7303 0.125
r12923 n7302 n7303 0.1875
r12924 n7224 n7304 0.055555555555555552
r12925 n7303 n7304 0.40625
r12926 n7225 n7305 0.023809523809523808
r12927 n7304 n7305 0.9375
r12928 n7226 n7306 0.25
r12929 n7305 n7306 0.71875
r12930 n7227 n7307 0.25
r12931 n7306 n7307 0.125
r12932 n7228 n7308 0.055555555555555552
r12933 n7307 n7308 0.34375
r12934 n7229 n7309 0.041666666666666664
r12935 n7308 n7309 0.65625
r12936 n7230 n7310 0.050000000000000003
r12937 n7231 n7311 0.071428571428571425
r12938 n7310 n7311 0.53125
r12939 n7232 n7312 0.16666666666666666
r12940 n7311 n7312 0.3125
r12941 n7233 n7313 0.16666666666666666
r12942 n7312 n7313 0.1875
r12943 n7234 n7314 0.25
r12944 n7313 n7314 0.15625
r12945 n7235 n7315 0.0625
r12946 n7314 n7315 0.3125
r12947 n7236 n7316 0.022727272727272728
r12948 n7315 n7316 0.9375
r12949 n7237 n7317 0.25
r12950 n7316 n7317 0.75
r12951 n7238 n7318 0.16666666666666666
r12952 n7317 n7318 0.15625
r12953 n7239 n7319 0.16666666666666666
r12954 n7318 n7319 0.1875
r12955 n7240 n7320 0.125
r12956 n7319 n7320 0.21875
r12957 n7241 n7321 0.16666666666666666
r12958 n7320 n7321 0.21875
r12959 n7242 n7322 0.050000000000000003
r12960 n7321 n7322 0.40625
r12961 n7243 n7323 0.041666666666666664
r12962 n7244 n7324 0.055555555555555552
r12963 n7323 n7324 0.65625
r12964 n7245 n7325 0.25
r12965 n7324 n7325 0.34375
r12966 n7246 n7326 0.25
r12967 n7325 n7326 0.125
r12968 n7247 n7327 0.0625
r12969 n7326 n7327 0.3125
r12970 n7248 n7328 0.022727272727272728
r12971 n7327 n7328 0.9375
r12972 n7249 n7329 0.5
r12973 n7328 n7329 0.71875
r12974 n7250 n7330 0.5
r12975 n7329 n7330 0.0625
r12976 n7251 n7331 0.5
r12977 n7330 n7331 0.0625
r12978 n7252 n7332 0.050000000000000003
r12979 n7331 n7332 0.34375
r12980 n7253 n7333 0.041666666666666664
r12981 n7332 n7333 0.6875
r12982 n7254 n7334 0.050000000000000003
r12983 n7255 n7335 0.071428571428571425
r12984 n7334 n7335 0.53125
r12985 n7256 n7336 0.16666666666666666
r12986 n7335 n7336 0.3125
r12987 n7257 n7337 0.16666666666666666
r12988 n7336 n7337 0.1875
r12989 n7258 n7338 0.25
r12990 n7337 n7338 0.15625
r12991 n7259 n7339 0.045454545454545456
r12992 n7338 n7339 0.40625
r12993 n7260 n7340 0.026315789473684209
r12994 n7339 n7340 0.9375
r12995 n7261 n7341 0.25
r12996 n7340 n7341 0.65625
r12997 n7262 n7342 0.16666666666666666
r12998 n7341 n7342 0.15625
r12999 n7263 n7343 0.16666666666666666
r13000 n7342 n7343 0.1875
r13001 n7264 n7344 0.071428571428571425
r13002 n7343 n7344 0.3125
r13003 n7265 n7345 0.050000000000000003
r13004 n7344 n7345 0.53125
r13005 n7266 n7346 0.050000000000000003
r13006 n7267 n7347 0.026315789473684209
r13007 n7346 n7347 0.90625
r13008 n7268 n7348 0.125
r13009 n7347 n7348 0.71875
r13010 n7269 n7349 0.25
r13011 n7348 n7349 0.1875
r13012 n7270 n7350 0.016666666666666666
r13013 n7349 n7350 1
r13014 n7271 n7351 0.25
r13015 n7350 n7351 1
r13016 n7272 n7352 0.125
r13017 n7351 n7352 0.1875
r13018 n7273 n7353 0.026315789473684209
r13019 n7352 n7353 0.71875
r13020 n7274 n7354 0.050000000000000003
r13021 n7353 n7354 0.90625
r13022 n7275 n7355 0.03125
r13023 n7276 n7356 0.01358695652173913
r13024 n7355 n7356 0.6875
r13025 n7277 n7357 0.15625
r13026 n7356 n7357 0.52083333333333337
r13027 n7278 n7358 0.010416666666666666
r13028 n7357 n7358 0.66666666666666663
r13029 n7279 n7359 0.15625
r13030 n7358 n7359 0.66666666666666663
r13031 n7280 n7360 0.01358695652173913
r13032 n7359 n7360 0.52083333333333337
r13033 n7281 n7361 0.03125
r13034 n7360 n7361 0.6875
r13035 n7282 n7362 0.03125
r13036 n7361 n7362 0.41666666666666669
r13037 n7283 n7363 0.0082236842105263153
r13038 n7362 n7363 1
r13039 n7284 n7364 0.0082236842105263153
r13040 n7363 n7364 1.5833333333333333
r13041 n7285 n7365 0.0082236842105263153
r13042 n7364 n7365 1.5833333333333333
r13043 n7286 n7366 0.0082236842105263153
r13044 n7365 n7366 1.5833333333333333
r13045 n7287 n7367 0.0091911764705882356
r13046 n7366 n7367 1.5
r13047 n7288 n7368 0.010080645161290322
r13048 n7367 n7368 1.3541666666666667
r13049 n7289 n7369 0.010080645161290322
r13050 n7368 n7369 1.2916666666666667
r13051 n7290 n7370 0.0091911764705882356
r13052 n7369 n7370 1.3541666666666667
r13053 n7291 n7371 0.013020833333333334
r13054 n7370 n7371 1.2083333333333333
r13055 n7292 n7372 0.078125
r13056 n7371 n7372 0.58333333333333337
r13057 n7293 n7373 0.03125
r13058 n7372 n7373 0.29166666666666669
r13059 n7294 n7374 0.15625
r13060 n7373 n7374 0.25
r13061 n7295 n7375 0.009765625
r13062 n7374 n7375 0.70833333333333337
r13063 n7296 n7376 0.15625
r13064 n7375 n7376 0.70833333333333337
r13065 n7297 n7377 0.0086805555555555559
r13066 n7376 n7377 0.79166666666666663
r13067 n7298 n7378 0.15625
r13068 n7377 n7378 0.79166666666666663
r13069 n7299 n7379 0.02403846153846154
r13070 n7378 n7379 0.3125
r13071 n7300 n7380 0.026041666666666668
r13072 n7379 n7380 0.52083333333333337
r13073 n7301 n7381 0.044642857142857144
r13074 n7380 n7381 0.39583333333333331
r13075 n7302 n7382 0.15625
r13076 n7381 n7382 0.1875
r13077 n7303 n7383 0.078125
r13078 n7382 n7383 0.125
r13079 n7304 n7384 0.034722222222222224
r13080 n7383 n7384 0.27083333333333331
r13081 n7305 n7385 0.01488095238095238
r13082 n7384 n7385 0.625
r13083 n7306 n7386 0.15625
r13084 n7385 n7386 0.47916666666666669
r13085 n7307 n7387 0.15625
r13086 n7386 n7387 0.083333333333333329
r13087 n7308 n7388 0.034722222222222224
r13088 n7387 n7388 0.22916666666666666
r13089 n7309 n7389 0.026041666666666668
r13090 n7388 n7389 0.4375
r13091 n7310 n7390 0.03125
r13092 n7311 n7391 0.044642857142857144
r13093 n7390 n7391 0.35416666666666669
r13094 n7312 n7392 0.10416666666666667
r13095 n7391 n7392 0.20833333333333334
r13096 n7313 n7393 0.10416666666666667
r13097 n7392 n7393 0.125
r13098 n7314 n7394 0.15625
r13099 n7393 n7394 0.10416666666666667
r13100 n7315 n7395 0.0390625
r13101 n7394 n7395 0.20833333333333334
r13102 n7316 n7396 0.014204545454545454
r13103 n7395 n7396 0.625
r13104 n7317 n7397 0.15625
r13105 n7396 n7397 0.5
r13106 n7318 n7398 0.10416666666666667
r13107 n7397 n7398 0.10416666666666667
r13108 n7319 n7399 0.10416666666666667
r13109 n7398 n7399 0.125
r13110 n7320 n7400 0.078125
r13111 n7399 n7400 0.14583333333333334
r13112 n7321 n7401 0.10416666666666667
r13113 n7400 n7401 0.14583333333333334
r13114 n7322 n7402 0.03125
r13115 n7401 n7402 0.27083333333333331
r13116 n7323 n7403 0.026041666666666668
r13117 n7324 n7404 0.034722222222222224
r13118 n7403 n7404 0.4375
r13119 n7325 n7405 0.15625
r13120 n7404 n7405 0.22916666666666666
r13121 n7326 n7406 0.15625
r13122 n7405 n7406 0.083333333333333329
r13123 n7327 n7407 0.0390625
r13124 n7406 n7407 0.20833333333333334
r13125 n7328 n7408 0.014204545454545454
r13126 n7407 n7408 0.625
r13127 n7329 n7409 0.3125
r13128 n7408 n7409 0.47916666666666669
r13129 n7330 n7410 0.3125
r13130 n7409 n7410 0.041666666666666664
r13131 n7331 n7411 0.3125
r13132 n7410 n7411 0.041666666666666664
r13133 n7332 n7412 0.03125
r13134 n7411 n7412 0.22916666666666666
r13135 n7333 n7413 0.026041666666666668
r13136 n7412 n7413 0.45833333333333331
r13137 n7334 n7414 0.03125
r13138 n7335 n7415 0.044642857142857144
r13139 n7414 n7415 0.35416666666666669
r13140 n7336 n7416 0.10416666666666667
r13141 n7415 n7416 0.20833333333333334
r13142 n7337 n7417 0.10416666666666667
r13143 n7416 n7417 0.125
r13144 n7338 n7418 0.15625
r13145 n7417 n7418 0.10416666666666667
r13146 n7339 n7419 0.028409090909090908
r13147 n7418 n7419 0.27083333333333331
r13148 n7340 n7420 0.016447368421052631
r13149 n7419 n7420 0.625
r13150 n7341 n7421 0.15625
r13151 n7420 n7421 0.4375
r13152 n7342 n7422 0.10416666666666667
r13153 n7421 n7422 0.10416666666666667
r13154 n7343 n7423 0.10416666666666667
r13155 n7422 n7423 0.125
r13156 n7344 n7424 0.044642857142857144
r13157 n7423 n7424 0.20833333333333334
r13158 n7345 n7425 0.03125
r13159 n7424 n7425 0.35416666666666669
r13160 n7346 n7426 0.03125
r13161 n7347 n7427 0.016447368421052631
r13162 n7426 n7427 0.60416666666666663
r13163 n7348 n7428 0.078125
r13164 n7427 n7428 0.47916666666666669
r13165 n7349 n7429 0.15625
r13166 n7428 n7429 0.125
r13167 n7350 n7430 0.010416666666666666
r13168 n7429 n7430 0.66666666666666663
r13169 n7351 n7431 0.15625
r13170 n7430 n7431 0.66666666666666663
r13171 n7352 n7432 0.078125
r13172 n7431 n7432 0.125
r13173 n7353 n7433 0.016447368421052631
r13174 n7432 n7433 0.47916666666666669
r13175 n7354 n7434 0.03125
r13176 n7433 n7434 0.60416666666666663
r13177 n7355 n7435 0.03125
r13178 n7356 n7436 0.01358695652173913
r13179 n7435 n7436 1.03125
r13180 n7357 n7437 0.15625
r13181 n7436 n7437 0.78125
r13182 n7358 n7438 0.010416666666666666
r13183 n7437 n7438 1
r13184 n7359 n7439 0.15625
r13185 n7438 n7439 1
r13186 n7360 n7440 0.01358695652173913
r13187 n7439 n7440 0.78125
r13188 n7361 n7441 0.03125
r13189 n7440 n7441 1.03125
r13190 n7380 n7442 0.026041666666666668
r13191 n7381 n7443 0.044642857142857144
r13192 n7442 n7443 0.59375
r13193 n7382 n7444 0.15625
r13194 n7443 n7444 0.28125
r13195 n7383 n7445 0.078125
r13196 n7444 n7445 0.1875
r13197 n7384 n7446 0.034722222222222224
r13198 n7445 n7446 0.40625
r13199 n7385 n7447 0.01488095238095238
r13200 n7446 n7447 0.9375
r13201 n7386 n7448 0.15625
r13202 n7447 n7448 0.71875
r13203 n7387 n7449 0.15625
r13204 n7448 n7449 0.125
r13205 n7388 n7450 0.034722222222222224
r13206 n7449 n7450 0.34375
r13207 n7389 n7451 0.026041666666666668
r13208 n7450 n7451 0.65625
r13209 n7390 n7452 0.03125
r13210 n7391 n7453 0.044642857142857144
r13211 n7452 n7453 0.53125
r13212 n7392 n7454 0.10416666666666667
r13213 n7453 n7454 0.3125
r13214 n7393 n7455 0.10416666666666667
r13215 n7454 n7455 0.1875
r13216 n7394 n7456 0.15625
r13217 n7455 n7456 0.15625
r13218 n7395 n7457 0.0390625
r13219 n7456 n7457 0.3125
r13220 n7396 n7458 0.014204545454545454
r13221 n7457 n7458 0.9375
r13222 n7397 n7459 0.15625
r13223 n7458 n7459 0.75
r13224 n7398 n7460 0.10416666666666667
r13225 n7459 n7460 0.15625
r13226 n7399 n7461 0.10416666666666667
r13227 n7460 n7461 0.1875
r13228 n7400 n7462 0.078125
r13229 n7461 n7462 0.21875
r13230 n7401 n7463 0.10416666666666667
r13231 n7462 n7463 0.21875
r13232 n7402 n7464 0.03125
r13233 n7463 n7464 0.40625
r13234 n7403 n7465 0.026041666666666668
r13235 n7404 n7466 0.034722222222222224
r13236 n7465 n7466 0.65625
r13237 n7405 n7467 0.15625
r13238 n7466 n7467 0.34375
r13239 n7406 n7468 0.15625
r13240 n7467 n7468 0.125
r13241 n7407 n7469 0.0390625
r13242 n7468 n7469 0.3125
r13243 n7408 n7470 0.014204545454545454
r13244 n7469 n7470 0.9375
r13245 n7409 n7471 0.3125
r13246 n7470 n7471 0.71875
r13247 n7410 n7472 0.3125
r13248 n7471 n7472 0.0625
r13249 n7411 n7473 0.3125
r13250 n7472 n7473 0.0625
r13251 n7412 n7474 0.03125
r13252 n7473 n7474 0.34375
r13253 n7413 n7475 0.026041666666666668
r13254 n7474 n7475 0.6875
r13255 n7414 n7476 0.03125
r13256 n7415 n7477 0.044642857142857144
r13257 n7476 n7477 0.53125
r13258 n7416 n7478 0.10416666666666667
r13259 n7477 n7478 0.3125
r13260 n7417 n7479 0.10416666666666667
r13261 n7478 n7479 0.1875
r13262 n7418 n7480 0.15625
r13263 n7479 n7480 0.15625
r13264 n7419 n7481 0.028409090909090908
r13265 n7480 n7481 0.40625
r13266 n7420 n7482 0.016447368421052631
r13267 n7481 n7482 0.9375
r13268 n7421 n7483 0.15625
r13269 n7482 n7483 0.65625
r13270 n7422 n7484 0.10416666666666667
r13271 n7483 n7484 0.15625
r13272 n7423 n7485 0.10416666666666667
r13273 n7484 n7485 0.1875
r13274 n7424 n7486 0.044642857142857144
r13275 n7485 n7486 0.3125
r13276 n7425 n7487 0.03125
r13277 n7486 n7487 0.53125
r13278 n7426 n7488 0.03125
r13279 n7427 n7489 0.016447368421052631
r13280 n7488 n7489 0.90625
r13281 n7428 n7490 0.078125
r13282 n7489 n7490 0.71875
r13283 n7429 n7491 0.15625
r13284 n7490 n7491 0.1875
r13285 n7430 n7492 0.010416666666666666
r13286 n7491 n7492 1
r13287 n7431 n7493 0.15625
r13288 n7492 n7493 1
r13289 n7432 n7494 0.078125
r13290 n7493 n7494 0.1875
r13291 n7433 n7495 0.016447368421052631
r13292 n7494 n7495 0.71875
r13293 n7434 n7496 0.03125
r13294 n7495 n7496 0.90625
r13295 n7435 n7497 0.20000000000000001
r13296 n7436 n7498 0.086956521739130432
r13297 n7497 n7498 0.068750000000000006
r13298 n7437 n7499 1
r13299 n7498 n7499 0.052083333333333336
r13300 n7438 n7500 0.066666666666666666
r13301 n7499 n7500 0.066666666666666666
r13302 n7439 n7501 1
r13303 n7500 n7501 0.066666666666666666
r13304 n7440 n7502 0.086956521739130432
r13305 n7501 n7502 0.052083333333333336
r13306 n7441 n7503 0.20000000000000001
r13307 n7502 n7503 0.068750000000000006
r13308 n7452 n7504 0.20000000000000001
r13309 n7453 n7505 0.2857142857142857
r13310 n7504 n7505 0.035416666666666666
r13311 n7454 n7506 0.66666666666666663
r13312 n7505 n7506 0.020833333333333332
r13313 n7455 n7507 0.66666666666666663
r13314 n7506 n7507 0.012500000000000001
r13315 n7456 n7508 1
r13316 n7507 n7508 0.010416666666666666
r13317 n7457 n7509 0.25
r13318 n7508 n7509 0.020833333333333332
r13319 n7458 n7510 0.090909090909090912
r13320 n7509 n7510 0.0625
r13321 n7459 n7511 1
r13322 n7510 n7511 0.050000000000000003
r13323 n7460 n7512 0.66666666666666663
r13324 n7511 n7512 0.010416666666666666
r13325 n7461 n7513 0.66666666666666663
r13326 n7512 n7513 0.012500000000000001
r13327 n7462 n7514 0.5
r13328 n7513 n7514 0.014583333333333334
r13329 n7463 n7515 0.66666666666666663
r13330 n7514 n7515 0.014583333333333334
r13331 n7464 n7516 0.20000000000000001
r13332 n7515 n7516 0.027083333333333334
r13333 n7476 n7517 0.20000000000000001
r13334 n7477 n7518 0.2857142857142857
r13335 n7517 n7518 0.035416666666666666
r13336 n7478 n7519 0.66666666666666663
r13337 n7518 n7519 0.020833333333333332
r13338 n7479 n7520 0.66666666666666663
r13339 n7519 n7520 0.012500000000000001
r13340 n7480 n7521 1
r13341 n7520 n7521 0.010416666666666666
r13342 n7481 n7522 0.18181818181818182
r13343 n7521 n7522 0.027083333333333334
r13344 n7482 n7523 0.10526315789473684
r13345 n7522 n7523 0.0625
r13346 n7483 n7524 1
r13347 n7523 n7524 0.043749999999999997
r13348 n7484 n7525 0.66666666666666663
r13349 n7524 n7525 0.010416666666666666
r13350 n7485 n7526 0.66666666666666663
r13351 n7525 n7526 0.012500000000000001
r13352 n7486 n7527 0.2857142857142857
r13353 n7526 n7527 0.020833333333333332
r13354 n7487 n7528 0.20000000000000001
r13355 n7527 n7528 0.035416666666666666
r13356 n7488 n7529 0.20000000000000001
r13357 n7489 n7530 0.10526315789473684
r13358 n7529 n7530 0.060416666666666667
r13359 n7490 n7531 0.5
r13360 n7530 n7531 0.04791666666666667
r13361 n7491 n7532 1
r13362 n7531 n7532 0.012500000000000001
r13363 n7492 n7533 0.066666666666666666
r13364 n7532 n7533 0.066666666666666666
r13365 n7493 n7534 1
r13366 n7533 n7534 0.066666666666666666
r13367 n7494 n7535 0.5
r13368 n7534 n7535 0.012500000000000001
r13369 n7495 n7536 0.10526315789473684
r13370 n7535 n7536 0.04791666666666667
r13371 n7496 n7537 0.20000000000000001
r13372 n7536 n7537 0.060416666666666667
r13373 n7497 n7538 0.20000000000000001
r13374 n7498 n7539 0.086956521739130432
r13375 n7538 n7539 1.03125
r13376 n7499 n7540 1
r13377 n7539 n7540 0.78125
r13378 n7500 n7541 0.066666666666666666
r13379 n7540 n7541 1
r13380 n7501 n7542 1
r13381 n7541 n7542 1
r13382 n7502 n7543 0.086956521739130432
r13383 n7542 n7543 0.78125
r13384 n7503 n7544 0.20000000000000001
r13385 n7543 n7544 1.03125
r13386 n7545 n7546 0.59375
r13387 n7546 n7547 0.28125
r13388 n7547 n7548 0.1875
r13389 n7548 n7549 0.40625
r13390 n7549 n7550 0.9375
r13391 n7550 n7551 0.71875
r13392 n7551 n7552 0.125
r13393 n7552 n7553 0.34375
r13394 n7553 n7554 0.65625
r13395 n7504 n7555 0.20000000000000001
r13396 n7505 n7556 0.2857142857142857
r13397 n7555 n7556 0.53125
r13398 n7506 n7557 0.66666666666666663
r13399 n7556 n7557 0.3125
r13400 n7507 n7558 0.66666666666666663
r13401 n7557 n7558 0.1875
r13402 n7508 n7559 1
r13403 n7558 n7559 0.15625
r13404 n7509 n7560 0.25
r13405 n7559 n7560 0.3125
r13406 n7510 n7561 0.090909090909090912
r13407 n7560 n7561 0.9375
r13408 n7511 n7562 1
r13409 n7561 n7562 0.75
r13410 n7512 n7563 0.66666666666666663
r13411 n7562 n7563 0.15625
r13412 n7513 n7564 0.66666666666666663
r13413 n7563 n7564 0.1875
r13414 n7514 n7565 0.5
r13415 n7564 n7565 0.21875
r13416 n7515 n7566 0.66666666666666663
r13417 n7565 n7566 0.21875
r13418 n7516 n7567 0.20000000000000001
r13419 n7566 n7567 0.40625
r13420 n7568 n7569 0.65625
r13421 n7569 n7570 0.34375
r13422 n7570 n7571 0.125
r13423 n7571 n7572 0.3125
r13424 n7572 n7573 0.9375
r13425 n7573 n7574 0.71875
r13426 n7574 n7575 0.0625
r13427 n7575 n7576 0.0625
r13428 n7576 n7577 0.34375
r13429 n7577 n7578 0.6875
r13430 n7517 n7579 0.20000000000000001
r13431 n7518 n7580 0.2857142857142857
r13432 n7579 n7580 0.53125
r13433 n7519 n7581 0.66666666666666663
r13434 n7580 n7581 0.3125
r13435 n7520 n7582 0.66666666666666663
r13436 n7581 n7582 0.1875
r13437 n7521 n7583 1
r13438 n7582 n7583 0.15625
r13439 n7522 n7584 0.18181818181818182
r13440 n7583 n7584 0.40625
r13441 n7523 n7585 0.10526315789473684
r13442 n7584 n7585 0.9375
r13443 n7524 n7586 1
r13444 n7585 n7586 0.65625
r13445 n7525 n7587 0.66666666666666663
r13446 n7586 n7587 0.15625
r13447 n7526 n7588 0.66666666666666663
r13448 n7587 n7588 0.1875
r13449 n7527 n7589 0.2857142857142857
r13450 n7588 n7589 0.3125
r13451 n7528 n7590 0.20000000000000001
r13452 n7589 n7590 0.53125
r13453 n7529 n7591 0.20000000000000001
r13454 n7530 n7592 0.10526315789473684
r13455 n7591 n7592 0.90625
r13456 n7531 n7593 0.5
r13457 n7592 n7593 0.71875
r13458 n7532 n7594 1
r13459 n7593 n7594 0.1875
r13460 n7533 n7595 0.066666666666666666
r13461 n7594 n7595 1
r13462 n7534 n7596 1
r13463 n7595 n7596 1
r13464 n7535 n7597 0.5
r13465 n7596 n7597 0.1875
r13466 n7536 n7598 0.10526315789473684
r13467 n7597 n7598 0.71875
r13468 n7537 n7599 0.20000000000000001
r13469 n7598 n7599 0.90625
r13470 n7538 n7600 0.03125
r13471 n7539 n7601 0.01358695652173913
r13472 n7600 n7601 0.6875
r13473 n7540 n7602 0.15625
r13474 n7601 n7602 0.52083333333333337
r13475 n7541 n7603 0.010416666666666666
r13476 n7602 n7603 0.66666666666666663
r13477 n7542 n7604 0.15625
r13478 n7603 n7604 0.66666666666666663
r13479 n7543 n7605 0.01358695652173913
r13480 n7604 n7605 0.52083333333333337
r13481 n7544 n7606 0.03125
r13482 n7605 n7606 0.6875
r13483 n7545 n7607 0.026041666666666668
r13484 n7546 n7608 0.044642857142857144
r13485 n7607 n7608 0.39583333333333331
r13486 n7547 n7609 0.15625
r13487 n7608 n7609 0.1875
r13488 n7548 n7610 0.078125
r13489 n7609 n7610 0.125
r13490 n7549 n7611 0.034722222222222224
r13491 n7610 n7611 0.27083333333333331
r13492 n7550 n7612 0.01488095238095238
r13493 n7611 n7612 0.625
r13494 n7551 n7613 0.15625
r13495 n7612 n7613 0.47916666666666669
r13496 n7552 n7614 0.15625
r13497 n7613 n7614 0.083333333333333329
r13498 n7553 n7615 0.034722222222222224
r13499 n7614 n7615 0.22916666666666666
r13500 n7554 n7616 0.026041666666666668
r13501 n7615 n7616 0.4375
r13502 n7555 n7617 0.03125
r13503 n7556 n7618 0.044642857142857144
r13504 n7617 n7618 0.35416666666666669
r13505 n7557 n7619 0.10416666666666667
r13506 n7618 n7619 0.20833333333333334
r13507 n7558 n7620 0.10416666666666667
r13508 n7619 n7620 0.125
r13509 n7559 n7621 0.15625
r13510 n7620 n7621 0.10416666666666667
r13511 n7560 n7622 0.0390625
r13512 n7621 n7622 0.20833333333333334
r13513 n7561 n7623 0.014204545454545454
r13514 n7622 n7623 0.625
r13515 n7562 n7624 0.15625
r13516 n7623 n7624 0.5
r13517 n7563 n7625 0.10416666666666667
r13518 n7624 n7625 0.10416666666666667
r13519 n7564 n7626 0.10416666666666667
r13520 n7625 n7626 0.125
r13521 n7565 n7627 0.078125
r13522 n7626 n7627 0.14583333333333334
r13523 n7566 n7628 0.10416666666666667
r13524 n7627 n7628 0.14583333333333334
r13525 n7567 n7629 0.03125
r13526 n7628 n7629 0.27083333333333331
r13527 n7568 n7630 0.026041666666666668
r13528 n7569 n7631 0.034722222222222224
r13529 n7630 n7631 0.4375
r13530 n7570 n7632 0.15625
r13531 n7631 n7632 0.22916666666666666
r13532 n7571 n7633 0.15625
r13533 n7632 n7633 0.083333333333333329
r13534 n7572 n7634 0.0390625
r13535 n7633 n7634 0.20833333333333334
r13536 n7573 n7635 0.014204545454545454
r13537 n7634 n7635 0.625
r13538 n7574 n7636 0.3125
r13539 n7635 n7636 0.47916666666666669
r13540 n7575 n7637 0.3125
r13541 n7636 n7637 0.041666666666666664
r13542 n7576 n7638 0.3125
r13543 n7637 n7638 0.041666666666666664
r13544 n7577 n7639 0.03125
r13545 n7638 n7639 0.22916666666666666
r13546 n7578 n7640 0.026041666666666668
r13547 n7639 n7640 0.45833333333333331
r13548 n7579 n7641 0.03125
r13549 n7580 n7642 0.044642857142857144
r13550 n7641 n7642 0.35416666666666669
r13551 n7581 n7643 0.10416666666666667
r13552 n7642 n7643 0.20833333333333334
r13553 n7582 n7644 0.10416666666666667
r13554 n7643 n7644 0.125
r13555 n7583 n7645 0.15625
r13556 n7644 n7645 0.10416666666666667
r13557 n7584 n7646 0.028409090909090908
r13558 n7645 n7646 0.27083333333333331
r13559 n7585 n7647 0.016447368421052631
r13560 n7646 n7647 0.625
r13561 n7586 n7648 0.15625
r13562 n7647 n7648 0.4375
r13563 n7587 n7649 0.10416666666666667
r13564 n7648 n7649 0.10416666666666667
r13565 n7588 n7650 0.10416666666666667
r13566 n7649 n7650 0.125
r13567 n7589 n7651 0.044642857142857144
r13568 n7650 n7651 0.20833333333333334
r13569 n7590 n7652 0.03125
r13570 n7651 n7652 0.35416666666666669
r13571 n7591 n7653 0.03125
r13572 n7592 n7654 0.016447368421052631
r13573 n7653 n7654 0.60416666666666663
r13574 n7593 n7655 0.078125
r13575 n7654 n7655 0.47916666666666669
r13576 n7594 n7656 0.15625
r13577 n7655 n7656 0.125
r13578 n7595 n7657 0.010416666666666666
r13579 n7656 n7657 0.66666666666666663
r13580 n7596 n7658 0.15625
r13581 n7657 n7658 0.66666666666666663
r13582 n7597 n7659 0.078125
r13583 n7658 n7659 0.125
r13584 n7598 n7660 0.016447368421052631
r13585 n7659 n7660 0.47916666666666669
r13586 n7599 n7661 0.03125
r13587 n7660 n7661 0.60416666666666663
r13588 n7600 n7662 0.03125
r13589 n7601 n7663 0.01358695652173913
r13590 n7662 n7663 1.03125
r13591 n7602 n7664 0.15625
r13592 n7663 n7664 0.78125
r13593 n7603 n7665 0.010416666666666666
r13594 n7664 n7665 1
r13595 n7604 n7666 0.15625
r13596 n7665 n7666 1
r13597 n7605 n7667 0.01358695652173913
r13598 n7666 n7667 0.78125
r13599 n7606 n7668 0.03125
r13600 n7667 n7668 1.03125
r13601 n7607 n7669 0.026041666666666668
r13602 n7608 n7670 0.044642857142857144
r13603 n7669 n7670 0.59375
r13604 n7609 n7671 0.15625
r13605 n7670 n7671 0.28125
r13606 n7610 n7672 0.078125
r13607 n7671 n7672 0.1875
r13608 n7611 n7673 0.034722222222222224
r13609 n7672 n7673 0.40625
r13610 n7612 n7674 0.01488095238095238
r13611 n7673 n7674 0.9375
r13612 n7613 n7675 0.15625
r13613 n7674 n7675 0.71875
r13614 n7614 n7676 0.15625
r13615 n7675 n7676 0.125
r13616 n7615 n7677 0.034722222222222224
r13617 n7676 n7677 0.34375
r13618 n7616 n7678 0.026041666666666668
r13619 n7677 n7678 0.65625
r13620 n7617 n7679 0.03125
r13621 n7618 n7680 0.044642857142857144
r13622 n7679 n7680 0.53125
r13623 n7619 n7681 0.10416666666666667
r13624 n7680 n7681 0.3125
r13625 n7620 n7682 0.10416666666666667
r13626 n7681 n7682 0.1875
r13627 n7621 n7683 0.15625
r13628 n7682 n7683 0.15625
r13629 n7622 n7684 0.0390625
r13630 n7683 n7684 0.3125
r13631 n7623 n7685 0.014204545454545454
r13632 n7684 n7685 0.9375
r13633 n7624 n7686 0.15625
r13634 n7685 n7686 0.75
r13635 n7625 n7687 0.10416666666666667
r13636 n7686 n7687 0.15625
r13637 n7626 n7688 0.10416666666666667
r13638 n7687 n7688 0.1875
r13639 n7627 n7689 0.078125
r13640 n7688 n7689 0.21875
r13641 n7628 n7690 0.10416666666666667
r13642 n7689 n7690 0.21875
r13643 n7629 n7691 0.03125
r13644 n7690 n7691 0.40625
r13645 n7630 n7692 0.026041666666666668
r13646 n7631 n7693 0.034722222222222224
r13647 n7692 n7693 0.65625
r13648 n7632 n7694 0.15625
r13649 n7693 n7694 0.34375
r13650 n7633 n7695 0.15625
r13651 n7694 n7695 0.125
r13652 n7634 n7696 0.0390625
r13653 n7695 n7696 0.3125
r13654 n7635 n7697 0.014204545454545454
r13655 n7696 n7697 0.9375
r13656 n7636 n7698 0.3125
r13657 n7697 n7698 0.71875
r13658 n7637 n7699 0.3125
r13659 n7698 n7699 0.0625
r13660 n7638 n7700 0.3125
r13661 n7699 n7700 0.0625
r13662 n7639 n7701 0.03125
r13663 n7700 n7701 0.34375
r13664 n7640 n7702 0.026041666666666668
r13665 n7701 n7702 0.6875
r13666 n7641 n7703 0.03125
r13667 n7642 n7704 0.044642857142857144
r13668 n7703 n7704 0.53125
r13669 n7643 n7705 0.10416666666666667
r13670 n7704 n7705 0.3125
r13671 n7644 n7706 0.10416666666666667
r13672 n7705 n7706 0.1875
r13673 n7645 n7707 0.15625
r13674 n7706 n7707 0.15625
r13675 n7646 n7708 0.028409090909090908
r13676 n7707 n7708 0.40625
r13677 n7647 n7709 0.016447368421052631
r13678 n7708 n7709 0.9375
r13679 n7648 n7710 0.15625
r13680 n7709 n7710 0.65625
r13681 n7649 n7711 0.10416666666666667
r13682 n7710 n7711 0.15625
r13683 n7650 n7712 0.10416666666666667
r13684 n7711 n7712 0.1875
r13685 n7651 n7713 0.044642857142857144
r13686 n7712 n7713 0.3125
r13687 n7652 n7714 0.03125
r13688 n7713 n7714 0.53125
r13689 n7653 n7715 0.03125
r13690 n7654 n7716 0.016447368421052631
r13691 n7715 n7716 0.90625
r13692 n7655 n7717 0.078125
r13693 n7716 n7717 0.71875
r13694 n7656 n7718 0.15625
r13695 n7717 n7718 0.1875
r13696 n7657 n7719 0.010416666666666666
r13697 n7718 n7719 1
r13698 n7658 n7720 0.15625
r13699 n7719 n7720 1
r13700 n7659 n7721 0.078125
r13701 n7720 n7721 0.1875
r13702 n7660 n7722 0.016447368421052631
r13703 n7721 n7722 0.71875
r13704 n7661 n7723 0.03125
r13705 n7722 n7723 0.90625
r13706 n7662 n7724 0.050000000000000003
r13707 n7663 n7725 0.021739130434782608
r13708 n7724 n7725 0.34375
r13709 n7664 n7726 0.25
r13710 n7725 n7726 0.26041666666666669
r13711 n7665 n7727 0.016666666666666666
r13712 n7726 n7727 0.33333333333333331
r13713 n7666 n7728 0.25
r13714 n7727 n7728 0.33333333333333331
r13715 n7667 n7729 0.021739130434782608
r13716 n7728 n7729 0.26041666666666669
r13717 n7668 n7730 0.050000000000000003
r13718 n7729 n7730 0.34375
r13719 n7669 n7731 0.041666666666666664
r13720 n7670 n7732 0.071428571428571425
r13721 n7731 n7732 0.19791666666666666
r13722 n7671 n7733 0.25
r13723 n7732 n7733 0.09375
r13724 n7672 n7734 0.125
r13725 n7733 n7734 0.0625
r13726 n7673 n7735 0.055555555555555552
r13727 n7734 n7735 0.13541666666666666
r13728 n7674 n7736 0.023809523809523808
r13729 n7735 n7736 0.3125
r13730 n7675 n7737 0.25
r13731 n7736 n7737 0.23958333333333334
r13732 n7676 n7738 0.25
r13733 n7737 n7738 0.041666666666666664
r13734 n7677 n7739 0.055555555555555552
r13735 n7738 n7739 0.11458333333333333
r13736 n7678 n7740 0.041666666666666664
r13737 n7739 n7740 0.21875
r13738 n7679 n7741 0.050000000000000003
r13739 n7680 n7742 0.071428571428571425
r13740 n7741 n7742 0.17708333333333334
r13741 n7681 n7743 0.16666666666666666
r13742 n7742 n7743 0.10416666666666667
r13743 n7682 n7744 0.16666666666666666
r13744 n7743 n7744 0.0625
r13745 n7683 n7745 0.25
r13746 n7744 n7745 0.052083333333333336
r13747 n7684 n7746 0.0625
r13748 n7745 n7746 0.10416666666666667
r13749 n7685 n7747 0.022727272727272728
r13750 n7746 n7747 0.3125
r13751 n7686 n7748 0.25
r13752 n7747 n7748 0.25
r13753 n7687 n7749 0.16666666666666666
r13754 n7748 n7749 0.052083333333333336
r13755 n7688 n7750 0.16666666666666666
r13756 n7749 n7750 0.0625
r13757 n7689 n7751 0.125
r13758 n7750 n7751 0.072916666666666671
r13759 n7690 n7752 0.16666666666666666
r13760 n7751 n7752 0.072916666666666671
r13761 n7691 n7753 0.050000000000000003
r13762 n7752 n7753 0.13541666666666666
r13763 n7692 n7754 0.041666666666666664
r13764 n7693 n7755 0.055555555555555552
r13765 n7754 n7755 0.21875
r13766 n7694 n7756 0.25
r13767 n7755 n7756 0.11458333333333333
r13768 n7695 n7757 0.25
r13769 n7756 n7757 0.041666666666666664
r13770 n7696 n7758 0.0625
r13771 n7757 n7758 0.10416666666666667
r13772 n7697 n7759 0.022727272727272728
r13773 n7758 n7759 0.3125
r13774 n7698 n7760 0.5
r13775 n7759 n7760 0.23958333333333334
r13776 n7699 n7761 0.5
r13777 n7760 n7761 0.020833333333333332
r13778 n7700 n7762 0.5
r13779 n7761 n7762 0.020833333333333332
r13780 n7701 n7763 0.050000000000000003
r13781 n7762 n7763 0.11458333333333333
r13782 n7702 n7764 0.041666666666666664
r13783 n7763 n7764 0.22916666666666666
r13784 n7703 n7765 0.050000000000000003
r13785 n7704 n7766 0.071428571428571425
r13786 n7765 n7766 0.17708333333333334
r13787 n7705 n7767 0.16666666666666666
r13788 n7766 n7767 0.10416666666666667
r13789 n7706 n7768 0.16666666666666666
r13790 n7767 n7768 0.0625
r13791 n7707 n7769 0.25
r13792 n7768 n7769 0.052083333333333336
r13793 n7708 n7770 0.045454545454545456
r13794 n7769 n7770 0.13541666666666666
r13795 n7709 n7771 0.026315789473684209
r13796 n7770 n7771 0.3125
r13797 n7710 n7772 0.25
r13798 n7771 n7772 0.21875
r13799 n7711 n7773 0.16666666666666666
r13800 n7772 n7773 0.052083333333333336
r13801 n7712 n7774 0.16666666666666666
r13802 n7773 n7774 0.0625
r13803 n7713 n7775 0.071428571428571425
r13804 n7774 n7775 0.10416666666666667
r13805 n7714 n7776 0.050000000000000003
r13806 n7775 n7776 0.17708333333333334
r13807 n7715 n7777 0.050000000000000003
r13808 n7716 n7778 0.026315789473684209
r13809 n7777 n7778 0.30208333333333331
r13810 n7717 n7779 0.125
r13811 n7778 n7779 0.23958333333333334
r13812 n7718 n7780 0.25
r13813 n7779 n7780 0.0625
r13814 n7719 n7781 0.016666666666666666
r13815 n7780 n7781 0.33333333333333331
r13816 n7720 n7782 0.25
r13817 n7781 n7782 0.33333333333333331
r13818 n7721 n7783 0.125
r13819 n7782 n7783 0.0625
r13820 n7722 n7784 0.026315789473684209
r13821 n7783 n7784 0.23958333333333334
r13822 n7723 n7785 0.050000000000000003
r13823 n7784 n7785 0.30208333333333331
r13824 n7724 n7786 0.050000000000000003
r13825 n7725 n7787 0.021739130434782608
r13826 n7786 n7787 1.03125
r13827 n7726 n7788 0.25
r13828 n7787 n7788 0.78125
r13829 n7727 n7789 0.016666666666666666
r13830 n7788 n7789 1
r13831 n7728 n7790 0.25
r13832 n7789 n7790 1
r13833 n7729 n7791 0.021739130434782608
r13834 n7790 n7791 0.78125
r13835 n7730 n7792 0.050000000000000003
r13836 n7791 n7792 1.03125
r13837 n7731 n7793 0.041666666666666664
r13838 n7732 n7794 0.071428571428571425
r13839 n7793 n7794 0.59375
r13840 n7733 n7795 0.25
r13841 n7794 n7795 0.28125
r13842 n7734 n7796 0.125
r13843 n7795 n7796 0.1875
r13844 n7735 n7797 0.055555555555555552
r13845 n7796 n7797 0.40625
r13846 n7736 n7798 0.023809523809523808
r13847 n7797 n7798 0.9375
r13848 n7737 n7799 0.25
r13849 n7798 n7799 0.71875
r13850 n7738 n7800 0.25
r13851 n7799 n7800 0.125
r13852 n7739 n7801 0.055555555555555552
r13853 n7800 n7801 0.34375
r13854 n7740 n7802 0.041666666666666664
r13855 n7801 n7802 0.65625
r13856 n7741 n7803 0.050000000000000003
r13857 n7742 n7804 0.071428571428571425
r13858 n7803 n7804 0.53125
r13859 n7743 n7805 0.16666666666666666
r13860 n7804 n7805 0.3125
r13861 n7744 n7806 0.16666666666666666
r13862 n7805 n7806 0.1875
r13863 n7745 n7807 0.25
r13864 n7806 n7807 0.15625
r13865 n7746 n7808 0.0625
r13866 n7807 n7808 0.3125
r13867 n7747 n7809 0.022727272727272728
r13868 n7808 n7809 0.9375
r13869 n7748 n7810 0.25
r13870 n7809 n7810 0.75
r13871 n7749 n7811 0.16666666666666666
r13872 n7810 n7811 0.15625
r13873 n7750 n7812 0.16666666666666666
r13874 n7811 n7812 0.1875
r13875 n7751 n7813 0.125
r13876 n7812 n7813 0.21875
r13877 n7752 n7814 0.16666666666666666
r13878 n7813 n7814 0.21875
r13879 n7753 n7815 0.050000000000000003
r13880 n7814 n7815 0.40625
r13881 n7754 n7816 0.041666666666666664
r13882 n7755 n7817 0.055555555555555552
r13883 n7816 n7817 0.65625
r13884 n7756 n7818 0.25
r13885 n7817 n7818 0.34375
r13886 n7757 n7819 0.25
r13887 n7818 n7819 0.125
r13888 n7758 n7820 0.0625
r13889 n7819 n7820 0.3125
r13890 n7759 n7821 0.022727272727272728
r13891 n7820 n7821 0.9375
r13892 n7760 n7822 0.5
r13893 n7821 n7822 0.71875
r13894 n7761 n7823 0.5
r13895 n7822 n7823 0.0625
r13896 n7762 n7824 0.5
r13897 n7823 n7824 0.0625
r13898 n7763 n7825 0.050000000000000003
r13899 n7824 n7825 0.34375
r13900 n7764 n7826 0.041666666666666664
r13901 n7825 n7826 0.6875
r13902 n7765 n7827 0.050000000000000003
r13903 n7766 n7828 0.071428571428571425
r13904 n7827 n7828 0.53125
r13905 n7767 n7829 0.16666666666666666
r13906 n7828 n7829 0.3125
r13907 n7768 n7830 0.16666666666666666
r13908 n7829 n7830 0.1875
r13909 n7769 n7831 0.25
r13910 n7830 n7831 0.15625
r13911 n7770 n7832 0.045454545454545456
r13912 n7831 n7832 0.40625
r13913 n7771 n7833 0.026315789473684209
r13914 n7832 n7833 0.9375
r13915 n7772 n7834 0.25
r13916 n7833 n7834 0.65625
r13917 n7773 n7835 0.16666666666666666
r13918 n7834 n7835 0.15625
r13919 n7774 n7836 0.16666666666666666
r13920 n7835 n7836 0.1875
r13921 n7775 n7837 0.071428571428571425
r13922 n7836 n7837 0.3125
r13923 n7776 n7838 0.050000000000000003
r13924 n7837 n7838 0.53125
r13925 n7777 n7839 0.050000000000000003
r13926 n7778 n7840 0.026315789473684209
r13927 n7839 n7840 0.90625
r13928 n7779 n7841 0.125
r13929 n7840 n7841 0.71875
r13930 n7780 n7842 0.25
r13931 n7841 n7842 0.1875
r13932 n7781 n7843 0.016666666666666666
r13933 n7842 n7843 1
r13934 n7782 n7844 0.25
r13935 n7843 n7844 1
r13936 n7783 n7845 0.125
r13937 n7844 n7845 0.1875
r13938 n7784 n7846 0.026315789473684209
r13939 n7845 n7846 0.71875
r13940 n7785 n7847 0.050000000000000003
r13941 n7846 n7847 0.90625
r13942 n7786 n7848 0.03125
r13943 n7787 n7849 0.01358695652173913
r13944 n7848 n7849 0.6875
r13945 n7788 n7850 0.15625
r13946 n7849 n7850 0.52083333333333337
r13947 n7789 n7851 0.010416666666666666
r13948 n7850 n7851 0.66666666666666663
r13949 n7790 n7852 0.15625
r13950 n7851 n7852 0.66666666666666663
r13951 n7791 n7853 0.01358695652173913
r13952 n7852 n7853 0.52083333333333337
r13953 n7792 n7854 0.03125
r13954 n7853 n7854 0.6875
r13955 n7793 n7855 0.026041666666666668
r13956 n7794 n7856 0.044642857142857144
r13957 n7855 n7856 0.39583333333333331
r13958 n7795 n7857 0.15625
r13959 n7856 n7857 0.1875
r13960 n7796 n7858 0.078125
r13961 n7857 n7858 0.125
r13962 n7797 n7859 0.034722222222222224
r13963 n7858 n7859 0.27083333333333331
r13964 n7798 n7860 0.01488095238095238
r13965 n7859 n7860 0.625
r13966 n7799 n7861 0.15625
r13967 n7860 n7861 0.47916666666666669
r13968 n7800 n7862 0.15625
r13969 n7861 n7862 0.083333333333333329
r13970 n7801 n7863 0.034722222222222224
r13971 n7862 n7863 0.22916666666666666
r13972 n7802 n7864 0.026041666666666668
r13973 n7863 n7864 0.4375
r13974 n7803 n7865 0.03125
r13975 n7804 n7866 0.044642857142857144
r13976 n7865 n7866 0.35416666666666669
r13977 n7805 n7867 0.10416666666666667
r13978 n7866 n7867 0.20833333333333334
r13979 n7806 n7868 0.10416666666666667
r13980 n7867 n7868 0.125
r13981 n7807 n7869 0.15625
r13982 n7868 n7869 0.10416666666666667
r13983 n7808 n7870 0.0390625
r13984 n7869 n7870 0.20833333333333334
r13985 n7809 n7871 0.014204545454545454
r13986 n7870 n7871 0.625
r13987 n7810 n7872 0.15625
r13988 n7871 n7872 0.5
r13989 n7811 n7873 0.10416666666666667
r13990 n7872 n7873 0.10416666666666667
r13991 n7812 n7874 0.10416666666666667
r13992 n7873 n7874 0.125
r13993 n7813 n7875 0.078125
r13994 n7874 n7875 0.14583333333333334
r13995 n7814 n7876 0.10416666666666667
r13996 n7875 n7876 0.14583333333333334
r13997 n7815 n7877 0.03125
r13998 n7876 n7877 0.27083333333333331
r13999 n7816 n7878 0.026041666666666668
r14000 n7817 n7879 0.034722222222222224
r14001 n7878 n7879 0.4375
r14002 n7818 n7880 0.15625
r14003 n7879 n7880 0.22916666666666666
r14004 n7819 n7881 0.15625
r14005 n7880 n7881 0.083333333333333329
r14006 n7820 n7882 0.0390625
r14007 n7881 n7882 0.20833333333333334
r14008 n7821 n7883 0.014204545454545454
r14009 n7882 n7883 0.625
r14010 n7822 n7884 0.3125
r14011 n7883 n7884 0.47916666666666669
r14012 n7823 n7885 0.3125
r14013 n7884 n7885 0.041666666666666664
r14014 n7824 n7886 0.3125
r14015 n7885 n7886 0.041666666666666664
r14016 n7825 n7887 0.03125
r14017 n7886 n7887 0.22916666666666666
r14018 n7826 n7888 0.026041666666666668
r14019 n7887 n7888 0.45833333333333331
r14020 n7827 n7889 0.03125
r14021 n7828 n7890 0.044642857142857144
r14022 n7889 n7890 0.35416666666666669
r14023 n7829 n7891 0.10416666666666667
r14024 n7890 n7891 0.20833333333333334
r14025 n7830 n7892 0.10416666666666667
r14026 n7891 n7892 0.125
r14027 n7831 n7893 0.15625
r14028 n7892 n7893 0.10416666666666667
r14029 n7832 n7894 0.028409090909090908
r14030 n7893 n7894 0.27083333333333331
r14031 n7833 n7895 0.016447368421052631
r14032 n7894 n7895 0.625
r14033 n7834 n7896 0.15625
r14034 n7895 n7896 0.4375
r14035 n7835 n7897 0.10416666666666667
r14036 n7896 n7897 0.10416666666666667
r14037 n7836 n7898 0.10416666666666667
r14038 n7897 n7898 0.125
r14039 n7837 n7899 0.044642857142857144
r14040 n7898 n7899 0.20833333333333334
r14041 n7838 n7900 0.03125
r14042 n7899 n7900 0.35416666666666669
r14043 n7839 n7901 0.03125
r14044 n7840 n7902 0.016447368421052631
r14045 n7901 n7902 0.60416666666666663
r14046 n7841 n7903 0.078125
r14047 n7902 n7903 0.47916666666666669
r14048 n7842 n7904 0.15625
r14049 n7903 n7904 0.125
r14050 n7843 n7905 0.010416666666666666
r14051 n7904 n7905 0.66666666666666663
r14052 n7844 n7906 0.15625
r14053 n7905 n7906 0.66666666666666663
r14054 n7845 n7907 0.078125
r14055 n7906 n7907 0.125
r14056 n7846 n7908 0.016447368421052631
r14057 n7907 n7908 0.47916666666666669
r14058 n7847 n7909 0.03125
r14059 n7908 n7909 0.60416666666666663
r14060 n7848 n7910 0.043749999999999997
r14061 n7849 n7911 0.019021739130434784
r14062 n7910 n7911 0.515625
r14063 n7850 n7912 0.21875
r14064 n7911 n7912 0.390625
r14065 n7851 n7913 0.014583333333333334
r14066 n7912 n7913 0.5
r14067 n7852 n7914 0.21875
r14068 n7913 n7914 0.5
r14069 n7853 n7915 0.019021739130434784
r14070 n7914 n7915 0.390625
r14071 n7854 n7916 0.043749999999999997
r14072 n7915 n7916 0.515625
r14073 n7855 n7917 0.036458333333333336
r14074 n7856 n7918 0.0625
r14075 n7917 n7918 0.296875
r14076 n7857 n7919 0.21875
r14077 n7918 n7919 0.140625
r14078 n7858 n7920 0.109375
r14079 n7919 n7920 0.09375
r14080 n7859 n7921 0.048611111111111112
r14081 n7920 n7921 0.203125
r14082 n7860 n7922 0.020833333333333332
r14083 n7921 n7922 0.46875
r14084 n7861 n7923 0.21875
r14085 n7922 n7923 0.359375
r14086 n7862 n7924 0.21875
r14087 n7923 n7924 0.0625
r14088 n7863 n7925 0.048611111111111112
r14089 n7924 n7925 0.171875
r14090 n7864 n7926 0.036458333333333336
r14091 n7925 n7926 0.328125
r14092 n7865 n7927 0.043749999999999997
r14093 n7866 n7928 0.0625
r14094 n7927 n7928 0.265625
r14095 n7867 n7929 0.14583333333333334
r14096 n7928 n7929 0.15625
r14097 n7868 n7930 0.14583333333333334
r14098 n7929 n7930 0.09375
r14099 n7869 n7931 0.21875
r14100 n7930 n7931 0.078125
r14101 n7870 n7932 0.0546875
r14102 n7931 n7932 0.15625
r14103 n7871 n7933 0.019886363636363636
r14104 n7932 n7933 0.46875
r14105 n7872 n7934 0.21875
r14106 n7933 n7934 0.375
r14107 n7873 n7935 0.14583333333333334
r14108 n7934 n7935 0.078125
r14109 n7874 n7936 0.14583333333333334
r14110 n7935 n7936 0.09375
r14111 n7875 n7937 0.109375
r14112 n7936 n7937 0.109375
r14113 n7876 n7938 0.14583333333333334
r14114 n7937 n7938 0.109375
r14115 n7877 n7939 0.043749999999999997
r14116 n7938 n7939 0.203125
r14117 n7878 n7940 0.036458333333333336
r14118 n7879 n7941 0.048611111111111112
r14119 n7940 n7941 0.328125
r14120 n7880 n7942 0.21875
r14121 n7941 n7942 0.171875
r14122 n7881 n7943 0.21875
r14123 n7942 n7943 0.0625
r14124 n7882 n7944 0.0546875
r14125 n7943 n7944 0.15625
r14126 n7883 n7945 0.019886363636363636
r14127 n7944 n7945 0.46875
r14128 n7884 n7946 0.4375
r14129 n7945 n7946 0.359375
r14130 n7885 n7947 0.4375
r14131 n7946 n7947 0.03125
r14132 n7886 n7948 0.4375
r14133 n7947 n7948 0.03125
r14134 n7887 n7949 0.043749999999999997
r14135 n7948 n7949 0.171875
r14136 n7888 n7950 0.036458333333333336
r14137 n7949 n7950 0.34375
r14138 n7889 n7951 0.043749999999999997
r14139 n7890 n7952 0.0625
r14140 n7951 n7952 0.265625
r14141 n7891 n7953 0.14583333333333334
r14142 n7952 n7953 0.15625
r14143 n7892 n7954 0.14583333333333334
r14144 n7953 n7954 0.09375
r14145 n7893 n7955 0.21875
r14146 n7954 n7955 0.078125
r14147 n7894 n7956 0.039772727272727272
r14148 n7955 n7956 0.203125
r14149 n7895 n7957 0.023026315789473683
r14150 n7956 n7957 0.46875
r14151 n7896 n7958 0.21875
r14152 n7957 n7958 0.328125
r14153 n7897 n7959 0.14583333333333334
r14154 n7958 n7959 0.078125
r14155 n7898 n7960 0.14583333333333334
r14156 n7959 n7960 0.09375
r14157 n7899 n7961 0.0625
r14158 n7960 n7961 0.15625
r14159 n7900 n7962 0.043749999999999997
r14160 n7961 n7962 0.265625
r14161 n7901 n7963 0.043749999999999997
r14162 n7902 n7964 0.023026315789473683
r14163 n7963 n7964 0.453125
r14164 n7903 n7965 0.109375
r14165 n7964 n7965 0.359375
r14166 n7904 n7966 0.21875
r14167 n7965 n7966 0.09375
r14168 n7905 n7967 0.014583333333333334
r14169 n7966 n7967 0.5
r14170 n7906 n7968 0.21875
r14171 n7967 n7968 0.5
r14172 n7907 n7969 0.109375
r14173 n7968 n7969 0.09375
r14174 n7908 n7970 0.023026315789473683
r14175 n7969 n7970 0.359375
r14176 n7909 n7971 0.043749999999999997
r14177 n7970 n7971 0.453125
r14178 n7910 n7972 0.043749999999999997
r14179 n7911 n7973 0.019021739130434784
r14180 n7972 n7973 0.6875
r14181 n7912 n7974 0.21875
r14182 n7973 n7974 0.52083333333333337
r14183 n7913 n7975 0.014583333333333334
r14184 n7974 n7975 0.66666666666666663
r14185 n7914 n7976 0.21875
r14186 n7975 n7976 0.66666666666666663
r14187 n7915 n7977 0.019021739130434784
r14188 n7976 n7977 0.52083333333333337
r14189 n7916 n7978 0.043749999999999997
r14190 n7977 n7978 0.6875
r14191 n7917 n7979 0.036458333333333336
r14192 n7918 n7980 0.0625
r14193 n7979 n7980 0.39583333333333331
r14194 n7919 n7981 0.21875
r14195 n7980 n7981 0.1875
r14196 n7920 n7982 0.109375
r14197 n7981 n7982 0.125
r14198 n7921 n7983 0.048611111111111112
r14199 n7982 n7983 0.27083333333333331
r14200 n7922 n7984 0.020833333333333332
r14201 n7983 n7984 0.625
r14202 n7923 n7985 0.21875
r14203 n7984 n7985 0.47916666666666669
r14204 n7924 n7986 0.21875
r14205 n7985 n7986 0.083333333333333329
r14206 n7925 n7987 0.048611111111111112
r14207 n7986 n7987 0.22916666666666666
r14208 n7926 n7988 0.036458333333333336
r14209 n7987 n7988 0.4375
r14210 n7927 n7989 0.043749999999999997
r14211 n7928 n7990 0.0625
r14212 n7989 n7990 0.35416666666666669
r14213 n7929 n7991 0.14583333333333334
r14214 n7990 n7991 0.20833333333333334
r14215 n7930 n7992 0.14583333333333334
r14216 n7991 n7992 0.125
r14217 n7931 n7993 0.21875
r14218 n7992 n7993 0.10416666666666667
r14219 n7932 n7994 0.0546875
r14220 n7993 n7994 0.20833333333333334
r14221 n7933 n7995 0.019886363636363636
r14222 n7994 n7995 0.625
r14223 n7934 n7996 0.21875
r14224 n7995 n7996 0.5
r14225 n7935 n7997 0.14583333333333334
r14226 n7996 n7997 0.10416666666666667
r14227 n7936 n7998 0.14583333333333334
r14228 n7997 n7998 0.125
r14229 n7937 n7999 0.109375
r14230 n7998 n7999 0.14583333333333334
r14231 n7938 n8000 0.14583333333333334
r14232 n7999 n8000 0.14583333333333334
r14233 n7939 n8001 0.043749999999999997
r14234 n8000 n8001 0.27083333333333331
r14235 n7940 n8002 0.036458333333333336
r14236 n7941 n8003 0.048611111111111112
r14237 n8002 n8003 0.4375
r14238 n7942 n8004 0.21875
r14239 n8003 n8004 0.22916666666666666
r14240 n7943 n8005 0.21875
r14241 n8004 n8005 0.083333333333333329
r14242 n7944 n8006 0.0546875
r14243 n8005 n8006 0.20833333333333334
r14244 n7945 n8007 0.019886363636363636
r14245 n8006 n8007 0.625
r14246 n7946 n8008 0.4375
r14247 n8007 n8008 0.47916666666666669
r14248 n7947 n8009 0.4375
r14249 n8008 n8009 0.041666666666666664
r14250 n7948 n8010 0.4375
r14251 n8009 n8010 0.041666666666666664
r14252 n7949 n8011 0.043749999999999997
r14253 n8010 n8011 0.22916666666666666
r14254 n7950 n8012 0.036458333333333336
r14255 n8011 n8012 0.45833333333333331
r14256 n7951 n8013 0.043749999999999997
r14257 n7952 n8014 0.0625
r14258 n8013 n8014 0.35416666666666669
r14259 n7953 n8015 0.14583333333333334
r14260 n8014 n8015 0.20833333333333334
r14261 n7954 n8016 0.14583333333333334
r14262 n8015 n8016 0.125
r14263 n7955 n8017 0.21875
r14264 n8016 n8017 0.10416666666666667
r14265 n7956 n8018 0.039772727272727272
r14266 n8017 n8018 0.27083333333333331
r14267 n7957 n8019 0.023026315789473683
r14268 n8018 n8019 0.625
r14269 n7958 n8020 0.21875
r14270 n8019 n8020 0.4375
r14271 n7959 n8021 0.14583333333333334
r14272 n8020 n8021 0.10416666666666667
r14273 n7960 n8022 0.14583333333333334
r14274 n8021 n8022 0.125
r14275 n7961 n8023 0.0625
r14276 n8022 n8023 0.20833333333333334
r14277 n7962 n8024 0.043749999999999997
r14278 n8023 n8024 0.35416666666666669
r14279 n7963 n8025 0.043749999999999997
r14280 n7964 n8026 0.023026315789473683
r14281 n8025 n8026 0.60416666666666663
r14282 n7965 n8027 0.109375
r14283 n8026 n8027 0.47916666666666669
r14284 n7966 n8028 0.21875
r14285 n8027 n8028 0.125
r14286 n7967 n8029 0.014583333333333334
r14287 n8028 n8029 0.66666666666666663
r14288 n7968 n8030 0.21875
r14289 n8029 n8030 0.66666666666666663
r14290 n7969 n8031 0.109375
r14291 n8030 n8031 0.125
r14292 n7970 n8032 0.023026315789473683
r14293 n8031 n8032 0.47916666666666669
r14294 n7971 n8033 0.043749999999999997
r14295 n8032 n8033 0.60416666666666663
r14296 n7972 n8034 0.1125
r14297 n7973 n8035 0.048913043478260872
r14298 n8034 n8035 0.13750000000000001
r14299 n7974 n8036 0.5625
r14300 n8035 n8036 0.10416666666666667
r14301 n7975 n8037 0.037499999999999999
r14302 n8036 n8037 0.13333333333333333
r14303 n7976 n8038 0.5625
r14304 n8037 n8038 0.13333333333333333
r14305 n7977 n8039 0.048913043478260872
r14306 n8038 n8039 0.10416666666666667
r14307 n7978 n8040 0.1125
r14308 n8039 n8040 0.13750000000000001
r14309 n7979 n8041 0.09375
r14310 n7980 n8042 0.16071428571428573
r14311 n8041 n8042 0.079166666666666663
r14312 n7981 n8043 0.5625
r14313 n8042 n8043 0.037499999999999999
r14314 n7982 n8044 0.28125
r14315 n8043 n8044 0.025000000000000001
r14316 n7983 n8045 0.125
r14317 n8044 n8045 0.054166666666666669
r14318 n7984 n8046 0.053571428571428568
r14319 n8045 n8046 0.125
r14320 n7985 n8047 0.5625
r14321 n8046 n8047 0.09583333333333334
r14322 n7986 n8048 0.5625
r14323 n8047 n8048 0.016666666666666666
r14324 n7987 n8049 0.125
r14325 n8048 n8049 0.04583333333333333
r14326 n7988 n8050 0.09375
r14327 n8049 n8050 0.087499999999999994
r14328 n8002 n8051 0.09375
r14329 n8003 n8052 0.125
r14330 n8051 n8052 0.087499999999999994
r14331 n8004 n8053 0.5625
r14332 n8052 n8053 0.04583333333333333
r14333 n8005 n8054 0.5625
r14334 n8053 n8054 0.016666666666666666
r14335 n8006 n8055 0.140625
r14336 n8054 n8055 0.041666666666666664
r14337 n8007 n8056 0.05113636363636364
r14338 n8055 n8056 0.125
r14339 n8008 n8057 1.125
r14340 n8056 n8057 0.09583333333333334
r14341 n8009 n8058 1.125
r14342 n8057 n8058 0.0083333333333333332
r14343 n8010 n8059 1.125
r14344 n8058 n8059 0.0083333333333333332
r14345 n8011 n8060 0.1125
r14346 n8059 n8060 0.04583333333333333
r14347 n8012 n8061 0.09375
r14348 n8060 n8061 0.09166666666666666
r14349 n8025 n8062 0.1125
r14350 n8026 n8063 0.05921052631578947
r14351 n8062 n8063 0.12083333333333333
r14352 n8027 n8064 0.28125
r14353 n8063 n8064 0.09583333333333334
r14354 n8028 n8065 0.5625
r14355 n8064 n8065 0.025000000000000001
r14356 n8029 n8066 0.037499999999999999
r14357 n8065 n8066 0.13333333333333333
r14358 n8030 n8067 0.5625
r14359 n8066 n8067 0.13333333333333333
r14360 n8031 n8068 0.28125
r14361 n8067 n8068 0.025000000000000001
r14362 n8032 n8069 0.05921052631578947
r14363 n8068 n8069 0.09583333333333334
r14364 n8033 n8070 0.1125
r14365 n8069 n8070 0.12083333333333333
r14366 n8034 n8071 0.125
r14367 n8035 n8072 0.05434782608695652
r14368 n8071 n8072 0.41249999999999998
r14369 n8036 n8073 0.625
r14370 n8072 n8073 0.3125
r14371 n8037 n8074 0.041666666666666664
r14372 n8073 n8074 0.40000000000000002
r14373 n8038 n8075 0.625
r14374 n8074 n8075 0.40000000000000002
r14375 n8039 n8076 0.05434782608695652
r14376 n8075 n8076 0.3125
r14377 n8040 n8077 0.125
r14378 n8076 n8077 0.41249999999999998
r14379 n8041 n8078 0.10416666666666667
r14380 n8042 n8079 0.17857142857142858
r14381 n8078 n8079 0.23749999999999999
r14382 n8043 n8080 0.625
r14383 n8079 n8080 0.1125
r14384 n8044 n8081 0.3125
r14385 n8080 n8081 0.074999999999999997
r14386 n8045 n8082 0.1388888888888889
r14387 n8081 n8082 0.16250000000000001
r14388 n8046 n8083 0.059523809523809521
r14389 n8082 n8083 0.375
r14390 n8047 n8084 0.625
r14391 n8083 n8084 0.28749999999999998
r14392 n8048 n8085 0.625
r14393 n8084 n8085 0.050000000000000003
r14394 n8049 n8086 0.1388888888888889
r14395 n8085 n8086 0.13750000000000001
r14396 n8050 n8087 0.10416666666666667
r14397 n8086 n8087 0.26250000000000001
r14398 n8051 n8088 0.10416666666666667
r14399 n8052 n8089 0.1388888888888889
r14400 n8088 n8089 0.26250000000000001
r14401 n8053 n8090 0.625
r14402 n8089 n8090 0.13750000000000001
r14403 n8054 n8091 0.625
r14404 n8090 n8091 0.050000000000000003
r14405 n8055 n8092 0.15625
r14406 n8091 n8092 0.125
r14407 n8056 n8093 0.056818181818181816
r14408 n8092 n8093 0.375
r14409 n8057 n8094 1.25
r14410 n8093 n8094 0.28749999999999998
r14411 n8058 n8095 1.25
r14412 n8094 n8095 0.025000000000000001
r14413 n8059 n8096 1.25
r14414 n8095 n8096 0.025000000000000001
r14415 n8060 n8097 0.125
r14416 n8096 n8097 0.13750000000000001
r14417 n8061 n8098 0.10416666666666667
r14418 n8097 n8098 0.27500000000000002
r14419 n8062 n8099 0.125
r14420 n8063 n8100 0.065789473684210523
r14421 n8099 n8100 0.36249999999999999
r14422 n8064 n8101 0.3125
r14423 n8100 n8101 0.28749999999999998
r14424 n8065 n8102 0.625
r14425 n8101 n8102 0.074999999999999997
r14426 n8066 n8103 0.041666666666666664
r14427 n8102 n8103 0.40000000000000002
r14428 n8067 n8104 0.625
r14429 n8103 n8104 0.40000000000000002
r14430 n8068 n8105 0.3125
r14431 n8104 n8105 0.074999999999999997
r14432 n8069 n8106 0.065789473684210523
r14433 n8105 n8106 0.28749999999999998
r14434 n8070 n8107 0.125
r14435 n8106 n8107 0.36249999999999999
r14436 n8071 n8108 0.043749999999999997
r14437 n8072 n8109 0.019021739130434784
r14438 n8108 n8109 1.03125
r14439 n8073 n8110 0.21875
r14440 n8109 n8110 0.78125
r14441 n8074 n8111 0.014583333333333334
r14442 n8110 n8111 1
r14443 n8075 n8112 0.21875
r14444 n8111 n8112 1
r14445 n8076 n8113 0.019021739130434784
r14446 n8112 n8113 0.78125
r14447 n8077 n8114 0.043749999999999997
r14448 n8113 n8114 1.03125
r14449 n8078 n8115 0.036458333333333336
r14450 n8079 n8116 0.0625
r14451 n8115 n8116 0.59375
r14452 n8080 n8117 0.21875
r14453 n8116 n8117 0.28125
r14454 n8081 n8118 0.109375
r14455 n8117 n8118 0.1875
r14456 n8082 n8119 0.048611111111111112
r14457 n8118 n8119 0.40625
r14458 n8083 n8120 0.020833333333333332
r14459 n8119 n8120 0.9375
r14460 n8084 n8121 0.21875
r14461 n8120 n8121 0.71875
r14462 n8085 n8122 0.21875
r14463 n8121 n8122 0.125
r14464 n8086 n8123 0.048611111111111112
r14465 n8122 n8123 0.34375
r14466 n8087 n8124 0.036458333333333336
r14467 n8123 n8124 0.65625
r14468 n8088 n8125 0.036458333333333336
r14469 n8089 n8126 0.048611111111111112
r14470 n8125 n8126 0.65625
r14471 n8090 n8127 0.21875
r14472 n8126 n8127 0.34375
r14473 n8091 n8128 0.21875
r14474 n8127 n8128 0.125
r14475 n8092 n8129 0.0546875
r14476 n8128 n8129 0.3125
r14477 n8093 n8130 0.019886363636363636
r14478 n8129 n8130 0.9375
r14479 n8094 n8131 0.4375
r14480 n8130 n8131 0.71875
r14481 n8095 n8132 0.4375
r14482 n8131 n8132 0.0625
r14483 n8096 n8133 0.4375
r14484 n8132 n8133 0.0625
r14485 n8097 n8134 0.043749999999999997
r14486 n8133 n8134 0.34375
r14487 n8098 n8135 0.036458333333333336
r14488 n8134 n8135 0.6875
r14489 n8099 n8136 0.043749999999999997
r14490 n8100 n8137 0.023026315789473683
r14491 n8136 n8137 0.90625
r14492 n8101 n8138 0.109375
r14493 n8137 n8138 0.71875
r14494 n8102 n8139 0.21875
r14495 n8138 n8139 0.1875
r14496 n8103 n8140 0.014583333333333334
r14497 n8139 n8140 1
r14498 n8104 n8141 0.21875
r14499 n8140 n8141 1
r14500 n8105 n8142 0.109375
r14501 n8141 n8142 0.1875
r14502 n8106 n8143 0.023026315789473683
r14503 n8142 n8143 0.71875
r14504 n8107 n8144 0.043749999999999997
r14505 n8143 n8144 0.90625
r14506 n8108 n8145 0.050000000000000003
r14507 n8109 n8146 0.021739130434782608
r14508 n8145 n8146 0.34375
r14509 n8110 n8147 0.25
r14510 n8146 n8147 0.26041666666666669
r14511 n8111 n8148 0.016666666666666666
r14512 n8147 n8148 0.33333333333333331
r14513 n8112 n8149 0.25
r14514 n8148 n8149 0.33333333333333331
r14515 n8113 n8150 0.021739130434782608
r14516 n8149 n8150 0.26041666666666669
r14517 n8114 n8151 0.050000000000000003
r14518 n8150 n8151 0.34375
r14519 n8115 n8152 0.041666666666666664
r14520 n8116 n8153 0.071428571428571425
r14521 n8152 n8153 0.19791666666666666
r14522 n8117 n8154 0.25
r14523 n8153 n8154 0.09375
r14524 n8118 n8155 0.125
r14525 n8154 n8155 0.0625
r14526 n8119 n8156 0.055555555555555552
r14527 n8155 n8156 0.13541666666666666
r14528 n8120 n8157 0.023809523809523808
r14529 n8156 n8157 0.3125
r14530 n8121 n8158 0.25
r14531 n8157 n8158 0.23958333333333334
r14532 n8122 n8159 0.25
r14533 n8158 n8159 0.041666666666666664
r14534 n8123 n8160 0.055555555555555552
r14535 n8159 n8160 0.11458333333333333
r14536 n8124 n8161 0.041666666666666664
r14537 n8160 n8161 0.21875
r14538 n8125 n8162 0.041666666666666664
r14539 n8126 n8163 0.055555555555555552
r14540 n8162 n8163 0.21875
r14541 n8127 n8164 0.25
r14542 n8163 n8164 0.11458333333333333
r14543 n8128 n8165 0.25
r14544 n8164 n8165 0.041666666666666664
r14545 n8129 n8166 0.0625
r14546 n8165 n8166 0.10416666666666667
r14547 n8130 n8167 0.022727272727272728
r14548 n8166 n8167 0.3125
r14549 n8131 n8168 0.5
r14550 n8167 n8168 0.23958333333333334
r14551 n8132 n8169 0.5
r14552 n8168 n8169 0.020833333333333332
r14553 n8133 n8170 0.5
r14554 n8169 n8170 0.020833333333333332
r14555 n8134 n8171 0.050000000000000003
r14556 n8170 n8171 0.11458333333333333
r14557 n8135 n8172 0.041666666666666664
r14558 n8171 n8172 0.22916666666666666
r14559 n8136 n8173 0.050000000000000003
r14560 n8137 n8174 0.026315789473684209
r14561 n8173 n8174 0.30208333333333331
r14562 n8138 n8175 0.125
r14563 n8174 n8175 0.23958333333333334
r14564 n8139 n8176 0.25
r14565 n8175 n8176 0.0625
r14566 n8140 n8177 0.016666666666666666
r14567 n8176 n8177 0.33333333333333331
r14568 n8141 n8178 0.25
r14569 n8177 n8178 0.33333333333333331
r14570 n8142 n8179 0.125
r14571 n8178 n8179 0.0625
r14572 n8143 n8180 0.026315789473684209
r14573 n8179 n8180 0.23958333333333334
r14574 n8144 n8181 0.050000000000000003
r14575 n8180 n8181 0.30208333333333331
r14576 n8145 n8182 0.081250000000000003
r14577 n8146 n8183 0.035326086956521736
r14578 n8182 n8183 0.29464285714285715
r14579 n8147 n8184 0.40625
r14580 n8183 n8184 0.22321428571428573
r14581 n8148 n8185 0.027083333333333334
r14582 n8184 n8185 0.2857142857142857
r14583 n8149 n8186 0.40625
r14584 n8185 n8186 0.2857142857142857
r14585 n8150 n8187 0.035326086956521736
r14586 n8186 n8187 0.22321428571428573
r14587 n8151 n8188 0.081250000000000003
r14588 n8187 n8188 0.29464285714285715
r14589 n8152 n8189 0.067708333333333329
r14590 n8153 n8190 0.11607142857142858
r14591 n8189 n8190 0.16964285714285715
r14592 n8154 n8191 0.40625
r14593 n8190 n8191 0.080357142857142863
r14594 n8155 n8192 0.203125
r14595 n8191 n8192 0.053571428571428568
r14596 n8156 n8193 0.090277777777777776
r14597 n8192 n8193 0.11607142857142858
r14598 n8157 n8194 0.038690476190476192
r14599 n8193 n8194 0.26785714285714285
r14600 n8158 n8195 0.40625
r14601 n8194 n8195 0.20535714285714285
r14602 n8159 n8196 0.40625
r14603 n8195 n8196 0.035714285714285712
r14604 n8160 n8197 0.090277777777777776
r14605 n8196 n8197 0.098214285714285712
r14606 n8161 n8198 0.067708333333333329
r14607 n8197 n8198 0.1875
r14608 n8162 n8199 0.067708333333333329
r14609 n8163 n8200 0.090277777777777776
r14610 n8199 n8200 0.1875
r14611 n8164 n8201 0.40625
r14612 n8200 n8201 0.098214285714285712
r14613 n8165 n8202 0.40625
r14614 n8201 n8202 0.035714285714285712
r14615 n8166 n8203 0.1015625
r14616 n8202 n8203 0.089285714285714288
r14617 n8167 n8204 0.036931818181818184
r14618 n8203 n8204 0.26785714285714285
r14619 n8168 n8205 0.8125
r14620 n8204 n8205 0.20535714285714285
r14621 n8169 n8206 0.8125
r14622 n8205 n8206 0.017857142857142856
r14623 n8170 n8207 0.8125
r14624 n8206 n8207 0.017857142857142856
r14625 n8171 n8208 0.081250000000000003
r14626 n8207 n8208 0.098214285714285712
r14627 n8172 n8209 0.067708333333333329
r14628 n8208 n8209 0.19642857142857142
r14629 n8173 n8210 0.081250000000000003
r14630 n8174 n8211 0.042763157894736843
r14631 n8210 n8211 0.25892857142857145
r14632 n8175 n8212 0.203125
r14633 n8211 n8212 0.20535714285714285
r14634 n8176 n8213 0.40625
r14635 n8212 n8213 0.053571428571428568
r14636 n8177 n8214 0.027083333333333334
r14637 n8213 n8214 0.2857142857142857
r14638 n8178 n8215 0.40625
r14639 n8214 n8215 0.2857142857142857
r14640 n8179 n8216 0.203125
r14641 n8215 n8216 0.053571428571428568
r14642 n8180 n8217 0.042763157894736843
r14643 n8216 n8217 0.20535714285714285
r14644 n8181 n8218 0.081250000000000003
r14645 n8217 n8218 0.25892857142857145
r14646 n8182 n8219 0.13125000000000001
r14647 n8183 n8220 0.057065217391304345
r14648 n8219 n8220 0.14732142857142858
r14649 n8184 n8221 0.65625
r14650 n8220 n8221 0.11160714285714286
r14651 n8185 n8222 0.043749999999999997
r14652 n8221 n8222 0.14285714285714285
r14653 n8186 n8223 0.65625
r14654 n8222 n8223 0.14285714285714285
r14655 n8187 n8224 0.057065217391304345
r14656 n8223 n8224 0.11160714285714286
r14657 n8188 n8225 0.13125000000000001
r14658 n8224 n8225 0.14732142857142858
r14659 n8190 n8226 0.1875
r14660 n8191 n8227 0.65625
r14661 n8226 n8227 0.040178571428571432
r14662 n8192 n8228 0.328125
r14663 n8227 n8228 0.026785714285714284
r14664 n8193 n8229 0.14583333333333334
r14665 n8228 n8229 0.058035714285714288
r14666 n8194 n8230 0.0625
r14667 n8229 n8230 0.13392857142857142
r14668 n8195 n8231 0.65625
r14669 n8230 n8231 0.10267857142857142
r14670 n8196 n8232 0.65625
r14671 n8231 n8232 0.017857142857142856
r14672 n8197 n8233 0.14583333333333334
r14673 n8232 n8233 0.049107142857142856
r14674 n8200 n8234 0.14583333333333334
r14675 n8201 n8235 0.65625
r14676 n8234 n8235 0.049107142857142856
r14677 n8202 n8236 0.65625
r14678 n8235 n8236 0.017857142857142856
r14679 n8203 n8237 0.1640625
r14680 n8236 n8237 0.044642857142857144
r14681 n8204 n8238 0.059659090909090912
r14682 n8237 n8238 0.13392857142857142
r14683 n8205 n8239 1.3125
r14684 n8238 n8239 0.10267857142857142
r14685 n8206 n8240 1.3125
r14686 n8239 n8240 0.0089285714285714281
r14687 n8207 n8241 1.3125
r14688 n8240 n8241 0.0089285714285714281
r14689 n8208 n8242 0.13125000000000001
r14690 n8241 n8242 0.049107142857142856
r14691 n8210 n8243 0.13125000000000001
r14692 n8211 n8244 0.069078947368421059
r14693 n8243 n8244 0.12946428571428573
r14694 n8212 n8245 0.328125
r14695 n8244 n8245 0.10267857142857142
r14696 n8213 n8246 0.65625
r14697 n8245 n8246 0.026785714285714284
r14698 n8214 n8247 0.043749999999999997
r14699 n8246 n8247 0.14285714285714285
r14700 n8215 n8248 0.65625
r14701 n8247 n8248 0.14285714285714285
r14702 n8216 n8249 0.328125
r14703 n8248 n8249 0.026785714285714284
r14704 n8217 n8250 0.069078947368421059
r14705 n8249 n8250 0.10267857142857142
r14706 n8218 n8251 0.13125000000000001
r14707 n8250 n8251 0.12946428571428573
r14708 n8219 n8252 0.32250000000000001
r14709 n8220 n8253 0.14021739130434782
r14710 n8252 n8253 0.054853723404255317
r14711 n8221 n8254 1.6125
r14712 n8253 n8254 0.041555851063829786
r14713 n8222 n8255 0.1075
r14714 n8254 n8255 0.053191489361702128
r14715 n8223 n8256 1.6125
r14716 n8255 n8256 0.053191489361702128
r14717 n8224 n8257 0.14021739130434782
r14718 n8256 n8257 0.041555851063829786
r14719 n8225 n8258 0.32250000000000001
r14720 n8257 n8258 0.054853723404255317
r14721 n8226 n8259 0.46071428571428569
r14722 n8227 n8260 1.6125
r14723 n8259 n8260 0.014960106382978724
r14724 n8228 n8261 0.80625000000000002
r14725 n8260 n8261 0.0099734042553191495
r14726 n8229 n8262 0.35833333333333334
r14727 n8261 n8262 0.021609042553191491
r14728 n8230 n8263 0.15357142857142858
r14729 n8262 n8263 0.049867021276595744
r14730 n8231 n8264 1.6125
r14731 n8263 n8264 0.038231382978723402
r14732 n8232 n8265 1.6125
r14733 n8264 n8265 0.006648936170212766
r14734 n8233 n8266 0.35833333333333334
r14735 n8265 n8266 0.018284574468085107
r14736 n8234 n8267 0.35833333333333334
r14737 n8235 n8268 1.6125
r14738 n8267 n8268 0.018284574468085107
r14739 n8236 n8269 1.6125
r14740 n8268 n8269 0.006648936170212766
r14741 n8237 n8270 0.40312500000000001
r14742 n8269 n8270 0.016622340425531915
r14743 n8238 n8271 0.14659090909090908
r14744 n8270 n8271 0.049867021276595744
r14745 n8239 n8272 3.2250000000000001
r14746 n8271 n8272 0.038231382978723402
r14747 n8240 n8273 3.2250000000000001
r14748 n8272 n8273 0.003324468085106383
r14749 n8241 n8274 3.2250000000000001
r14750 n8273 n8274 0.003324468085106383
r14751 n8242 n8275 0.32250000000000001
r14752 n8274 n8275 0.018284574468085107
r14753 n8243 n8276 0.32250000000000001
r14754 n8244 n8277 0.16973684210526316
r14755 n8276 n8277 0.048204787234042555
r14756 n8245 n8278 0.80625000000000002
r14757 n8277 n8278 0.038231382978723402
r14758 n8246 n8279 1.6125
r14759 n8278 n8279 0.0099734042553191495
r14760 n8247 n8280 0.1075
r14761 n8279 n8280 0.053191489361702128
r14762 n8248 n8281 1.6125
r14763 n8280 n8281 0.053191489361702128
r14764 n8249 n8282 0.80625000000000002
r14765 n8281 n8282 0.0099734042553191495
r14766 n8250 n8283 0.16973684210526316
r14767 n8282 n8283 0.038231382978723402
r14768 n8251 n8284 0.32250000000000001
r14769 n8283 n8284 0.048204787234042555
r14770 n8252 n8285 0.46875
r14771 n8253 n8286 0.20380434782608695
r14772 n8285 n8286 0.05514705882352941
r14773 n8254 n8287 2.34375
r14774 n8286 n8287 0.041778074866310161
r14775 n8255 n8288 0.15625
r14776 n8287 n8288 0.053475935828877004
r14777 n8256 n8289 2.34375
r14778 n8288 n8289 0.053475935828877004
r14779 n8257 n8290 0.20380434782608695
r14780 n8289 n8290 0.041778074866310161
r14781 n8258 n8291 0.46875
r14782 n8290 n8291 0.05514705882352941
r14783 n8259 n8292 0.6696428571428571
r14784 n8260 n8293 2.34375
r14785 n8292 n8293 0.015040106951871657
r14786 n8261 n8294 1.171875
r14787 n8293 n8294 0.010026737967914439
r14788 n8262 n8295 0.52083333333333337
r14789 n8294 n8295 0.021724598930481284
r14790 n8263 n8296 0.22321428571428573
r14791 n8295 n8296 0.050133689839572192
r14792 n8264 n8297 2.34375
r14793 n8296 n8297 0.038435828877005349
r14794 n8265 n8298 2.34375
r14795 n8297 n8298 0.0066844919786096255
r14796 n8266 n8299 0.52083333333333337
r14797 n8298 n8299 0.018382352941176471
r14798 n8267 n8300 0.52083333333333337
r14799 n8268 n8301 2.34375
r14800 n8300 n8301 0.018382352941176471
r14801 n8269 n8302 2.34375
r14802 n8301 n8302 0.0066844919786096255
r14803 n8270 n8303 0.5859375
r14804 n8302 n8303 0.016711229946524065
r14805 n8271 n8304 0.21306818181818182
r14806 n8303 n8304 0.050133689839572192
r14807 n8272 n8305 4.6875
r14808 n8304 n8305 0.038435828877005349
r14809 n8273 n8306 4.6875
r14810 n8305 n8306 0.0033422459893048127
r14811 n8274 n8307 4.6875
r14812 n8306 n8307 0.0033422459893048127
r14813 n8275 n8308 0.46875
r14814 n8307 n8308 0.018382352941176471
r14815 n8276 n8309 0.46875
r14816 n8277 n8310 0.24671052631578946
r14817 n8309 n8310 0.048462566844919786
r14818 n8278 n8311 1.171875
r14819 n8310 n8311 0.038435828877005349
r14820 n8279 n8312 2.34375
r14821 n8311 n8312 0.010026737967914439
r14822 n8280 n8313 0.15625
r14823 n8312 n8313 0.053475935828877004
r14824 n8281 n8314 2.34375
r14825 n8313 n8314 0.053475935828877004
r14826 n8282 n8315 1.171875
r14827 n8314 n8315 0.010026737967914439
r14828 n8283 n8316 0.24671052631578946
r14829 n8315 n8316 0.038435828877005349
r14830 n8284 n8317 0.46875
r14831 n8316 n8317 0.048462566844919786
r14832 n8285 n8318 0.44624999999999998
r14833 n8286 n8319 0.19402173913043477
r14834 n8318 n8319 0.060661764705882353
r14835 n8287 n8320 2.2312500000000002
r14836 n8319 n8320 0.04595588235294118
r14837 n8288 n8321 0.14874999999999999
r14838 n8320 n8321 0.058823529411764705
r14839 n8289 n8322 2.2312500000000002
r14840 n8321 n8322 0.058823529411764705
r14841 n8290 n8323 0.19402173913043477
r14842 n8322 n8323 0.04595588235294118
r14843 n8291 n8324 0.44624999999999998
r14844 n8323 n8324 0.060661764705882353
r14845 n8292 n8325 0.63749999999999996
r14846 n8293 n8326 2.2312500000000002
r14847 n8325 n8326 0.016544117647058824
r14848 n8294 n8327 1.1156250000000001
r14849 n8326 n8327 0.011029411764705883
r14850 n8295 n8328 0.49583333333333335
r14851 n8327 n8328 0.02389705882352941
r14852 n8296 n8329 0.21249999999999999
r14853 n8328 n8329 0.05514705882352941
r14854 n8297 n8330 2.2312500000000002
r14855 n8329 n8330 0.042279411764705885
r14856 n8298 n8331 2.2312500000000002
r14857 n8330 n8331 0.0073529411764705881
r14858 n8299 n8332 0.49583333333333335
r14859 n8331 n8332 0.020220588235294119
r14860 n8300 n8333 0.49583333333333335
r14861 n8301 n8334 2.2312500000000002
r14862 n8333 n8334 0.020220588235294119
r14863 n8302 n8335 2.2312500000000002
r14864 n8334 n8335 0.0073529411764705881
r14865 n8303 n8336 0.55781250000000004
r14866 n8335 n8336 0.018382352941176471
r14867 n8304 n8337 0.2028409090909091
r14868 n8336 n8337 0.05514705882352941
r14869 n8305 n8338 4.4625000000000004
r14870 n8337 n8338 0.042279411764705885
r14871 n8306 n8339 4.4625000000000004
r14872 n8338 n8339 0.0036764705882352941
r14873 n8307 n8340 4.4625000000000004
r14874 n8339 n8340 0.0036764705882352941
r14875 n8308 n8341 0.44624999999999998
r14876 n8340 n8341 0.020220588235294119
r14877 n8309 n8342 0.44624999999999998
r14878 n8310 n8343 0.23486842105263159
r14879 n8342 n8343 0.053308823529411763
r14880 n8311 n8344 1.1156250000000001
r14881 n8343 n8344 0.042279411764705885
r14882 n8312 n8345 2.2312500000000002
r14883 n8344 n8345 0.011029411764705883
r14884 n8313 n8346 0.14874999999999999
r14885 n8345 n8346 0.058823529411764705
r14886 n8314 n8347 2.2312500000000002
r14887 n8346 n8347 0.058823529411764705
r14888 n8315 n8348 1.1156250000000001
r14889 n8347 n8348 0.011029411764705883
r14890 n8316 n8349 0.23486842105263159
r14891 n8348 n8349 0.042279411764705885
r14892 n8317 n8350 0.44624999999999998
r14893 n8349 n8350 0.053308823529411763
r14894 n8318 n8351 0.46000000000000002
r14895 n8319 n8352 0.20000000000000001
r14896 n8351 n8352 0.052083333333333336
r14897 n8320 n8353 2.2999999999999998
r14898 n8352 n8353 0.039457070707070704
r14899 n8321 n8354 0.15333333333333332
r14900 n8353 n8354 0.050505050505050504
r14901 n8322 n8355 2.2999999999999998
r14902 n8354 n8355 0.050505050505050504
r14903 n8323 n8356 0.20000000000000001
r14904 n8355 n8356 0.039457070707070704
r14905 n8324 n8357 0.46000000000000002
r14906 n8356 n8357 0.052083333333333336
r14907 n8325 n8358 0.65714285714285714
r14908 n8326 n8359 2.2999999999999998
r14909 n8358 n8359 0.014204545454545454
r14910 n8327 n8360 1.1499999999999999
r14911 n8359 n8360 0.00946969696969697
r14912 n8328 n8361 0.51111111111111107
r14913 n8360 n8361 0.020517676767676768
r14914 n8329 n8362 0.21904761904761905
r14915 n8361 n8362 0.047348484848484848
r14916 n8330 n8363 2.2999999999999998
r14917 n8362 n8363 0.036300505050505048
r14918 n8331 n8364 2.2999999999999998
r14919 n8363 n8364 0.006313131313131313
r14920 n8332 n8365 0.51111111111111107
r14921 n8364 n8365 0.017361111111111112
r14922 n8333 n8366 0.51111111111111107
r14923 n8334 n8367 2.2999999999999998
r14924 n8366 n8367 0.017361111111111112
r14925 n8335 n8368 2.2999999999999998
r14926 n8367 n8368 0.006313131313131313
r14927 n8336 n8369 0.57499999999999996
r14928 n8368 n8369 0.015782828282828284
r14929 n8337 n8370 0.20909090909090908
r14930 n8369 n8370 0.047348484848484848
r14931 n8338 n8371 4.5999999999999996
r14932 n8370 n8371 0.036300505050505048
r14933 n8339 n8372 4.5999999999999996
r14934 n8371 n8372 0.0031565656565656565
r14935 n8340 n8373 4.5999999999999996
r14936 n8372 n8373 0.0031565656565656565
r14937 n8341 n8374 0.46000000000000002
r14938 n8373 n8374 0.017361111111111112
r14939 n8342 n8375 0.46000000000000002
r14940 n8343 n8376 0.24210526315789474
r14941 n8375 n8376 0.045770202020202023
r14942 n8344 n8377 1.1499999999999999
r14943 n8376 n8377 0.036300505050505048
r14944 n8345 n8378 2.2999999999999998
r14945 n8377 n8378 0.00946969696969697
r14946 n8346 n8379 0.15333333333333332
r14947 n8378 n8379 0.050505050505050504
r14948 n8347 n8380 2.2999999999999998
r14949 n8379 n8380 0.050505050505050504
r14950 n8348 n8381 1.1499999999999999
r14951 n8380 n8381 0.00946969696969697
r14952 n8349 n8382 0.24210526315789474
r14953 n8381 n8382 0.036300505050505048
r14954 n8350 n8383 0.46000000000000002
r14955 n8382 n8383 0.045770202020202023
r14956 n8351 n8384 0.49625000000000002
r14957 n8352 n8385 0.21576086956521739
r14958 n8384 n8385 0.051821608040201007
r14959 n8353 n8386 2.4812500000000002
r14960 n8385 n8386 0.03925879396984925
r14961 n8354 n8387 0.16541666666666666
r14962 n8386 n8387 0.050251256281407038
r14963 n8355 n8388 2.4812500000000002
r14964 n8387 n8388 0.050251256281407038
r14965 n8356 n8389 0.21576086956521739
r14966 n8388 n8389 0.03925879396984925
r14967 n8357 n8390 0.49625000000000002
r14968 n8389 n8390 0.051821608040201007
r14969 n8358 n8391 0.70892857142857146
r14970 n8359 n8392 2.4812500000000002
r14971 n8391 n8392 0.014133165829145729
r14972 n8360 n8393 1.2406250000000001
r14973 n8392 n8393 0.0094221105527638183
r14974 n8361 n8394 0.55138888888888893
r14975 n8393 n8394 0.02041457286432161
r14976 n8362 n8395 0.2363095238095238
r14977 n8394 n8395 0.047110552763819098
r14978 n8363 n8396 2.4812500000000002
r14979 n8395 n8396 0.036118090452261303
r14980 n8364 n8397 2.4812500000000002
r14981 n8396 n8397 0.0062814070351758797
r14982 n8365 n8398 0.55138888888888893
r14983 n8397 n8398 0.017273869346733667
r14984 n8366 n8399 0.55138888888888893
r14985 n8367 n8400 2.4812500000000002
r14986 n8399 n8400 0.017273869346733667
r14987 n8368 n8401 2.4812500000000002
r14988 n8400 n8401 0.0062814070351758797
r14989 n8369 n8402 0.62031250000000004
r14990 n8401 n8402 0.015703517587939697
r14991 n8370 n8403 0.22556818181818181
r14992 n8402 n8403 0.047110552763819098
r14993 n8371 n8404 4.9625000000000004
r14994 n8403 n8404 0.036118090452261303
r14995 n8372 n8405 4.9625000000000004
r14996 n8404 n8405 0.0031407035175879399
r14997 n8373 n8406 4.9625000000000004
r14998 n8405 n8406 0.0031407035175879399
r14999 n8374 n8407 0.49625000000000002
r15000 n8406 n8407 0.017273869346733667
r15001 n8375 n8408 0.49625000000000002
r15002 n8376 n8409 0.2611842105263158
r15003 n8408 n8409 0.045540201005025129
r15004 n8377 n8410 1.2406250000000001
r15005 n8409 n8410 0.036118090452261303
r15006 n8378 n8411 2.4812500000000002
r15007 n8410 n8411 0.0094221105527638183
r15008 n8379 n8412 0.16541666666666666
r15009 n8411 n8412 0.050251256281407038
r15010 n8380 n8413 2.4812500000000002
r15011 n8412 n8413 0.050251256281407038
r15012 n8381 n8414 1.2406250000000001
r15013 n8413 n8414 0.0094221105527638183
r15014 n8382 n8415 0.2611842105263158
r15015 n8414 n8415 0.036118090452261303
r15016 n8383 n8416 0.49625000000000002
r15017 n8415 n8416 0.045540201005025129
r15018 n8384 n8417 0.49625000000000002
r15019 n8385 n8418 0.21576086956521739
r15020 n8417 n8418 0.052083333333333336
r15021 n8386 n8419 2.4812500000000002
r15022 n8418 n8419 0.039457070707070704
r15023 n8387 n8420 0.16541666666666666
r15024 n8419 n8420 0.050505050505050504
r15025 n8388 n8421 2.4812500000000002
r15026 n8420 n8421 0.050505050505050504
r15027 n8389 n8422 0.21576086956521739
r15028 n8421 n8422 0.039457070707070704
r15029 n8390 n8423 0.49625000000000002
r15030 n8422 n8423 0.052083333333333336
r15031 n8391 n8424 0.70892857142857146
r15032 n8392 n8425 2.4812500000000002
r15033 n8424 n8425 0.014204545454545454
r15034 n8393 n8426 1.2406250000000001
r15035 n8425 n8426 0.00946969696969697
r15036 n8394 n8427 0.55138888888888893
r15037 n8426 n8427 0.020517676767676768
r15038 n8395 n8428 0.2363095238095238
r15039 n8427 n8428 0.047348484848484848
r15040 n8396 n8429 2.4812500000000002
r15041 n8428 n8429 0.036300505050505048
r15042 n8397 n8430 2.4812500000000002
r15043 n8429 n8430 0.006313131313131313
r15044 n8398 n8431 0.55138888888888893
r15045 n8430 n8431 0.017361111111111112
r15046 n8399 n8432 0.55138888888888893
r15047 n8400 n8433 2.4812500000000002
r15048 n8432 n8433 0.017361111111111112
r15049 n8401 n8434 2.4812500000000002
r15050 n8433 n8434 0.006313131313131313
r15051 n8402 n8435 0.62031250000000004
r15052 n8434 n8435 0.015782828282828284
r15053 n8403 n8436 0.22556818181818181
r15054 n8435 n8436 0.047348484848484848
r15055 n8404 n8437 4.9625000000000004
r15056 n8436 n8437 0.036300505050505048
r15057 n8405 n8438 4.9625000000000004
r15058 n8437 n8438 0.0031565656565656565
r15059 n8406 n8439 4.9625000000000004
r15060 n8438 n8439 0.0031565656565656565
r15061 n8407 n8440 0.49625000000000002
r15062 n8439 n8440 0.017361111111111112
r15063 n8408 n8441 0.49625000000000002
r15064 n8409 n8442 0.2611842105263158
r15065 n8441 n8442 0.045770202020202023
r15066 n8410 n8443 1.2406250000000001
r15067 n8442 n8443 0.036300505050505048
r15068 n8411 n8444 2.4812500000000002
r15069 n8443 n8444 0.00946969696969697
r15070 n8412 n8445 0.16541666666666666
r15071 n8444 n8445 0.050505050505050504
r15072 n8413 n8446 2.4812500000000002
r15073 n8445 n8446 0.050505050505050504
r15074 n8414 n8447 1.2406250000000001
r15075 n8446 n8447 0.00946969696969697
r15076 n8415 n8448 0.2611842105263158
r15077 n8447 n8448 0.036300505050505048
r15078 n8416 n8449 0.49625000000000002
r15079 n8448 n8449 0.045770202020202023
r15080 n8417 n8450 0.42249999999999999
r15081 n8418 n8451 0.18369565217391304
r15082 n8450 n8451 0.073660714285714288
r15083 n8419 n8452 2.1124999999999998
r15084 n8451 n8452 0.055803571428571432
r15085 n8420 n8453 0.14083333333333334
r15086 n8452 n8453 0.071428571428571425
r15087 n8421 n8454 2.1124999999999998
r15088 n8453 n8454 0.071428571428571425
r15089 n8422 n8455 0.18369565217391304
r15090 n8454 n8455 0.055803571428571432
r15091 n8423 n8456 0.42249999999999999
r15092 n8455 n8456 0.073660714285714288
r15093 n8424 n8457 0.60357142857142854
r15094 n8425 n8458 2.1124999999999998
r15095 n8457 n8458 0.020089285714285716
r15096 n8426 n8459 1.0562499999999999
r15097 n8458 n8459 0.013392857142857142
r15098 n8427 n8460 0.46944444444444444
r15099 n8459 n8460 0.029017857142857144
r15100 n8428 n8461 0.2011904761904762
r15101 n8460 n8461 0.066964285714285712
r15102 n8429 n8462 2.1124999999999998
r15103 n8461 n8462 0.051339285714285712
r15104 n8430 n8463 2.1124999999999998
r15105 n8462 n8463 0.0089285714285714281
r15106 n8431 n8464 0.46944444444444444
r15107 n8463 n8464 0.024553571428571428
r15108 n8464 n8465 0.046875
r15109 n8465 n8466 0.046875
r15110 n8466 n8467 0.024553571428571428
r15111 n8467 n8468 0.0089285714285714281
r15112 n8468 n8469 0.051339285714285712
r15113 n8469 n8470 0.080357142857142863
r15114 n8470 n8471 0.037946428571428568
r15115 n8471 n8472 0.075892857142857137
r15116 n8472 n8473 0.075892857142857137
r15117 n8473 n8474 0.03125
r15118 n8474 n8475 0.035714285714285712
r15119 n8475 n8476 0.053571428571428568
r15120 n8476 n8477 0.12053571428571429
r15121 n8477 n8478 0.087053571428571425
r15122 n8478 n8479 0.033482142857142856
r15123 n8479 n8480 0.037946428571428568
r15124 n8480 n8481 0.022321428571428572
r15125 n8481 n8482 0.013392857142857142
r15126 n8482 n8483 0.011160714285714286
r15127 n8483 n8484 0.022321428571428572
r15128 n8484 n8485 0.066964285714285712
r15129 n8485 n8486 0.053571428571428568
r15130 n8486 n8487 0.011160714285714286
r15131 n8487 n8488 0.013392857142857142
r15132 n8488 n8489 0.015625
r15133 n8489 n8490 0.015625
r15134 n8490 n8491 0.029017857142857144
r15135 n8491 n8492 0.13169642857142858
r15136 n8492 n8493 0.18526785714285715
r15137 n8493 n8494 0.17053571428571429
r15138 n8494 n8495 0.18973214285714285
r15139 n8495 n8496 0.19017857142857142
r15140 n8496 n8497 0.18973214285714285
r15141 n8497 n8498 0.16160714285714287
r15142 n8498 n8499 0.13392857142857142
r15143 n8499 n8500 0.13392857142857142
r15144 n8500 n8501 0.13392857142857142
r15145 n8501 n8502 0.15625
r15146 n8502 n8503 0.17857142857142858
r15147 n8503 n8504 0.16071428571428573
r15148 n8504 n8505 0.13392857142857142
r15149 n8505 n8506 0.125
r15150 n8506 n8507 0.13392857142857142
r15151 n8507 n8508 0.12946428571428573
r15152 n8508 n8509 0.11607142857142858
r15153 n8509 n8510 0.13392857142857142
r15154 n8510 n8511 0.14285714285714285
r15155 n8511 n8512 0.13392857142857142
r15156 n8512 n8513 0.14285714285714285
r15157 n8513 n8514 0.12946428571428573
r15158 n8514 n8515 0.0625
r15159 n8515 n8516 0.03125
r15160 n8516 n8517 0.026785714285714284
r15161 n8517 n8518 0.075892857142857137
r15162 n8518 n8519 0.075892857142857137
r15163 n8519 n8520 0.084821428571428575
r15164 n8520 n8521 0.084821428571428575
r15165 n8521 n8522 0.075892857142857137
r15166 n8522 n8523 0.075892857142857137
r15167 n8523 n8524 0.084821428571428575
r15168 n8524 n8525 0.084821428571428575
r15169 n8525 n8526 0.075892857142857137
r15170 n8526 n8527 0.075892857142857137
r15171 n8527 n8528 0.084821428571428575
r15172 n8528 n8529 0.084821428571428575
r15173 n8529 n8530 0.075892857142857137
r15174 n8530 n8531 0.075892857142857137
r15175 n8531 n8532 0.084821428571428575
r15176 n8532 n8533 0.084821428571428575
r15177 n8533 n8534 0.075892857142857137
r15178 n8534 n8535 0.075892857142857137
r15179 n8535 n8536 0.084821428571428575
r15180 n8536 n8537 0.084821428571428575
r15181 n8537 n8538 0.075892857142857137
r15182 n8538 n8539 0.075892857142857137
r15183 n8539 n8540 0.084821428571428575
r15184 n8540 n8541 0.084821428571428575
r15185 n8541 n8542 0.075892857142857137
r15186 n8542 n8543 0.075892857142857137
r15187 n8543 n8544 0.084821428571428575
r15188 n8544 n8545 0.084821428571428575
r15189 n8545 n8546 0.075892857142857137
r15190 n8546 n8547 0.075892857142857137
r15191 n8547 n8548 0.037946428571428568
r15192 n8548 n8549 0.060267857142857144
r15193 n8432 n8550 0.46944444444444444
r15194 n8549 n8550 0.046875
r15195 n8433 n8551 2.1124999999999998
r15196 n8550 n8551 0.024553571428571428
r15197 n8434 n8552 2.1124999999999998
r15198 n8551 n8552 0.0089285714285714281
r15199 n8435 n8553 0.52812499999999996
r15200 n8552 n8553 0.022321428571428572
r15201 n8436 n8554 0.19204545454545455
r15202 n8553 n8554 0.066964285714285712
r15203 n8437 n8555 4.2249999999999996
r15204 n8554 n8555 0.051339285714285712
r15205 n8438 n8556 4.2249999999999996
r15206 n8555 n8556 0.004464285714285714
r15207 n8439 n8557 4.2249999999999996
r15208 n8556 n8557 0.004464285714285714
r15209 n8440 n8558 0.42249999999999999
r15210 n8557 n8558 0.024553571428571428
r15211 n8441 n8559 0.42249999999999999
r15212 n8442 n8560 0.22236842105263158
r15213 n8559 n8560 0.064732142857142863
r15214 n8443 n8561 1.0562499999999999
r15215 n8560 n8561 0.051339285714285712
r15216 n8444 n8562 2.1124999999999998
r15217 n8561 n8562 0.013392857142857142
r15218 n8445 n8563 0.14083333333333334
r15219 n8562 n8563 0.071428571428571425
r15220 n8446 n8564 2.1124999999999998
r15221 n8563 n8564 0.071428571428571425
r15222 n8447 n8565 1.0562499999999999
r15223 n8564 n8565 0.013392857142857142
r15224 n8448 n8566 0.22236842105263158
r15225 n8565 n8566 0.051339285714285712
r15226 n8449 n8567 0.42249999999999999
r15227 n8566 n8567 0.064732142857142863
r15228 n8450 n8568 0.34999999999999998
r15229 n8451 n8569 0.15217391304347827
r15230 n8568 n8569 0.073660714285714288
r15231 n8452 n8570 1.75
r15232 n8569 n8570 0.055803571428571432
r15233 n8453 n8571 0.11666666666666667
r15234 n8570 n8571 0.071428571428571425
r15235 n8454 n8572 1.75
r15236 n8571 n8572 0.071428571428571425
r15237 n8455 n8573 0.15217391304347827
r15238 n8572 n8573 0.055803571428571432
r15239 n8456 n8574 0.34999999999999998
r15240 n8573 n8574 0.073660714285714288
r15241 n8457 n8575 0.5
r15242 n8458 n8576 1.75
r15243 n8575 n8576 0.020089285714285716
r15244 n8459 n8577 0.875
r15245 n8576 n8577 0.013392857142857142
r15246 n8460 n8578 0.3888888888888889
r15247 n8577 n8578 0.029017857142857144
r15248 n8461 n8579 0.16666666666666666
r15249 n8578 n8579 0.066964285714285712
r15250 n8462 n8580 1.75
r15251 n8579 n8580 0.051339285714285712
r15252 n8463 n8581 1.75
r15253 n8580 n8581 0.0089285714285714281
r15254 n8464 n8582 0.3888888888888889
r15255 n8581 n8582 0.024553571428571428
r15256 n8465 n8583 0.29166666666666669
r15257 n8582 n8583 0.046875
r15258 n8466 n8584 0.3888888888888889
r15259 n8583 n8584 0.046875
r15260 n8467 n8585 1.75
r15261 n8584 n8585 0.024553571428571428
r15262 n8468 n8586 1.75
r15263 n8585 n8586 0.0089285714285714281
r15264 n8469 n8587 0.16666666666666666
r15265 n8586 n8587 0.051339285714285712
r15266 n8470 n8588 0.23333333333333334
r15267 n8587 n8588 0.080357142857142863
r15268 n8471 n8589 1.75
r15269 n8588 n8589 0.037946428571428568
r15270 n8472 n8590 0.109375
r15271 n8589 n8590 0.075892857142857137
r15272 n8473 n8591 1.75
r15273 n8590 n8591 0.075892857142857137
r15274 n8474 n8592 0.29166666666666669
r15275 n8591 n8592 0.03125
r15276 n8475 n8593 0.875
r15277 n8592 n8593 0.035714285714285712
r15278 n8476 n8594 0.17499999999999999
r15279 n8593 n8594 0.053571428571428568
r15280 n8477 n8595 0.10294117647058823
r15281 n8594 n8595 0.12053571428571429
r15282 n8478 n8596 0.69999999999999996
r15283 n8595 n8596 0.087053571428571425
r15284 n8479 n8597 0.34999999999999998
r15285 n8596 n8597 0.033482142857142856
r15286 n8480 n8598 0.5
r15287 n8597 n8598 0.037946428571428568
r15288 n8481 n8599 1.1666666666666667
r15289 n8598 n8599 0.022321428571428572
r15290 n8482 n8600 1.1666666666666667
r15291 n8599 n8600 0.013392857142857142
r15292 n8483 n8601 1.75
r15293 n8600 n8601 0.011160714285714286
r15294 n8484 n8602 0.4375
r15295 n8601 n8602 0.022321428571428572
r15296 n8485 n8603 0.15909090909090909
r15297 n8602 n8603 0.066964285714285712
r15298 n8486 n8604 1.75
r15299 n8603 n8604 0.053571428571428568
r15300 n8487 n8605 1.1666666666666667
r15301 n8604 n8605 0.011160714285714286
r15302 n8488 n8606 1.1666666666666667
r15303 n8605 n8606 0.013392857142857142
r15304 n8489 n8607 0.875
r15305 n8606 n8607 0.015625
r15306 n8490 n8608 1.1666666666666667
r15307 n8607 n8608 0.015625
r15308 n8491 n8609 0.34999999999999998
r15309 n8608 n8609 0.029017857142857144
r15310 n8492 n8610 0.071428571428571425
r15311 n8609 n8610 0.13169642857142858
r15312 n8493 n8611 0.10294117647058823
r15313 n8610 n8611 0.18526785714285715
r15314 n8494 n8612 0.08254716981132075
r15315 n8611 n8612 0.17053571428571429
r15316 n8495 n8613 0.082159624413145546
r15317 n8612 n8613 0.18973214285714285
r15318 n8496 n8614 0.082159624413145546
r15319 n8613 n8614 0.19017857142857142
r15320 n8497 n8615 0.08254716981132075
r15321 n8614 n8615 0.18973214285714285
r15322 n8498 n8616 0.11666666666666667
r15323 n8615 n8616 0.16160714285714287
r15324 n8499 n8617 0.11666666666666667
r15325 n8616 n8617 0.13392857142857142
r15326 n8500 n8618 0.11666666666666667
r15327 n8617 n8618 0.13392857142857142
r15328 n8501 n8619 0.11666666666666667
r15329 n8618 n8619 0.13392857142857142
r15330 n8502 n8620 0.087499999999999994
r15331 n8619 n8620 0.15625
r15332 n8503 n8621 0.087499999999999994
r15333 n8620 n8621 0.17857142857142858
r15334 n8504 n8622 0.109375
r15335 n8621 n8622 0.16071428571428573
r15336 n8505 n8623 0.125
r15337 n8622 n8623 0.13392857142857142
r15338 n8506 n8624 0.125
r15339 n8623 n8624 0.125
r15340 n8507 n8625 0.109375
r15341 n8624 n8625 0.13392857142857142
r15342 n8508 n8626 0.13461538461538461
r15343 n8625 n8626 0.12946428571428573
r15344 n8509 n8627 0.13461538461538461
r15345 n8626 n8627 0.11607142857142858
r15346 n8510 n8628 0.10294117647058823
r15347 n8627 n8628 0.13392857142857142
r15348 n8511 n8629 0.11666666666666667
r15349 n8628 n8629 0.14285714285714285
r15350 n8512 n8630 0.11666666666666667
r15351 n8629 n8630 0.13392857142857142
r15352 n8513 n8631 0.10294117647058823
r15353 n8630 n8631 0.14285714285714285
r15354 n8514 n8632 0.14583333333333334
r15355 n8631 n8632 0.12946428571428573
r15356 n8515 n8633 0.875
r15357 n8632 n8633 0.0625
r15358 n8516 n8634 0.34999999999999998
r15359 n8633 n8634 0.03125
r15360 n8517 n8635 1.75
r15361 n8634 n8635 0.026785714285714284
r15362 n8518 n8636 0.109375
r15363 n8635 n8636 0.075892857142857137
r15364 n8519 n8637 1.75
r15365 n8636 n8637 0.075892857142857137
r15366 n8520 n8638 0.097222222222222224
r15367 n8637 n8638 0.084821428571428575
r15368 n8521 n8639 1.75
r15369 n8638 n8639 0.084821428571428575
r15370 n8522 n8640 0.109375
r15371 n8639 n8640 0.075892857142857137
r15372 n8523 n8641 1.75
r15373 n8640 n8641 0.075892857142857137
r15374 n8524 n8642 0.097222222222222224
r15375 n8641 n8642 0.084821428571428575
r15376 n8525 n8643 1.75
r15377 n8642 n8643 0.084821428571428575
r15378 n8526 n8644 0.109375
r15379 n8643 n8644 0.075892857142857137
r15380 n8527 n8645 1.75
r15381 n8644 n8645 0.075892857142857137
r15382 n8528 n8646 0.097222222222222224
r15383 n8645 n8646 0.084821428571428575
r15384 n8529 n8647 1.75
r15385 n8646 n8647 0.084821428571428575
r15386 n8530 n8648 0.109375
r15387 n8647 n8648 0.075892857142857137
r15388 n8531 n8649 1.75
r15389 n8648 n8649 0.075892857142857137
r15390 n8532 n8650 0.097222222222222224
r15391 n8649 n8650 0.084821428571428575
r15392 n8533 n8651 1.75
r15393 n8650 n8651 0.084821428571428575
r15394 n8534 n8652 0.109375
r15395 n8651 n8652 0.075892857142857137
r15396 n8535 n8653 1.75
r15397 n8652 n8653 0.075892857142857137
r15398 n8536 n8654 0.097222222222222224
r15399 n8653 n8654 0.084821428571428575
r15400 n8537 n8655 1.75
r15401 n8654 n8655 0.084821428571428575
r15402 n8538 n8656 0.109375
r15403 n8655 n8656 0.075892857142857137
r15404 n8539 n8657 1.75
r15405 n8656 n8657 0.075892857142857137
r15406 n8540 n8658 0.097222222222222224
r15407 n8657 n8658 0.084821428571428575
r15408 n8541 n8659 1.75
r15409 n8658 n8659 0.084821428571428575
r15410 n8542 n8660 0.109375
r15411 n8659 n8660 0.075892857142857137
r15412 n8543 n8661 1.75
r15413 n8660 n8661 0.075892857142857137
r15414 n8544 n8662 0.097222222222222224
r15415 n8661 n8662 0.084821428571428575
r15416 n8545 n8663 1.75
r15417 n8662 n8663 0.084821428571428575
r15418 n8546 n8664 0.109375
r15419 n8663 n8664 0.075892857142857137
r15420 n8547 n8665 1.75
r15421 n8664 n8665 0.075892857142857137
r15422 n8548 n8666 0.23333333333333334
r15423 n8665 n8666 0.037946428571428568
r15424 n8549 n8667 0.29166666666666669
r15425 n8666 n8667 0.060267857142857144
r15426 n8550 n8668 0.3888888888888889
r15427 n8667 n8668 0.046875
r15428 n8551 n8669 1.75
r15429 n8668 n8669 0.024553571428571428
r15430 n8552 n8670 1.75
r15431 n8669 n8670 0.0089285714285714281
r15432 n8553 n8671 0.4375
r15433 n8670 n8671 0.022321428571428572
r15434 n8554 n8672 0.15909090909090909
r15435 n8671 n8672 0.066964285714285712
r15436 n8555 n8673 3.5
r15437 n8672 n8673 0.051339285714285712
r15438 n8556 n8674 3.5
r15439 n8673 n8674 0.004464285714285714
r15440 n8557 n8675 3.5
r15441 n8674 n8675 0.004464285714285714
r15442 n8558 n8676 0.34999999999999998
r15443 n8675 n8676 0.024553571428571428
r15444 n8559 n8677 0.34999999999999998
r15445 n8560 n8678 0.18421052631578946
r15446 n8677 n8678 0.064732142857142863
r15447 n8561 n8679 0.875
r15448 n8678 n8679 0.051339285714285712
r15449 n8562 n8680 1.75
r15450 n8679 n8680 0.013392857142857142
r15451 n8563 n8681 0.11666666666666667
r15452 n8680 n8681 0.071428571428571425
r15453 n8564 n8682 1.75
r15454 n8681 n8682 0.071428571428571425
r15455 n8565 n8683 0.875
r15456 n8682 n8683 0.013392857142857142
r15457 n8566 n8684 0.18421052631578946
r15458 n8683 n8684 0.051339285714285712
r15459 n8567 n8685 0.34999999999999998
r15460 n8684 n8685 0.064732142857142863
r15461 n8568 n8686 0.40875
r15462 n8569 n8687 0.17771739130434783
r15463 n8686 n8687 0.05514705882352941
r15464 n8570 n8688 2.0437500000000002
r15465 n8687 n8688 0.041778074866310161
r15466 n8571 n8689 0.13625000000000001
r15467 n8688 n8689 0.053475935828877004
r15468 n8572 n8690 2.0437500000000002
r15469 n8689 n8690 0.053475935828877004
r15470 n8573 n8691 0.17771739130434783
r15471 n8690 n8691 0.041778074866310161
r15472 n8574 n8692 0.40875
r15473 n8691 n8692 0.05514705882352941
r15474 n8623 n8693 0.14598214285714287
r15475 n8624 n8694 0.14598214285714287
r15476 n8693 n8694 0.093582887700534759
r15477 n8677 n8695 0.40875
r15478 n8678 n8696 0.21513157894736842
r15479 n8695 n8696 0.048462566844919786
r15480 n8679 n8697 1.0218750000000001
r15481 n8696 n8697 0.038435828877005349
r15482 n8680 n8698 2.0437500000000002
r15483 n8697 n8698 0.010026737967914439
r15484 n8681 n8699 0.13625000000000001
r15485 n8698 n8699 0.053475935828877004
r15486 n8682 n8700 2.0437500000000002
r15487 n8699 n8700 0.053475935828877004
r15488 n8683 n8701 1.0218750000000001
r15489 n8700 n8701 0.010026737967914439
r15490 n8684 n8702 0.21513157894736842
r15491 n8701 n8702 0.038435828877005349
r15492 n8685 n8703 0.40875
r15493 n8702 n8703 0.048462566844919786
r15494 n8686 n8704 0.46625
r15495 n8687 n8705 0.20271739130434782
r15496 n8704 n8705 0.055443548387096774
r15497 n8688 n8706 2.3312499999999998
r15498 n8705 n8706 0.042002688172043008
r15499 n8689 n8707 0.15541666666666668
r15500 n8706 n8707 0.053763440860215055
r15501 n8690 n8708 2.3312499999999998
r15502 n8707 n8708 0.053763440860215055
r15503 n8691 n8709 0.20271739130434782
r15504 n8708 n8709 0.042002688172043008
r15505 n8692 n8710 0.46625
r15506 n8709 n8710 0.055443548387096774
r15507 n8693 n8711 0.16651785714285713
r15508 n8694 n8712 0.16651785714285713
r15509 n8711 n8712 0.094086021505376344
r15510 n8695 n8713 0.46625
r15511 n8696 n8714 0.24539473684210528
r15512 n8713 n8714 0.048723118279569891
r15513 n8697 n8715 1.1656249999999999
r15514 n8714 n8715 0.03864247311827957
r15515 n8698 n8716 2.3312499999999998
r15516 n8715 n8716 0.010080645161290322
r15517 n8699 n8717 0.15541666666666668
r15518 n8716 n8717 0.053763440860215055
r15519 n8700 n8718 2.3312499999999998
r15520 n8717 n8718 0.053763440860215055
r15521 n8701 n8719 1.1656249999999999
r15522 n8718 n8719 0.010080645161290322
r15523 n8702 n8720 0.24539473684210528
r15524 n8719 n8720 0.03864247311827957
r15525 n8703 n8721 0.46625
r15526 n8720 n8721 0.048723118279569891
r15527 n8704 n8722 0.46625
r15528 n8705 n8723 0.20271739130434782
r15529 n8722 n8723 0.05514705882352941
r15530 n8706 n8724 2.3312499999999998
r15531 n8723 n8724 0.041778074866310161
r15532 n8707 n8725 0.15541666666666668
r15533 n8724 n8725 0.053475935828877004
r15534 n8708 n8726 2.3312499999999998
r15535 n8725 n8726 0.053475935828877004
r15536 n8709 n8727 0.20271739130434782
r15537 n8726 n8727 0.041778074866310161
r15538 n8710 n8728 0.46625
r15539 n8727 n8728 0.05514705882352941
r15540 n8711 n8729 0.16651785714285713
r15541 n8712 n8730 0.16651785714285713
r15542 n8729 n8730 0.093582887700534759
r15543 n8713 n8731 0.46625
r15544 n8714 n8732 0.24539473684210528
r15545 n8731 n8732 0.048462566844919786
r15546 n8715 n8733 1.1656249999999999
r15547 n8732 n8733 0.038435828877005349
r15548 n8716 n8734 2.3312499999999998
r15549 n8733 n8734 0.010026737967914439
r15550 n8717 n8735 0.15541666666666668
r15551 n8734 n8735 0.053475935828877004
r15552 n8718 n8736 2.3312499999999998
r15553 n8735 n8736 0.053475935828877004
r15554 n8719 n8737 1.1656249999999999
r15555 n8736 n8737 0.010026737967914439
r15556 n8720 n8738 0.24539473684210528
r15557 n8737 n8738 0.038435828877005349
r15558 n8721 n8739 0.46625
r15559 n8738 n8739 0.048462566844919786
r15560 n8722 n8740 0.46250000000000002
r15561 n8723 n8741 0.20108695652173914
r15562 n8740 n8741 0.056352459016393443
r15563 n8724 n8742 2.3125
r15564 n8741 n8742 0.042691256830601092
r15565 n8725 n8743 0.15416666666666667
r15566 n8742 n8743 0.054644808743169397
r15567 n8726 n8744 2.3125
r15568 n8743 n8744 0.054644808743169397
r15569 n8727 n8745 0.20108695652173914
r15570 n8744 n8745 0.042691256830601092
r15571 n8728 n8746 0.46250000000000002
r15572 n8745 n8746 0.056352459016393443
r15573 n8729 out 0.16517857142857142
r15574 n8730 out 0.16517857142857142
r15575 n8731 n8751 0.46250000000000002
r15576 n8732 n8752 0.24342105263157895
r15577 n8751 n8752 0.049521857923497267
r15578 n8733 n8753 1.15625
r15579 n8752 n8753 0.039275956284153007
r15580 n8734 n8754 2.3125
r15581 n8753 n8754 0.010245901639344262
r15582 n8735 n8755 0.15416666666666667
r15583 n8754 n8755 0.054644808743169397
r15584 n8736 n8756 2.3125
r15585 n8755 n8756 0.054644808743169397
r15586 n8737 n8757 1.15625
r15587 n8756 n8757 0.010245901639344262
r15588 n8738 n8758 0.24342105263157895
r15589 n8757 n8758 0.039275956284153007
r15590 n8739 n8759 0.46250000000000002
r15591 n8758 n8759 0.049521857923497267
r15592 n8740 n8760 0.45874999999999999
r15593 n8741 n8761 0.19945652173913042
r15594 n8760 n8761 0.056046195652173912
r15595 n8742 n8762 2.2937500000000002
r15596 n8761 n8762 0.042459239130434784
r15597 n8743 n8763 0.15291666666666667
r15598 n8762 n8763 0.05434782608695652
r15599 n8744 n8764 2.2937500000000002
r15600 n8763 n8764 0.05434782608695652
r15601 n8745 n8765 0.19945652173913042
r15602 n8764 n8765 0.042459239130434784
r15603 n8746 n8766 0.45874999999999999
r15604 n8765 n8766 0.056046195652173912
r15605 n8751 n8771 0.45874999999999999
r15606 n8752 n8772 0.24144736842105263
r15607 n8771 n8772 0.049252717391304345
r15608 n8753 n8773 1.1468750000000001
r15609 n8772 n8773 0.0390625
r15610 n8754 n8774 2.2937500000000002
r15611 n8773 n8774 0.010190217391304348
r15612 n8755 n8775 0.15291666666666667
r15613 n8774 n8775 0.05434782608695652
r15614 n8756 n8776 2.2937500000000002
r15615 n8775 n8776 0.05434782608695652
r15616 n8757 n8777 1.1468750000000001
r15617 n8776 n8777 0.010190217391304348
r15618 n8758 n8778 0.24144736842105263
r15619 n8777 n8778 0.0390625
r15620 n8759 n8779 0.45874999999999999
r15621 n8778 n8779 0.049252717391304345
r15622 n8760 n8780 0.45874999999999999
r15623 n8761 n8781 0.19945652173913042
r15624 n8780 n8781 0.056352459016393443
r15625 n8762 n8782 2.2937500000000002
r15626 n8781 n8782 0.042691256830601092
r15627 n8763 n8783 0.15291666666666667
r15628 n8782 n8783 0.054644808743169397
r15629 n8764 n8784 2.2937500000000002
r15630 n8783 n8784 0.054644808743169397
r15631 n8765 n8785 0.19945652173913042
r15632 n8784 n8785 0.042691256830601092
r15633 n8766 n8786 0.45874999999999999
r15634 n8785 n8786 0.056352459016393443
r15635 n8771 n8791 0.45874999999999999
r15636 n8772 n8792 0.24144736842105263
r15637 n8791 n8792 0.049521857923497267
r15638 n8773 n8793 1.1468750000000001
r15639 n8792 n8793 0.039275956284153007
r15640 n8774 n8794 2.2937500000000002
r15641 n8793 n8794 0.010245901639344262
r15642 n8775 n8795 0.15291666666666667
r15643 n8794 n8795 0.054644808743169397
r15644 n8776 n8796 2.2937500000000002
r15645 n8795 n8796 0.054644808743169397
r15646 n8777 n8797 1.1468750000000001
r15647 n8796 n8797 0.010245901639344262
r15648 n8778 n8798 0.24144736842105263
r15649 n8797 n8798 0.039275956284153007
r15650 n8779 n8799 0.45874999999999999
r15651 n8798 n8799 0.049521857923497267
r15652 in n8820 0.043083333333333335
r15653 in n8821 0.043083333333333335
r15654 n8820 n8821 0.040285714285714286
r15655 n8820 n8822 0.054833333333333331
r15656 n8821 n8823 0.054833333333333331
r15657 n8822 n8823 0.040285714285714286
r15658 n8824 n8825 0.0078333333333333328
r15659 n8825 n8826 0.0046999999999999993
r15660 n8826 n8827 0.0039166666666666664
r15661 n8827 n8828 0.0078333333333333328
r15662 n8828 n8829 0.0235
r15663 n8829 n8830 0.018799999999999997
r15664 n8830 n8831 0.0039166666666666664
r15665 n8831 n8832 0.0046999999999999993
r15666 n8832 n8833 0.0054833333333333331
r15667 n8833 n8834 0.0054833333333333331
r15668 n8834 n8835 0.010183333333333334
r15669 n8835 n8836 0.04621666666666667
r15670 n8836 n8837 0.065016666666666667
r15671 n8837 n8838 0.059846666666666666
r15672 n8838 n8839 0.066583333333333342
r15673 n8839 n8840 0.066739999999999994
r15674 n8840 n8841 0.066583333333333342
r15675 n8841 n8842 0.056713333333333331
r15676 n8822 n8843 0.050916666666666666
r15677 n8842 n8843 0.047
r15678 n8823 n8844 0.050916666666666666
r15679 n8843 n8844 0.047
r15680 n8844 n8845 0.047
r15681 n8845 n8846 0.054833333333333331
r15682 n8846 n8847 0.062666666666666662
r15683 n8847 n8848 0.056400000000000006
r15684 n8848 n8849 0.047
r15685 n8849 n8850 0.043866666666666665
r15686 n8850 n8851 0.047
r15687 n8851 n8852 0.045433333333333333
r15688 n8852 n8853 0.040733333333333337
r15689 n8853 n8854 0.047
r15690 n8854 n8855 0.050133333333333328
r15691 n8855 n8856 0.047
r15692 n8856 n8857 0.050133333333333328
r15693 n8857 n8858 0.045433333333333333
r15694 n8858 n8859 0.021933333333333332
r15695 n8859 n8860 0.010966666666666666
r15696 n8860 n8861 0.0093999999999999986
r15697 n8861 n8862 0.026633333333333335
r15698 n8862 n8863 0.026633333333333335
r15699 n8863 n8864 0.029766666666666667
r15700 n8864 n8865 0.029766666666666667
r15701 n8865 n8866 0.026633333333333335
r15702 n8866 n8867 0.026633333333333335
r15703 n8867 n8868 0.029766666666666667
r15704 n8868 n8869 0.029766666666666667
r15705 n8869 n8870 0.026633333333333335
r15706 n8870 n8871 0.026633333333333335
r15707 n8871 n8872 0.029766666666666667
r15708 n8872 n8873 0.029766666666666667
r15709 n8873 n8874 0.026633333333333335
r15710 n8874 n8875 0.026633333333333335
r15711 n8875 n8876 0.029766666666666667
r15712 n8876 n8877 0.029766666666666667
r15713 n8877 n8878 0.026633333333333335
r15714 n8878 n8879 0.026633333333333335
r15715 n8879 n8880 0.029766666666666667
r15716 n8880 n8881 0.029766666666666667
r15717 n8881 n8882 0.026633333333333335
r15718 n8882 n8883 0.026633333333333335
r15719 n8883 n8884 0.029766666666666667
r15720 n8884 n8885 0.029766666666666667
r15721 n8885 n8886 0.026633333333333335
r15722 n8886 n8887 0.026633333333333335
r15723 n8887 n8888 0.029766666666666667
r15724 n8888 n8889 0.029766666666666667
r15725 n8889 n8890 0.026633333333333335
r15726 n8890 n8891 0.026633333333333335
r15727 n8891 n8892 0.013316666666666668
r15728 n8892 n8893 0.021149999999999999
r15729 n8893 n8894 0.016449999999999999
r15730 n8894 n8895 0.0086166666666666666
r15731 n8895 n8896 0.003133333333333333
r15732 n8896 n8897 0.0078333333333333328
r15733 n8897 n8898 0.0235
r15734 n8898 n8899 0.018016666666666667
r15735 n8899 n8900 0.0015666666666666665
r15736 n8900 n8901 0.0015666666666666665
r15737 n8901 n8902 0.0086166666666666666
r15738 n8902 n8903 0.017233333333333333
r15739 n8903 n8904 0.015666666666666666
r15740 n8904 n8905 0.0078333333333333328
r15741 n8905 n8906 0.0039166666666666664
r15742 n8906 n8907 0.0039166666666666664
r15743 n8907 n8908 0.006266666666666666
r15744 n8908 n8909 0.014100000000000001
r15745 n8909 n8910 0.020366666666666668
r15746 n8910 n8911 0.012533333333333332
r15747 n8911 n8912 0.029766666666666667
r15748 n8912 n8913 0.029766666666666667
r15749 n8913 n8914 0.026633333333333335
r15750 n8914 n8915 0.026633333333333335
r15751 n8915 n8916 0.029766666666666667
r15752 n8916 n8917 0.029766666666666667
r15753 n8917 n8918 0.026633333333333335
r15754 n8918 n8919 0.026633333333333335
r15755 n8919 n8920 0.029766666666666667
r15756 n8920 n8921 0.029766666666666667
r15757 n8921 n8922 0.026633333333333335
r15758 n8922 n8923 0.026633333333333335
r15759 n8923 n8924 0.029766666666666667
r15760 n8924 n8925 0.029766666666666667
r15761 n8925 n8926 0.026633333333333335
r15762 n8926 n8927 0.026633333333333335
r15763 n8927 n8928 0.029766666666666667
r15764 n8928 n8929 0.029766666666666667
r15765 n8929 n8930 0.026633333333333335
r15766 n8930 n8931 0.026633333333333335
r15767 n8931 n8932 0.029766666666666667
r15768 n8932 n8933 0.029766666666666667
r15769 n8933 n8934 0.026633333333333335
r15770 n8934 n8935 0.026633333333333335
r15771 n8935 n8936 0.029766666666666667
r15772 n8936 n8937 0.029766666666666667
r15773 n8937 n8938 0.026633333333333335
r15774 n8938 n8939 0.026633333333333335
r15775 n8939 n8940 0.010966666666666666
r15776 n8940 n8941 0.012533333333333332
r15777 n8941 n8942 0.018799999999999997
r15778 n8942 n8943 0.042299999999999997
r15779 n8943 n8944 0.028200000000000003
r15780 n8944 n8945 0.0093999999999999986
r15781 n8945 n8946 0.013316666666666668
r15782 n8946 n8947 0.0078333333333333328
r15783 n8947 n8948 0.0046999999999999993
r15784 n8948 n8949 0.0039166666666666664
r15785 n8949 n8950 0.010183333333333334
r15786 n8950 n8951 0.0235
r15787 n8951 n8952 0.016449999999999999
r15788 n8952 n8953 0.0039166666666666664
r15789 n8953 n8954 0.0046999999999999993
r15790 n8954 n8955 0.0078333333333333328
r15791 n8824 n8956 0.20142857142857143
r15792 n8825 n8957 0.46999999999999997
r15793 n8956 n8957 0.0078333333333333328
r15794 n8826 n8958 0.46999999999999997
r15795 n8957 n8958 0.0046999999999999993
r15796 n8827 n8959 0.70499999999999996
r15797 n8958 n8959 0.0039166666666666664
r15798 n8828 n8960 0.17624999999999999
r15799 n8959 n8960 0.0078333333333333328
r15800 n8829 n8961 0.064090909090909087
r15801 n8960 n8961 0.0235
r15802 n8830 n8962 0.70499999999999996
r15803 n8961 n8962 0.018799999999999997
r15804 n8831 n8963 0.46999999999999997
r15805 n8962 n8963 0.0039166666666666664
r15806 n8832 n8964 0.46999999999999997
r15807 n8963 n8964 0.0046999999999999993
r15808 n8833 n8965 0.35249999999999998
r15809 n8964 n8965 0.0054833333333333331
r15810 n8834 n8966 0.46999999999999997
r15811 n8965 n8966 0.0054833333333333331
r15812 n8835 n8967 0.14099999999999999
r15813 n8966 n8967 0.010183333333333334
r15814 n8836 n8968 0.028775510204081631
r15815 n8967 n8968 0.04621666666666667
r15816 n8837 n8969 0.041470588235294113
r15817 n8968 n8969 0.065016666666666667
r15818 n8838 n8970 0.033254716981132075
r15819 n8969 n8970 0.059846666666666666
r15820 n8839 n8971 0.033098591549295772
r15821 n8970 n8971 0.066583333333333342
r15822 n8840 n8972 0.033098591549295772
r15823 n8971 n8972 0.066739999999999994
r15824 n8841 n8973 0.033254716981132075
r15825 n8972 n8973 0.066583333333333342
r15826 n8842 n8974 0.047
r15827 n8973 n8974 0.056713333333333331
r15828 n8843 n8975 0.047
r15829 n8974 n8975 0.047
r15830 n8844 n8976 0.047
r15831 n8975 n8976 0.047
r15832 n8845 n8977 0.047
r15833 n8976 n8977 0.047
r15834 n8846 n8978 0.035249999999999997
r15835 n8977 n8978 0.054833333333333331
r15836 n8847 n8979 0.035249999999999997
r15837 n8978 n8979 0.062666666666666662
r15838 n8848 n8980 0.044062499999999998
r15839 n8979 n8980 0.056400000000000006
r15840 n8849 n8981 0.050357142857142857
r15841 n8980 n8981 0.047
r15842 n8850 n8982 0.050357142857142857
r15843 n8981 n8982 0.043866666666666665
r15844 n8851 n8983 0.044062499999999998
r15845 n8982 n8983 0.047
r15846 n8852 n8984 0.054230769230769228
r15847 n8983 n8984 0.045433333333333333
r15848 n8853 n8985 0.054230769230769228
r15849 n8984 n8985 0.040733333333333337
r15850 n8854 n8986 0.041470588235294113
r15851 n8985 n8986 0.047
r15852 n8855 n8987 0.047
r15853 n8986 n8987 0.050133333333333328
r15854 n8856 n8988 0.047
r15855 n8987 n8988 0.047
r15856 n8857 n8989 0.041470588235294113
r15857 n8988 n8989 0.050133333333333328
r15858 n8858 n8990 0.058749999999999997
r15859 n8989 n8990 0.045433333333333333
r15860 n8859 n8991 0.35249999999999998
r15861 n8990 n8991 0.021933333333333332
r15862 n8860 n8992 0.14099999999999999
r15863 n8991 n8992 0.010966666666666666
r15864 n8861 n8993 0.70499999999999996
r15865 n8992 n8993 0.0093999999999999986
r15866 n8862 n8994 0.044062499999999998
r15867 n8993 n8994 0.026633333333333335
r15868 n8863 n8995 0.70499999999999996
r15869 n8994 n8995 0.026633333333333335
r15870 n8864 n8996 0.039166666666666669
r15871 n8995 n8996 0.029766666666666667
r15872 n8865 n8997 0.70499999999999996
r15873 n8996 n8997 0.029766666666666667
r15874 n8866 n8998 0.044062499999999998
r15875 n8997 n8998 0.026633333333333335
r15876 n8867 n8999 0.70499999999999996
r15877 n8998 n8999 0.026633333333333335
r15878 n8868 n9000 0.039166666666666669
r15879 n8999 n9000 0.029766666666666667
r15880 n8869 n9001 0.70499999999999996
r15881 n9000 n9001 0.029766666666666667
r15882 n8870 n9002 0.044062499999999998
r15883 n9001 n9002 0.026633333333333335
r15884 n8871 n9003 0.70499999999999996
r15885 n9002 n9003 0.026633333333333335
r15886 n8872 n9004 0.039166666666666669
r15887 n9003 n9004 0.029766666666666667
r15888 n8873 n9005 0.70499999999999996
r15889 n9004 n9005 0.029766666666666667
r15890 n8874 n9006 0.044062499999999998
r15891 n9005 n9006 0.026633333333333335
r15892 n8875 n9007 0.70499999999999996
r15893 n9006 n9007 0.026633333333333335
r15894 n8876 n9008 0.039166666666666669
r15895 n9007 n9008 0.029766666666666667
r15896 n8877 n9009 0.70499999999999996
r15897 n9008 n9009 0.029766666666666667
r15898 n8878 n9010 0.044062499999999998
r15899 n9009 n9010 0.026633333333333335
r15900 n8879 n9011 0.70499999999999996
r15901 n9010 n9011 0.026633333333333335
r15902 n8880 n9012 0.039166666666666669
r15903 n9011 n9012 0.029766666666666667
r15904 n8881 n9013 0.70499999999999996
r15905 n9012 n9013 0.029766666666666667
r15906 n8882 n9014 0.044062499999999998
r15907 n9013 n9014 0.026633333333333335
r15908 n8883 n9015 0.70499999999999996
r15909 n9014 n9015 0.026633333333333335
r15910 n8884 n9016 0.039166666666666669
r15911 n9015 n9016 0.029766666666666667
r15912 n8885 n9017 0.70499999999999996
r15913 n9016 n9017 0.029766666666666667
r15914 n8886 n9018 0.044062499999999998
r15915 n9017 n9018 0.026633333333333335
r15916 n8887 n9019 0.70499999999999996
r15917 n9018 n9019 0.026633333333333335
r15918 n8888 n9020 0.039166666666666669
r15919 n9019 n9020 0.029766666666666667
r15920 n8889 n9021 0.70499999999999996
r15921 n9020 n9021 0.029766666666666667
r15922 n8890 n9022 0.044062499999999998
r15923 n9021 n9022 0.026633333333333335
r15924 n8891 n9023 0.70499999999999996
r15925 n9022 n9023 0.026633333333333335
r15926 n8892 n9024 0.094
r15927 n9023 n9024 0.013316666666666668
r15928 n8893 n9025 0.11749999999999999
r15929 n9024 n9025 0.021149999999999999
r15930 n8894 n9026 0.15666666666666668
r15931 n9025 n9026 0.016449999999999999
r15932 n8895 n9027 0.70499999999999996
r15933 n9026 n9027 0.0086166666666666666
r15934 n8896 n9028 0.70499999999999996
r15935 n9027 n9028 0.003133333333333333
r15936 n8897 n9029 0.17624999999999999
r15937 n9028 n9029 0.0078333333333333328
r15938 n8898 n9030 0.064090909090909087
r15939 n9029 n9030 0.0235
r15940 n8899 n9031 1.4099999999999999
r15941 n9030 n9031 0.018016666666666667
r15942 n8900 n9032 1.4099999999999999
r15943 n9031 n9032 0.0015666666666666665
r15944 n8901 n9033 1.4099999999999999
r15945 n9032 n9033 0.0015666666666666665
r15946 n8902 n9034 0.14099999999999999
r15947 n9033 n9034 0.0086166666666666666
r15948 n8903 n9035 0.11749999999999999
r15949 n9034 n9035 0.017233333333333333
r15950 n8904 n9036 0.17624999999999999
r15951 n9035 n9036 0.015666666666666666
r15952 n8905 n9037 0.70499999999999996
r15953 n9036 n9037 0.0078333333333333328
r15954 n8906 n9038 0.46999999999999997
r15955 n9037 n9038 0.0039166666666666664
r15956 n8907 n9039 0.70499999999999996
r15957 n9038 n9039 0.0039166666666666664
r15958 n8908 n9040 0.23499999999999999
r15959 n9039 n9040 0.006266666666666666
r15960 n8909 n9041 0.11749999999999999
r15961 n9040 n9041 0.014100000000000001
r15962 n8910 n9042 0.10071428571428571
r15963 n9041 n9042 0.020366666666666668
r15964 n8911 n9043 0.70499999999999996
r15965 n9042 n9043 0.012533333333333332
r15966 n8912 n9044 0.039166666666666669
r15967 n9043 n9044 0.029766666666666667
r15968 n8913 n9045 0.70499999999999996
r15969 n9044 n9045 0.029766666666666667
r15970 n8914 n9046 0.044062499999999998
r15971 n9045 n9046 0.026633333333333335
r15972 n8915 n9047 0.70499999999999996
r15973 n9046 n9047 0.026633333333333335
r15974 n8916 n9048 0.039166666666666669
r15975 n9047 n9048 0.029766666666666667
r15976 n8917 n9049 0.70499999999999996
r15977 n9048 n9049 0.029766666666666667
r15978 n8918 n9050 0.044062499999999998
r15979 n9049 n9050 0.026633333333333335
r15980 n8919 n9051 0.70499999999999996
r15981 n9050 n9051 0.026633333333333335
r15982 n8920 n9052 0.039166666666666669
r15983 n9051 n9052 0.029766666666666667
r15984 n8921 n9053 0.70499999999999996
r15985 n9052 n9053 0.029766666666666667
r15986 n8922 n9054 0.044062499999999998
r15987 n9053 n9054 0.026633333333333335
r15988 n8923 n9055 0.70499999999999996
r15989 n9054 n9055 0.026633333333333335
r15990 n8924 n9056 0.039166666666666669
r15991 n9055 n9056 0.029766666666666667
r15992 n8925 n9057 0.70499999999999996
r15993 n9056 n9057 0.029766666666666667
r15994 n8926 n9058 0.044062499999999998
r15995 n9057 n9058 0.026633333333333335
r15996 n8927 n9059 0.70499999999999996
r15997 n9058 n9059 0.026633333333333335
r15998 n8928 n9060 0.039166666666666669
r15999 n9059 n9060 0.029766666666666667
r16000 n8929 n9061 0.70499999999999996
r16001 n9060 n9061 0.029766666666666667
r16002 n8930 n9062 0.044062499999999998
r16003 n9061 n9062 0.026633333333333335
r16004 n8931 n9063 0.70499999999999996
r16005 n9062 n9063 0.026633333333333335
r16006 n8932 n9064 0.039166666666666669
r16007 n9063 n9064 0.029766666666666667
r16008 n8933 n9065 0.70499999999999996
r16009 n9064 n9065 0.029766666666666667
r16010 n8934 n9066 0.044062499999999998
r16011 n9065 n9066 0.026633333333333335
r16012 n8935 n9067 0.70499999999999996
r16013 n9066 n9067 0.026633333333333335
r16014 n8936 n9068 0.039166666666666669
r16015 n9067 n9068 0.029766666666666667
r16016 n8937 n9069 0.70499999999999996
r16017 n9068 n9069 0.029766666666666667
r16018 n8938 n9070 0.044062499999999998
r16019 n9069 n9070 0.026633333333333335
r16020 n8939 n9071 0.70499999999999996
r16021 n9070 n9071 0.026633333333333335
r16022 n8940 n9072 0.11749999999999999
r16023 n9071 n9072 0.010966666666666666
r16024 n8941 n9073 0.35249999999999998
r16025 n9072 n9073 0.012533333333333332
r16026 n8942 n9074 0.070499999999999993
r16027 n9073 n9074 0.018799999999999997
r16028 n8943 n9075 0.041470588235294113
r16029 n9074 n9075 0.042299999999999997
r16030 n8944 n9076 0.70499999999999996
r16031 n9075 n9076 0.028200000000000003
r16032 n8945 n9077 0.14099999999999999
r16033 n9076 n9077 0.0093999999999999986
r16034 n8946 n9078 0.20142857142857143
r16035 n9077 n9078 0.013316666666666668
r16036 n8947 n9079 0.46999999999999997
r16037 n9078 n9079 0.0078333333333333328
r16038 n8948 n9080 0.46999999999999997
r16039 n9079 n9080 0.0046999999999999993
r16040 n8949 n9081 0.70499999999999996
r16041 n9080 n9081 0.0039166666666666664
r16042 n8950 n9082 0.12818181818181817
r16043 n9081 n9082 0.010183333333333334
r16044 n8951 n9083 0.074210526315789477
r16045 n9082 n9083 0.0235
r16046 n8952 n9084 0.70499999999999996
r16047 n9083 n9084 0.016449999999999999
r16048 n8953 n9085 0.46999999999999997
r16049 n9084 n9085 0.0039166666666666664
r16050 n8954 n9086 0.46999999999999997
r16051 n9085 n9086 0.0046999999999999993
r16052 n8955 n9087 0.20142857142857143
r16053 n9086 n9087 0.0078333333333333328
r16054 n8956 n9088 0.22157142857142856
r16055 n8957 n9089 0.51700000000000002
r16056 n9088 n9089 0.0065277777777777782
r16057 n8958 n9090 0.51700000000000002
r16058 n9089 n9090 0.0039166666666666664
r16059 n8959 n9091 0.77549999999999997
r16060 n9090 n9091 0.0032638888888888891
r16061 n8960 n9092 0.19387499999999999
r16062 n9091 n9092 0.0065277777777777782
r16063 n8961 n9093 0.070499999999999993
r16064 n9092 n9093 0.019583333333333335
r16065 n8962 n9094 0.77549999999999997
r16066 n9093 n9094 0.015666666666666666
r16067 n8963 n9095 0.51700000000000002
r16068 n9094 n9095 0.0032638888888888891
r16069 n8964 n9096 0.51700000000000002
r16070 n9095 n9096 0.0039166666666666664
r16071 n8965 n9097 0.38774999999999998
r16072 n9096 n9097 0.0045694444444444446
r16073 n8966 n9098 0.51700000000000002
r16074 n9097 n9098 0.0045694444444444446
r16075 n9078 n9099 0.22157142857142856
r16076 n9079 n9100 0.51700000000000002
r16077 n9099 n9100 0.0065277777777777782
r16078 n9080 n9101 0.51700000000000002
r16079 n9100 n9101 0.0039166666666666664
r16080 n9081 n9102 0.77549999999999997
r16081 n9101 n9102 0.0032638888888888891
r16082 n9082 n9103 0.14099999999999999
r16083 n9102 n9103 0.0084861111111111109
r16084 n9083 n9104 0.081631578947368416
r16085 n9103 n9104 0.019583333333333335
r16086 n9084 n9105 0.77549999999999997
r16087 n9104 n9105 0.013708333333333333
r16088 n9085 n9106 0.51700000000000002
r16089 n9105 n9106 0.0032638888888888891
r16090 n9086 n9107 0.51700000000000002
r16091 n9106 n9107 0.0039166666666666664
r16092 n9087 n9108 0.22157142857142856
r16093 n9107 n9108 0.0065277777777777782
r16094 n9088 n9109 0.24171428571428574
r16095 n9089 n9110 0.56400000000000006
r16096 n9109 n9110 0.0065277777777777782
r16097 n9090 n9111 0.56400000000000006
r16098 n9110 n9111 0.0039166666666666664
r16099 n9091 n9112 0.84600000000000009
r16100 n9111 n9112 0.0032638888888888891
r16101 n9092 n9113 0.21150000000000002
r16102 n9112 n9113 0.0065277777777777782
r16103 n9093 n9114 0.076909090909090913
r16104 n9113 n9114 0.019583333333333335
r16105 n9094 n9115 0.84600000000000009
r16106 n9114 n9115 0.015666666666666666
r16107 n9095 n9116 0.56400000000000006
r16108 n9115 n9116 0.0032638888888888891
r16109 n9096 n9117 0.56400000000000006
r16110 n9116 n9117 0.0039166666666666664
r16111 n9097 n9118 0.42300000000000004
r16112 n9117 n9118 0.0045694444444444446
r16113 n9098 n9119 0.56400000000000006
r16114 n9118 n9119 0.0045694444444444446
r16115 n9099 n9120 0.24171428571428574
r16116 n9100 n9121 0.56400000000000006
r16117 n9120 n9121 0.0065277777777777782
r16118 n9101 n9122 0.56400000000000006
r16119 n9121 n9122 0.0039166666666666664
r16120 n9102 n9123 0.84600000000000009
r16121 n9122 n9123 0.0032638888888888891
r16122 n9103 n9124 0.15381818181818183
r16123 n9123 n9124 0.0084861111111111109
r16124 n9104 n9125 0.089052631578947383
r16125 n9124 n9125 0.019583333333333335
r16126 n9105 n9126 0.84600000000000009
r16127 n9125 n9126 0.013708333333333333
r16128 n9106 n9127 0.56400000000000006
r16129 n9126 n9127 0.0032638888888888891
r16130 n9107 n9128 0.56400000000000006
r16131 n9127 n9128 0.0039166666666666664
r16132 n9108 n9129 0.24171428571428574
r16133 n9128 n9129 0.0065277777777777782
r16134 n9109 n9130 0.21485714285714286
r16135 n9110 n9131 0.5013333333333333
r16136 n9130 n9131 0.0083928571428571429
r16137 n9111 n9132 0.5013333333333333
r16138 n9131 n9132 0.0050357142857142857
r16139 n9112 n9133 0.752
r16140 n9132 n9133 0.0041964285714285714
r16141 n9113 n9134 0.188
r16142 n9133 n9134 0.0083928571428571429
r16143 n9114 n9135 0.068363636363636363
r16144 n9134 n9135 0.025178571428571429
r16145 n9115 n9136 0.752
r16146 n9135 n9136 0.020142857142857143
r16147 n9116 n9137 0.5013333333333333
r16148 n9136 n9137 0.0041964285714285714
r16149 n9117 n9138 0.5013333333333333
r16150 n9137 n9138 0.0050357142857142857
r16151 n9118 n9139 0.376
r16152 n9138 n9139 0.005875
r16153 n9119 n9140 0.5013333333333333
r16154 n9139 n9140 0.005875
r16155 n9120 n9141 0.21485714285714286
r16156 n9121 n9142 0.5013333333333333
r16157 n9141 n9142 0.0083928571428571429
r16158 n9122 n9143 0.5013333333333333
r16159 n9142 n9143 0.0050357142857142857
r16160 n9123 n9144 0.752
r16161 n9143 n9144 0.0041964285714285714
r16162 n9124 n9145 0.13672727272727273
r16163 n9144 n9145 0.010910714285714286
r16164 n9125 n9146 0.079157894736842108
r16165 n9145 n9146 0.025178571428571429
r16166 n9126 n9147 0.752
r16167 n9146 n9147 0.017624999999999998
r16168 n9127 n9148 0.5013333333333333
r16169 n9147 n9148 0.0041964285714285714
r16170 n9128 n9149 0.5013333333333333
r16171 n9148 n9149 0.0050357142857142857
r16172 n9129 n9150 0.21485714285714286
r16173 n9149 n9150 0.0083928571428571429
r16174 n9130 n9151 0.188
r16175 n9131 n9152 0.43866666666666665
r16176 n9151 n9152 0.0083928571428571429
r16177 n9132 n9153 0.43866666666666665
r16178 n9152 n9153 0.0050357142857142857
r16179 n9133 n9154 0.65800000000000003
r16180 n9153 n9154 0.0041964285714285714
r16181 n9134 n9155 0.16450000000000001
r16182 n9154 n9155 0.0083928571428571429
r16183 n9135 n9156 0.059818181818181819
r16184 n9155 n9156 0.025178571428571429
r16185 n9136 n9157 0.65800000000000003
r16186 n9156 n9157 0.020142857142857143
r16187 n9137 n9158 0.43866666666666665
r16188 n9157 n9158 0.0041964285714285714
r16189 n9138 n9159 0.43866666666666665
r16190 n9158 n9159 0.0050357142857142857
r16191 n9139 n9160 0.32900000000000001
r16192 n9159 n9160 0.005875
r16193 n9140 n9161 0.43866666666666665
r16194 n9160 n9161 0.005875
r16195 n9141 n9162 0.188
r16196 n9142 n9163 0.43866666666666665
r16197 n9162 n9163 0.0083928571428571429
r16198 n9143 n9164 0.43866666666666665
r16199 n9163 n9164 0.0050357142857142857
r16200 n9144 n9165 0.65800000000000003
r16201 n9164 n9165 0.0041964285714285714
r16202 n9145 n9166 0.11963636363636364
r16203 n9165 n9166 0.010910714285714286
r16204 n9146 n9167 0.069263157894736846
r16205 n9166 n9167 0.025178571428571429
r16206 n9147 n9168 0.65800000000000003
r16207 n9167 n9168 0.017624999999999998
r16208 n9148 n9169 0.43866666666666665
r16209 n9168 n9169 0.0041964285714285714
r16210 n9149 n9170 0.43866666666666665
r16211 n9169 n9170 0.0050357142857142857
r16212 n9150 n9171 0.188
r16213 n9170 n9171 0.0083928571428571429
r16214 n9151 n9172 0.24842857142857144
r16215 n9152 n9173 0.57966666666666666
r16216 n9172 n9173 0.0051086956521739129
r16217 n9153 n9174 0.57966666666666666
r16218 n9173 n9174 0.0030652173913043477
r16219 n9154 n9175 0.86950000000000005
r16220 n9174 n9175 0.0025543478260869564
r16221 n9155 n9176 0.21737500000000001
r16222 n9175 n9176 0.0051086956521739129
r16223 n9156 n9177 0.079045454545454544
r16224 n9176 n9177 0.015326086956521739
r16225 n9157 n9178 0.86950000000000005
r16226 n9177 n9178 0.012260869565217391
r16227 n9158 n9179 0.57966666666666666
r16228 n9178 n9179 0.0025543478260869564
r16229 n9159 n9180 0.57966666666666666
r16230 n9179 n9180 0.0030652173913043477
r16231 n9160 n9181 0.43475000000000003
r16232 n9180 n9181 0.003576086956521739
r16233 n9161 n9182 0.57966666666666666
r16234 n9181 n9182 0.003576086956521739
r16235 n9162 n9183 0.24842857142857144
r16236 n9163 n9184 0.57966666666666666
r16237 n9183 n9184 0.0051086956521739129
r16238 n9164 n9185 0.57966666666666666
r16239 n9184 n9185 0.0030652173913043477
r16240 n9165 n9186 0.86950000000000005
r16241 n9185 n9186 0.0025543478260869564
r16242 n9166 n9187 0.15809090909090909
r16243 n9186 n9187 0.0066413043478260872
r16244 n9167 n9188 0.091526315789473692
r16245 n9187 n9188 0.015326086956521739
r16246 n9168 n9189 0.86950000000000005
r16247 n9188 n9189 0.010728260869565217
r16248 n9169 n9190 0.57966666666666666
r16249 n9189 n9190 0.0025543478260869564
r16250 n9170 n9191 0.57966666666666666
r16251 n9190 n9191 0.0030652173913043477
r16252 n9171 n9192 0.24842857142857144
r16253 n9191 n9192 0.0051086956521739129
r16254 n9172 n9193 0.16114285714285714
r16255 n9173 n9194 0.376
r16256 n9193 n9194 0.11750000000000001
r16257 n9174 n9195 0.376
r16258 n9194 n9195 0.070499999999999993
r16259 n9175 n9196 0.56399999999999995
r16260 n9195 n9196 0.058750000000000004
r16261 n9176 n9197 0.14099999999999999
r16262 n9196 n9197 0.11750000000000001
r16263 n9177 n9198 0.051272727272727268
r16264 n9197 n9198 0.35249999999999998
r16265 n9178 n9199 0.56399999999999995
r16266 n9198 n9199 0.28199999999999997
r16267 n9179 n9200 0.376
r16268 n9199 n9200 0.058750000000000004
r16269 n9180 n9201 0.376
r16270 n9200 n9201 0.070499999999999993
r16271 n9181 n9202 0.28199999999999997
r16272 n9201 n9202 0.082250000000000004
r16273 n9182 n9203 0.376
r16274 n9202 n9203 0.082250000000000004
r16275 n9183 n9204 0.16114285714285714
r16276 n9184 n9205 0.376
r16277 n9204 n9205 0.11750000000000001
r16278 n9185 n9206 0.376
r16279 n9205 n9206 0.070499999999999993
r16280 n9186 n9207 0.56399999999999995
r16281 n9206 n9207 0.058750000000000004
r16282 n9187 n9208 0.10254545454545454
r16283 n9207 n9208 0.15275
r16284 n9188 n9209 0.059368421052631577
r16285 n9208 n9209 0.35249999999999998
r16286 n9189 n9210 0.56399999999999995
r16287 n9209 n9210 0.24674999999999997
r16288 n9190 n9211 0.376
r16289 n9210 n9211 0.058750000000000004
r16290 n9191 n9212 0.376
r16291 n9211 n9212 0.070499999999999993
r16292 n9192 n9213 0.16114285714285714
r16293 n9212 n9213 0.11750000000000001
r16294 n9193 n9214 0.043642857142857143
r16295 n9194 n9215 0.10183333333333335
r16296 n9214 n9215 0.021363636363636366
r16297 n9195 n9216 0.10183333333333335
r16298 n9215 n9216 0.012818181818181817
r16299 n9196 n9217 0.15275
r16300 n9216 n9217 0.010681818181818183
r16301 n9197 n9218 0.038187499999999999
r16302 n9217 n9218 0.021363636363636366
r16303 n9198 n9219 0.013886363636363638
r16304 n9218 n9219 0.064090909090909087
r16305 n9199 n9220 0.15275
r16306 n9219 n9220 0.051272727272727268
r16307 n9200 n9221 0.10183333333333335
r16308 n9220 n9221 0.010681818181818183
r16309 n9201 n9222 0.10183333333333335
r16310 n9221 n9222 0.012818181818181817
r16311 n9202 n9223 0.076374999999999998
r16312 n9222 n9223 0.014954545454545455
r16313 n9203 n9224 0.10183333333333335
r16314 n9223 n9224 0.014954545454545455
r16315 n9204 n9225 0.043642857142857143
r16316 n9205 n9226 0.10183333333333335
r16317 n9225 n9226 0.021363636363636366
r16318 n9206 n9227 0.10183333333333335
r16319 n9226 n9227 0.012818181818181817
r16320 n9207 n9228 0.15275
r16321 n9227 n9228 0.010681818181818183
r16322 n9208 n9229 0.027772727272727275
r16323 n9228 n9229 0.027772727272727275
r16324 n9209 n9230 0.016078947368421054
r16325 n9229 n9230 0.064090909090909087
r16326 n9210 n9231 0.15275
r16327 n9230 n9231 0.044863636363636362
r16328 n9211 n9232 0.10183333333333335
r16329 n9231 n9232 0.010681818181818183
r16330 n9212 n9233 0.10183333333333335
r16331 n9232 n9233 0.012818181818181817
r16332 n9213 n9234 0.043642857142857143
r16333 n9233 n9234 0.021363636363636366
r16334 n9214 n9235 0.043642857142857143
r16335 n9215 n9236 0.10183333333333335
r16336 n9235 n9236 0.11750000000000001
r16337 n9216 n9237 0.10183333333333335
r16338 n9236 n9237 0.070499999999999993
r16339 n9217 n9238 0.15275
r16340 n9237 n9238 0.058750000000000004
r16341 n9218 n9239 0.038187499999999999
r16342 n9238 n9239 0.11750000000000001
r16343 n9219 n9240 0.013886363636363638
r16344 n9239 n9240 0.35249999999999998
r16345 n9220 n9241 0.15275
r16346 n9240 n9241 0.28199999999999997
r16347 n9221 n9242 0.10183333333333335
r16348 n9241 n9242 0.058750000000000004
r16349 n9222 n9243 0.10183333333333335
r16350 n9242 n9243 0.070499999999999993
r16351 n9223 n9244 0.076374999999999998
r16352 n9243 n9244 0.082250000000000004
r16353 n9224 n9245 0.10183333333333335
r16354 n9244 n9245 0.082250000000000004
r16355 n9225 n9246 0.043642857142857143
r16356 n9226 n9247 0.10183333333333335
r16357 n9246 n9247 0.11750000000000001
r16358 n9227 n9248 0.10183333333333335
r16359 n9247 n9248 0.070499999999999993
r16360 n9228 n9249 0.15275
r16361 n9248 n9249 0.058750000000000004
r16362 n9229 n9250 0.027772727272727275
r16363 n9249 n9250 0.15275
r16364 n9230 n9251 0.016078947368421054
r16365 n9250 n9251 0.35249999999999998
r16366 n9231 n9252 0.15275
r16367 n9251 n9252 0.24674999999999997
r16368 n9232 n9253 0.10183333333333335
r16369 n9252 n9253 0.058750000000000004
r16370 n9233 n9254 0.10183333333333335
r16371 n9253 n9254 0.070499999999999993
r16372 n9234 n9255 0.043642857142857143
r16373 n9254 n9255 0.11750000000000001
r16374 n9235 n9256 0.10742857142857143
r16375 n9236 n9257 0.25066666666666665
r16376 n9256 n9257 0.0078333333333333328
r16377 n9237 n9258 0.25066666666666665
r16378 n9257 n9258 0.0046999999999999993
r16379 n9238 n9259 0.376
r16380 n9258 n9259 0.0039166666666666664
r16381 n9239 n9260 0.094
r16382 n9259 n9260 0.0078333333333333328
r16383 n9240 n9261 0.034181818181818181
r16384 n9260 n9261 0.0235
r16385 n9241 n9262 0.376
r16386 n9261 n9262 0.018799999999999997
r16387 n9242 n9263 0.25066666666666665
r16388 n9262 n9263 0.0039166666666666664
r16389 n9243 n9264 0.25066666666666665
r16390 n9263 n9264 0.0046999999999999993
r16391 n9244 n9265 0.188
r16392 n9264 n9265 0.0054833333333333331
r16393 n9245 n9266 0.25066666666666665
r16394 n9265 n9266 0.0054833333333333331
r16395 n9246 n9267 0.10742857142857143
r16396 n9247 n9268 0.25066666666666665
r16397 n9267 n9268 0.0078333333333333328
r16398 n9248 n9269 0.25066666666666665
r16399 n9268 n9269 0.0046999999999999993
r16400 n9249 n9270 0.376
r16401 n9269 n9270 0.0039166666666666664
r16402 n9250 n9271 0.068363636363636363
r16403 n9270 n9271 0.010183333333333334
r16404 n9251 n9272 0.039578947368421054
r16405 n9271 n9272 0.0235
r16406 n9252 n9273 0.376
r16407 n9272 n9273 0.016449999999999999
r16408 n9253 n9274 0.25066666666666665
r16409 n9273 n9274 0.0039166666666666664
r16410 n9254 n9275 0.25066666666666665
r16411 n9274 n9275 0.0046999999999999993
r16412 n9255 n9276 0.10742857142857143
r16413 n9275 n9276 0.0078333333333333328
r16414 n9256 n9277 0.10742857142857143
r16415 n9257 n9278 0.25066666666666665
r16416 n9277 n9278 0.11750000000000001
r16417 n9258 n9279 0.25066666666666665
r16418 n9278 n9279 0.070499999999999993
r16419 n9259 n9280 0.376
r16420 n9279 n9280 0.058750000000000004
r16421 n9260 n9281 0.094
r16422 n9280 n9281 0.11750000000000001
r16423 n9261 n9282 0.034181818181818181
r16424 n9281 n9282 0.35249999999999998
r16425 n9262 n9283 0.376
r16426 n9282 n9283 0.28199999999999997
r16427 n9263 n9284 0.25066666666666665
r16428 n9283 n9284 0.058750000000000004
r16429 n9264 n9285 0.25066666666666665
r16430 n9284 n9285 0.070499999999999993
r16431 n9265 n9286 0.188
r16432 n9285 n9286 0.082250000000000004
r16433 n9266 n9287 0.25066666666666665
r16434 n9286 n9287 0.082250000000000004
r16435 n9267 n9288 0.10742857142857143
r16436 n9268 n9289 0.25066666666666665
r16437 n9288 n9289 0.11750000000000001
r16438 n9269 n9290 0.25066666666666665
r16439 n9289 n9290 0.070499999999999993
r16440 n9270 n9291 0.376
r16441 n9290 n9291 0.058750000000000004
r16442 n9271 n9292 0.068363636363636363
r16443 n9291 n9292 0.15275
r16444 n9272 n9293 0.039578947368421054
r16445 n9292 n9293 0.35249999999999998
r16446 n9273 n9294 0.376
r16447 n9293 n9294 0.24674999999999997
r16448 n9274 n9295 0.25066666666666665
r16449 n9294 n9295 0.058750000000000004
r16450 n9275 n9296 0.25066666666666665
r16451 n9295 n9296 0.070499999999999993
r16452 n9276 n9297 0.10742857142857143
r16453 n9296 n9297 0.11750000000000001
r16454 n9277 n9298 0.043642857142857143
r16455 n9278 n9299 0.10183333333333335
r16456 n9298 n9299 0.021363636363636366
r16457 n9279 n9300 0.10183333333333335
r16458 n9299 n9300 0.012818181818181817
r16459 n9280 n9301 0.15275
r16460 n9300 n9301 0.010681818181818183
r16461 n9281 n9302 0.038187499999999999
r16462 n9301 n9302 0.021363636363636366
r16463 n9282 n9303 0.013886363636363638
r16464 n9302 n9303 0.064090909090909087
r16465 n9283 n9304 0.15275
r16466 n9303 n9304 0.051272727272727268
r16467 n9284 n9305 0.10183333333333335
r16468 n9304 n9305 0.010681818181818183
r16469 n9285 n9306 0.10183333333333335
r16470 n9305 n9306 0.012818181818181817
r16471 n9286 n9307 0.076374999999999998
r16472 n9306 n9307 0.014954545454545455
r16473 n9287 n9308 0.10183333333333335
r16474 n9307 n9308 0.014954545454545455
r16475 n9288 n9309 0.043642857142857143
r16476 n9289 n9310 0.10183333333333335
r16477 n9309 n9310 0.021363636363636366
r16478 n9290 n9311 0.10183333333333335
r16479 n9310 n9311 0.012818181818181817
r16480 n9291 n9312 0.15275
r16481 n9311 n9312 0.010681818181818183
r16482 n9292 n9313 0.027772727272727275
r16483 n9312 n9313 0.027772727272727275
r16484 n9293 n9314 0.016078947368421054
r16485 n9313 n9314 0.064090909090909087
r16486 n9294 n9315 0.15275
r16487 n9314 n9315 0.044863636363636362
r16488 n9295 n9316 0.10183333333333335
r16489 n9315 n9316 0.010681818181818183
r16490 n9296 n9317 0.10183333333333335
r16491 n9316 n9317 0.012818181818181817
r16492 n9297 n9318 0.043642857142857143
r16493 n9317 n9318 0.021363636363636366
r16494 n9298 n9319 0.043642857142857143
r16495 n9299 n9320 0.10183333333333335
r16496 n9319 n9320 0.11750000000000001
r16497 n9300 n9321 0.10183333333333335
r16498 n9320 n9321 0.070499999999999993
r16499 n9301 n9322 0.15275
r16500 n9321 n9322 0.058750000000000004
r16501 n9302 n9323 0.038187499999999999
r16502 n9322 n9323 0.11750000000000001
r16503 n9303 n9324 0.013886363636363638
r16504 n9323 n9324 0.35249999999999998
r16505 n9304 n9325 0.15275
r16506 n9324 n9325 0.28199999999999997
r16507 n9305 n9326 0.10183333333333335
r16508 n9325 n9326 0.058750000000000004
r16509 n9306 n9327 0.10183333333333335
r16510 n9326 n9327 0.070499999999999993
r16511 n9307 n9328 0.076374999999999998
r16512 n9327 n9328 0.082250000000000004
r16513 n9308 n9329 0.10183333333333335
r16514 n9328 n9329 0.082250000000000004
r16515 n9309 n9330 0.043642857142857143
r16516 n9310 n9331 0.10183333333333335
r16517 n9330 n9331 0.11750000000000001
r16518 n9311 n9332 0.10183333333333335
r16519 n9331 n9332 0.070499999999999993
r16520 n9312 n9333 0.15275
r16521 n9332 n9333 0.058750000000000004
r16522 n9313 n9334 0.027772727272727275
r16523 n9333 n9334 0.15275
r16524 n9314 n9335 0.016078947368421054
r16525 n9334 n9335 0.35249999999999998
r16526 n9315 n9336 0.15275
r16527 n9335 n9336 0.24674999999999997
r16528 n9316 n9337 0.10183333333333335
r16529 n9336 n9337 0.058750000000000004
r16530 n9317 n9338 0.10183333333333335
r16531 n9337 n9338 0.070499999999999993
r16532 n9318 n9339 0.043642857142857143
r16533 n9338 n9339 0.11750000000000001
r16534 n9319 n9340 0.11078571428571428
r16535 n9320 n9341 0.25850000000000001
r16536 n9340 n9341 0.0075806451612903227
r16537 n9321 n9342 0.25850000000000001
r16538 n9341 n9342 0.0045483870967741929
r16539 n9322 n9343 0.38774999999999998
r16540 n9342 n9343 0.0037903225806451613
r16541 n9323 n9344 0.096937499999999996
r16542 n9343 n9344 0.0075806451612903227
r16543 n9324 n9345 0.035249999999999997
r16544 n9344 n9345 0.022741935483870965
r16545 n9325 n9346 0.38774999999999998
r16546 n9345 n9346 0.018193548387096772
r16547 n9326 n9347 0.25850000000000001
r16548 n9346 n9347 0.0037903225806451613
r16549 n9327 n9348 0.25850000000000001
r16550 n9347 n9348 0.0045483870967741929
r16551 n9328 n9349 0.19387499999999999
r16552 n9348 n9349 0.0053064516129032258
r16553 n9329 n9350 0.25850000000000001
r16554 n9349 n9350 0.0053064516129032258
r16555 n9330 n9351 0.11078571428571428
r16556 n9331 n9352 0.25850000000000001
r16557 n9351 n9352 0.0075806451612903227
r16558 n9332 n9353 0.25850000000000001
r16559 n9352 n9353 0.0045483870967741929
r16560 n9333 n9354 0.38774999999999998
r16561 n9353 n9354 0.0037903225806451613
r16562 n9334 n9355 0.070499999999999993
r16563 n9354 n9355 0.0098548387096774204
r16564 n9335 n9356 0.040815789473684208
r16565 n9355 n9356 0.022741935483870965
r16566 n9336 n9357 0.38774999999999998
r16567 n9356 n9357 0.015919354838709675
r16568 n9337 n9358 0.25850000000000001
r16569 n9357 n9358 0.0037903225806451613
r16570 n9338 n9359 0.25850000000000001
r16571 n9358 n9359 0.0045483870967741929
r16572 n9339 n9360 0.11078571428571428
r16573 n9359 n9360 0.0075806451612903227
r16574 n9340 n9361 0.20814285714285716
r16575 n9341 n9362 0.48566666666666669
r16576 n9361 n9362 0.0075806451612903227
r16577 n9342 n9363 0.48566666666666669
r16578 n9362 n9363 0.0045483870967741929
r16579 n9343 n9364 0.72850000000000004
r16580 n9363 n9364 0.0037903225806451613
r16581 n9344 n9365 0.18212500000000001
r16582 n9364 n9365 0.0075806451612903227
r16583 n9345 n9366 0.066227272727272732
r16584 n9365 n9366 0.022741935483870965
r16585 n9346 n9367 0.72850000000000004
r16586 n9366 n9367 0.018193548387096772
r16587 n9347 n9368 0.48566666666666669
r16588 n9367 n9368 0.0037903225806451613
r16589 n9348 n9369 0.48566666666666669
r16590 n9368 n9369 0.0045483870967741929
r16591 n9349 n9370 0.36425000000000002
r16592 n9369 n9370 0.0053064516129032258
r16593 n9350 n9371 0.48566666666666669
r16594 n9370 n9371 0.0053064516129032258
r16595 n9351 n9372 0.20814285714285716
r16596 n9352 n9373 0.48566666666666669
r16597 n9372 n9373 0.0075806451612903227
r16598 n9353 n9374 0.48566666666666669
r16599 n9373 n9374 0.0045483870967741929
r16600 n9354 n9375 0.72850000000000004
r16601 n9374 n9375 0.0037903225806451613
r16602 n9355 n9376 0.13245454545454546
r16603 n9375 n9376 0.0098548387096774204
r16604 n9356 n9377 0.076684210526315785
r16605 n9376 n9377 0.022741935483870965
r16606 n9357 n9378 0.72850000000000004
r16607 n9377 n9378 0.015919354838709675
r16608 n9358 n9379 0.48566666666666669
r16609 n9378 n9379 0.0037903225806451613
r16610 n9359 n9380 0.48566666666666669
r16611 n9379 n9380 0.0045483870967741929
r16612 n9360 n9381 0.20814285714285716
r16613 n9380 n9381 0.0075806451612903227
r16614 n9361 n9382 0.15107142857142855
r16615 n9362 n9383 0.35249999999999998
r16616 n9382 n9383 0.016785714285714286
r16617 n9363 n9384 0.35249999999999998
r16618 n9383 n9384 0.010071428571428571
r16619 n9364 n9385 0.52874999999999994
r16620 n9384 n9385 0.0083928571428571429
r16621 n9365 n9386 0.13218749999999999
r16622 n9385 n9386 0.016785714285714286
r16623 n9366 n9387 0.048068181818181815
r16624 n9386 n9387 0.050357142857142857
r16625 n9367 n9388 0.52874999999999994
r16626 n9387 n9388 0.040285714285714286
r16627 n9368 n9389 0.35249999999999998
r16628 n9388 n9389 0.0083928571428571429
r16629 n9369 n9390 0.35249999999999998
r16630 n9389 n9390 0.010071428571428571
r16631 n9370 n9391 0.26437499999999997
r16632 n9390 n9391 0.01175
r16633 n9371 n9392 0.35249999999999998
r16634 n9391 n9392 0.01175
r16635 n9372 n9393 0.15107142857142855
r16636 n9373 n9394 0.35249999999999998
r16637 n9393 n9394 0.016785714285714286
r16638 n9374 n9395 0.35249999999999998
r16639 n9394 n9395 0.010071428571428571
r16640 n9375 n9396 0.52874999999999994
r16641 n9395 n9396 0.0083928571428571429
r16642 n9376 n9397 0.096136363636363631
r16643 n9396 n9397 0.021821428571428571
r16644 n9377 n9398 0.055657894736842101
r16645 n9397 n9398 0.050357142857142857
r16646 n9378 n9399 0.52874999999999994
r16647 n9398 n9399 0.035249999999999997
r16648 n9379 n9400 0.35249999999999998
r16649 n9399 n9400 0.0083928571428571429
r16650 n9380 n9401 0.35249999999999998
r16651 n9400 n9401 0.010071428571428571
r16652 n9381 n9402 0.15107142857142855
r16653 n9401 n9402 0.016785714285714286
r16654 n9382 n9403 0.053714285714285714
r16655 n9383 n9404 0.12533333333333332
r16656 n9403 n9404 0.11750000000000001
r16657 n9384 n9405 0.12533333333333332
r16658 n9404 n9405 0.070499999999999993
r16659 n9385 n9406 0.188
r16660 n9405 n9406 0.058750000000000004
r16661 n9386 n9407 0.047
r16662 n9406 n9407 0.11750000000000001
r16663 n9387 n9408 0.017090909090909091
r16664 n9407 n9408 0.35249999999999998
r16665 n9388 n9409 0.188
r16666 n9408 n9409 0.28199999999999997
r16667 n9389 n9410 0.12533333333333332
r16668 n9409 n9410 0.058750000000000004
r16669 n9390 n9411 0.12533333333333332
r16670 n9410 n9411 0.070499999999999993
r16671 n9391 n9412 0.094
r16672 n9411 n9412 0.082250000000000004
r16673 n9392 n9413 0.12533333333333332
r16674 n9412 n9413 0.082250000000000004
r16675 n9393 n9414 0.053714285714285714
r16676 n9394 n9415 0.12533333333333332
r16677 n9414 n9415 0.11750000000000001
r16678 n9395 n9416 0.12533333333333332
r16679 n9415 n9416 0.070499999999999993
r16680 n9396 n9417 0.188
r16681 n9416 n9417 0.058750000000000004
r16682 n9397 n9418 0.034181818181818181
r16683 n9417 n9418 0.15275
r16684 n9398 n9419 0.019789473684210527
r16685 n9418 n9419 0.35249999999999998
r16686 n9399 n9420 0.188
r16687 n9419 n9420 0.24674999999999997
r16688 n9400 n9421 0.12533333333333332
r16689 n9420 n9421 0.058750000000000004
r16690 n9401 n9422 0.12533333333333332
r16691 n9421 n9422 0.070499999999999993
r16692 n9402 n9423 0.053714285714285714
r16693 n9422 n9423 0.11750000000000001
r16694 n9403 n9424 0.0235
r16695 n9404 n9425 0.054833333333333331
r16696 n9424 n9425 0.047
r16697 n9405 n9426 0.054833333333333331
r16698 n9425 n9426 0.028199999999999999
r16699 n9406 n9427 0.082250000000000004
r16700 n9426 n9427 0.0235
r16701 n9407 n9428 0.020562500000000001
r16702 n9427 n9428 0.047
r16703 n9408 n9429 0.0074772727272727274
r16704 n9428 n9429 0.14099999999999999
r16705 n9409 n9430 0.082250000000000004
r16706 n9429 n9430 0.1128
r16707 n9410 n9431 0.054833333333333331
r16708 n9430 n9431 0.0235
r16709 n9411 n9432 0.054833333333333331
r16710 n9431 n9432 0.028199999999999999
r16711 n9412 n9433 0.041125000000000002
r16712 n9432 n9433 0.032899999999999999
r16713 n9413 n9434 0.054833333333333331
r16714 n9433 n9434 0.032899999999999999
r16715 n9414 n9435 0.0235
r16716 n9415 n9436 0.054833333333333331
r16717 n9435 n9436 0.047
r16718 n9416 n9437 0.054833333333333331
r16719 n9436 n9437 0.028199999999999999
r16720 n9417 n9438 0.082250000000000004
r16721 n9437 n9438 0.0235
r16722 n9418 n9439 0.014954545454545455
r16723 n9438 n9439 0.061100000000000002
r16724 n9419 n9440 0.0086578947368421057
r16725 n9439 n9440 0.14099999999999999
r16726 n9420 n9441 0.082250000000000004
r16727 n9440 n9441 0.098699999999999996
r16728 n9421 n9442 0.054833333333333331
r16729 n9441 n9442 0.0235
r16730 n9422 n9443 0.054833333333333331
r16731 n9442 n9443 0.028199999999999999
r16732 n9423 n9444 0.0235
r16733 n9443 n9444 0.047
r16734 n9424 n9445 0.036928571428571429
r16735 n9425 n9446 0.086166666666666669
r16736 n9445 n9446 0.039166666666666669
r16737 n9426 n9447 0.086166666666666669
r16738 n9446 n9447 0.0235
r16739 n9427 n9448 0.12925
r16740 n9447 n9448 0.019583333333333335
r16741 n9428 n9449 0.032312500000000001
r16742 n9448 n9449 0.039166666666666669
r16743 n9429 n9450 0.01175
r16744 n9449 n9450 0.11749999999999999
r16745 n9430 n9451 0.12925
r16746 n9450 n9451 0.094
r16747 n9431 n9452 0.086166666666666669
r16748 n9451 n9452 0.019583333333333335
r16749 n9432 n9453 0.086166666666666669
r16750 n9452 n9453 0.0235
r16751 n9433 n9454 0.064625000000000002
r16752 n9453 n9454 0.027416666666666666
r16753 n9434 n9455 0.086166666666666669
r16754 n9454 n9455 0.027416666666666666
r16755 n9435 n9456 0.036928571428571429
r16756 n9436 n9457 0.086166666666666669
r16757 n9456 n9457 0.039166666666666669
r16758 n9437 n9458 0.086166666666666669
r16759 n9457 n9458 0.0235
r16760 n9438 n9459 0.12925
r16761 n9458 n9459 0.019583333333333335
r16762 n9439 n9460 0.0235
r16763 n9459 n9460 0.050916666666666673
r16764 n9440 n9461 0.013605263157894737
r16765 n9460 n9461 0.11749999999999999
r16766 n9441 n9462 0.12925
r16767 n9461 n9462 0.08224999999999999
r16768 n9442 n9463 0.086166666666666669
r16769 n9462 n9463 0.019583333333333335
r16770 n9443 n9464 0.086166666666666669
r16771 n9463 n9464 0.0235
r16772 n9444 n9465 0.036928571428571429
r16773 n9464 n9465 0.039166666666666669
r16774 n9445 n9466 0.026857142857142857
r16775 n9446 n9467 0.062666666666666662
r16776 n9466 n9467 0.11750000000000001
r16777 n9447 n9468 0.062666666666666662
r16778 n9467 n9468 0.070499999999999993
r16779 n9448 n9469 0.094
r16780 n9468 n9469 0.058750000000000004
r16781 n9449 n9470 0.0235
r16782 n9469 n9470 0.11750000000000001
r16783 n9450 n9471 0.0085454545454545453
r16784 n9470 n9471 0.35249999999999998
r16785 n9451 n9472 0.094
r16786 n9471 n9472 0.28199999999999997
r16787 n9452 n9473 0.062666666666666662
r16788 n9472 n9473 0.058750000000000004
r16789 n9453 n9474 0.062666666666666662
r16790 n9473 n9474 0.070499999999999993
r16791 n9454 n9475 0.047
r16792 n9474 n9475 0.082250000000000004
r16793 n9455 n9476 0.062666666666666662
r16794 n9475 n9476 0.082250000000000004
r16795 n9456 n9477 0.026857142857142857
r16796 n9457 n9478 0.062666666666666662
r16797 n9477 n9478 0.11750000000000001
r16798 n9458 n9479 0.062666666666666662
r16799 n9478 n9479 0.070499999999999993
r16800 n9459 n9480 0.094
r16801 n9479 n9480 0.058750000000000004
r16802 n9460 n9481 0.017090909090909091
r16803 n9480 n9481 0.15275
r16804 n9461 n9482 0.0098947368421052635
r16805 n9481 n9482 0.35249999999999998
r16806 n9462 n9483 0.094
r16807 n9482 n9483 0.24674999999999997
r16808 n9463 n9484 0.062666666666666662
r16809 n9483 n9484 0.058750000000000004
r16810 n9464 n9485 0.062666666666666662
r16811 n9484 n9485 0.070499999999999993
r16812 n9465 n9486 0.026857142857142857
r16813 n9485 n9486 0.11750000000000001
r16814 n9466 n9487 0.0235
r16815 n9467 n9488 0.054833333333333331
r16816 n9487 n9488 0.047
r16817 n9468 n9489 0.054833333333333331
r16818 n9488 n9489 0.028199999999999999
r16819 n9469 n9490 0.082250000000000004
r16820 n9489 n9490 0.0235
r16821 n9470 n9491 0.020562500000000001
r16822 n9490 n9491 0.047
r16823 n9471 n9492 0.0074772727272727274
r16824 n9491 n9492 0.14099999999999999
r16825 n9472 n9493 0.082250000000000004
r16826 n9492 n9493 0.1128
r16827 n9473 n9494 0.054833333333333331
r16828 n9493 n9494 0.0235
r16829 n9474 n9495 0.054833333333333331
r16830 n9494 n9495 0.028199999999999999
r16831 n9475 n9496 0.041125000000000002
r16832 n9495 n9496 0.032899999999999999
r16833 n9476 n9497 0.054833333333333331
r16834 n9496 n9497 0.032899999999999999
r16835 n9477 n9498 0.0235
r16836 n9478 n9499 0.054833333333333331
r16837 n9498 n9499 0.047
r16838 n9479 n9500 0.054833333333333331
r16839 n9499 n9500 0.028199999999999999
r16840 n9480 n9501 0.082250000000000004
r16841 n9500 n9501 0.0235
r16842 n9481 n9502 0.014954545454545455
r16843 n9501 n9502 0.061100000000000002
r16844 n9482 n9503 0.0086578947368421057
r16845 n9502 n9503 0.14099999999999999
r16846 n9483 n9504 0.082250000000000004
r16847 n9503 n9504 0.098699999999999996
r16848 n9484 n9505 0.054833333333333331
r16849 n9504 n9505 0.0235
r16850 n9485 n9506 0.054833333333333331
r16851 n9505 n9506 0.028199999999999999
r16852 n9486 n9507 0.0235
r16853 n9506 n9507 0.047
r16854 n9487 n9508 0.067142857142857143
r16855 n9488 n9509 0.15666666666666668
r16856 n9508 n9509 0.015666666666666666
r16857 n9489 n9510 0.15666666666666668
r16858 n9509 n9510 0.0093999999999999986
r16859 n9490 n9511 0.23500000000000001
r16860 n9510 n9511 0.0078333333333333328
r16861 n9491 n9512 0.058750000000000004
r16862 n9511 n9512 0.015666666666666666
r16863 n9492 n9513 0.021363636363636366
r16864 n9512 n9513 0.047
r16865 n9493 n9514 0.23500000000000001
r16866 n9513 n9514 0.037599999999999995
r16867 n9494 n9515 0.15666666666666668
r16868 n9514 n9515 0.0078333333333333328
r16869 n9495 n9516 0.15666666666666668
r16870 n9515 n9516 0.0093999999999999986
r16871 n9496 n9517 0.11750000000000001
r16872 n9516 n9517 0.010966666666666666
r16873 n9497 n9518 0.15666666666666668
r16874 n9517 n9518 0.010966666666666666
r16875 n9498 n9519 0.067142857142857143
r16876 n9499 n9520 0.15666666666666668
r16877 n9519 n9520 0.015666666666666666
r16878 n9500 n9521 0.15666666666666668
r16879 n9520 n9521 0.0093999999999999986
r16880 n9501 n9522 0.23500000000000001
r16881 n9521 n9522 0.0078333333333333328
r16882 n9502 n9523 0.042727272727272732
r16883 n9522 n9523 0.020366666666666668
r16884 n9503 n9524 0.024736842105263158
r16885 n9523 n9524 0.047
r16886 n9504 n9525 0.23500000000000001
r16887 n9524 n9525 0.032899999999999999
r16888 n9505 n9526 0.15666666666666668
r16889 n9525 n9526 0.0078333333333333328
r16890 n9506 n9527 0.15666666666666668
r16891 n9526 n9527 0.0093999999999999986
r16892 n9507 n9528 0.067142857142857143
r16893 n9527 n9528 0.015666666666666666
r16894 n9508 n9530 0.060428571428571436
r16895 n9529 n9530 0.13316666666666668
r16896 n9509 n9531 0.14100000000000001
r16897 n9530 n9531 0.078333333333333338
r16898 n9510 n9532 0.14100000000000001
r16899 n9531 n9532 0.047
r16900 n9511 n9533 0.21150000000000002
r16901 n9532 n9533 0.039166666666666669
r16902 n9512 n9534 0.052875000000000005
r16903 n9533 n9534 0.078333333333333338
r16904 n9513 n9535 0.019227272727272728
r16905 n9534 n9535 0.23499999999999999
r16906 n9514 n9536 0.21150000000000002
r16907 n9535 n9536 0.188
r16908 n9515 n9537 0.14100000000000001
r16909 n9536 n9537 0.039166666666666669
r16910 n9516 n9538 0.14100000000000001
r16911 n9537 n9538 0.047
r16912 n9517 n9539 0.10575000000000001
r16913 n9538 n9539 0.054833333333333331
r16914 n9518 n9540 0.14100000000000001
r16915 n9539 n9540 0.054833333333333331
r16916 n9540 n9541 0.10183333333333335
r16917 n9519 n9543 0.060428571428571436
r16918 n9542 n9543 0.13316666666666668
r16919 n9520 n9544 0.14100000000000001
r16920 n9543 n9544 0.078333333333333338
r16921 n9521 n9545 0.14100000000000001
r16922 n9544 n9545 0.047
r16923 n9522 n9546 0.21150000000000002
r16924 n9545 n9546 0.039166666666666669
r16925 n9523 n9547 0.038454545454545457
r16926 n9546 n9547 0.10183333333333335
r16927 n9524 n9548 0.022263157894736846
r16928 n9547 n9548 0.23499999999999999
r16929 n9525 n9549 0.21150000000000002
r16930 n9548 n9549 0.16449999999999998
r16931 n9526 n9550 0.14100000000000001
r16932 n9549 n9550 0.039166666666666669
r16933 n9527 n9551 0.14100000000000001
r16934 n9550 n9551 0.047
r16935 n9528 n9552 0.060428571428571436
r16936 n9551 n9552 0.078333333333333338
r16937 n9552 n9553 0.13316666666666668
r16938 n9529 n9554 0.016449999999999999
r16939 n9530 n9555 0.0235
r16940 n9554 n9555 0.099875000000000005
r16941 n9531 n9556 0.054833333333333331
r16942 n9555 n9556 0.058750000000000004
r16943 n9532 n9557 0.054833333333333331
r16944 n9556 n9557 0.035249999999999997
r16945 n9533 n9558 0.082250000000000004
r16946 n9557 n9558 0.029375000000000002
r16947 n9534 n9559 0.020562500000000001
r16948 n9558 n9559 0.058750000000000004
r16949 n9535 n9560 0.0074772727272727274
r16950 n9559 n9560 0.17624999999999999
r16951 n9536 n9561 0.082250000000000004
r16952 n9560 n9561 0.14099999999999999
r16953 n9537 n9562 0.054833333333333331
r16954 n9561 n9562 0.029375000000000002
r16955 n9538 n9563 0.054833333333333331
r16956 n9562 n9563 0.035249999999999997
r16957 n9539 n9564 0.041125000000000002
r16958 n9563 n9564 0.041125000000000002
r16959 n9540 n9565 0.054833333333333331
r16960 n9564 n9565 0.041125000000000002
r16961 n9541 n9566 0.016449999999999999
r16962 n9565 n9566 0.076374999999999998
r16963 n9542 n9567 0.016449999999999999
r16964 n9543 n9568 0.0235
r16965 n9567 n9568 0.099875000000000005
r16966 n9544 n9569 0.054833333333333331
r16967 n9568 n9569 0.058750000000000004
r16968 n9545 n9570 0.054833333333333331
r16969 n9569 n9570 0.035249999999999997
r16970 n9546 n9571 0.082250000000000004
r16971 n9570 n9571 0.029375000000000002
r16972 n9547 n9572 0.014954545454545455
r16973 n9571 n9572 0.076374999999999998
r16974 n9548 n9573 0.0086578947368421057
r16975 n9572 n9573 0.17624999999999999
r16976 n9549 n9574 0.082250000000000004
r16977 n9573 n9574 0.12337499999999998
r16978 n9550 n9575 0.054833333333333331
r16979 n9574 n9575 0.029375000000000002
r16980 n9551 n9576 0.054833333333333331
r16981 n9575 n9576 0.035249999999999997
r16982 n9552 n9577 0.0235
r16983 n9576 n9577 0.058750000000000004
r16984 n9553 n9578 0.016449999999999999
r16985 n9577 n9578 0.099875000000000005
r16986 n9554 n9579 0.016449999999999999
r16987 n9555 n9580 0.0235
r16988 n9579 n9580 0.13316666666666668
r16989 n9556 n9581 0.054833333333333331
r16990 n9580 n9581 0.078333333333333338
r16991 n9557 n9582 0.054833333333333331
r16992 n9581 n9582 0.047
r16993 n9558 n9583 0.082250000000000004
r16994 n9582 n9583 0.039166666666666669
r16995 n9559 n9584 0.020562500000000001
r16996 n9583 n9584 0.078333333333333338
r16997 n9560 n9585 0.0074772727272727274
r16998 n9584 n9585 0.23499999999999999
r16999 n9561 n9586 0.082250000000000004
r17000 n9585 n9586 0.188
r17001 n9562 n9587 0.054833333333333331
r17002 n9586 n9587 0.039166666666666669
r17003 n9563 n9588 0.054833333333333331
r17004 n9587 n9588 0.047
r17005 n9564 n9589 0.041125000000000002
r17006 n9588 n9589 0.054833333333333331
r17007 n9565 n9590 0.054833333333333331
r17008 n9589 n9590 0.054833333333333331
r17009 n9566 n9591 0.016449999999999999
r17010 n9590 n9591 0.10183333333333335
r17011 n9567 n9592 0.016449999999999999
r17012 n9568 n9593 0.0235
r17013 n9592 n9593 0.13316666666666668
r17014 n9569 n9594 0.054833333333333331
r17015 n9593 n9594 0.078333333333333338
r17016 n9570 n9595 0.054833333333333331
r17017 n9594 n9595 0.047
r17018 n9571 n9596 0.082250000000000004
r17019 n9595 n9596 0.039166666666666669
r17020 n9572 n9597 0.014954545454545455
r17021 n9596 n9597 0.10183333333333335
r17022 n9573 n9598 0.0086578947368421057
r17023 n9597 n9598 0.23499999999999999
r17024 n9574 n9599 0.082250000000000004
r17025 n9598 n9599 0.16449999999999998
r17026 n9575 n9600 0.054833333333333331
r17027 n9599 n9600 0.039166666666666669
r17028 n9576 n9601 0.054833333333333331
r17029 n9600 n9601 0.047
r17030 n9577 n9602 0.0235
r17031 n9601 n9602 0.078333333333333338
r17032 n9578 n9603 0.016449999999999999
r17033 n9602 n9603 0.13316666666666668
r17034 n9579 n9604 0.01175
r17035 n9580 n9605 0.016785714285714286
r17036 n9604 n9605 0.19975000000000001
r17037 n9581 n9606 0.039166666666666669
r17038 n9605 n9606 0.11750000000000001
r17039 n9582 n9607 0.039166666666666669
r17040 n9606 n9607 0.070499999999999993
r17041 n9583 n9608 0.058750000000000004
r17042 n9607 n9608 0.058750000000000004
r17043 n9584 n9609 0.014687500000000001
r17044 n9608 n9609 0.11750000000000001
r17045 n9585 n9610 0.0053409090909090915
r17046 n9609 n9610 0.35249999999999998
r17047 n9586 n9611 0.058750000000000004
r17048 n9610 n9611 0.28199999999999997
r17049 n9587 n9612 0.039166666666666669
r17050 n9611 n9612 0.058750000000000004
r17051 n9588 n9613 0.039166666666666669
r17052 n9612 n9613 0.070499999999999993
r17053 n9589 n9614 0.029375000000000002
r17054 n9613 n9614 0.082250000000000004
r17055 n9590 n9615 0.039166666666666669
r17056 n9614 n9615 0.082250000000000004
r17057 n9591 n9616 0.01175
r17058 n9615 n9616 0.15275
r17059 n9592 n9617 0.01175
r17060 n9593 n9618 0.016785714285714286
r17061 n9617 n9618 0.19975000000000001
r17062 n9594 n9619 0.039166666666666669
r17063 n9618 n9619 0.11750000000000001
r17064 n9595 n9620 0.039166666666666669
r17065 n9619 n9620 0.070499999999999993
r17066 n9596 n9621 0.058750000000000004
r17067 n9620 n9621 0.058750000000000004
r17068 n9597 n9622 0.010681818181818183
r17069 n9621 n9622 0.15275
r17070 n9598 n9623 0.0061842105263157894
r17071 n9622 n9623 0.35249999999999998
r17072 n9599 n9624 0.058750000000000004
r17073 n9623 n9624 0.24674999999999997
r17074 n9600 n9625 0.039166666666666669
r17075 n9624 n9625 0.058750000000000004
r17076 n9601 n9626 0.039166666666666669
r17077 n9625 n9626 0.070499999999999993
r17078 n9602 n9627 0.016785714285714286
r17079 n9626 n9627 0.11750000000000001
r17080 n9603 n9628 0.01175
r17081 n9627 n9628 0.19975000000000001
r17082 n9604 n9629 0.018799999999999997
r17083 n9605 n9630 0.026857142857142857
r17084 n9629 n9630 0.066583333333333342
r17085 n9606 n9631 0.062666666666666662
r17086 n9630 n9631 0.039166666666666669
r17087 n9607 n9632 0.062666666666666662
r17088 n9631 n9632 0.0235
r17089 n9608 n9633 0.094
r17090 n9632 n9633 0.019583333333333335
r17091 n9609 n9634 0.0235
r17092 n9633 n9634 0.039166666666666669
r17093 n9610 n9635 0.0085454545454545453
r17094 n9634 n9635 0.11749999999999999
r17095 n9611 n9636 0.094
r17096 n9635 n9636 0.094
r17097 n9612 n9637 0.062666666666666662
r17098 n9636 n9637 0.019583333333333335
r17099 n9613 n9638 0.062666666666666662
r17100 n9637 n9638 0.0235
r17101 n9614 n9639 0.047
r17102 n9638 n9639 0.027416666666666666
r17103 n9615 n9640 0.062666666666666662
r17104 n9639 n9640 0.027416666666666666
r17105 n9616 n9641 0.018799999999999997
r17106 n9640 n9641 0.050916666666666673
r17107 n9617 n9642 0.018799999999999997
r17108 n9618 n9643 0.026857142857142857
r17109 n9642 n9643 0.066583333333333342
r17110 n9619 n9644 0.062666666666666662
r17111 n9643 n9644 0.039166666666666669
r17112 n9620 n9645 0.062666666666666662
r17113 n9644 n9645 0.0235
r17114 n9621 n9646 0.094
r17115 n9645 n9646 0.019583333333333335
r17116 n9622 n9647 0.017090909090909091
r17117 n9646 n9647 0.050916666666666673
r17118 n9623 n9648 0.0098947368421052635
r17119 n9647 n9648 0.11749999999999999
r17120 n9624 n9649 0.094
r17121 n9648 n9649 0.08224999999999999
r17122 n9625 n9650 0.062666666666666662
r17123 n9649 n9650 0.019583333333333335
r17124 n9626 n9651 0.062666666666666662
r17125 n9650 n9651 0.0235
r17126 n9627 n9652 0.026857142857142857
r17127 n9651 n9652 0.039166666666666669
r17128 n9628 n9653 0.018799999999999997
r17129 n9652 n9653 0.066583333333333342
r17130 n9629 n9654 0.018799999999999997
r17131 n9630 n9655 0.026857142857142857
r17132 n9654 n9655 0.19975000000000001
r17133 n9631 n9656 0.062666666666666662
r17134 n9655 n9656 0.11750000000000001
r17135 n9632 n9657 0.062666666666666662
r17136 n9656 n9657 0.070499999999999993
r17137 n9633 n9658 0.094
r17138 n9657 n9658 0.058750000000000004
r17139 n9634 n9659 0.0235
r17140 n9658 n9659 0.11750000000000001
r17141 n9635 n9660 0.0085454545454545453
r17142 n9659 n9660 0.35249999999999998
r17143 n9636 n9661 0.094
r17144 n9660 n9661 0.28199999999999997
r17145 n9637 n9662 0.062666666666666662
r17146 n9661 n9662 0.058750000000000004
r17147 n9638 n9663 0.062666666666666662
r17148 n9662 n9663 0.070499999999999993
r17149 n9639 n9664 0.047
r17150 n9663 n9664 0.082250000000000004
r17151 n9640 n9665 0.062666666666666662
r17152 n9664 n9665 0.082250000000000004
r17153 n9641 n9666 0.018799999999999997
r17154 n9665 n9666 0.15275
r17155 n9642 n9667 0.018799999999999997
r17156 n9643 n9668 0.026857142857142857
r17157 n9667 n9668 0.19975000000000001
r17158 n9644 n9669 0.062666666666666662
r17159 n9668 n9669 0.11750000000000001
r17160 n9645 n9670 0.062666666666666662
r17161 n9669 n9670 0.070499999999999993
r17162 n9646 n9671 0.094
r17163 n9670 n9671 0.058750000000000004
r17164 n9647 n9672 0.017090909090909091
r17165 n9671 n9672 0.15275
r17166 n9648 n9673 0.0098947368421052635
r17167 n9672 n9673 0.35249999999999998
r17168 n9649 n9674 0.094
r17169 n9673 n9674 0.24674999999999997
r17170 n9650 n9675 0.062666666666666662
r17171 n9674 n9675 0.058750000000000004
r17172 n9651 n9676 0.062666666666666662
r17173 n9675 n9676 0.070499999999999993
r17174 n9652 n9677 0.026857142857142857
r17175 n9676 n9677 0.11750000000000001
r17176 n9653 n9678 0.018799999999999997
r17177 n9677 n9678 0.19975000000000001
r17178 n9654 n9679 0.01175
r17179 n9655 n9680 0.016785714285714286
r17180 n9679 n9680 0.13316666666666668
r17181 n9656 n9681 0.039166666666666669
r17182 n9680 n9681 0.078333333333333338
r17183 n9657 n9682 0.039166666666666669
r17184 n9681 n9682 0.047
r17185 n9658 n9683 0.058750000000000004
r17186 n9682 n9683 0.039166666666666669
r17187 n9659 n9684 0.014687500000000001
r17188 n9683 n9684 0.078333333333333338
r17189 n9660 n9685 0.0053409090909090915
r17190 n9684 n9685 0.23499999999999999
r17191 n9661 n9686 0.058750000000000004
r17192 n9685 n9686 0.188
r17193 n9662 n9687 0.039166666666666669
r17194 n9686 n9687 0.039166666666666669
r17195 n9663 n9688 0.039166666666666669
r17196 n9687 n9688 0.047
r17197 n9664 n9689 0.029375000000000002
r17198 n9688 n9689 0.054833333333333331
r17199 n9665 n9690 0.039166666666666669
r17200 n9689 n9690 0.054833333333333331
r17201 n9666 n9691 0.01175
r17202 n9690 n9691 0.10183333333333335
r17203 n9667 n9692 0.01175
r17204 n9668 n9693 0.016785714285714286
r17205 n9692 n9693 0.13316666666666668
r17206 n9669 n9694 0.039166666666666669
r17207 n9693 n9694 0.078333333333333338
r17208 n9670 n9695 0.039166666666666669
r17209 n9694 n9695 0.047
r17210 n9671 n9696 0.058750000000000004
r17211 n9695 n9696 0.039166666666666669
r17212 n9672 n9697 0.010681818181818183
r17213 n9696 n9697 0.10183333333333335
r17214 n9673 n9698 0.0061842105263157894
r17215 n9697 n9698 0.23499999999999999
r17216 n9674 n9699 0.058750000000000004
r17217 n9698 n9699 0.16449999999999998
r17218 n9675 n9700 0.039166666666666669
r17219 n9699 n9700 0.039166666666666669
r17220 n9676 n9701 0.039166666666666669
r17221 n9700 n9701 0.047
r17222 n9677 n9702 0.016785714285714286
r17223 n9701 n9702 0.078333333333333338
r17224 n9678 n9703 0.01175
r17225 n9702 n9703 0.13316666666666668
r17226 n9679 n9704 0.01175
r17227 n9680 n9705 0.016785714285714286
r17228 n9704 n9705 0.19975000000000001
r17229 n9681 n9706 0.039166666666666669
r17230 n9705 n9706 0.11750000000000001
r17231 n9682 n9707 0.039166666666666669
r17232 n9706 n9707 0.070499999999999993
r17233 n9683 n9708 0.058750000000000004
r17234 n9707 n9708 0.058750000000000004
r17235 n9684 n9709 0.014687500000000001
r17236 n9708 n9709 0.11750000000000001
r17237 n9685 n9710 0.0053409090909090915
r17238 n9709 n9710 0.35249999999999998
r17239 n9686 n9711 0.058750000000000004
r17240 n9710 n9711 0.28199999999999997
r17241 n9687 n9712 0.039166666666666669
r17242 n9711 n9712 0.058750000000000004
r17243 n9688 n9713 0.039166666666666669
r17244 n9712 n9713 0.070499999999999993
r17245 n9689 n9714 0.029375000000000002
r17246 n9713 n9714 0.082250000000000004
r17247 n9690 n9715 0.039166666666666669
r17248 n9714 n9715 0.082250000000000004
r17249 n9691 n9716 0.01175
r17250 n9715 n9716 0.15275
r17251 n9692 n9717 0.01175
r17252 n9693 n9718 0.016785714285714286
r17253 n9717 n9718 0.19975000000000001
r17254 n9694 n9719 0.039166666666666669
r17255 n9718 n9719 0.11750000000000001
r17256 n9695 n9720 0.039166666666666669
r17257 n9719 n9720 0.070499999999999993
r17258 n9696 n9721 0.058750000000000004
r17259 n9720 n9721 0.058750000000000004
r17260 n9697 n9722 0.010681818181818183
r17261 n9721 n9722 0.15275
r17262 n9698 n9723 0.0061842105263157894
r17263 n9722 n9723 0.35249999999999998
r17264 n9699 n9724 0.058750000000000004
r17265 n9723 n9724 0.24674999999999997
r17266 n9700 n9725 0.039166666666666669
r17267 n9724 n9725 0.058750000000000004
r17268 n9701 n9726 0.039166666666666669
r17269 n9725 n9726 0.070499999999999993
r17270 n9702 n9727 0.016785714285714286
r17271 n9726 n9727 0.11750000000000001
r17272 n9703 n9728 0.01175
r17273 n9727 n9728 0.19975000000000001
r17274 n9704 n9729 0.075199999999999989
r17275 n9705 n9730 0.10742857142857143
r17276 n9729 n9730 0.013316666666666668
r17277 n9706 n9731 0.25066666666666665
r17278 n9730 n9731 0.0078333333333333328
r17279 n9707 n9732 0.25066666666666665
r17280 n9731 n9732 0.0046999999999999993
r17281 n9708 n9733 0.376
r17282 n9732 n9733 0.0039166666666666664
r17283 n9709 n9734 0.094
r17284 n9733 n9734 0.0078333333333333328
r17285 n9710 n9735 0.034181818181818181
r17286 n9734 n9735 0.0235
r17287 n9711 n9736 0.376
r17288 n9735 n9736 0.018799999999999997
r17289 n9712 n9737 0.25066666666666665
r17290 n9736 n9737 0.0039166666666666664
r17291 n9713 n9738 0.25066666666666665
r17292 n9737 n9738 0.0046999999999999993
r17293 n9714 n9739 0.188
r17294 n9738 n9739 0.0054833333333333331
r17295 n9715 n9740 0.25066666666666665
r17296 n9739 n9740 0.0054833333333333331
r17297 n9716 n9741 0.075199999999999989
r17298 n9740 n9741 0.010183333333333334
r17299 n9717 n9742 0.075199999999999989
r17300 n9718 n9743 0.10742857142857143
r17301 n9742 n9743 0.013316666666666668
r17302 n9719 n9744 0.25066666666666665
r17303 n9743 n9744 0.0078333333333333328
r17304 n9720 n9745 0.25066666666666665
r17305 n9744 n9745 0.0046999999999999993
r17306 n9721 n9746 0.376
r17307 n9745 n9746 0.0039166666666666664
r17308 n9722 n9747 0.068363636363636363
r17309 n9746 n9747 0.010183333333333334
r17310 n9723 n9748 0.039578947368421054
r17311 n9747 n9748 0.0235
r17312 n9724 n9749 0.376
r17313 n9748 n9749 0.016449999999999999
r17314 n9725 n9750 0.25066666666666665
r17315 n9749 n9750 0.0039166666666666664
r17316 n9726 n9751 0.25066666666666665
r17317 n9750 n9751 0.0046999999999999993
r17318 n9727 n9752 0.10742857142857143
r17319 n9751 n9752 0.0078333333333333328
r17320 n9728 n9753 0.075199999999999989
r17321 n9752 n9753 0.013316666666666668
r17322 n9729 n9754 0.075199999999999989
r17323 n9730 n9755 0.10742857142857143
r17324 n9754 n9755 0.19975000000000001
r17325 n9731 n9756 0.25066666666666665
r17326 n9755 n9756 0.11750000000000001
r17327 n9732 n9757 0.25066666666666665
r17328 n9756 n9757 0.070499999999999993
r17329 n9733 n9758 0.376
r17330 n9757 n9758 0.058750000000000004
r17331 n9734 n9759 0.094
r17332 n9758 n9759 0.11750000000000001
r17333 n9735 n9760 0.034181818181818181
r17334 n9759 n9760 0.35249999999999998
r17335 n9736 n9761 0.376
r17336 n9760 n9761 0.28199999999999997
r17337 n9737 n9762 0.25066666666666665
r17338 n9761 n9762 0.058750000000000004
r17339 n9738 n9763 0.25066666666666665
r17340 n9762 n9763 0.070499999999999993
r17341 n9739 n9764 0.188
r17342 n9763 n9764 0.082250000000000004
r17343 n9740 n9765 0.25066666666666665
r17344 n9764 n9765 0.082250000000000004
r17345 n9741 n9766 0.075199999999999989
r17346 n9765 n9766 0.15275
r17347 n9742 n9767 0.075199999999999989
r17348 n9743 n9768 0.10742857142857143
r17349 n9767 n9768 0.19975000000000001
r17350 n9744 n9769 0.25066666666666665
r17351 n9768 n9769 0.11750000000000001
r17352 n9745 n9770 0.25066666666666665
r17353 n9769 n9770 0.070499999999999993
r17354 n9746 n9771 0.376
r17355 n9770 n9771 0.058750000000000004
r17356 n9747 n9772 0.068363636363636363
r17357 n9771 n9772 0.15275
r17358 n9748 n9773 0.039578947368421054
r17359 n9772 n9773 0.35249999999999998
r17360 n9749 n9774 0.376
r17361 n9773 n9774 0.24674999999999997
r17362 n9750 n9775 0.25066666666666665
r17363 n9774 n9775 0.058750000000000004
r17364 n9751 n9776 0.25066666666666665
r17365 n9775 n9776 0.070499999999999993
r17366 n9752 n9777 0.10742857142857143
r17367 n9776 n9777 0.11750000000000001
r17368 n9753 n9778 0.075199999999999989
r17369 n9777 n9778 0.19975000000000001
r17370 n9754 n9779 0.01175
r17371 n9755 n9780 0.016785714285714286
r17372 n9779 n9780 0.13316666666666668
r17373 n9756 n9781 0.039166666666666669
r17374 n9780 n9781 0.078333333333333338
r17375 n9757 n9782 0.039166666666666669
r17376 n9781 n9782 0.047
r17377 n9758 n9783 0.058750000000000004
r17378 n9782 n9783 0.039166666666666669
r17379 n9759 n9784 0.014687500000000001
r17380 n9783 n9784 0.078333333333333338
r17381 n9760 n9785 0.0053409090909090915
r17382 n9784 n9785 0.23499999999999999
r17383 n9761 n9786 0.058750000000000004
r17384 n9785 n9786 0.188
r17385 n9762 n9787 0.039166666666666669
r17386 n9786 n9787 0.039166666666666669
r17387 n9763 n9788 0.039166666666666669
r17388 n9787 n9788 0.047
r17389 n9764 n9789 0.029375000000000002
r17390 n9788 n9789 0.054833333333333331
r17391 n9765 n9790 0.039166666666666669
r17392 n9789 n9790 0.054833333333333331
r17393 n9766 n9791 0.01175
r17394 n9790 n9791 0.10183333333333335
r17395 n9767 n9792 0.01175
r17396 n9768 n9793 0.016785714285714286
r17397 n9792 n9793 0.13316666666666668
r17398 n9769 n9794 0.039166666666666669
r17399 n9793 n9794 0.078333333333333338
r17400 n9770 n9795 0.039166666666666669
r17401 n9794 n9795 0.047
r17402 n9771 n9796 0.058750000000000004
r17403 n9795 n9796 0.039166666666666669
r17404 n9772 n9797 0.010681818181818183
r17405 n9796 n9797 0.10183333333333335
r17406 n9773 n9798 0.0061842105263157894
r17407 n9797 n9798 0.23499999999999999
r17408 n9774 n9799 0.058750000000000004
r17409 n9798 n9799 0.16449999999999998
r17410 n9775 n9800 0.039166666666666669
r17411 n9799 n9800 0.039166666666666669
r17412 n9776 n9801 0.039166666666666669
r17413 n9800 n9801 0.047
r17414 n9777 n9802 0.016785714285714286
r17415 n9801 n9802 0.078333333333333338
r17416 n9778 n9803 0.01175
r17417 n9802 n9803 0.13316666666666668
r17418 n9779 n9804 0.01175
r17419 n9780 n9805 0.016785714285714286
r17420 n9804 n9805 0.19975000000000001
r17421 n9781 n9806 0.039166666666666669
r17422 n9805 n9806 0.11750000000000001
r17423 n9782 n9807 0.039166666666666669
r17424 n9806 n9807 0.070499999999999993
r17425 n9783 n9808 0.058750000000000004
r17426 n9807 n9808 0.058750000000000004
r17427 n9784 n9809 0.014687500000000001
r17428 n9808 n9809 0.11750000000000001
r17429 n9785 n9810 0.0053409090909090915
r17430 n9809 n9810 0.35249999999999998
r17431 n9786 n9811 0.058750000000000004
r17432 n9810 n9811 0.28199999999999997
r17433 n9787 n9812 0.039166666666666669
r17434 n9811 n9812 0.058750000000000004
r17435 n9788 n9813 0.039166666666666669
r17436 n9812 n9813 0.070499999999999993
r17437 n9789 n9814 0.029375000000000002
r17438 n9813 n9814 0.082250000000000004
r17439 n9790 n9815 0.039166666666666669
r17440 n9814 n9815 0.082250000000000004
r17441 n9791 n9816 0.01175
r17442 n9815 n9816 0.15275
r17443 n9792 n9817 0.01175
r17444 n9793 n9818 0.016785714285714286
r17445 n9817 n9818 0.19975000000000001
r17446 n9794 n9819 0.039166666666666669
r17447 n9818 n9819 0.11750000000000001
r17448 n9795 n9820 0.039166666666666669
r17449 n9819 n9820 0.070499999999999993
r17450 n9796 n9821 0.058750000000000004
r17451 n9820 n9821 0.058750000000000004
r17452 n9797 n9822 0.010681818181818183
r17453 n9821 n9822 0.15275
r17454 n9798 n9823 0.0061842105263157894
r17455 n9822 n9823 0.35249999999999998
r17456 n9799 n9824 0.058750000000000004
r17457 n9823 n9824 0.24674999999999997
r17458 n9800 n9825 0.039166666666666669
r17459 n9824 n9825 0.058750000000000004
r17460 n9801 n9826 0.039166666666666669
r17461 n9825 n9826 0.070499999999999993
r17462 n9802 n9827 0.016785714285714286
r17463 n9826 n9827 0.11750000000000001
r17464 n9803 n9828 0.01175
r17465 n9827 n9828 0.19975000000000001
r17466 n9804 n9829 0.018799999999999997
r17467 n9805 n9830 0.026857142857142857
r17468 n9829 n9830 0.066583333333333342
r17469 n9806 n9831 0.062666666666666662
r17470 n9830 n9831 0.039166666666666669
r17471 n9807 n9832 0.062666666666666662
r17472 n9831 n9832 0.0235
r17473 n9808 n9833 0.094
r17474 n9832 n9833 0.019583333333333335
r17475 n9809 n9834 0.0235
r17476 n9833 n9834 0.039166666666666669
r17477 n9810 n9835 0.0085454545454545453
r17478 n9834 n9835 0.11749999999999999
r17479 n9811 n9836 0.094
r17480 n9835 n9836 0.094
r17481 n9812 n9837 0.062666666666666662
r17482 n9836 n9837 0.019583333333333335
r17483 n9813 n9838 0.062666666666666662
r17484 n9837 n9838 0.0235
r17485 n9814 n9839 0.047
r17486 n9838 n9839 0.027416666666666666
r17487 n9815 n9840 0.062666666666666662
r17488 n9839 n9840 0.027416666666666666
r17489 n9816 n9841 0.018799999999999997
r17490 n9840 n9841 0.050916666666666673
r17491 n9817 n9842 0.018799999999999997
r17492 n9818 n9843 0.026857142857142857
r17493 n9842 n9843 0.066583333333333342
r17494 n9819 n9844 0.062666666666666662
r17495 n9843 n9844 0.039166666666666669
r17496 n9820 n9845 0.062666666666666662
r17497 n9844 n9845 0.0235
r17498 n9821 n9846 0.094
r17499 n9845 n9846 0.019583333333333335
r17500 n9822 n9847 0.017090909090909091
r17501 n9846 n9847 0.050916666666666673
r17502 n9823 n9848 0.0098947368421052635
r17503 n9847 n9848 0.11749999999999999
r17504 n9824 n9849 0.094
r17505 n9848 n9849 0.08224999999999999
r17506 n9825 n9850 0.062666666666666662
r17507 n9849 n9850 0.019583333333333335
r17508 n9826 n9851 0.062666666666666662
r17509 n9850 n9851 0.0235
r17510 n9827 n9852 0.026857142857142857
r17511 n9851 n9852 0.039166666666666669
r17512 n9828 n9853 0.018799999999999997
r17513 n9852 n9853 0.066583333333333342
r17514 n9829 n9854 0.018799999999999997
r17515 n9830 n9855 0.026857142857142857
r17516 n9854 n9855 0.19975000000000001
r17517 n9831 n9856 0.062666666666666662
r17518 n9855 n9856 0.11750000000000001
r17519 n9832 n9857 0.062666666666666662
r17520 n9856 n9857 0.070499999999999993
r17521 n9833 n9858 0.094
r17522 n9857 n9858 0.058750000000000004
r17523 n9834 n9859 0.0235
r17524 n9858 n9859 0.11750000000000001
r17525 n9835 n9860 0.0085454545454545453
r17526 n9859 n9860 0.35249999999999998
r17527 n9836 n9861 0.094
r17528 n9860 n9861 0.28199999999999997
r17529 n9837 n9862 0.062666666666666662
r17530 n9861 n9862 0.058750000000000004
r17531 n9838 n9863 0.062666666666666662
r17532 n9862 n9863 0.070499999999999993
r17533 n9839 n9864 0.047
r17534 n9863 n9864 0.082250000000000004
r17535 n9840 n9865 0.062666666666666662
r17536 n9864 n9865 0.082250000000000004
r17537 n9841 n9866 0.018799999999999997
r17538 n9865 n9866 0.15275
r17539 n9842 n9867 0.018799999999999997
r17540 n9843 n9868 0.026857142857142857
r17541 n9867 n9868 0.19975000000000001
r17542 n9844 n9869 0.062666666666666662
r17543 n9868 n9869 0.11750000000000001
r17544 n9845 n9870 0.062666666666666662
r17545 n9869 n9870 0.070499999999999993
r17546 n9846 n9871 0.094
r17547 n9870 n9871 0.058750000000000004
r17548 n9847 n9872 0.017090909090909091
r17549 n9871 n9872 0.15275
r17550 n9848 n9873 0.0098947368421052635
r17551 n9872 n9873 0.35249999999999998
r17552 n9849 n9874 0.094
r17553 n9873 n9874 0.24674999999999997
r17554 n9850 n9875 0.062666666666666662
r17555 n9874 n9875 0.058750000000000004
r17556 n9851 n9876 0.062666666666666662
r17557 n9875 n9876 0.070499999999999993
r17558 n9852 n9877 0.026857142857142857
r17559 n9876 n9877 0.11750000000000001
r17560 n9853 n9878 0.018799999999999997
r17561 n9877 n9878 0.19975000000000001
r17562 n9854 n9879 0.01175
r17563 n9855 n9880 0.016785714285714286
r17564 n9879 n9880 0.13316666666666668
r17565 n9856 n9881 0.039166666666666669
r17566 n9880 n9881 0.078333333333333338
r17567 n9857 n9882 0.039166666666666669
r17568 n9881 n9882 0.047
r17569 n9858 n9883 0.058750000000000004
r17570 n9882 n9883 0.039166666666666669
r17571 n9859 n9884 0.014687500000000001
r17572 n9883 n9884 0.078333333333333338
r17573 n9860 n9885 0.0053409090909090915
r17574 n9884 n9885 0.23499999999999999
r17575 n9861 n9886 0.058750000000000004
r17576 n9885 n9886 0.188
r17577 n9862 n9887 0.039166666666666669
r17578 n9886 n9887 0.039166666666666669
r17579 n9863 n9888 0.039166666666666669
r17580 n9887 n9888 0.047
r17581 n9864 n9889 0.029375000000000002
r17582 n9888 n9889 0.054833333333333331
r17583 n9865 n9890 0.039166666666666669
r17584 n9889 n9890 0.054833333333333331
r17585 n9866 n9891 0.01175
r17586 n9890 n9891 0.10183333333333335
r17587 n9867 n9892 0.01175
r17588 n9868 n9893 0.016785714285714286
r17589 n9892 n9893 0.13316666666666668
r17590 n9869 n9894 0.039166666666666669
r17591 n9893 n9894 0.078333333333333338
r17592 n9870 n9895 0.039166666666666669
r17593 n9894 n9895 0.047
r17594 n9871 n9896 0.058750000000000004
r17595 n9895 n9896 0.039166666666666669
r17596 n9872 n9897 0.010681818181818183
r17597 n9896 n9897 0.10183333333333335
r17598 n9873 n9898 0.0061842105263157894
r17599 n9897 n9898 0.23499999999999999
r17600 n9874 n9899 0.058750000000000004
r17601 n9898 n9899 0.16449999999999998
r17602 n9875 n9900 0.039166666666666669
r17603 n9899 n9900 0.039166666666666669
r17604 n9876 n9901 0.039166666666666669
r17605 n9900 n9901 0.047
r17606 n9877 n9902 0.016785714285714286
r17607 n9901 n9902 0.078333333333333338
r17608 n9878 n9903 0.01175
r17609 n9902 n9903 0.13316666666666668
r17610 n9879 n9904 0.016449999999999999
r17611 n9880 n9905 0.0235
r17612 n9904 n9905 0.099875000000000005
r17613 n9881 n9906 0.054833333333333331
r17614 n9905 n9906 0.058750000000000004
r17615 n9882 n9907 0.054833333333333331
r17616 n9906 n9907 0.035249999999999997
r17617 n9883 n9908 0.082250000000000004
r17618 n9907 n9908 0.029375000000000002
r17619 n9884 n9909 0.020562500000000001
r17620 n9908 n9909 0.058750000000000004
r17621 n9885 n9910 0.0074772727272727274
r17622 n9909 n9910 0.17624999999999999
r17623 n9886 n9911 0.082250000000000004
r17624 n9910 n9911 0.14099999999999999
r17625 n9887 n9912 0.054833333333333331
r17626 n9911 n9912 0.029375000000000002
r17627 n9888 n9913 0.054833333333333331
r17628 n9912 n9913 0.035249999999999997
r17629 n9889 n9914 0.041125000000000002
r17630 n9913 n9914 0.041125000000000002
r17631 n9890 n9915 0.054833333333333331
r17632 n9914 n9915 0.041125000000000002
r17633 n9891 n9916 0.016449999999999999
r17634 n9915 n9916 0.076374999999999998
r17635 n9892 n9917 0.016449999999999999
r17636 n9893 n9918 0.0235
r17637 n9917 n9918 0.099875000000000005
r17638 n9894 n9919 0.054833333333333331
r17639 n9918 n9919 0.058750000000000004
r17640 n9895 n9920 0.054833333333333331
r17641 n9919 n9920 0.035249999999999997
r17642 n9896 n9921 0.082250000000000004
r17643 n9920 n9921 0.029375000000000002
r17644 n9897 n9922 0.014954545454545455
r17645 n9921 n9922 0.076374999999999998
r17646 n9898 n9923 0.0086578947368421057
r17647 n9922 n9923 0.17624999999999999
r17648 n9899 n9924 0.082250000000000004
r17649 n9923 n9924 0.12337499999999998
r17650 n9900 n9925 0.054833333333333331
r17651 n9924 n9925 0.029375000000000002
r17652 n9901 n9926 0.054833333333333331
r17653 n9925 n9926 0.035249999999999997
r17654 n9902 n9927 0.0235
r17655 n9926 n9927 0.058750000000000004
r17656 n9903 n9928 0.016449999999999999
r17657 n9927 n9928 0.099875000000000005
r17658 n9904 n9929 0.016449999999999999
r17659 n9905 n9930 0.0235
r17660 n9929 n9930 0.13316666666666668
r17661 n9906 n9931 0.054833333333333331
r17662 n9930 n9931 0.078333333333333338
r17663 n9907 n9932 0.054833333333333331
r17664 n9931 n9932 0.047
r17665 n9908 n9933 0.082250000000000004
r17666 n9932 n9933 0.039166666666666669
r17667 n9909 n9934 0.020562500000000001
r17668 n9933 n9934 0.078333333333333338
r17669 n9910 n9935 0.0074772727272727274
r17670 n9934 n9935 0.23499999999999999
r17671 n9911 n9936 0.082250000000000004
r17672 n9935 n9936 0.188
r17673 n9912 n9937 0.054833333333333331
r17674 n9936 n9937 0.039166666666666669
r17675 n9913 n9938 0.054833333333333331
r17676 n9937 n9938 0.047
r17677 n9914 n9939 0.041125000000000002
r17678 n9938 n9939 0.054833333333333331
r17679 n9915 n9940 0.054833333333333331
r17680 n9939 n9940 0.054833333333333331
r17681 n9916 n9941 0.016449999999999999
r17682 n9940 n9941 0.10183333333333335
r17683 n9917 n9942 0.016449999999999999
r17684 n9918 n9943 0.0235
r17685 n9942 n9943 0.13316666666666668
r17686 n9919 n9944 0.054833333333333331
r17687 n9943 n9944 0.078333333333333338
r17688 n9920 n9945 0.054833333333333331
r17689 n9944 n9945 0.047
r17690 n9921 n9946 0.082250000000000004
r17691 n9945 n9946 0.039166666666666669
r17692 n9922 n9947 0.014954545454545455
r17693 n9946 n9947 0.10183333333333335
r17694 n9923 n9948 0.0086578947368421057
r17695 n9947 n9948 0.23499999999999999
r17696 n9924 n9949 0.082250000000000004
r17697 n9948 n9949 0.16449999999999998
r17698 n9925 n9950 0.054833333333333331
r17699 n9949 n9950 0.039166666666666669
r17700 n9926 n9951 0.054833333333333331
r17701 n9950 n9951 0.047
r17702 n9927 n9952 0.0235
r17703 n9951 n9952 0.078333333333333338
r17704 n9928 n9953 0.016449999999999999
r17705 n9952 n9953 0.13316666666666668
r17706 n23 0 158.10000000000002
r17707 n24 0 10.540000000000001
r17708 n25 0 158.10000000000002
r17709 n463 n3009 158.10000000000002
r17710 n464 n3010 10.540000000000001
r17711 n465 n3011 158.10000000000002
r17712 n1004 n3404 167.98125000000002
r17713 n1005 n3405 2687.7000000000003
r17714 n1119 n3511 67.192499999999995
r17715 n1120 n3512 1075.0799999999999
r17716 n1234 n3618 22.397500000000004
r17717 n1235 n3619 358.36000000000007
r17718 n1349 n3725 111.98750000000001
r17719 n1350 n3726 1791.8000000000002
r17720 n1464 n3832 83.990625000000009
r17721 n1465 n3833 1343.8500000000001
r17722 n1579 n3955 111.98750000000001
r17723 n1580 n3956 1791.8000000000002
r17724 n1702 n4078 167.98125000000002
r17725 n1703 n4079 2687.7000000000003
r17726 n1933 n4775 167.98125000000002
r17727 n1934 n4776 2687.7000000000003
r17728 n2056 n4907 111.98750000000001
r17729 n2057 n4908 1791.8000000000002
r17730 n2179 n5030 83.990625000000009
r17731 n2180 n5031 1343.8500000000001
r17732 n2294 n5153 111.98750000000001
r17733 n2295 n5154 1791.8000000000002
r17734 n2409 n5260 22.397500000000004
r17735 n2410 n5261 358.36000000000007
r17736 n2524 n5367 67.192499999999995
r17737 n2525 n5368 1075.0799999999999
r17738 n2639 n5474 167.98125000000002
r17739 n2640 n5475 2687.7000000000003
r17740 n1008 n3408 413.49230769230769
r17741 n1009 n3409 447.95000000000005
r17742 n1010 n3410 767.91428571428582
r17743 n1011 n3411 2687.7000000000003
r17744 n1123 n3515 165.39692307692309
r17745 n1124 n3516 179.18000000000004
r17746 n1125 n3517 307.16571428571433
r17747 n1126 n3518 1075.0799999999999
r17748 n1238 n3622 55.132307692307698
r17749 n1239 n3623 59.726666666666674
r17750 n1240 n3624 102.38857142857144
r17751 n1241 n3625 358.36000000000007
r17752 n1353 n3729 275.66153846153844
r17753 n1354 n3730 298.63333333333338
r17754 n1355 n3731 511.94285714285718
r17755 n1356 n3732 1791.8000000000002
r17756 n1468 n3836 206.74615384615385
r17757 n1469 n3837 223.97500000000002
r17758 n1470 n3838 383.95714285714291
r17759 n1471 n3839 1343.8500000000001
r17760 n1583 n3959 275.66153846153844
r17761 n1584 n3960 298.63333333333338
r17762 n1585 n3961 511.94285714285718
r17763 n1586 n3962 1791.8000000000002
r17764 n1706 n4082 413.49230769230769
r17765 n1707 n4083 447.95000000000005
r17766 n1708 n4084 767.91428571428582
r17767 n1709 n4085 2687.7000000000003
r17768 n1937 n4779 413.49230769230769
r17769 n1938 n4780 447.95000000000005
r17770 n1939 n4781 767.91428571428582
r17771 n1940 n4782 2687.7000000000003
r17772 n2060 n4911 275.66153846153844
r17773 n2061 n4912 298.63333333333338
r17774 n2062 n4913 511.94285714285718
r17775 n2063 n4914 1791.8000000000002
r17776 n2183 n5034 206.74615384615385
r17777 n2184 n5035 223.97500000000002
r17778 n2185 n5036 383.95714285714291
r17779 n2186 n5037 1343.8500000000001
r17780 n2298 n5157 275.66153846153844
r17781 n2299 n5158 298.63333333333338
r17782 n2300 n5159 511.94285714285718
r17783 n2301 n5160 1791.8000000000002
r17784 n2413 n5264 55.132307692307698
r17785 n2414 n5265 59.726666666666674
r17786 n2415 n5266 102.38857142857144
r17787 n2416 n5267 358.36000000000007
r17788 n2528 n5371 165.39692307692309
r17789 n2529 n5372 179.18000000000004
r17790 n2530 n5373 307.16571428571433
r17791 n2531 n5374 1075.0799999999999
r17792 n2643 n5478 413.49230769230769
r17793 n2644 n5479 447.95000000000005
r17794 n2645 n5480 767.91428571428582
r17795 n2646 n5481 2687.7000000000003
r17796 n520 n3150 2687.7000000000003
r17797 n521 n3151 597.26666666666677
r17798 n522 n3152 447.95000000000005
r17799 n523 n3153 597.26666666666677
r17800 n524 n3154 2687.7000000000003
r17801 n676 n3171 179.18000000000004
r17802 n677 n3172 39.817777777777778
r17803 n678 n3173 29.863333333333337
r17804 n679 n3174 39.817777777777778
r17805 n680 n3175 179.18000000000004
r17806 n832 n3192 2687.7000000000003
r17807 n833 n3193 597.26666666666677
r17808 n834 n3194 447.95000000000005
r17809 n835 n3195 597.26666666666677
r17810 n836 n3196 2687.7000000000003
r17811 n1017 n3417 597.26666666666677
r17812 n1018 n3418 447.95000000000005
r17813 n1019 n3419 597.26666666666677
r17814 n1020 n3420 2687.7000000000003
r17815 n1021 n3421 2687.7000000000003
r17816 n1132 n3524 238.90666666666669
r17817 n1133 n3525 179.18000000000004
r17818 n1134 n3526 238.90666666666669
r17819 n1135 n3527 1075.0799999999999
r17820 n1136 n3528 1075.0799999999999
r17821 n1247 n3631 79.635555555555555
r17822 n1248 n3632 59.726666666666674
r17823 n1249 n3633 79.635555555555555
r17824 n1250 n3634 358.36000000000007
r17825 n1251 n3635 358.36000000000007
r17826 n1362 n3738 398.17777777777781
r17827 n1363 n3739 298.63333333333338
r17828 n1364 n3740 398.17777777777781
r17829 n1365 n3741 1791.8000000000002
r17830 n1366 n3742 1791.8000000000002
r17831 n1477 n3845 298.63333333333338
r17832 n1478 n3846 223.97500000000002
r17833 n1479 n3847 298.63333333333338
r17834 n1480 n3848 1343.8500000000001
r17835 n1481 n3849 1343.8500000000001
r17836 n1592 n3968 398.17777777777781
r17837 n1593 n3969 298.63333333333338
r17838 n1594 n3970 398.17777777777781
r17839 n1595 n3971 1791.8000000000002
r17840 n1596 n3972 1791.8000000000002
r17841 n1715 n4091 597.26666666666677
r17842 n1716 n4092 447.95000000000005
r17843 n1717 n4093 597.26666666666677
r17844 n1718 n4094 2687.7000000000003
r17845 n1719 n4095 2687.7000000000003
r17846 n1946 n4788 597.26666666666677
r17847 n1947 n4789 447.95000000000005
r17848 n1948 n4790 597.26666666666677
r17849 n1949 n4791 2687.7000000000003
r17850 n1950 n4792 2687.7000000000003
r17851 n2069 n4920 398.17777777777781
r17852 n2070 n4921 298.63333333333338
r17853 n2071 n4922 398.17777777777781
r17854 n2072 n4923 1791.8000000000002
r17855 n2073 n4924 1791.8000000000002
r17856 n2192 n5043 298.63333333333338
r17857 n2193 n5044 223.97500000000002
r17858 n2194 n5045 298.63333333333338
r17859 n2195 n5046 1343.8500000000001
r17860 n2196 n5047 1343.8500000000001
r17861 n2307 n5166 398.17777777777781
r17862 n2308 n5167 298.63333333333338
r17863 n2309 n5168 398.17777777777781
r17864 n2310 n5169 1791.8000000000002
r17865 n2311 n5170 1791.8000000000002
r17866 n2422 n5273 79.635555555555555
r17867 n2423 n5274 59.726666666666674
r17868 n2424 n5275 79.635555555555555
r17869 n2425 n5276 358.36000000000007
r17870 n2426 n5277 358.36000000000007
r17871 n2537 n5380 238.90666666666669
r17872 n2538 n5381 179.18000000000004
r17873 n2539 n5382 238.90666666666669
r17874 n2540 n5383 1075.0799999999999
r17875 n2541 n5384 1075.0799999999999
r17876 n2652 n5487 597.26666666666677
r17877 n2653 n5488 447.95000000000005
r17878 n2654 n5489 597.26666666666677
r17879 n2655 n5490 2687.7000000000003
r17880 n2656 n5491 2687.7000000000003
r17881 n1025 n3425 167.98125000000002
r17882 n1026 n3426 2687.7000000000003
r17883 n1140 n3532 67.192499999999995
r17884 n1141 n3533 1075.0799999999999
r17885 n1255 n3639 22.397500000000004
r17886 n1256 n3640 358.36000000000007
r17887 n1370 n3746 111.98750000000001
r17888 n1371 n3747 1791.8000000000002
r17889 n1485 n3853 83.990625000000009
r17890 n1486 n3854 1343.8500000000001
r17891 n1600 n3976 111.98750000000001
r17892 n1601 n3977 1791.8000000000002
r17893 n1723 n4099 167.98125000000002
r17894 n1724 n4100 2687.7000000000003
r17895 n1954 n4796 167.98125000000002
r17896 n1955 n4797 2687.7000000000003
r17897 n2077 n4928 111.98750000000001
r17898 n2078 n4929 1791.8000000000002
r17899 n2200 n5051 83.990625000000009
r17900 n2201 n5052 1343.8500000000001
r17901 n2315 n5174 111.98750000000001
r17902 n2316 n5175 1791.8000000000002
r17903 n2430 n5281 22.397500000000004
r17904 n2431 n5282 358.36000000000007
r17905 n2545 n5388 67.192499999999995
r17906 n2546 n5389 1075.0799999999999
r17907 n2660 n5495 167.98125000000002
r17908 n2661 n5496 2687.7000000000003
r17909 n1858 n4446 2687.7000000000003
r17910 n1859 n4447 671.92500000000007
r17911 n1860 n4448 244.33636363636364
r17912 n1861 n4449 2687.7000000000003
r17913 n1870 n4482 179.18000000000004
r17914 n1871 n4483 44.795000000000009
r17915 n1872 n4484 16.289090909090913
r17916 n1873 n4485 179.18000000000004
r17917 n1882 n4517 2687.7000000000003
r17918 n1883 n4518 671.92500000000007
r17919 n1884 n4519 244.33636363636364
r17920 n1885 n4520 2687.7000000000003
r17921 n1034 n3430 167.98125000000002
r17922 n1035 n3431 2687.7000000000003
r17923 n1149 n3537 67.192499999999995
r17924 n1150 n3538 1075.0799999999999
r17925 n1264 n3644 22.397500000000004
r17926 n1265 n3645 358.36000000000007
r17927 n1379 n3751 111.98750000000001
r17928 n1380 n3752 1791.8000000000002
r17929 n1494 n3866 83.990625000000009
r17930 n1495 n3867 1343.8500000000001
r17931 n1613 n3989 111.98750000000001
r17932 n1614 n3990 1791.8000000000002
r17933 n1736 n4117 167.98125000000002
r17934 n1737 n4118 2687.7000000000003
r17935 n1967 n4814 167.98125000000002
r17936 n1968 n4815 2687.7000000000003
r17937 n2090 n4941 111.98750000000001
r17938 n2091 n4942 1791.8000000000002
r17939 n2209 n5064 83.990625000000009
r17940 n2210 n5065 1343.8500000000001
r17941 n2324 n5179 111.98750000000001
r17942 n2325 n5180 1791.8000000000002
r17943 n2439 n5286 22.397500000000004
r17944 n2440 n5287 358.36000000000007
r17945 n2554 n5393 67.192499999999995
r17946 n2555 n5394 1075.0799999999999
r17947 n2669 n5500 167.98125000000002
r17948 n2670 n5501 2687.7000000000003
r17949 n1038 n3434 167.98125000000002
r17950 n1039 n3435 2687.7000000000003
r17951 n1153 n3541 67.192499999999995
r17952 n1154 n3542 1075.0799999999999
r17953 n1268 n3648 22.397500000000004
r17954 n1269 n3649 358.36000000000007
r17955 n1383 n3755 111.98750000000001
r17956 n1384 n3756 1791.8000000000002
r17957 n1498 n3870 83.990625000000009
r17958 n1499 n3871 1343.8500000000001
r17959 n1617 n3993 111.98750000000001
r17960 n1618 n3994 1791.8000000000002
r17961 n1740 n4121 167.98125000000002
r17962 n1741 n4122 2687.7000000000003
r17963 n1971 n4818 167.98125000000002
r17964 n1972 n4819 2687.7000000000003
r17965 n2094 n4945 111.98750000000001
r17966 n2095 n4946 1791.8000000000002
r17967 n2213 n5068 83.990625000000009
r17968 n2214 n5069 1343.8500000000001
r17969 n2328 n5183 111.98750000000001
r17970 n2329 n5184 1791.8000000000002
r17971 n2443 n5290 22.397500000000004
r17972 n2444 n5291 358.36000000000007
r17973 n2558 n5397 67.192499999999995
r17974 n2559 n5398 1075.0799999999999
r17975 n2673 n5504 167.98125000000002
r17976 n2674 n5505 2687.7000000000003
r17977 n1042 n3438 167.98125000000002
r17978 n1043 n3439 2687.7000000000003
r17979 n1157 n3545 67.192499999999995
r17980 n1158 n3546 1075.0799999999999
r17981 n1272 n3652 22.397500000000004
r17982 n1273 n3653 358.36000000000007
r17983 n1387 n3759 111.98750000000001
r17984 n1388 n3760 1791.8000000000002
r17985 n1502 n3874 83.990625000000009
r17986 n1503 n3875 1343.8500000000001
r17987 n1621 n3997 111.98750000000001
r17988 n1622 n3998 1791.8000000000002
r17989 n1744 n4125 167.98125000000002
r17990 n1745 n4126 2687.7000000000003
r17991 n1975 n4822 167.98125000000002
r17992 n1976 n4823 2687.7000000000003
r17993 n2098 n4949 111.98750000000001
r17994 n2099 n4950 1791.8000000000002
r17995 n2217 n5072 83.990625000000009
r17996 n2218 n5073 1343.8500000000001
r17997 n2332 n5187 111.98750000000001
r17998 n2333 n5188 1791.8000000000002
r17999 n2447 n5294 22.397500000000004
r18000 n2448 n5295 358.36000000000007
r18001 n2562 n5401 67.192499999999995
r18002 n2563 n5402 1075.0799999999999
r18003 n2677 n5508 167.98125000000002
r18004 n2678 n5509 2687.7000000000003
r18005 n1046 n3442 167.98125000000002
r18006 n1047 n3443 2687.7000000000003
r18007 n1161 n3549 67.192499999999995
r18008 n1162 n3550 1075.0799999999999
r18009 n1276 n3656 22.397500000000004
r18010 n1277 n3657 358.36000000000007
r18011 n1391 n3763 111.98750000000001
r18012 n1392 n3764 1791.8000000000002
r18013 n1506 n3878 83.990625000000009
r18014 n1507 n3879 1343.8500000000001
r18015 n1625 n4001 111.98750000000001
r18016 n1626 n4002 1791.8000000000002
r18017 n1748 n4129 167.98125000000002
r18018 n1749 n4130 2687.7000000000003
r18019 n1979 n4826 167.98125000000002
r18020 n1980 n4827 2687.7000000000003
r18021 n2102 n4953 111.98750000000001
r18022 n2103 n4954 1791.8000000000002
r18023 n2221 n5076 83.990625000000009
r18024 n2222 n5077 1343.8500000000001
r18025 n2336 n5191 111.98750000000001
r18026 n2337 n5192 1791.8000000000002
r18027 n2451 n5298 22.397500000000004
r18028 n2452 n5299 358.36000000000007
r18029 n2566 n5405 67.192499999999995
r18030 n2567 n5406 1075.0799999999999
r18031 n2681 n5512 167.98125000000002
r18032 n2682 n5513 2687.7000000000003
r18033 n1050 n3446 167.98125000000002
r18034 n1051 n3447 2687.7000000000003
r18035 n1165 n3553 67.192499999999995
r18036 n1166 n3554 1075.0799999999999
r18037 n1280 n3660 22.397500000000004
r18038 n1281 n3661 358.36000000000007
r18039 n1395 n3767 111.98750000000001
r18040 n1396 n3768 1791.8000000000002
r18041 n1510 n3882 83.990625000000009
r18042 n1511 n3883 1343.8500000000001
r18043 n1629 n4005 111.98750000000001
r18044 n1630 n4006 1791.8000000000002
r18045 n1752 n4133 167.98125000000002
r18046 n1753 n4134 2687.7000000000003
r18047 n1983 n4830 167.98125000000002
r18048 n1984 n4831 2687.7000000000003
r18049 n2106 n4957 111.98750000000001
r18050 n2107 n4958 1791.8000000000002
r18051 n2225 n5080 83.990625000000009
r18052 n2226 n5081 1343.8500000000001
r18053 n2340 n5195 111.98750000000001
r18054 n2341 n5196 1791.8000000000002
r18055 n2455 n5302 22.397500000000004
r18056 n2456 n5303 358.36000000000007
r18057 n2570 n5409 67.192499999999995
r18058 n2571 n5410 1075.0799999999999
r18059 n2685 n5516 167.98125000000002
r18060 n2686 n5517 2687.7000000000003
r18061 n1054 n3450 167.98125000000002
r18062 n1055 n3451 2687.7000000000003
r18063 n1169 n3557 67.192499999999995
r18064 n1170 n3558 1075.0799999999999
r18065 n1284 n3664 22.397500000000004
r18066 n1285 n3665 358.36000000000007
r18067 n1399 n3771 111.98750000000001
r18068 n1400 n3772 1791.8000000000002
r18069 n1514 n3886 83.990625000000009
r18070 n1515 n3887 1343.8500000000001
r18071 n1633 n4009 111.98750000000001
r18072 n1634 n4010 1791.8000000000002
r18073 n1756 n4137 167.98125000000002
r18074 n1757 n4138 2687.7000000000003
r18075 n1987 n4834 167.98125000000002
r18076 n1988 n4835 2687.7000000000003
r18077 n2110 n4961 111.98750000000001
r18078 n2111 n4962 1791.8000000000002
r18079 n2229 n5084 83.990625000000009
r18080 n2230 n5085 1343.8500000000001
r18081 n2344 n5199 111.98750000000001
r18082 n2345 n5200 1791.8000000000002
r18083 n2459 n5306 22.397500000000004
r18084 n2460 n5307 358.36000000000007
r18085 n2574 n5413 67.192499999999995
r18086 n2575 n5414 1075.0799999999999
r18087 n2689 n5520 167.98125000000002
r18088 n2690 n5521 2687.7000000000003
r18089 n1058 n3454 167.98125000000002
r18090 n1059 n3455 2687.7000000000003
r18091 n1173 n3561 67.192499999999995
r18092 n1174 n3562 1075.0799999999999
r18093 n1288 n3668 22.397500000000004
r18094 n1289 n3669 358.36000000000007
r18095 n1403 n3775 111.98750000000001
r18096 n1404 n3776 1791.8000000000002
r18097 n1518 n3890 83.990625000000009
r18098 n1519 n3891 1343.8500000000001
r18099 n1637 n4013 111.98750000000001
r18100 n1638 n4014 1791.8000000000002
r18101 n1760 n4141 167.98125000000002
r18102 n1761 n4142 2687.7000000000003
r18103 n1991 n4838 167.98125000000002
r18104 n1992 n4839 2687.7000000000003
r18105 n2114 n4965 111.98750000000001
r18106 n2115 n4966 1791.8000000000002
r18107 n2233 n5088 83.990625000000009
r18108 n2234 n5089 1343.8500000000001
r18109 n2348 n5203 111.98750000000001
r18110 n2349 n5204 1791.8000000000002
r18111 n2463 n5310 22.397500000000004
r18112 n2464 n5311 358.36000000000007
r18113 n2578 n5417 67.192499999999995
r18114 n2579 n5418 1075.0799999999999
r18115 n2693 n5524 167.98125000000002
r18116 n2694 n5525 2687.7000000000003
r18117 n1062 n3458 167.98125000000002
r18118 n1063 n3459 2687.7000000000003
r18119 n1177 n3565 67.192499999999995
r18120 n1178 n3566 1075.0799999999999
r18121 n1292 n3672 22.397500000000004
r18122 n1293 n3673 358.36000000000007
r18123 n1407 n3779 111.98750000000001
r18124 n1408 n3780 1791.8000000000002
r18125 n1522 n3894 83.990625000000009
r18126 n1523 n3895 1343.8500000000001
r18127 n1641 n4017 111.98750000000001
r18128 n1642 n4018 1791.8000000000002
r18129 n1764 n4145 167.98125000000002
r18130 n1765 n4146 2687.7000000000003
r18131 n1995 n4842 167.98125000000002
r18132 n1996 n4843 2687.7000000000003
r18133 n2118 n4969 111.98750000000001
r18134 n2119 n4970 1791.8000000000002
r18135 n2237 n5092 83.990625000000009
r18136 n2238 n5093 1343.8500000000001
r18137 n2352 n5207 111.98750000000001
r18138 n2353 n5208 1791.8000000000002
r18139 n2467 n5314 22.397500000000004
r18140 n2468 n5315 358.36000000000007
r18141 n2582 n5421 67.192499999999995
r18142 n2583 n5422 1075.0799999999999
r18143 n2697 n5528 167.98125000000002
r18144 n2698 n5529 2687.7000000000003
r18145 n1068 n3464 2687.7000000000003
r18146 n1069 n3465 671.92500000000007
r18147 n1070 n3466 244.33636363636364
r18148 n1071 n3467 5375.4000000000005
r18149 n1072 n3468 5375.4000000000005
r18150 n1183 n3571 1075.0799999999999
r18151 n1184 n3572 268.76999999999998
r18152 n1185 n3573 97.734545454545454
r18153 n1186 n3574 2150.1599999999999
r18154 n1187 n3575 2150.1599999999999
r18155 n1298 n3678 358.36000000000007
r18156 n1299 n3679 89.590000000000018
r18157 n1300 n3680 32.578181818181825
r18158 n1301 n3681 716.72000000000014
r18159 n1302 n3682 716.72000000000014
r18160 n1413 n3785 1791.8000000000002
r18161 n1414 n3786 447.95000000000005
r18162 n1415 n3787 162.8909090909091
r18163 n1416 n3788 3583.6000000000004
r18164 n1417 n3789 3583.6000000000004
r18165 n1528 n3900 1343.8500000000001
r18166 n1529 n3901 335.96250000000003
r18167 n1530 n3902 122.16818181818182
r18168 n1531 n3903 2687.7000000000003
r18169 n1532 n3904 2687.7000000000003
r18170 n1647 n4023 1791.8000000000002
r18171 n1648 n4024 447.95000000000005
r18172 n1649 n4025 162.8909090909091
r18173 n1650 n4026 3583.6000000000004
r18174 n1651 n4027 3583.6000000000004
r18175 n1770 n4151 2687.7000000000003
r18176 n1771 n4152 671.92500000000007
r18177 n1772 n4153 244.33636363636364
r18178 n1773 n4154 5375.4000000000005
r18179 n1774 n4155 5375.4000000000005
r18180 n2001 n4848 2687.7000000000003
r18181 n2002 n4849 671.92500000000007
r18182 n2003 n4850 244.33636363636364
r18183 n2004 n4851 5375.4000000000005
r18184 n2005 n4852 5375.4000000000005
r18185 n2124 n4975 1791.8000000000002
r18186 n2125 n4976 447.95000000000005
r18187 n2126 n4977 162.8909090909091
r18188 n2127 n4978 3583.6000000000004
r18189 n2128 n4979 3583.6000000000004
r18190 n2243 n5098 1343.8500000000001
r18191 n2244 n5099 335.96250000000003
r18192 n2245 n5100 122.16818181818182
r18193 n2246 n5101 2687.7000000000003
r18194 n2247 n5102 2687.7000000000003
r18195 n2358 n5213 1791.8000000000002
r18196 n2359 n5214 447.95000000000005
r18197 n2360 n5215 162.8909090909091
r18198 n2361 n5216 3583.6000000000004
r18199 n2362 n5217 3583.6000000000004
r18200 n2473 n5320 358.36000000000007
r18201 n2474 n5321 89.590000000000018
r18202 n2475 n5322 32.578181818181825
r18203 n2476 n5323 716.72000000000014
r18204 n2477 n5324 716.72000000000014
r18205 n2588 n5427 1075.0799999999999
r18206 n2589 n5428 268.76999999999998
r18207 n2590 n5429 97.734545454545454
r18208 n2591 n5430 2150.1599999999999
r18209 n2592 n5431 2150.1599999999999
r18210 n2703 n5534 2687.7000000000003
r18211 n2704 n5535 671.92500000000007
r18212 n2705 n5536 244.33636363636364
r18213 n2706 n5537 5375.4000000000005
r18214 n2707 n5538 5375.4000000000005
r18215 n597 n3159 5375.4000000000005
r18216 n598 n3160 5375.4000000000005
r18217 n599 n3161 537.53999999999996
r18218 n600 n3162 447.95000000000005
r18219 n601 n3163 671.92500000000007
r18220 n602 n3164 2687.7000000000003
r18221 n753 n3180 358.36000000000007
r18222 n754 n3181 358.36000000000007
r18223 n755 n3182 35.836000000000006
r18224 n756 n3183 29.863333333333337
r18225 n757 n3184 44.795000000000009
r18226 n758 n3185 179.18000000000004
r18227 n909 n3201 5375.4000000000005
r18228 n910 n3202 5375.4000000000005
r18229 n911 n3203 537.53999999999996
r18230 n912 n3204 447.95000000000005
r18231 n913 n3205 671.92500000000007
r18232 n914 n3206 2687.7000000000003
r18233 n1080 n3476 895.90000000000009
r18234 n1081 n3477 447.95000000000005
r18235 n1082 n3478 383.95714285714291
r18236 n1083 n3479 2687.7000000000003
r18237 n1195 n3583 358.36000000000007
r18238 n1196 n3584 179.18000000000004
r18239 n1197 n3585 153.58285714285716
r18240 n1198 n3586 1075.0799999999999
r18241 n1310 n3690 119.45333333333335
r18242 n1311 n3691 59.726666666666674
r18243 n1312 n3692 51.194285714285719
r18244 n1313 n3693 358.36000000000007
r18245 n1425 n3797 597.26666666666677
r18246 n1426 n3798 298.63333333333338
r18247 n1427 n3799 255.97142857142859
r18248 n1428 n3800 1791.8000000000002
r18249 n1540 n3912 447.95000000000005
r18250 n1541 n3913 223.97500000000002
r18251 n1542 n3914 191.97857142857146
r18252 n1543 n3915 1343.8500000000001
r18253 n1659 n4035 597.26666666666677
r18254 n1660 n4036 298.63333333333338
r18255 n1661 n4037 255.97142857142859
r18256 n1662 n4038 1791.8000000000002
r18257 n1782 n4163 895.90000000000009
r18258 n1783 n4164 447.95000000000005
r18259 n1784 n4165 383.95714285714291
r18260 n1785 n4166 2687.7000000000003
r18261 n2013 n4860 895.90000000000009
r18262 n2014 n4861 447.95000000000005
r18263 n2015 n4862 383.95714285714291
r18264 n2016 n4863 2687.7000000000003
r18265 n2136 n4987 597.26666666666677
r18266 n2137 n4988 298.63333333333338
r18267 n2138 n4989 255.97142857142859
r18268 n2139 n4990 1791.8000000000002
r18269 n2255 n5110 447.95000000000005
r18270 n2256 n5111 223.97500000000002
r18271 n2257 n5112 191.97857142857146
r18272 n2258 n5113 1343.8500000000001
r18273 n2370 n5225 597.26666666666677
r18274 n2371 n5226 298.63333333333338
r18275 n2372 n5227 255.97142857142859
r18276 n2373 n5228 1791.8000000000002
r18277 n2485 n5332 119.45333333333335
r18278 n2486 n5333 59.726666666666674
r18279 n2487 n5334 51.194285714285719
r18280 n2488 n5335 358.36000000000007
r18281 n2600 n5439 358.36000000000007
r18282 n2601 n5440 179.18000000000004
r18283 n2602 n5441 153.58285714285716
r18284 n2603 n5442 1075.0799999999999
r18285 n2715 n5546 895.90000000000009
r18286 n2716 n5547 447.95000000000005
r18287 n2717 n5548 383.95714285714291
r18288 n2718 n5549 2687.7000000000003
r18289 n1086 n3482 167.98125000000002
r18290 n1087 n3483 2687.7000000000003
r18291 n1201 n3589 67.192499999999995
r18292 n1202 n3590 1075.0799999999999
r18293 n1316 n3696 22.397500000000004
r18294 n1317 n3697 358.36000000000007
r18295 n1431 n3803 111.98750000000001
r18296 n1432 n3804 1791.8000000000002
r18297 n1546 n3918 83.990625000000009
r18298 n1547 n3919 1343.8500000000001
r18299 n1665 n4041 111.98750000000001
r18300 n1666 n4042 1791.8000000000002
r18301 n1788 n4169 167.98125000000002
r18302 n1789 n4170 2687.7000000000003
r18303 n2019 n4866 167.98125000000002
r18304 n2020 n4867 2687.7000000000003
r18305 n2142 n4993 111.98750000000001
r18306 n2143 n4994 1791.8000000000002
r18307 n2261 n5116 83.990625000000009
r18308 n2262 n5117 1343.8500000000001
r18309 n2376 n5231 111.98750000000001
r18310 n2377 n5232 1791.8000000000002
r18311 n2491 n5338 22.397500000000004
r18312 n2492 n5339 358.36000000000007
r18313 n2606 n5445 67.192499999999995
r18314 n2607 n5446 1075.0799999999999
r18315 n2721 n5552 167.98125000000002
r18316 n2722 n5553 2687.7000000000003
r18317 n1090 n3486 167.98125000000002
r18318 n1091 n3487 2687.7000000000003
r18319 n1205 n3593 67.192499999999995
r18320 n1206 n3594 1075.0799999999999
r18321 n1320 n3700 22.397500000000004
r18322 n1321 n3701 358.36000000000007
r18323 n1435 n3807 111.98750000000001
r18324 n1436 n3808 1791.8000000000002
r18325 n1550 n3922 83.990625000000009
r18326 n1551 n3923 1343.8500000000001
r18327 n1669 n4045 111.98750000000001
r18328 n1670 n4046 1791.8000000000002
r18329 n1792 n4173 167.98125000000002
r18330 n1793 n4174 2687.7000000000003
r18331 n2023 n4870 167.98125000000002
r18332 n2024 n4871 2687.7000000000003
r18333 n2146 n4997 111.98750000000001
r18334 n2147 n4998 1791.8000000000002
r18335 n2265 n5120 83.990625000000009
r18336 n2266 n5121 1343.8500000000001
r18337 n2380 n5235 111.98750000000001
r18338 n2381 n5236 1791.8000000000002
r18339 n2495 n5342 22.397500000000004
r18340 n2496 n5343 358.36000000000007
r18341 n2610 n5449 67.192499999999995
r18342 n2611 n5450 1075.0799999999999
r18343 n2725 n5556 167.98125000000002
r18344 n2726 n5557 2687.7000000000003
r18345 n1094 n3490 167.98125000000002
r18346 n1095 n3491 2687.7000000000003
r18347 n1209 n3597 67.192499999999995
r18348 n1210 n3598 1075.0799999999999
r18349 n1324 n3704 22.397500000000004
r18350 n1325 n3705 358.36000000000007
r18351 n1439 n3811 111.98750000000001
r18352 n1440 n3812 1791.8000000000002
r18353 n1554 n3926 83.990625000000009
r18354 n1555 n3927 1343.8500000000001
r18355 n1673 n4049 111.98750000000001
r18356 n1674 n4050 1791.8000000000002
r18357 n1796 n4177 167.98125000000002
r18358 n1797 n4178 2687.7000000000003
r18359 n2027 n4874 167.98125000000002
r18360 n2028 n4875 2687.7000000000003
r18361 n2150 n5001 111.98750000000001
r18362 n2151 n5002 1791.8000000000002
r18363 n2269 n5124 83.990625000000009
r18364 n2270 n5125 1343.8500000000001
r18365 n2384 n5239 111.98750000000001
r18366 n2385 n5240 1791.8000000000002
r18367 n2499 n5346 22.397500000000004
r18368 n2500 n5347 358.36000000000007
r18369 n2614 n5453 67.192499999999995
r18370 n2615 n5454 1075.0799999999999
r18371 n2729 n5560 167.98125000000002
r18372 n2730 n5561 2687.7000000000003
r18373 n1098 n3494 167.98125000000002
r18374 n1099 n3495 2687.7000000000003
r18375 n1213 n3601 67.192499999999995
r18376 n1214 n3602 1075.0799999999999
r18377 n1328 n3708 22.397500000000004
r18378 n1329 n3709 358.36000000000007
r18379 n1443 n3815 111.98750000000001
r18380 n1444 n3816 1791.8000000000002
r18381 n1558 n3930 83.990625000000009
r18382 n1559 n3931 1343.8500000000001
r18383 n1677 n4053 111.98750000000001
r18384 n1678 n4054 1791.8000000000002
r18385 n1800 n4181 167.98125000000002
r18386 n1801 n4182 2687.7000000000003
r18387 n2031 n4878 167.98125000000002
r18388 n2032 n4879 2687.7000000000003
r18389 n2154 n5005 111.98750000000001
r18390 n2155 n5006 1791.8000000000002
r18391 n2273 n5128 83.990625000000009
r18392 n2274 n5129 1343.8500000000001
r18393 n2388 n5243 111.98750000000001
r18394 n2389 n5244 1791.8000000000002
r18395 n2503 n5350 22.397500000000004
r18396 n2504 n5351 358.36000000000007
r18397 n2618 n5457 67.192499999999995
r18398 n2619 n5458 1075.0799999999999
r18399 n2733 n5564 167.98125000000002
r18400 n2734 n5565 2687.7000000000003
r18401 n1102 n3498 167.98125000000002
r18402 n1103 n3499 2687.7000000000003
r18403 n1217 n3605 67.192499999999995
r18404 n1218 n3606 1075.0799999999999
r18405 n1332 n3712 22.397500000000004
r18406 n1333 n3713 358.36000000000007
r18407 n1447 n3819 111.98750000000001
r18408 n1448 n3820 1791.8000000000002
r18409 n1562 n3934 83.990625000000009
r18410 n1563 n3935 1343.8500000000001
r18411 n1681 n4057 111.98750000000001
r18412 n1682 n4058 1791.8000000000002
r18413 n1804 n4185 167.98125000000002
r18414 n1805 n4186 2687.7000000000003
r18415 n2035 n4882 167.98125000000002
r18416 n2036 n4883 2687.7000000000003
r18417 n2158 n5009 111.98750000000001
r18418 n2159 n5010 1791.8000000000002
r18419 n2277 n5132 83.990625000000009
r18420 n2278 n5133 1343.8500000000001
r18421 n2392 n5247 111.98750000000001
r18422 n2393 n5248 1791.8000000000002
r18423 n2507 n5354 22.397500000000004
r18424 n2508 n5355 358.36000000000007
r18425 n2622 n5461 67.192499999999995
r18426 n2623 n5462 1075.0799999999999
r18427 n2737 n5568 167.98125000000002
r18428 n2738 n5569 2687.7000000000003
r18429 n1106 n3502 167.98125000000002
r18430 n1107 n3503 2687.7000000000003
r18431 n1221 n3609 67.192499999999995
r18432 n1222 n3610 1075.0799999999999
r18433 n1336 n3716 22.397500000000004
r18434 n1337 n3717 358.36000000000007
r18435 n1451 n3823 111.98750000000001
r18436 n1452 n3824 1791.8000000000002
r18437 n1566 n3938 83.990625000000009
r18438 n1567 n3939 1343.8500000000001
r18439 n1685 n4061 111.98750000000001
r18440 n1686 n4062 1791.8000000000002
r18441 n1808 n4189 167.98125000000002
r18442 n1809 n4190 2687.7000000000003
r18443 n2039 n4886 167.98125000000002
r18444 n2040 n4887 2687.7000000000003
r18445 n2162 n5013 111.98750000000001
r18446 n2163 n5014 1791.8000000000002
r18447 n2281 n5136 83.990625000000009
r18448 n2282 n5137 1343.8500000000001
r18449 n2396 n5251 111.98750000000001
r18450 n2397 n5252 1791.8000000000002
r18451 n2511 n5358 22.397500000000004
r18452 n2512 n5359 358.36000000000007
r18453 n2626 n5465 67.192499999999995
r18454 n2627 n5466 1075.0799999999999
r18455 n2741 n5572 167.98125000000002
r18456 n2742 n5573 2687.7000000000003
r18457 n1110 n3506 167.98125000000002
r18458 n1111 n3507 2687.7000000000003
r18459 n1225 n3613 67.192499999999995
r18460 n1226 n3614 1075.0799999999999
r18461 n1340 n3720 22.397500000000004
r18462 n1341 n3721 358.36000000000007
r18463 n1455 n3827 111.98750000000001
r18464 n1456 n3828 1791.8000000000002
r18465 n1570 n3942 83.990625000000009
r18466 n1571 n3943 1343.8500000000001
r18467 n1689 n4065 111.98750000000001
r18468 n1690 n4066 1791.8000000000002
r18469 n1812 n4193 167.98125000000002
r18470 n1813 n4194 2687.7000000000003
r18471 n2043 n4890 167.98125000000002
r18472 n2044 n4891 2687.7000000000003
r18473 n2166 n5017 111.98750000000001
r18474 n2167 n5018 1791.8000000000002
r18475 n2285 n5140 83.990625000000009
r18476 n2286 n5141 1343.8500000000001
r18477 n2400 n5255 111.98750000000001
r18478 n2401 n5256 1791.8000000000002
r18479 n2515 n5362 22.397500000000004
r18480 n2516 n5363 358.36000000000007
r18481 n2630 n5469 67.192499999999995
r18482 n2631 n5470 1075.0799999999999
r18483 n2745 n5576 167.98125000000002
r18484 n2746 n5577 2687.7000000000003
r18485 n1864 n4470 2687.7000000000003
r18486 n1865 n4471 488.67272727272729
r18487 n1866 n4472 282.91578947368424
r18488 n1867 n4473 2687.7000000000003
r18489 n1876 n4495 179.18000000000004
r18490 n1877 n4496 32.578181818181825
r18491 n1878 n4497 18.86105263157895
r18492 n1879 n4498 179.18000000000004
r18493 n1888 n4541 2687.7000000000003
r18494 n1889 n4542 488.67272727272729
r18495 n1890 n4543 282.91578947368424
r18496 n1891 n4544 2687.7000000000003
r18497 n33 vdd 158.10000000000002
r18498 n34 vdd 10.540000000000001
r18499 n35 vdd 158.10000000000002
r18500 n473 n3019 158.10000000000002
r18501 n474 n3020 10.540000000000001
r18502 n475 n3021 158.10000000000002
r18503 n3084 n5731 4.5
r18504 n3520 n6794 90
r18505 n3521 n6795 38.571428571428569
r18506 n3627 n6849 30
r18507 n3628 n6850 12.857142857142858
r18508 n3734 n6904 150
r18509 n3735 n6905 64.285714285714278
r18510 n3841 n6984 112.5
r18511 n3842 n6985 48.214285714285715
r18512 n3964 n7064 150
r18513 n3965 n7065 64.285714285714278
r18514 n4916 n7859 150
r18515 n4917 n7860 64.285714285714278
r18516 n5039 n7921 112.5
r18517 n5040 n7922 48.214285714285715
r18518 n5162 n7983 150
r18519 n5163 n7984 64.285714285714278
r18520 n5269 n8045 30
r18521 n5270 n8046 12.857142857142858
r18522 n5376 n8082 90
r18523 n5377 n8083 38.571428571428569
r18524 n3172 n6288 15
r18525 n3173 n6289 11.25
r18526 n3174 n6290 15
r18527 n4483 n7509 16.875
r18528 n4484 n7510 6.1363636363636367
r18529 n3572 n6804 101.25
r18530 n3573 n6805 36.81818181818182
r18531 n3679 n6859 33.75
r18532 n3680 n6860 12.272727272727273
r18533 n3786 n6927 168.75
r18534 n3787 n6928 61.363636363636367
r18535 n3901 n7007 126.5625
r18536 n3902 n7008 46.022727272727273
r18537 n4024 n7087 168.75
r18538 n4025 n7088 61.363636363636367
r18539 n4976 n7882 168.75
r18540 n4977 n7883 61.363636363636367
r18541 n5099 n7944 126.5625
r18542 n5100 n7945 46.022727272727273
r18543 n5214 n8006 168.75
r18544 n5215 n8007 61.363636363636367
r18545 n5321 n8055 33.75
r18546 n5322 n8056 12.272727272727273
r18547 n5428 n8092 101.25
r18548 n5429 n8093 36.81818181818182
r18549 n3182 n6302 13.5
r18550 n3183 n6303 11.25
r18551 n3184 n6304 16.875
r18552 n4496 n7522 12.272727272727273
r18553 n4497 n7523 7.1052631578947372
r18554 n3090 n5741 4.5
r18555 n7393 n9682 606.22222222222229
r18556 n7394 n9683 909.33333333333337
r18557 n7395 n9684 227.33333333333334
r18558 n7396 n9685 82.666666666666671
r18559 n7397 n9686 909.33333333333337
r18560 n7398 n9687 606.22222222222229
r18561 n7455 n9707 909.33333333333337
r18562 n7456 n9708 1364
r18563 n7457 n9709 341
r18564 n7458 n9710 124
r18565 n7459 n9711 1364
r18566 n7460 n9712 909.33333333333337
r18567 n7507 n9732 60.62222222222222
r18568 n7508 n9733 90.933333333333337
r18569 n7509 n9734 22.733333333333334
r18570 n7510 n9735 8.2666666666666675
r18571 n7511 n9736 90.933333333333337
r18572 n7512 n9737 60.62222222222222
r18573 n7558 n9757 909.33333333333337
r18574 n7559 n9758 1364
r18575 n7560 n9759 341
r18576 n7561 n9760 124
r18577 n7562 n9761 1364
r18578 n7563 n9762 909.33333333333337
r18579 n7620 n9782 606.22222222222229
r18580 n7621 n9783 909.33333333333337
r18581 n7622 n9784 227.33333333333334
r18582 n7623 n9785 82.666666666666671
r18583 n7624 n9786 909.33333333333337
r18584 n7625 n9787 606.22222222222229
r18585 n7417 n9695 606.22222222222229
r18586 n7418 n9696 909.33333333333337
r18587 n7419 n9697 165.33333333333334
r18588 n7420 n9698 95.719298245614041
r18589 n7421 n9699 909.33333333333337
r18590 n7422 n9700 606.22222222222229
r18591 n7479 n9720 909.33333333333337
r18592 n7480 n9721 1364
r18593 n7481 n9722 248
r18594 n7482 n9723 143.57894736842107
r18595 n7483 n9724 1364
r18596 n7484 n9725 909.33333333333337
r18597 n7520 n9745 60.62222222222222
r18598 n7521 n9746 90.933333333333337
r18599 n7522 n9747 16.533333333333335
r18600 n7523 n9748 9.5719298245614031
r18601 n7524 n9749 90.933333333333337
r18602 n7525 n9750 60.62222222222222
r18603 n7582 n9770 909.33333333333337
r18604 n7583 n9771 1364
r18605 n7584 n9772 248
r18606 n7585 n9773 143.57894736842107
r18607 n7586 n9774 1364
r18608 n7587 n9775 909.33333333333337
r18609 n7644 n9795 606.22222222222229
r18610 n7645 n9796 909.33333333333337
r18611 n7646 n9797 165.33333333333334
r18612 n7647 n9798 95.719298245614041
r18613 n7648 n9799 909.33333333333337
r18614 n7649 n9800 606.22222222222229
r18615 n984 t_m2_b 1420.7142857142858
r18616 n988 t_m2_b 9945
r18617 n992 t_m2_b 3978
r18618 n996 t_m2_b 3315
r18619 n1000 t_m2_b 9945
r18620 n1115 t_m2_b 3978
r18621 n1857 t_m2_b 9945
r18622 n1869 t_m2_b 663
r18623 n1881 t_m2_b 9945
r18624 n2520 t_m2_b 3978
r18625 n2635 t_m2_b 9945
r18626 n2750 t_m2_b 3315
r18627 n2754 t_m2_b 2841.4285714285716
r18628 n2758 t_m2_b 1420.7142857142858
r18629 n503 t_m2_b 9945
r18630 n659 t_m2_b 663
r18631 n815 t_m2_b 9945
r18632 n2773 t_m2_b 585
r18633 n507 t_m2_b 169065
r18634 n508 t_m2_b 10566.5625
r18635 n663 t_m2_b 11271
r18636 n664 t_m2_b 704.4375
r18637 n819 t_m2_b 169065
r18638 n820 t_m2_b 10566.5625
r18639 n2777 t_m2_b 9945
r18640 n2778 t_m2_b 621.5625
r18641 n1004 t_m2_s 3341.5625
r18642 n1005 t_m2_s 53465
r18643 n1119 t_m2_s 1336.625
r18644 n1120 t_m2_s 21386
r18645 n1234 t_m2_s 445.54166666666669
r18646 n1235 t_m2_s 7128.666666666667
r18647 n1349 t_m2_s 2227.7083333333335
r18648 n1350 t_m2_s 35643.333333333336
r18649 n1464 t_m2_s 1670.78125
r18650 n1465 t_m2_s 26732.5
r18651 n1579 t_m2_s 2227.7083333333335
r18652 n1580 t_m2_s 35643.333333333336
r18653 n1702 t_m2_s 3341.5625
r18654 n1703 t_m2_s 53465
r18655 n1933 t_m2_d 3341.5625
r18656 n1934 t_m2_d 53465
r18657 n2056 t_m2_d 2227.7083333333335
r18658 n2057 t_m2_d 35643.333333333336
r18659 n2179 t_m2_d 1670.78125
r18660 n2180 t_m2_d 26732.5
r18661 n2294 t_m2_d 2227.7083333333335
r18662 n2295 t_m2_d 35643.333333333336
r18663 n2409 t_m2_d 445.54166666666669
r18664 n2410 t_m2_d 7128.666666666667
r18665 n2524 t_m2_d 1336.625
r18666 n2525 t_m2_d 21386
r18667 n2639 t_m2_d 3341.5625
r18668 n2640 t_m2_d 53465
r18669 n511 t_m2_b 169065
r18670 n512 t_m2_b 26010
r18671 n513 t_m2_b 28177.5
r18672 n514 t_m2_b 48304.285714285717
r18673 n667 t_m2_b 11271
r18674 n668 t_m2_b 1734
r18675 n669 t_m2_b 1878.5
r18676 n670 t_m2_b 3220.2857142857142
r18677 n823 t_m2_b 169065
r18678 n824 t_m2_b 26010
r18679 n825 t_m2_b 28177.5
r18680 n826 t_m2_b 48304.285714285717
r18681 n2781 t_m2_b 9945
r18682 n2782 t_m2_b 1530
r18683 n2783 t_m2_b 1657.5
r18684 n2784 t_m2_b 2841.4285714285716
r18685 n1008 t_m2_s 8225.3846153846152
r18686 n1009 t_m2_s 8910.8333333333339
r18687 n1010 t_m2_s 15275.714285714286
r18688 n1011 t_m2_s 53465
r18689 n1123 t_m2_s 3290.1538461538462
r18690 n1124 t_m2_s 3564.3333333333335
r18691 n1125 t_m2_s 6110.2857142857147
r18692 n1126 t_m2_s 21386
r18693 n1238 t_m2_s 1096.7179487179487
r18694 n1239 t_m2_s 1188.1111111111111
r18695 n1240 t_m2_s 2036.7619047619046
r18696 n1241 t_m2_s 7128.666666666667
r18697 n1353 t_m2_s 5483.5897435897432
r18698 n1354 t_m2_s 5940.5555555555557
r18699 n1355 t_m2_s 10183.809523809523
r18700 n1356 t_m2_s 35643.333333333336
r18701 n1468 t_m2_s 4112.6923076923076
r18702 n1469 t_m2_s 4455.416666666667
r18703 n1470 t_m2_s 7637.8571428571431
r18704 n1471 t_m2_s 26732.5
r18705 n1583 t_m2_s 5483.5897435897432
r18706 n1584 t_m2_s 5940.5555555555557
r18707 n1585 t_m2_s 10183.809523809523
r18708 n1586 t_m2_s 35643.333333333336
r18709 n1706 t_m2_s 8225.3846153846152
r18710 n1707 t_m2_s 8910.8333333333339
r18711 n1708 t_m2_s 15275.714285714286
r18712 n1709 t_m2_s 53465
r18713 n1937 t_m2_d 8225.3846153846152
r18714 n1938 t_m2_d 8910.8333333333339
r18715 n1939 t_m2_d 15275.714285714286
r18716 n1940 t_m2_d 53465
r18717 n2060 t_m2_d 5483.5897435897432
r18718 n2061 t_m2_d 5940.5555555555557
r18719 n2062 t_m2_d 10183.809523809523
r18720 n2063 t_m2_d 35643.333333333336
r18721 n2183 t_m2_d 4112.6923076923076
r18722 n2184 t_m2_d 4455.416666666667
r18723 n2185 t_m2_d 7637.8571428571431
r18724 n2186 t_m2_d 26732.5
r18725 n2298 t_m2_d 5483.5897435897432
r18726 n2299 t_m2_d 5940.5555555555557
r18727 n2300 t_m2_d 10183.809523809523
r18728 n2301 t_m2_d 35643.333333333336
r18729 n2413 t_m2_d 1096.7179487179487
r18730 n2414 t_m2_d 1188.1111111111111
r18731 n2415 t_m2_d 2036.7619047619046
r18732 n2416 t_m2_d 7128.666666666667
r18733 n2528 t_m2_d 3290.1538461538462
r18734 n2529 t_m2_d 3564.3333333333335
r18735 n2530 t_m2_d 6110.2857142857147
r18736 n2531 t_m2_d 21386
r18737 n2643 t_m2_d 8225.3846153846152
r18738 n2644 t_m2_d 8910.8333333333339
r18739 n2645 t_m2_d 15275.714285714286
r18740 n2646 t_m2_d 53465
r18741 n520 t_m2_b 169065
r18742 n521 t_m2_b 37570
r18743 n522 t_m2_b 28177.5
r18744 n523 t_m2_b 37570
r18745 n524 t_m2_b 169065
r18746 n676 t_m2_b 11271
r18747 n677 t_m2_b 2504.6666666666665
r18748 n678 t_m2_b 1878.5
r18749 n679 t_m2_b 2504.6666666666665
r18750 n680 t_m2_b 11271
r18751 n832 t_m2_b 169065
r18752 n833 t_m2_b 37570
r18753 n834 t_m2_b 28177.5
r18754 n835 t_m2_b 37570
r18755 n836 t_m2_b 169065
r18756 n2790 t_m2_b 9945
r18757 n2791 t_m2_b 2210
r18758 n2792 t_m2_b 1657.5
r18759 n2793 t_m2_b 2210
r18760 n2794 t_m2_b 9945
r18761 n1017 t_m2_s 11881.111111111111
r18762 n1018 t_m2_s 8910.8333333333339
r18763 n1019 t_m2_s 11881.111111111111
r18764 n1020 t_m2_s 53465
r18765 n1021 t_m2_s 53465
r18766 n1132 t_m2_s 4752.4444444444443
r18767 n1133 t_m2_s 3564.3333333333335
r18768 n1134 t_m2_s 4752.4444444444443
r18769 n1135 t_m2_s 21386
r18770 n1136 t_m2_s 21386
r18771 n1247 t_m2_s 1584.1481481481483
r18772 n1248 t_m2_s 1188.1111111111111
r18773 n1249 t_m2_s 1584.1481481481483
r18774 n1250 t_m2_s 7128.666666666667
r18775 n1251 t_m2_s 7128.666666666667
r18776 n1362 t_m2_s 7920.7407407407409
r18777 n1363 t_m2_s 5940.5555555555557
r18778 n1364 t_m2_s 7920.7407407407409
r18779 n1365 t_m2_s 35643.333333333336
r18780 n1366 t_m2_s 35643.333333333336
r18781 n1477 t_m2_s 5940.5555555555557
r18782 n1478 t_m2_s 4455.416666666667
r18783 n1479 t_m2_s 5940.5555555555557
r18784 n1480 t_m2_s 26732.5
r18785 n1481 t_m2_s 26732.5
r18786 n1592 t_m2_s 7920.7407407407409
r18787 n1593 t_m2_s 5940.5555555555557
r18788 n1594 t_m2_s 7920.7407407407409
r18789 n1595 t_m2_s 35643.333333333336
r18790 n1596 t_m2_s 35643.333333333336
r18791 n1715 t_m2_s 11881.111111111111
r18792 n1716 t_m2_s 8910.8333333333339
r18793 n1717 t_m2_s 11881.111111111111
r18794 n1718 t_m2_s 53465
r18795 n1719 t_m2_s 53465
r18796 n1946 t_m2_d 11881.111111111111
r18797 n1947 t_m2_d 8910.8333333333339
r18798 n1948 t_m2_d 11881.111111111111
r18799 n1949 t_m2_d 53465
r18800 n1950 t_m2_d 53465
r18801 n2069 t_m2_d 7920.7407407407409
r18802 n2070 t_m2_d 5940.5555555555557
r18803 n2071 t_m2_d 7920.7407407407409
r18804 n2072 t_m2_d 35643.333333333336
r18805 n2073 t_m2_d 35643.333333333336
r18806 n2192 t_m2_d 5940.5555555555557
r18807 n2193 t_m2_d 4455.416666666667
r18808 n2194 t_m2_d 5940.5555555555557
r18809 n2195 t_m2_d 26732.5
r18810 n2196 t_m2_d 26732.5
r18811 n2307 t_m2_d 7920.7407407407409
r18812 n2308 t_m2_d 5940.5555555555557
r18813 n2309 t_m2_d 7920.7407407407409
r18814 n2310 t_m2_d 35643.333333333336
r18815 n2311 t_m2_d 35643.333333333336
r18816 n2422 t_m2_d 1584.1481481481483
r18817 n2423 t_m2_d 1188.1111111111111
r18818 n2424 t_m2_d 1584.1481481481483
r18819 n2425 t_m2_d 7128.666666666667
r18820 n2426 t_m2_d 7128.666666666667
r18821 n2537 t_m2_d 4752.4444444444443
r18822 n2538 t_m2_d 3564.3333333333335
r18823 n2539 t_m2_d 4752.4444444444443
r18824 n2540 t_m2_d 21386
r18825 n2541 t_m2_d 21386
r18826 n2652 t_m2_d 11881.111111111111
r18827 n2653 t_m2_d 8910.8333333333339
r18828 n2654 t_m2_d 11881.111111111111
r18829 n2655 t_m2_d 53465
r18830 n2656 t_m2_d 53465
r18831 n528 t_m2_b 169065
r18832 n529 t_m2_b 10566.5625
r18833 n684 t_m2_b 11271
r18834 n685 t_m2_b 704.4375
r18835 n840 t_m2_b 169065
r18836 n841 t_m2_b 10566.5625
r18837 n2798 t_m2_b 9945
r18838 n2799 t_m2_b 621.5625
r18839 n1025 t_m2_s 3341.5625
r18840 n1026 t_m2_s 53465
r18841 n1140 t_m2_s 1336.625
r18842 n1141 t_m2_s 21386
r18843 n1255 t_m2_s 445.54166666666669
r18844 n1256 t_m2_s 7128.666666666667
r18845 n1370 t_m2_s 2227.7083333333335
r18846 n1371 t_m2_s 35643.333333333336
r18847 n1485 t_m2_s 1670.78125
r18848 n1486 t_m2_s 26732.5
r18849 n1600 t_m2_s 2227.7083333333335
r18850 n1601 t_m2_s 35643.333333333336
r18851 n1723 t_m2_s 3341.5625
r18852 n1724 t_m2_s 53465
r18853 n1954 t_m2_d 3341.5625
r18854 n1955 t_m2_d 53465
r18855 n2077 t_m2_d 2227.7083333333335
r18856 n2078 t_m2_d 35643.333333333336
r18857 n2200 t_m2_d 1670.78125
r18858 n2201 t_m2_d 26732.5
r18859 n2315 t_m2_d 2227.7083333333335
r18860 n2316 t_m2_d 35643.333333333336
r18861 n2430 t_m2_d 445.54166666666669
r18862 n2431 t_m2_d 7128.666666666667
r18863 n2545 t_m2_d 1336.625
r18864 n2546 t_m2_d 21386
r18865 n2660 t_m2_d 3341.5625
r18866 n2661 t_m2_d 53465
r18867 n534 t_m2_b 9945
r18868 n690 t_m2_b 663
r18869 n846 t_m2_b 9945
r18870 n2804 t_m2_b 585
r18871 n1858 t_m2_g 43928
r18872 n1859 t_m2_g 10982
r18873 n1860 t_m2_g 3993.4545454545455
r18874 n1861 t_m2_g 43928
r18875 n1870 t_m2_g 2928.5333333333333
r18876 n1871 t_m2_g 732.13333333333333
r18877 n1872 t_m2_g 266.23030303030305
r18878 n1873 t_m2_g 2928.5333333333333
r18879 n1882 t_m2_g 43928
r18880 n1883 t_m2_g 10982
r18881 n1884 t_m2_g 3993.4545454545455
r18882 n1885 t_m2_g 43928
r18883 n542 t_m2_b 15369.545454545454
r18884 n543 t_m2_b 169065
r18885 n544 t_m2_b 112710
r18886 n545 t_m2_b 112710
r18887 n546 t_m2_b 84532.5
r18888 n698 t_m2_b 1024.6363636363637
r18889 n699 t_m2_b 11271
r18890 n700 t_m2_b 7514
r18891 n701 t_m2_b 7514
r18892 n702 t_m2_b 5635.5
r18893 n854 t_m2_b 15369.545454545454
r18894 n855 t_m2_b 169065
r18895 n856 t_m2_b 112710
r18896 n857 t_m2_b 112710
r18897 n858 t_m2_b 84532.5
r18898 n2812 t_m2_b 904.09090909090901
r18899 n2813 t_m2_b 9945
r18900 n2814 t_m2_b 6630
r18901 n2815 t_m2_b 6630
r18902 n2816 t_m2_b 4972.5
r18903 n985 t_m2_b 1420.7142857142858
r18904 n989 t_m2_b 9945
r18905 n993 t_m2_b 3978
r18906 n997 t_m2_b 3315
r18907 n1029 t_m2_b 9945
r18908 n1144 t_m2_b 3978
r18909 n1862 t_m2_b 9945
r18910 n1874 t_m2_b 663
r18911 n1886 t_m2_b 9945
r18912 n2549 t_m2_b 3978
r18913 n2664 t_m2_b 9945
r18914 n2751 t_m2_b 3315
r18915 n2755 t_m2_b 2841.4285714285716
r18916 n2759 t_m2_b 1420.7142857142858
r18917 n986 t_m1_b 449.28571428571433
r18918 n990 t_m1_b 3145
r18919 n994 t_m1_b 1258
r18920 n998 t_m1_b 1048.3333333333333
r18921 n1030 t_m1_b 3145
r18922 n1145 t_m1_b 1258
r18923 n1863 t_m1_b 3145
r18924 n1875 t_m1_b 209.66666666666669
r18925 n1887 t_m1_b 3145
r18926 n2550 t_m1_b 1258
r18927 n2665 t_m1_b 3145
r18928 n2752 t_m1_b 1048.3333333333333
r18929 n2756 t_m1_b 898.57142857142867
r18930 n2760 t_m1_b 449.28571428571433
r18931 n554 t_m1_b 3145
r18932 n710 t_m1_b 209.66666666666669
r18933 n866 t_m1_b 3145
r18934 n2824 t_m1_b 185
r18935 n558 t_m1_b 53465
r18936 n559 t_m1_b 3341.5625
r18937 n714 t_m1_b 3564.3333333333335
r18938 n715 t_m1_b 222.77083333333334
r18939 n870 t_m1_b 53465
r18940 n871 t_m1_b 3341.5625
r18941 n2828 t_m1_b 3145
r18942 n2829 t_m1_b 196.5625
r18943 n1034 t_m1_s 10566.5625
r18944 n1035 t_m1_s 169065
r18945 n1149 t_m1_s 4226.625
r18946 n1150 t_m1_s 67626
r18947 n1264 t_m1_s 1408.875
r18948 n1265 t_m1_s 22542
r18949 n1379 t_m1_s 7044.375
r18950 n1380 t_m1_s 112710
r18951 n1494 t_m1_s 5283.28125
r18952 n1495 t_m1_s 84532.5
r18953 n1613 t_m1_s 7044.375
r18954 n1614 t_m1_s 112710
r18955 n1736 t_m1_s 10566.5625
r18956 n1737 t_m1_s 169065
r18957 n1967 t_m1_d 10566.5625
r18958 n1968 t_m1_d 169065
r18959 n2090 t_m1_d 7044.375
r18960 n2091 t_m1_d 112710
r18961 n2209 t_m1_d 5283.28125
r18962 n2210 t_m1_d 84532.5
r18963 n2324 t_m1_d 7044.375
r18964 n2325 t_m1_d 112710
r18965 n2439 t_m1_d 1408.875
r18966 n2440 t_m1_d 22542
r18967 n2554 t_m1_d 4226.625
r18968 n2555 t_m1_d 67626
r18969 n2669 t_m1_d 10566.5625
r18970 n2670 t_m1_d 169065
r18971 n562 t_m1_b 53465
r18972 n563 t_m1_b 3341.5625
r18973 n718 t_m1_b 3564.3333333333335
r18974 n719 t_m1_b 222.77083333333334
r18975 n874 t_m1_b 53465
r18976 n875 t_m1_b 3341.5625
r18977 n2832 t_m1_b 3145
r18978 n2833 t_m1_b 196.5625
r18979 n1038 t_m1_s 10566.5625
r18980 n1039 t_m1_s 169065
r18981 n1153 t_m1_s 4226.625
r18982 n1154 t_m1_s 67626
r18983 n1268 t_m1_s 1408.875
r18984 n1269 t_m1_s 22542
r18985 n1383 t_m1_s 7044.375
r18986 n1384 t_m1_s 112710
r18987 n1498 t_m1_s 5283.28125
r18988 n1499 t_m1_s 84532.5
r18989 n1617 t_m1_s 7044.375
r18990 n1618 t_m1_s 112710
r18991 n1740 t_m1_s 10566.5625
r18992 n1741 t_m1_s 169065
r18993 n1971 t_m1_d 10566.5625
r18994 n1972 t_m1_d 169065
r18995 n2094 t_m1_d 7044.375
r18996 n2095 t_m1_d 112710
r18997 n2213 t_m1_d 5283.28125
r18998 n2214 t_m1_d 84532.5
r18999 n2328 t_m1_d 7044.375
r19000 n2329 t_m1_d 112710
r19001 n2443 t_m1_d 1408.875
r19002 n2444 t_m1_d 22542
r19003 n2558 t_m1_d 4226.625
r19004 n2559 t_m1_d 67626
r19005 n2673 t_m1_d 10566.5625
r19006 n2674 t_m1_d 169065
r19007 n566 t_m1_b 53465
r19008 n567 t_m1_b 3341.5625
r19009 n722 t_m1_b 3564.3333333333335
r19010 n723 t_m1_b 222.77083333333334
r19011 n878 t_m1_b 53465
r19012 n879 t_m1_b 3341.5625
r19013 n2836 t_m1_b 3145
r19014 n2837 t_m1_b 196.5625
r19015 n1042 t_m1_s 10566.5625
r19016 n1043 t_m1_s 169065
r19017 n1157 t_m1_s 4226.625
r19018 n1158 t_m1_s 67626
r19019 n1272 t_m1_s 1408.875
r19020 n1273 t_m1_s 22542
r19021 n1387 t_m1_s 7044.375
r19022 n1388 t_m1_s 112710
r19023 n1502 t_m1_s 5283.28125
r19024 n1503 t_m1_s 84532.5
r19025 n1621 t_m1_s 7044.375
r19026 n1622 t_m1_s 112710
r19027 n1744 t_m1_s 10566.5625
r19028 n1745 t_m1_s 169065
r19029 n1975 t_m1_d 10566.5625
r19030 n1976 t_m1_d 169065
r19031 n2098 t_m1_d 7044.375
r19032 n2099 t_m1_d 112710
r19033 n2217 t_m1_d 5283.28125
r19034 n2218 t_m1_d 84532.5
r19035 n2332 t_m1_d 7044.375
r19036 n2333 t_m1_d 112710
r19037 n2447 t_m1_d 1408.875
r19038 n2448 t_m1_d 22542
r19039 n2562 t_m1_d 4226.625
r19040 n2563 t_m1_d 67626
r19041 n2677 t_m1_d 10566.5625
r19042 n2678 t_m1_d 169065
r19043 n570 t_m1_b 53465
r19044 n571 t_m1_b 3341.5625
r19045 n726 t_m1_b 3564.3333333333335
r19046 n727 t_m1_b 222.77083333333334
r19047 n882 t_m1_b 53465
r19048 n883 t_m1_b 3341.5625
r19049 n2840 t_m1_b 3145
r19050 n2841 t_m1_b 196.5625
r19051 n1046 t_m1_s 10566.5625
r19052 n1047 t_m1_s 169065
r19053 n1161 t_m1_s 4226.625
r19054 n1162 t_m1_s 67626
r19055 n1276 t_m1_s 1408.875
r19056 n1277 t_m1_s 22542
r19057 n1391 t_m1_s 7044.375
r19058 n1392 t_m1_s 112710
r19059 n1506 t_m1_s 5283.28125
r19060 n1507 t_m1_s 84532.5
r19061 n1625 t_m1_s 7044.375
r19062 n1626 t_m1_s 112710
r19063 n1748 t_m1_s 10566.5625
r19064 n1749 t_m1_s 169065
r19065 n1979 t_m1_d 10566.5625
r19066 n1980 t_m1_d 169065
r19067 n2102 t_m1_d 7044.375
r19068 n2103 t_m1_d 112710
r19069 n2221 t_m1_d 5283.28125
r19070 n2222 t_m1_d 84532.5
r19071 n2336 t_m1_d 7044.375
r19072 n2337 t_m1_d 112710
r19073 n2451 t_m1_d 1408.875
r19074 n2452 t_m1_d 22542
r19075 n2566 t_m1_d 4226.625
r19076 n2567 t_m1_d 67626
r19077 n2681 t_m1_d 10566.5625
r19078 n2682 t_m1_d 169065
r19079 n574 t_m1_b 53465
r19080 n575 t_m1_b 3341.5625
r19081 n730 t_m1_b 3564.3333333333335
r19082 n731 t_m1_b 222.77083333333334
r19083 n886 t_m1_b 53465
r19084 n887 t_m1_b 3341.5625
r19085 n2844 t_m1_b 3145
r19086 n2845 t_m1_b 196.5625
r19087 n1050 t_m1_s 10566.5625
r19088 n1051 t_m1_s 169065
r19089 n1165 t_m1_s 4226.625
r19090 n1166 t_m1_s 67626
r19091 n1280 t_m1_s 1408.875
r19092 n1281 t_m1_s 22542
r19093 n1395 t_m1_s 7044.375
r19094 n1396 t_m1_s 112710
r19095 n1510 t_m1_s 5283.28125
r19096 n1511 t_m1_s 84532.5
r19097 n1629 t_m1_s 7044.375
r19098 n1630 t_m1_s 112710
r19099 n1752 t_m1_s 10566.5625
r19100 n1753 t_m1_s 169065
r19101 n1983 t_m1_d 10566.5625
r19102 n1984 t_m1_d 169065
r19103 n2106 t_m1_d 7044.375
r19104 n2107 t_m1_d 112710
r19105 n2225 t_m1_d 5283.28125
r19106 n2226 t_m1_d 84532.5
r19107 n2340 t_m1_d 7044.375
r19108 n2341 t_m1_d 112710
r19109 n2455 t_m1_d 1408.875
r19110 n2456 t_m1_d 22542
r19111 n2570 t_m1_d 4226.625
r19112 n2571 t_m1_d 67626
r19113 n2685 t_m1_d 10566.5625
r19114 n2686 t_m1_d 169065
r19115 n578 t_m1_b 53465
r19116 n579 t_m1_b 3341.5625
r19117 n734 t_m1_b 3564.3333333333335
r19118 n735 t_m1_b 222.77083333333334
r19119 n890 t_m1_b 53465
r19120 n891 t_m1_b 3341.5625
r19121 n2848 t_m1_b 3145
r19122 n2849 t_m1_b 196.5625
r19123 n1054 t_m1_s 10566.5625
r19124 n1055 t_m1_s 169065
r19125 n1169 t_m1_s 4226.625
r19126 n1170 t_m1_s 67626
r19127 n1284 t_m1_s 1408.875
r19128 n1285 t_m1_s 22542
r19129 n1399 t_m1_s 7044.375
r19130 n1400 t_m1_s 112710
r19131 n1514 t_m1_s 5283.28125
r19132 n1515 t_m1_s 84532.5
r19133 n1633 t_m1_s 7044.375
r19134 n1634 t_m1_s 112710
r19135 n1756 t_m1_s 10566.5625
r19136 n1757 t_m1_s 169065
r19137 n1987 t_m1_d 10566.5625
r19138 n1988 t_m1_d 169065
r19139 n2110 t_m1_d 7044.375
r19140 n2111 t_m1_d 112710
r19141 n2229 t_m1_d 5283.28125
r19142 n2230 t_m1_d 84532.5
r19143 n2344 t_m1_d 7044.375
r19144 n2345 t_m1_d 112710
r19145 n2459 t_m1_d 1408.875
r19146 n2460 t_m1_d 22542
r19147 n2574 t_m1_d 4226.625
r19148 n2575 t_m1_d 67626
r19149 n2689 t_m1_d 10566.5625
r19150 n2690 t_m1_d 169065
r19151 n582 t_m1_b 53465
r19152 n583 t_m1_b 3341.5625
r19153 n738 t_m1_b 3564.3333333333335
r19154 n739 t_m1_b 222.77083333333334
r19155 n894 t_m1_b 53465
r19156 n895 t_m1_b 3341.5625
r19157 n2852 t_m1_b 3145
r19158 n2853 t_m1_b 196.5625
r19159 n1058 t_m1_s 10566.5625
r19160 n1059 t_m1_s 169065
r19161 n1173 t_m1_s 4226.625
r19162 n1174 t_m1_s 67626
r19163 n1288 t_m1_s 1408.875
r19164 n1289 t_m1_s 22542
r19165 n1403 t_m1_s 7044.375
r19166 n1404 t_m1_s 112710
r19167 n1518 t_m1_s 5283.28125
r19168 n1519 t_m1_s 84532.5
r19169 n1637 t_m1_s 7044.375
r19170 n1638 t_m1_s 112710
r19171 n1760 t_m1_s 10566.5625
r19172 n1761 t_m1_s 169065
r19173 n1991 t_m1_d 10566.5625
r19174 n1992 t_m1_d 169065
r19175 n2114 t_m1_d 7044.375
r19176 n2115 t_m1_d 112710
r19177 n2233 t_m1_d 5283.28125
r19178 n2234 t_m1_d 84532.5
r19179 n2348 t_m1_d 7044.375
r19180 n2349 t_m1_d 112710
r19181 n2463 t_m1_d 1408.875
r19182 n2464 t_m1_d 22542
r19183 n2578 t_m1_d 4226.625
r19184 n2579 t_m1_d 67626
r19185 n2693 t_m1_d 10566.5625
r19186 n2694 t_m1_d 169065
r19187 n586 t_m1_b 53465
r19188 n587 t_m1_b 3341.5625
r19189 n742 t_m1_b 3564.3333333333335
r19190 n743 t_m1_b 222.77083333333334
r19191 n898 t_m1_b 53465
r19192 n899 t_m1_b 3341.5625
r19193 n2856 t_m1_b 3145
r19194 n2857 t_m1_b 196.5625
r19195 n1062 t_m1_s 10566.5625
r19196 n1063 t_m1_s 169065
r19197 n1177 t_m1_s 4226.625
r19198 n1178 t_m1_s 67626
r19199 n1292 t_m1_s 1408.875
r19200 n1293 t_m1_s 22542
r19201 n1407 t_m1_s 7044.375
r19202 n1408 t_m1_s 112710
r19203 n1522 t_m1_s 5283.28125
r19204 n1523 t_m1_s 84532.5
r19205 n1641 t_m1_s 7044.375
r19206 n1642 t_m1_s 112710
r19207 n1764 t_m1_s 10566.5625
r19208 n1765 t_m1_s 169065
r19209 n1995 t_m1_d 10566.5625
r19210 n1996 t_m1_d 169065
r19211 n2118 t_m1_d 7044.375
r19212 n2119 t_m1_d 112710
r19213 n2237 t_m1_d 5283.28125
r19214 n2238 t_m1_d 84532.5
r19215 n2352 t_m1_d 7044.375
r19216 n2353 t_m1_d 112710
r19217 n2467 t_m1_d 1408.875
r19218 n2468 t_m1_d 22542
r19219 n2582 t_m1_d 4226.625
r19220 n2583 t_m1_d 67626
r19221 n2697 t_m1_d 10566.5625
r19222 n2698 t_m1_d 169065
r19223 n592 t_m1_b 53465
r19224 n593 t_m1_b 53465
r19225 n594 t_m1_b 13366.25
r19226 n595 t_m1_b 4860.454545454545
r19227 n748 t_m1_b 3564.3333333333335
r19228 n749 t_m1_b 3564.3333333333335
r19229 n750 t_m1_b 891.08333333333337
r19230 n751 t_m1_b 324.03030303030306
r19231 n904 t_m1_b 53465
r19232 n905 t_m1_b 53465
r19233 n906 t_m1_b 13366.25
r19234 n907 t_m1_b 4860.454545454545
r19235 n2862 t_m1_b 3145
r19236 n2863 t_m1_b 3145
r19237 n2864 t_m1_b 786.25
r19238 n2865 t_m1_b 285.90909090909088
r19239 n1068 t_m1_s 169065
r19240 n1069 t_m1_s 42266.25
r19241 n1070 t_m1_s 15369.545454545454
r19242 n1071 t_m1_s 338130
r19243 n1072 t_m1_s 338130
r19244 n1183 t_m1_s 67626
r19245 n1184 t_m1_s 16906.5
r19246 n1185 t_m1_s 6147.818181818182
r19247 n1186 t_m1_s 135252
r19248 n1187 t_m1_s 135252
r19249 n1298 t_m1_s 22542
r19250 n1299 t_m1_s 5635.5
r19251 n1300 t_m1_s 2049.2727272727275
r19252 n1301 t_m1_s 45084
r19253 n1302 t_m1_s 45084
r19254 n1413 t_m1_s 112710
r19255 n1414 t_m1_s 28177.5
r19256 n1415 t_m1_s 10246.363636363636
r19257 n1416 t_m1_s 225420
r19258 n1417 t_m1_s 225420
r19259 n1528 t_m1_s 84532.5
r19260 n1529 t_m1_s 21133.125
r19261 n1530 t_m1_s 7684.772727272727
r19262 n1531 t_m1_s 169065
r19263 n1532 t_m1_s 169065
r19264 n1647 t_m1_s 112710
r19265 n1648 t_m1_s 28177.5
r19266 n1649 t_m1_s 10246.363636363636
r19267 n1650 t_m1_s 225420
r19268 n1651 t_m1_s 225420
r19269 n1770 t_m1_s 169065
r19270 n1771 t_m1_s 42266.25
r19271 n1772 t_m1_s 15369.545454545454
r19272 n1773 t_m1_s 338130
r19273 n1774 t_m1_s 338130
r19274 n2001 t_m1_d 169065
r19275 n2002 t_m1_d 42266.25
r19276 n2003 t_m1_d 15369.545454545454
r19277 n2004 t_m1_d 338130
r19278 n2005 t_m1_d 338130
r19279 n2124 t_m1_d 112710
r19280 n2125 t_m1_d 28177.5
r19281 n2126 t_m1_d 10246.363636363636
r19282 n2127 t_m1_d 225420
r19283 n2128 t_m1_d 225420
r19284 n2243 t_m1_d 84532.5
r19285 n2244 t_m1_d 21133.125
r19286 n2245 t_m1_d 7684.772727272727
r19287 n2246 t_m1_d 169065
r19288 n2247 t_m1_d 169065
r19289 n2358 t_m1_d 112710
r19290 n2359 t_m1_d 28177.5
r19291 n2360 t_m1_d 10246.363636363636
r19292 n2361 t_m1_d 225420
r19293 n2362 t_m1_d 225420
r19294 n2473 t_m1_d 22542
r19295 n2474 t_m1_d 5635.5
r19296 n2475 t_m1_d 2049.2727272727275
r19297 n2476 t_m1_d 45084
r19298 n2477 t_m1_d 45084
r19299 n2588 t_m1_d 67626
r19300 n2589 t_m1_d 16906.5
r19301 n2590 t_m1_d 6147.818181818182
r19302 n2591 t_m1_d 135252
r19303 n2592 t_m1_d 135252
r19304 n2703 t_m1_d 169065
r19305 n2704 t_m1_d 42266.25
r19306 n2705 t_m1_d 15369.545454545454
r19307 n2706 t_m1_d 338130
r19308 n2707 t_m1_d 338130
r19309 n604 t_m1_b 53465
r19310 n605 t_m1_b 17821.666666666668
r19311 n606 t_m1_b 8910.8333333333339
r19312 n607 t_m1_b 7637.8571428571431
r19313 n760 t_m1_b 3564.3333333333335
r19314 n761 t_m1_b 1188.1111111111111
r19315 n762 t_m1_b 594.05555555555554
r19316 n763 t_m1_b 509.19047619047615
r19317 n916 t_m1_b 53465
r19318 n917 t_m1_b 17821.666666666668
r19319 n918 t_m1_b 8910.8333333333339
r19320 n919 t_m1_b 7637.8571428571431
r19321 n2874 t_m1_b 3145
r19322 n2875 t_m1_b 1048.3333333333333
r19323 n2876 t_m1_b 524.16666666666663
r19324 n2877 t_m1_b 449.28571428571433
r19325 n1080 t_m1_s 56355
r19326 n1081 t_m1_s 28177.5
r19327 n1082 t_m1_s 24152.142857142859
r19328 n1083 t_m1_s 169065
r19329 n1195 t_m1_s 22542
r19330 n1196 t_m1_s 11271
r19331 n1197 t_m1_s 9660.8571428571431
r19332 n1198 t_m1_s 67626
r19333 n1310 t_m1_s 7514
r19334 n1311 t_m1_s 3757
r19335 n1312 t_m1_s 3220.2857142857142
r19336 n1313 t_m1_s 22542
r19337 n1425 t_m1_s 37570
r19338 n1426 t_m1_s 18785
r19339 n1427 t_m1_s 16101.428571428571
r19340 n1428 t_m1_s 112710
r19341 n1540 t_m1_s 28177.5
r19342 n1541 t_m1_s 14088.75
r19343 n1542 t_m1_s 12076.071428571429
r19344 n1543 t_m1_s 84532.5
r19345 n1659 t_m1_s 37570
r19346 n1660 t_m1_s 18785
r19347 n1661 t_m1_s 16101.428571428571
r19348 n1662 t_m1_s 112710
r19349 n1782 t_m1_s 56355
r19350 n1783 t_m1_s 28177.5
r19351 n1784 t_m1_s 24152.142857142859
r19352 n1785 t_m1_s 169065
r19353 n2013 t_m1_d 56355
r19354 n2014 t_m1_d 28177.5
r19355 n2015 t_m1_d 24152.142857142859
r19356 n2016 t_m1_d 169065
r19357 n2136 t_m1_d 37570
r19358 n2137 t_m1_d 18785
r19359 n2138 t_m1_d 16101.428571428571
r19360 n2139 t_m1_d 112710
r19361 n2255 t_m1_d 28177.5
r19362 n2256 t_m1_d 14088.75
r19363 n2257 t_m1_d 12076.071428571429
r19364 n2258 t_m1_d 84532.5
r19365 n2370 t_m1_d 37570
r19366 n2371 t_m1_d 18785
r19367 n2372 t_m1_d 16101.428571428571
r19368 n2373 t_m1_d 112710
r19369 n2485 t_m1_d 7514
r19370 n2486 t_m1_d 3757
r19371 n2487 t_m1_d 3220.2857142857142
r19372 n2488 t_m1_d 22542
r19373 n2600 t_m1_d 22542
r19374 n2601 t_m1_d 11271
r19375 n2602 t_m1_d 9660.8571428571431
r19376 n2603 t_m1_d 67626
r19377 n2715 t_m1_d 56355
r19378 n2716 t_m1_d 28177.5
r19379 n2717 t_m1_d 24152.142857142859
r19380 n2718 t_m1_d 169065
r19381 n610 t_m1_b 53465
r19382 n611 t_m1_b 3341.5625
r19383 n766 t_m1_b 3564.3333333333335
r19384 n767 t_m1_b 222.77083333333334
r19385 n922 t_m1_b 53465
r19386 n923 t_m1_b 3341.5625
r19387 n2880 t_m1_b 3145
r19388 n2881 t_m1_b 196.5625
r19389 n1086 t_m1_s 10566.5625
r19390 n1087 t_m1_s 169065
r19391 n1201 t_m1_s 4226.625
r19392 n1202 t_m1_s 67626
r19393 n1316 t_m1_s 1408.875
r19394 n1317 t_m1_s 22542
r19395 n1431 t_m1_s 7044.375
r19396 n1432 t_m1_s 112710
r19397 n1546 t_m1_s 5283.28125
r19398 n1547 t_m1_s 84532.5
r19399 n1665 t_m1_s 7044.375
r19400 n1666 t_m1_s 112710
r19401 n1788 t_m1_s 10566.5625
r19402 n1789 t_m1_s 169065
r19403 n2019 t_m1_d 10566.5625
r19404 n2020 t_m1_d 169065
r19405 n2142 t_m1_d 7044.375
r19406 n2143 t_m1_d 112710
r19407 n2261 t_m1_d 5283.28125
r19408 n2262 t_m1_d 84532.5
r19409 n2376 t_m1_d 7044.375
r19410 n2377 t_m1_d 112710
r19411 n2491 t_m1_d 1408.875
r19412 n2492 t_m1_d 22542
r19413 n2606 t_m1_d 4226.625
r19414 n2607 t_m1_d 67626
r19415 n2721 t_m1_d 10566.5625
r19416 n2722 t_m1_d 169065
r19417 n614 t_m1_b 53465
r19418 n615 t_m1_b 3341.5625
r19419 n770 t_m1_b 3564.3333333333335
r19420 n771 t_m1_b 222.77083333333334
r19421 n926 t_m1_b 53465
r19422 n927 t_m1_b 3341.5625
r19423 n2884 t_m1_b 3145
r19424 n2885 t_m1_b 196.5625
r19425 n1090 t_m1_s 10566.5625
r19426 n1091 t_m1_s 169065
r19427 n1205 t_m1_s 4226.625
r19428 n1206 t_m1_s 67626
r19429 n1320 t_m1_s 1408.875
r19430 n1321 t_m1_s 22542
r19431 n1435 t_m1_s 7044.375
r19432 n1436 t_m1_s 112710
r19433 n1550 t_m1_s 5283.28125
r19434 n1551 t_m1_s 84532.5
r19435 n1669 t_m1_s 7044.375
r19436 n1670 t_m1_s 112710
r19437 n1792 t_m1_s 10566.5625
r19438 n1793 t_m1_s 169065
r19439 n2023 t_m1_d 10566.5625
r19440 n2024 t_m1_d 169065
r19441 n2146 t_m1_d 7044.375
r19442 n2147 t_m1_d 112710
r19443 n2265 t_m1_d 5283.28125
r19444 n2266 t_m1_d 84532.5
r19445 n2380 t_m1_d 7044.375
r19446 n2381 t_m1_d 112710
r19447 n2495 t_m1_d 1408.875
r19448 n2496 t_m1_d 22542
r19449 n2610 t_m1_d 4226.625
r19450 n2611 t_m1_d 67626
r19451 n2725 t_m1_d 10566.5625
r19452 n2726 t_m1_d 169065
r19453 n618 t_m1_b 53465
r19454 n619 t_m1_b 3341.5625
r19455 n774 t_m1_b 3564.3333333333335
r19456 n775 t_m1_b 222.77083333333334
r19457 n930 t_m1_b 53465
r19458 n931 t_m1_b 3341.5625
r19459 n2888 t_m1_b 3145
r19460 n2889 t_m1_b 196.5625
r19461 n1094 t_m1_s 10566.5625
r19462 n1095 t_m1_s 169065
r19463 n1209 t_m1_s 4226.625
r19464 n1210 t_m1_s 67626
r19465 n1324 t_m1_s 1408.875
r19466 n1325 t_m1_s 22542
r19467 n1439 t_m1_s 7044.375
r19468 n1440 t_m1_s 112710
r19469 n1554 t_m1_s 5283.28125
r19470 n1555 t_m1_s 84532.5
r19471 n1673 t_m1_s 7044.375
r19472 n1674 t_m1_s 112710
r19473 n1796 t_m1_s 10566.5625
r19474 n1797 t_m1_s 169065
r19475 n2027 t_m1_d 10566.5625
r19476 n2028 t_m1_d 169065
r19477 n2150 t_m1_d 7044.375
r19478 n2151 t_m1_d 112710
r19479 n2269 t_m1_d 5283.28125
r19480 n2270 t_m1_d 84532.5
r19481 n2384 t_m1_d 7044.375
r19482 n2385 t_m1_d 112710
r19483 n2499 t_m1_d 1408.875
r19484 n2500 t_m1_d 22542
r19485 n2614 t_m1_d 4226.625
r19486 n2615 t_m1_d 67626
r19487 n2729 t_m1_d 10566.5625
r19488 n2730 t_m1_d 169065
r19489 n622 t_m1_b 53465
r19490 n623 t_m1_b 3341.5625
r19491 n778 t_m1_b 3564.3333333333335
r19492 n779 t_m1_b 222.77083333333334
r19493 n934 t_m1_b 53465
r19494 n935 t_m1_b 3341.5625
r19495 n2892 t_m1_b 3145
r19496 n2893 t_m1_b 196.5625
r19497 n1098 t_m1_s 10566.5625
r19498 n1099 t_m1_s 169065
r19499 n1213 t_m1_s 4226.625
r19500 n1214 t_m1_s 67626
r19501 n1328 t_m1_s 1408.875
r19502 n1329 t_m1_s 22542
r19503 n1443 t_m1_s 7044.375
r19504 n1444 t_m1_s 112710
r19505 n1558 t_m1_s 5283.28125
r19506 n1559 t_m1_s 84532.5
r19507 n1677 t_m1_s 7044.375
r19508 n1678 t_m1_s 112710
r19509 n1800 t_m1_s 10566.5625
r19510 n1801 t_m1_s 169065
r19511 n2031 t_m1_d 10566.5625
r19512 n2032 t_m1_d 169065
r19513 n2154 t_m1_d 7044.375
r19514 n2155 t_m1_d 112710
r19515 n2273 t_m1_d 5283.28125
r19516 n2274 t_m1_d 84532.5
r19517 n2388 t_m1_d 7044.375
r19518 n2389 t_m1_d 112710
r19519 n2503 t_m1_d 1408.875
r19520 n2504 t_m1_d 22542
r19521 n2618 t_m1_d 4226.625
r19522 n2619 t_m1_d 67626
r19523 n2733 t_m1_d 10566.5625
r19524 n2734 t_m1_d 169065
r19525 n626 t_m1_b 53465
r19526 n627 t_m1_b 3341.5625
r19527 n782 t_m1_b 3564.3333333333335
r19528 n783 t_m1_b 222.77083333333334
r19529 n938 t_m1_b 53465
r19530 n939 t_m1_b 3341.5625
r19531 n2896 t_m1_b 3145
r19532 n2897 t_m1_b 196.5625
r19533 n1102 t_m1_s 10566.5625
r19534 n1103 t_m1_s 169065
r19535 n1217 t_m1_s 4226.625
r19536 n1218 t_m1_s 67626
r19537 n1332 t_m1_s 1408.875
r19538 n1333 t_m1_s 22542
r19539 n1447 t_m1_s 7044.375
r19540 n1448 t_m1_s 112710
r19541 n1562 t_m1_s 5283.28125
r19542 n1563 t_m1_s 84532.5
r19543 n1681 t_m1_s 7044.375
r19544 n1682 t_m1_s 112710
r19545 n1804 t_m1_s 10566.5625
r19546 n1805 t_m1_s 169065
r19547 n2035 t_m1_d 10566.5625
r19548 n2036 t_m1_d 169065
r19549 n2158 t_m1_d 7044.375
r19550 n2159 t_m1_d 112710
r19551 n2277 t_m1_d 5283.28125
r19552 n2278 t_m1_d 84532.5
r19553 n2392 t_m1_d 7044.375
r19554 n2393 t_m1_d 112710
r19555 n2507 t_m1_d 1408.875
r19556 n2508 t_m1_d 22542
r19557 n2622 t_m1_d 4226.625
r19558 n2623 t_m1_d 67626
r19559 n2737 t_m1_d 10566.5625
r19560 n2738 t_m1_d 169065
r19561 n630 t_m1_b 53465
r19562 n631 t_m1_b 3341.5625
r19563 n786 t_m1_b 3564.3333333333335
r19564 n787 t_m1_b 222.77083333333334
r19565 n942 t_m1_b 53465
r19566 n943 t_m1_b 3341.5625
r19567 n2900 t_m1_b 3145
r19568 n2901 t_m1_b 196.5625
r19569 n1106 t_m1_s 10566.5625
r19570 n1107 t_m1_s 169065
r19571 n1221 t_m1_s 4226.625
r19572 n1222 t_m1_s 67626
r19573 n1336 t_m1_s 1408.875
r19574 n1337 t_m1_s 22542
r19575 n1451 t_m1_s 7044.375
r19576 n1452 t_m1_s 112710
r19577 n1566 t_m1_s 5283.28125
r19578 n1567 t_m1_s 84532.5
r19579 n1685 t_m1_s 7044.375
r19580 n1686 t_m1_s 112710
r19581 n1808 t_m1_s 10566.5625
r19582 n1809 t_m1_s 169065
r19583 n2039 t_m1_d 10566.5625
r19584 n2040 t_m1_d 169065
r19585 n2162 t_m1_d 7044.375
r19586 n2163 t_m1_d 112710
r19587 n2281 t_m1_d 5283.28125
r19588 n2282 t_m1_d 84532.5
r19589 n2396 t_m1_d 7044.375
r19590 n2397 t_m1_d 112710
r19591 n2511 t_m1_d 1408.875
r19592 n2512 t_m1_d 22542
r19593 n2626 t_m1_d 4226.625
r19594 n2627 t_m1_d 67626
r19595 n2741 t_m1_d 10566.5625
r19596 n2742 t_m1_d 169065
r19597 n634 t_m1_b 53465
r19598 n635 t_m1_b 3341.5625
r19599 n790 t_m1_b 3564.3333333333335
r19600 n791 t_m1_b 222.77083333333334
r19601 n946 t_m1_b 53465
r19602 n947 t_m1_b 3341.5625
r19603 n2904 t_m1_b 3145
r19604 n2905 t_m1_b 196.5625
r19605 n1110 t_m1_s 10566.5625
r19606 n1111 t_m1_s 169065
r19607 n1225 t_m1_s 4226.625
r19608 n1226 t_m1_s 67626
r19609 n1340 t_m1_s 1408.875
r19610 n1341 t_m1_s 22542
r19611 n1455 t_m1_s 7044.375
r19612 n1456 t_m1_s 112710
r19613 n1570 t_m1_s 5283.28125
r19614 n1571 t_m1_s 84532.5
r19615 n1689 t_m1_s 7044.375
r19616 n1690 t_m1_s 112710
r19617 n1812 t_m1_s 10566.5625
r19618 n1813 t_m1_s 169065
r19619 n2043 t_m1_d 10566.5625
r19620 n2044 t_m1_d 169065
r19621 n2166 t_m1_d 7044.375
r19622 n2167 t_m1_d 112710
r19623 n2285 t_m1_d 5283.28125
r19624 n2286 t_m1_d 84532.5
r19625 n2400 t_m1_d 7044.375
r19626 n2401 t_m1_d 112710
r19627 n2515 t_m1_d 1408.875
r19628 n2516 t_m1_d 22542
r19629 n2630 t_m1_d 4226.625
r19630 n2631 t_m1_d 67626
r19631 n2745 t_m1_d 10566.5625
r19632 n2746 t_m1_d 169065
r19633 n640 t_m1_b 3145
r19634 n796 t_m1_b 209.66666666666669
r19635 n952 t_m1_b 3145
r19636 n2910 t_m1_b 185
r19637 n1864 t_m1_g 43928
r19638 n1865 t_m1_g 7986.909090909091
r19639 n1866 t_m1_g 4624
r19640 n1867 t_m1_g 43928
r19641 n1876 t_m1_g 2928.5333333333333
r19642 n1877 t_m1_g 532.4606060606061
r19643 n1878 t_m1_g 308.26666666666665
r19644 n1879 t_m1_g 2928.5333333333333
r19645 n1888 t_m1_g 43928
r19646 n1889 t_m1_g 7986.909090909091
r19647 n1890 t_m1_g 4624
r19648 n1891 t_m1_g 43928
r19649 n648 t_m1_b 5627.8947368421059
r19650 n649 t_m1_b 53465
r19651 n650 t_m1_b 35643.333333333336
r19652 n651 t_m1_b 35643.333333333336
r19653 n652 t_m1_b 15275.714285714286
r19654 n804 t_m1_b 375.19298245614033
r19655 n805 t_m1_b 3564.3333333333335
r19656 n806 t_m1_b 2376.2222222222222
r19657 n807 t_m1_b 2376.2222222222222
r19658 n808 t_m1_b 1018.3809523809523
r19659 n960 t_m1_b 5627.8947368421059
r19660 n961 t_m1_b 53465
r19661 n962 t_m1_b 35643.333333333336
r19662 n963 t_m1_b 35643.333333333336
r19663 n964 t_m1_b 15275.714285714286
r19664 n2918 t_m1_b 331.05263157894734
r19665 n2919 t_m1_b 3145
r19666 n2920 t_m1_b 2096.6666666666665
r19667 n2921 t_m1_b 2096.6666666666665
r19668 n2922 t_m1_b 898.57142857142867
r19669 n987 t_m1_b 449.28571428571433
r19670 n991 t_m1_b 3145
r19671 n995 t_m1_b 1258
r19672 n999 t_m1_b 1048.3333333333333
r19673 n1114 t_m1_b 3145
r19674 n1229 t_m1_b 1258
r19675 n1868 t_m1_b 3145
r19676 n1880 t_m1_b 209.66666666666669
r19677 n1892 t_m1_b 3145
r19678 n2634 t_m1_b 1258
r19679 n2749 t_m1_b 3145
r19680 n2753 t_m1_b 1048.3333333333333
r19681 n2757 t_m1_b 898.57142857142867
r19682 n2761 t_m1_b 449.28571428571433
.save all
.control
set filetype=ascii
ac lin 1 869272781.82837343 869272781.82837343
write ac_0.raw all
ac lin 1 870142489.39150774 870142489.39150774
write ac_1.raw all
ac lin 1 871013067.09720397 871013067.09720397
write ac_2.raw all
quit
.endc
.end
