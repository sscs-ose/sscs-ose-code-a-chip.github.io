* Extracted by KLayout with SKY130 LVS runset on : 30/10/2026 17:11

.SUBCKT INV IN OUT VDD VSS
XM$1 VDD IN OUT VDD sky130_fd_pr__pfet_01v8 L=0.15 W=6.325 AS=1.8975 AD=1.8975
+ PS=13.25 PD=13.25
XM$2 VSS IN OUT VSS sky130_fd_pr__nfet_01v8 L=0.15 W=1.67 AS=0.501 AD=0.501
+ PS=3.94 PD=3.94
.ENDS INV
