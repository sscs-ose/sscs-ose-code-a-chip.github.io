PerfPDN connected layout circuit
.lib /home/gokalp/.local/share/perfpdn/pdks/sky130A/libs.tech/ngspice/sky130.lib.spice tt
.option scale=1e-6 reltol=1e-8 abstol=1e-14
.temp 27
.option klu reltol=1e-8 abstol=1e-14 vntol=1e-10
vin in 0 DC 0 AC 1 0
vdd vdd 0 DC 0 AC 0 0
C1 out 0 9.9999999999999998e-13
v_r1_a t_r1_a r1_a 0
v_r1_b t_r1_b r1_b -1.2
v_r1_w t_r1_w r1_w -0
XR1 r1_a r1_b r1_w sky130_fd_pr__res_high_po_0p35 L=8.67 mult=1 m=1
v_m1_d t_m1_d m1_d 0
v_m1_g t_m1_g m1_g -0.95472500000000005
v_m1_s t_m1_s m1_s -0
v_m1_b t_m1_b m1_b -0
XM1 m1_d m1_g m1_s m1_b sky130_fd_pr__nfet_01v8_lvt L=0.235 W=0.865 nf=1 ad='int(( 1 + 1 ) / 2 ) * 0.865 / 1 * 0.29' as='int(( 1 + 2 ) / 2 ) * 0.865 / 1 * 0.29' pd='2 * int(( 1 + 1 ) / 2 ) * ( 0.865 / 1 + 0.29 )' ps='2 * int(( 1 + 2 ) / 2 ) * ( 0.865 / 1 + 0.29 )' nrd='0.29 / 0.865 ' nrs='0.29 / 0.865 ' sa=0 sb=0 sd=0 mult=1 m=1
r0 n0 n1 6.4000000000000004
r1 n1 n2 5.2093023255813957
r2 n2 n3 4.7627906976744185
r3 n3 n4 4.7627906976744185
r4 n4 n5 5.2093023255813957
r5 n5 n6 6.4000000000000004
r6 n0 n7 49.280000000000001
r7 n1 n8 14.933333333333334
r8 n7 n8 8.0941176470588232
r9 n2 n9 246.40000000000001
r10 n8 n9 6.5882352941176467
r11 n3 n10 16.426666666666666
r12 n9 n10 6.0235294117647058
r13 n4 n11 246.40000000000001
r14 n10 n11 6.0235294117647058
r15 n5 n12 14.933333333333334
r16 n11 n12 6.5882352941176467
r17 n6 n13 49.280000000000001
r18 n12 n13 8.0941176470588232
r19 n7 n14 49.280000000000001
r20 n8 n15 14.933333333333334
r21 n14 n15 6.4000000000000004
r22 n9 n16 246.40000000000001
r23 n15 n16 5.2093023255813957
r24 n10 n17 16.426666666666666
r25 n16 n17 4.7627906976744185
r26 n11 n18 246.40000000000001
r27 n17 n18 4.7627906976744185
r28 n12 n19 14.933333333333334
r29 n18 n19 5.2093023255813957
r30 n13 n20 49.280000000000001
r31 n19 n20 6.4000000000000004
r32 n16 n21 296.32000000000005
r33 n17 n22 19.754666666666669
r34 n21 n22 4.129032258064516
r35 n18 n23 296.32000000000005
r36 n22 n23 4.129032258064516
r37 n21 n24 317.44
r38 n22 n25 21.162666666666667
r39 n24 n25 4.129032258064516
r40 n23 n26 317.44
r41 n25 n26 4.129032258064516
r42 n24 n27 317.44
r43 n25 n28 21.162666666666667
r44 n27 n28 4.129032258064516
r45 n26 n29 317.44
r46 n28 n29 4.129032258064516
r47 n27 n30 317.44
r48 n28 n31 21.162666666666667
r49 n30 n31 4.129032258064516
r50 n29 n32 317.44
r51 n31 n32 4.129032258064516
r52 n30 n33 317.44
r53 n31 n34 21.162666666666667
r54 n33 n34 4.129032258064516
r55 n32 n35 317.44
r56 n34 n35 4.129032258064516
r57 n33 n36 317.44
r58 n34 n37 21.162666666666667
r59 n36 n37 4.129032258064516
r60 n35 n38 317.44
r61 n37 n38 4.129032258064516
r62 n36 n39 318.08000000000004
r63 n37 n40 21.205333333333336
r64 n39 n40 4.1124497991967868
r65 n38 n41 318.08000000000004
r66 n40 n41 4.1124497991967868
r67 n39 n42 318.08000000000004
r68 n40 n43 21.205333333333336
r69 n42 n43 4.129032258064516
r70 n41 n44 318.08000000000004
r71 n43 n44 4.129032258064516
r72 n42 n45 317.44
r73 n43 n46 21.162666666666667
r74 n45 n46 4.129032258064516
r75 n44 n47 317.44
r76 n46 n47 4.129032258064516
r77 n45 n48 317.44
r78 n46 n49 21.162666666666667
r79 n48 n49 4.129032258064516
r80 n47 n50 317.44
r81 n49 n50 4.129032258064516
r82 n48 n51 317.44
r83 n49 n52 21.162666666666667
r84 n51 n52 4.129032258064516
r85 n50 n53 317.44
r86 n52 n53 4.129032258064516
r87 n51 n54 317.44
r88 n52 n55 21.162666666666667
r89 n54 n55 4.129032258064516
r90 n53 n56 317.44
r91 n55 n56 4.129032258064516
r92 n54 n57 317.44
r93 n55 n58 21.162666666666667
r94 n57 n58 4.129032258064516
r95 n56 n59 317.44
r96 n58 n59 4.129032258064516
r97 n57 n60 317.44
r98 n58 n61 21.162666666666667
r99 n60 n61 4.129032258064516
r100 n59 n62 317.44
r101 n61 n62 4.129032258064516
r102 n60 n63 317.44
r103 n61 n64 21.162666666666667
r104 n63 n64 4.129032258064516
r105 n62 n65 317.44
r106 n64 n65 4.129032258064516
r107 n63 n66 317.44
r108 n64 n67 21.162666666666667
r109 n66 n67 4.129032258064516
r110 n65 n68 317.44
r111 n67 n68 4.129032258064516
r112 n66 n69 317.44
r113 n67 n70 21.162666666666667
r114 n69 n70 4.129032258064516
r115 n68 n71 317.44
r116 n70 n71 4.129032258064516
r117 n69 n72 317.44
r118 n70 n73 21.162666666666667
r119 n72 n73 4.129032258064516
r120 n71 n74 317.44
r121 n73 n74 4.129032258064516
r122 n72 n75 317.44
r123 n73 n76 21.162666666666667
r124 n75 n76 4.129032258064516
r125 n74 n77 317.44
r126 n76 n77 4.129032258064516
r127 n75 n78 318.08000000000004
r128 n76 n79 21.205333333333336
r129 n78 n79 4.1124497991967868
r130 n77 n80 318.08000000000004
r131 n79 n80 4.1124497991967868
r132 n78 n81 318.08000000000004
r133 n79 n82 21.205333333333336
r134 n81 n82 4.129032258064516
r135 n80 n83 318.08000000000004
r136 n82 n83 4.129032258064516
r137 n81 n84 317.44
r138 n82 n85 21.162666666666667
r139 n84 n85 4.129032258064516
r140 n83 n86 317.44
r141 n85 n86 4.129032258064516
r142 n84 n87 317.44
r143 n85 n88 21.162666666666667
r144 n87 n88 4.129032258064516
r145 n86 n89 317.44
r146 n88 n89 4.129032258064516
r147 n87 n90 317.44
r148 n88 n91 21.162666666666667
r149 n90 n91 4.129032258064516
r150 n89 n92 317.44
r151 n91 n92 4.129032258064516
r152 n90 n93 317.44
r153 n91 n94 21.162666666666667
r154 n93 n94 4.129032258064516
r155 n92 n95 317.44
r156 n94 n95 4.129032258064516
r157 n93 n96 317.44
r158 n94 n97 21.162666666666667
r159 n96 n97 4.129032258064516
r160 n95 n98 317.44
r161 n97 n98 4.129032258064516
r162 n96 n99 317.44
r163 n97 n100 21.162666666666667
r164 n99 n100 4.129032258064516
r165 n98 n101 317.44
r166 n100 n101 4.129032258064516
r167 n99 n102 317.44
r168 n100 n103 21.162666666666667
r169 n102 n103 4.129032258064516
r170 n101 n104 317.44
r171 n103 n104 4.129032258064516
r172 n102 n105 317.44
r173 n103 n106 21.162666666666667
r174 n105 n106 4.129032258064516
r175 n104 n107 317.44
r176 n106 n107 4.129032258064516
r177 n105 n108 317.44
r178 n106 n109 21.162666666666667
r179 n108 n109 4.129032258064516
r180 n107 n110 317.44
r181 n109 n110 4.129032258064516
r182 n108 n111 317.44
r183 n109 n112 21.162666666666667
r184 n111 n112 4.129032258064516
r185 n110 n113 317.44
r186 n112 n113 4.129032258064516
r187 n111 n114 317.44
r188 n112 n115 21.162666666666667
r189 n114 n115 4.129032258064516
r190 n113 n116 317.44
r191 n115 n116 4.129032258064516
r192 n114 n117 318.08000000000004
r193 n115 n118 21.205333333333336
r194 n117 n118 4.1124497991967868
r195 n116 n119 318.08000000000004
r196 n118 n119 4.1124497991967868
r197 n117 n120 318.08000000000004
r198 n118 n121 21.205333333333336
r199 n120 n121 4.129032258064516
r200 n119 n122 318.08000000000004
r201 n121 n122 4.129032258064516
r202 n120 n123 317.44
r203 n121 n124 21.162666666666667
r204 n123 n124 4.129032258064516
r205 n122 n125 317.44
r206 n124 n125 4.129032258064516
r207 n123 n126 317.44
r208 n124 n127 21.162666666666667
r209 n126 n127 4.129032258064516
r210 n125 n128 317.44
r211 n127 n128 4.129032258064516
r212 n126 n129 317.44
r213 n127 n130 21.162666666666667
r214 n129 n130 4.129032258064516
r215 n128 n131 317.44
r216 n130 n131 4.129032258064516
r217 n129 n132 317.44
r218 n130 n133 21.162666666666667
r219 n132 n133 4.129032258064516
r220 n131 n134 317.44
r221 n133 n134 4.129032258064516
r222 n132 n135 317.44
r223 n133 n136 21.162666666666667
r224 n135 n136 4.129032258064516
r225 n134 n137 317.44
r226 n136 n137 4.129032258064516
r227 n135 n138 317.44
r228 n136 n139 21.162666666666667
r229 n138 n139 4.129032258064516
r230 n137 n140 317.44
r231 n139 n140 4.129032258064516
r232 n138 n141 317.44
r233 n139 n142 21.162666666666667
r234 n141 n142 4.129032258064516
r235 n140 n143 317.44
r236 n142 n143 4.129032258064516
r237 n141 n144 317.44
r238 n142 n145 21.162666666666667
r239 n144 n145 4.129032258064516
r240 n143 n146 317.44
r241 n145 n146 4.129032258064516
r242 n144 n147 317.44
r243 n145 n148 21.162666666666667
r244 n147 n148 4.129032258064516
r245 n146 n149 317.44
r246 n148 n149 4.129032258064516
r247 n147 n150 317.44
r248 n148 n151 21.162666666666667
r249 n150 n151 4.129032258064516
r250 n149 n152 317.44
r251 n151 n152 4.129032258064516
r252 n150 n153 317.44
r253 n151 n154 21.162666666666667
r254 n153 n154 4.129032258064516
r255 n152 n155 317.44
r256 n154 n155 4.129032258064516
r257 n153 n156 318.08000000000004
r258 n154 n157 21.205333333333336
r259 n156 n157 4.1124497991967868
r260 n155 n158 318.08000000000004
r261 n157 n158 4.1124497991967868
r262 n156 n159 318.08000000000004
r263 n157 n160 21.205333333333336
r264 n159 n160 4.129032258064516
r265 n158 n161 318.08000000000004
r266 n160 n161 4.129032258064516
r267 n159 n162 317.44
r268 n160 n163 21.162666666666667
r269 n162 n163 4.129032258064516
r270 n161 n164 317.44
r271 n163 n164 4.129032258064516
r272 n162 n165 317.44
r273 n163 n166 21.162666666666667
r274 n165 n166 4.129032258064516
r275 n164 n167 317.44
r276 n166 n167 4.129032258064516
r277 n165 n168 317.44
r278 n166 n169 21.162666666666667
r279 n168 n169 4.129032258064516
r280 n167 n170 317.44
r281 n169 n170 4.129032258064516
r282 n168 n171 317.44
r283 n169 n172 21.162666666666667
r284 n171 n172 4.129032258064516
r285 n170 n173 317.44
r286 n172 n173 4.129032258064516
r287 n171 n174 317.44
r288 n172 n175 21.162666666666667
r289 n174 n175 4.129032258064516
r290 n173 n176 317.44
r291 n175 n176 4.129032258064516
r292 n177 n178 13.76
r293 n174 n179 222.72000000000003
r294 n178 n179 11.199999999999999
r295 n175 n180 14.848000000000003
r296 n179 n180 10.24
r297 n176 n181 222.72000000000003
r298 n180 n181 10.24
r299 n181 n182 11.199999999999999
r300 n182 n183 13.76
r301 n177 n184 27.52
r302 n178 n185 8.3393939393939398
r303 n184 n185 11.965217391304348
r304 n179 n186 137.59999999999999
r305 n185 n186 9.7391304347826093
r306 n180 n187 9.1733333333333338
r307 n186 n187 8.9043478260869566
r308 n181 n188 137.59999999999999
r309 n187 n188 8.9043478260869566
r310 n182 n189 8.3393939393939398
r311 n188 n189 9.7391304347826093
r312 n183 n190 27.52
r313 n189 n190 11.965217391304348
r314 n184 n191 16
r315 n185 n192 4.8484848484848486
r316 n191 n192 137.59999999999999
r317 n186 n193 80
r318 n192 n193 112
r319 n187 n194 5.333333333333333
r320 n193 n194 102.40000000000001
r321 n188 n195 80
r322 n194 n195 102.40000000000001
r323 n189 n196 4.8484848484848486
r324 n195 n196 112
r325 n190 n197 16
r326 n196 n197 137.59999999999999
r327 n191 n198 20.48
r328 n192 n199 6.2060606060606061
r329 n198 n199 9.1733333333333338
r330 n193 n200 102.40000000000001
r331 n199 n200 7.4666666666666668
r332 n194 n201 6.8266666666666671
r333 n200 n201 6.8266666666666671
r334 n195 n202 102.40000000000001
r335 n201 n202 6.8266666666666671
r336 n196 n203 6.2060606060606061
r337 n202 n203 7.4666666666666668
r338 n197 n204 20.48
r339 n203 n204 9.1733333333333338
r340 n198 n205 20.48
r341 n199 n206 6.2060606060606061
r342 n205 n206 137.59999999999999
r343 n200 n207 102.40000000000001
r344 n206 n207 112
r345 n201 n208 6.8266666666666671
r346 n207 n208 102.40000000000001
r347 n202 n209 102.40000000000001
r348 n208 n209 102.40000000000001
r349 n203 n210 6.2060606060606061
r350 n209 n210 112
r351 n204 n211 20.48
r352 n210 n211 137.59999999999999
r353 n205 n212 16
r354 n206 n213 4.8484848484848486
r355 n212 n213 11.965217391304348
r356 n207 n214 80
r357 n213 n214 9.7391304347826093
r358 n208 n215 5.333333333333333
r359 n214 n215 8.9043478260869566
r360 n209 n216 80
r361 n215 n216 8.9043478260869566
r362 n210 n217 4.8484848484848486
r363 n216 n217 9.7391304347826093
r364 n211 n218 16
r365 n217 n218 11.965217391304348
r366 n212 n219 27.52
r367 n213 n220 8.3393939393939398
r368 n219 n220 13.76
r369 n214 n221 137.59999999999999
r370 n220 n221 11.199999999999999
r371 n215 n222 9.1733333333333338
r372 n221 n222 10.24
r373 n216 n223 137.59999999999999
r374 n222 n223 10.24
r375 n217 n224 8.3393939393939398
r376 n223 n224 11.199999999999999
r377 n218 n225 27.52
r378 n224 n225 13.76
r379 n226 n227 150.40000000000001
r380 n227 n228 169.59999999999999
r381 n228 n229 131.19999999999999
r382 n229 n230 108.8
r383 n230 n231 108.8
r384 n231 n232 76.799999999999997
r385 n232 n233 86.400000000000006
r386 n233 n234 32
r387 n234 n235 35.200000000000003
r388 n235 n236 19.199999999999999
r389 n236 n237 44.799999999999997
r390 n237 n238 73.599999999999994
r391 n238 n239 48
r392 n239 n240 32
r393 n240 n241 19.199999999999999
r394 n241 n242 12.800000000000001
r395 n242 n243 12.800000000000001
r396 n243 n244 32
r397 n244 n245 60.799999999999997
r398 n245 n246 48
r399 n246 n247 32
r400 n247 n248 19.199999999999999
r401 n248 n249 9.5999999999999996
r402 n249 n250 9.5999999999999996
r403 n250 n251 6.4000000000000004
r404 n251 n252 6.4000000000000004
r405 n252 n253 16
r406 n253 n254 28.800000000000001
r407 n254 n255 19.199999999999999
r408 n255 n256 35.200000000000003
r409 n256 n257 41.600000000000001
r410 n257 n258 28.800000000000001
r411 n258 n259 25.600000000000001
r412 n259 n260 9.5999999999999996
r413 n260 n261 6.4000000000000004
r414 n261 n262 22.399999999999999
r415 n262 n263 35.200000000000003
r416 n263 n264 19.199999999999999
r417 n264 n265 16
r418 n265 n266 28.800000000000001
r419 n266 n267 25.600000000000001
r420 n267 n268 32
r421 n268 n269 41.600000000000001
r422 n269 n270 51.200000000000003
r423 n270 n271 44.799999999999997
r424 n271 n272 35.200000000000003
r425 n272 n273 51.200000000000003
r426 n273 n274 41.600000000000001
r427 n274 n275 38.399999999999999
r428 n275 n276 41.600000000000001
r429 n276 n277 35.200000000000003
r430 n277 n278 25.600000000000001
r431 n278 n279 60.799999999999997
r432 n279 n280 96
r433 n280 n281 48
r434 n281 n282 12.800000000000001
r435 n282 n283 19.199999999999999
r436 n283 n284 28.800000000000001
r437 n284 n285 41.600000000000001
r438 n285 n286 38.399999999999999
r439 n286 n287 54.399999999999999
r440 n287 n288 64
r441 n288 n289 108.8
r442 n289 n290 92.799999999999997
r443 n290 n291 22.399999999999999
r444 n291 n292 102.40000000000001
r445 n292 n293 92.799999999999997
r446 n226 n294 6.0235294117647058
r447 n227 n295 15.753846153846155
r448 n294 n295 10.026666666666667
r449 n228 n296 5.1200000000000001
r450 n295 n296 11.306666666666667
r451 n229 n297 204.80000000000001
r452 n296 n297 8.7466666666666661
r453 n230 n298 6.2060606060606061
r454 n297 n298 7.253333333333333
r455 n231 n299 204.80000000000001
r456 n298 n299 7.253333333333333
r457 n232 n300 8.9043478260869566
r458 n299 n300 5.1200000000000001
r459 n233 n301 51.200000000000003
r460 n300 n301 5.7599999999999998
r461 n234 n302 34.133333333333333
r462 n301 n302 2.1333333333333333
r463 n235 n303 40.960000000000001
r464 n302 n303 2.3466666666666667
r465 n236 n304 204.80000000000001
r466 n303 n304 1.28
r467 n237 n305 15.753846153846155
r468 n304 n305 2.9866666666666668
r469 n238 n306 20.48
r470 n305 n306 4.9066666666666663
r471 n239 n307 40.960000000000001
r472 n306 n307 3.2000000000000002
r473 n240 n308 40.960000000000001
r474 n307 n308 2.1333333333333333
r475 n241 n309 204.80000000000001
r476 n308 n309 1.28
r477 n242 n310 68.266666666666666
r478 n309 n310 0.85333333333333339
r479 n243 n311 204.80000000000001
r480 n310 n311 0.85333333333333339
r481 n244 n312 22.755555555555556
r482 n311 n312 2.1333333333333333
r483 n245 n313 20.48
r484 n312 n313 4.0533333333333337
r485 n246 n314 40.960000000000001
r486 n313 n314 3.2000000000000002
r487 n247 n315 40.960000000000001
r488 n314 n315 2.1333333333333333
r489 n248 n316 204.80000000000001
r490 n315 n316 1.28
r491 n249 n317 102.40000000000001
r492 n316 n317 0.64000000000000001
r493 n250 n318 204.80000000000001
r494 n317 n318 0.64000000000000001
r495 n251 n319 204.80000000000001
r496 n318 n319 0.42666666666666669
r497 n252 n320 204.80000000000001
r498 n319 n320 0.42666666666666669
r499 n253 n321 51.200000000000003
r500 n320 n321 1.0666666666666667
r501 n254 n322 40.960000000000001
r502 n321 n322 1.9199999999999999
r503 n255 n323 204.80000000000001
r504 n322 n323 1.28
r505 n256 n324 20.48
r506 n323 n324 2.3466666666666667
r507 n257 n325 68.266666666666666
r508 n324 n325 2.7733333333333334
r509 n258 n326 34.133333333333333
r510 n325 n326 1.9199999999999999
r511 n259 n327 102.40000000000001
r512 n326 n327 1.7066666666666668
r513 n260 n328 204.80000000000001
r514 n327 n328 0.64000000000000001
r515 n261 n329 204.80000000000001
r516 n328 n329 0.42666666666666669
r517 n262 n330 34.133333333333333
r518 n329 n330 1.4933333333333334
r519 n263 n331 40.960000000000001
r520 n330 n331 2.3466666666666667
r521 n264 n332 204.80000000000001
r522 n331 n332 1.28
r523 n265 n333 51.200000000000003
r524 n332 n333 1.0666666666666667
r525 n266 n334 40.960000000000001
r526 n333 n334 1.9199999999999999
r527 n267 n335 68.266666666666666
r528 n334 n335 1.7066666666666668
r529 n268 n336 29.257142857142856
r530 n335 n336 2.1333333333333333
r531 n269 n337 34.133333333333333
r532 n336 n337 2.7733333333333334
r533 n270 n338 20.48
r534 n337 n338 3.4133333333333336
r535 n271 n339 51.200000000000003
r536 n338 n339 2.9866666666666668
r537 n272 n340 29.257142857142856
r538 n339 n340 2.3466666666666667
r539 n273 n341 22.755555555555556
r540 n340 n341 3.4133333333333336
r541 n274 n342 51.200000000000003
r542 n341 n342 2.7733333333333334
r543 n275 n343 25.600000000000001
r544 n342 n343 2.5600000000000001
r545 n276 n344 40.960000000000001
r546 n343 n344 2.7733333333333334
r547 n277 n345 34.133333333333333
r548 n344 n345 2.3466666666666667
r549 n278 n346 102.40000000000001
r550 n345 n346 1.7066666666666668
r551 n279 n347 12.047058823529412
r552 n346 n347 4.0533333333333337
r553 n280 n348 15.753846153846155
r554 n347 n348 6.4000000000000004
r555 n281 n349 102.40000000000001
r556 n348 n349 3.2000000000000002
r557 n282 n350 102.40000000000001
r558 n349 n350 0.85333333333333339
r559 n283 n351 51.200000000000003
r560 n350 n351 1.28
r561 n284 n352 40.960000000000001
r562 n351 n352 1.9199999999999999
r563 n285 n353 25.600000000000001
r564 n352 n353 2.7733333333333334
r565 n286 n354 51.200000000000003
r566 n353 n354 2.5600000000000001
r567 n287 n355 15.753846153846155
r568 n354 n355 3.6266666666666665
r569 n288 n356 29.257142857142856
r570 n355 n356 4.2666666666666666
r571 n289 n357 7.5851851851851855
r572 n356 n357 7.253333333333333
r573 n290 n358 102.40000000000001
r574 n357 n358 6.1866666666666665
r575 n291 n359 40.960000000000001
r576 n358 n359 1.4933333333333334
r577 n292 n360 7.5851851851851855
r578 n359 n360 6.8266666666666671
r579 n293 n361 102.40000000000001
r580 n360 n361 6.1866666666666665
r581 n294 n362 6.0235294117647058
r582 n295 n363 15.753846153846155
r583 n362 n363 150.40000000000001
r584 n296 n364 5.1200000000000001
r585 n363 n364 169.59999999999999
r586 n297 n365 204.80000000000001
r587 n364 n365 131.19999999999999
r588 n298 n366 6.2060606060606061
r589 n365 n366 108.8
r590 n299 n367 204.80000000000001
r591 n366 n367 108.8
r592 n300 n368 8.9043478260869566
r593 n367 n368 76.799999999999997
r594 n301 n369 51.200000000000003
r595 n368 n369 86.400000000000006
r596 n302 n370 34.133333333333333
r597 n369 n370 32
r598 n303 n371 40.960000000000001
r599 n370 n371 35.200000000000003
r600 n304 n372 204.80000000000001
r601 n371 n372 19.199999999999999
r602 n305 n373 15.753846153846155
r603 n372 n373 44.799999999999997
r604 n306 n374 20.48
r605 n373 n374 73.599999999999994
r606 n307 n375 40.960000000000001
r607 n374 n375 48
r608 n308 n376 40.960000000000001
r609 n375 n376 32
r610 n309 n377 204.80000000000001
r611 n376 n377 19.199999999999999
r612 n310 n378 68.266666666666666
r613 n377 n378 12.800000000000001
r614 n311 n379 204.80000000000001
r615 n378 n379 12.800000000000001
r616 n312 n380 22.755555555555556
r617 n379 n380 32
r618 n313 n381 20.48
r619 n380 n381 60.799999999999997
r620 n314 n382 40.960000000000001
r621 n381 n382 48
r622 n315 n383 40.960000000000001
r623 n382 n383 32
r624 n316 n384 204.80000000000001
r625 n383 n384 19.199999999999999
r626 n317 n385 102.40000000000001
r627 n384 n385 9.5999999999999996
r628 n318 n386 204.80000000000001
r629 n385 n386 9.5999999999999996
r630 n319 n387 204.80000000000001
r631 n386 n387 6.4000000000000004
r632 n320 n388 204.80000000000001
r633 n387 n388 6.4000000000000004
r634 n321 n389 51.200000000000003
r635 n388 n389 16
r636 n322 n390 40.960000000000001
r637 n389 n390 28.800000000000001
r638 n323 n391 204.80000000000001
r639 n390 n391 19.199999999999999
r640 n324 n392 20.48
r641 n391 n392 35.200000000000003
r642 n325 n393 68.266666666666666
r643 n392 n393 41.600000000000001
r644 n326 n394 34.133333333333333
r645 n393 n394 28.800000000000001
r646 n327 n395 102.40000000000001
r647 n394 n395 25.600000000000001
r648 n328 n396 204.80000000000001
r649 n395 n396 9.5999999999999996
r650 n329 n397 204.80000000000001
r651 n396 n397 6.4000000000000004
r652 n330 n398 34.133333333333333
r653 n397 n398 22.399999999999999
r654 n331 n399 40.960000000000001
r655 n398 n399 35.200000000000003
r656 n332 n400 204.80000000000001
r657 n399 n400 19.199999999999999
r658 n333 n401 51.200000000000003
r659 n400 n401 16
r660 n334 n402 40.960000000000001
r661 n401 n402 28.800000000000001
r662 n335 n403 68.266666666666666
r663 n402 n403 25.600000000000001
r664 n336 n404 29.257142857142856
r665 n403 n404 32
r666 n337 n405 34.133333333333333
r667 n404 n405 41.600000000000001
r668 n338 n406 20.48
r669 n405 n406 51.200000000000003
r670 n339 n407 51.200000000000003
r671 n406 n407 44.799999999999997
r672 n340 n408 29.257142857142856
r673 n407 n408 35.200000000000003
r674 n341 n409 22.755555555555556
r675 n408 n409 51.200000000000003
r676 n342 n410 51.200000000000003
r677 n409 n410 41.600000000000001
r678 n343 n411 25.600000000000001
r679 n410 n411 38.399999999999999
r680 n344 n412 40.960000000000001
r681 n411 n412 41.600000000000001
r682 n345 n413 34.133333333333333
r683 n412 n413 35.200000000000003
r684 n346 n414 102.40000000000001
r685 n413 n414 25.600000000000001
r686 n347 n415 12.047058823529412
r687 n414 n415 60.799999999999997
r688 n348 n416 15.753846153846155
r689 n415 n416 96
r690 n349 n417 102.40000000000001
r691 n416 n417 48
r692 n350 n418 102.40000000000001
r693 n417 n418 12.800000000000001
r694 n351 n419 51.200000000000003
r695 n418 n419 19.199999999999999
r696 n352 n420 40.960000000000001
r697 n419 n420 28.800000000000001
r698 n353 n421 25.600000000000001
r699 n420 n421 41.600000000000001
r700 n354 n422 51.200000000000003
r701 n421 n422 38.399999999999999
r702 n355 n423 15.753846153846155
r703 n422 n423 54.399999999999999
r704 n356 n424 29.257142857142856
r705 n423 n424 64
r706 n357 n425 7.5851851851851855
r707 n424 n425 108.8
r708 n358 n426 102.40000000000001
r709 n425 n426 92.799999999999997
r710 n359 n427 40.960000000000001
r711 n426 n427 22.399999999999999
r712 n360 n428 7.5851851851851855
r713 n427 n428 102.40000000000001
r714 n361 n429 102.40000000000001
r715 n428 n429 92.799999999999997
r716 n362 n430 2.447058823529412
r717 n427 n431 16.640000000000001
r718 n428 n432 3.0814814814814815
r719 n431 n432 18.618181818181817
r720 n429 n433 41.600000000000001
r721 n432 n433 16.872727272727271
r722 n430 n434 2.447058823529412
r723 n431 n435 16.640000000000001
r724 n432 n436 3.0814814814814815
r725 n435 n436 102.40000000000001
r726 n433 n437 41.600000000000001
r727 n436 n437 92.799999999999997
r728 n434 n438 6.9647058823529413
r729 n435 n439 47.359999999999999
r730 n436 n440 8.7703703703703706
r731 n439 n440 5.8514285714285714
r732 n437 n441 118.40000000000001
r733 n440 n441 5.3028571428571425
r734 n438 n442 12.988235294117647
r735 n439 n443 88.319999999999993
r736 n440 n444 16.355555555555554
r737 n443 n444 6.0235294117647058
r738 n441 n445 220.80000000000001
r739 n444 n445 5.4588235294117649
r740 n442 n446 7.7176470588235295
r741 n443 n447 52.479999999999997
r742 n444 n448 9.7185185185185183
r743 n447 n448 29.257142857142856
r744 n445 n449 131.19999999999999
r745 n448 n449 26.514285714285716
r746 n446 n450 1.6941176470588235
r747 n447 n451 11.52
r748 n448 n452 2.1333333333333333
r749 n451 n452 102.40000000000001
r750 n449 n453 28.800000000000001
r751 n452 n453 92.799999999999997
r752 n450 n454 1.3176470588235294
r753 n451 n455 8.9600000000000009
r754 n452 n456 1.6592592592592592
r755 n455 n456 40.960000000000001
r756 n453 n457 22.399999999999999
r757 n456 n457 37.119999999999997
r758 n454 n458 2.0705882352941178
r759 n455 n459 14.08
r760 n456 n460 2.6074074074074076
r761 n459 n460 34.133333333333333
r762 n457 n461 35.200000000000003
r763 n460 n461 30.933333333333334
r764 n458 n462 1.5058823529411764
r765 n463 n464 32
r766 n464 n465 35.200000000000003
r767 n465 n466 19.199999999999999
r768 n466 n467 44.799999999999997
r769 n467 n468 73.599999999999994
r770 n468 n469 48
r771 n469 n470 32
r772 n470 n471 19.199999999999999
r773 n471 n472 12.800000000000001
r774 n472 n473 12.800000000000001
r775 n473 n474 32
r776 n474 n475 60.799999999999997
r777 n475 n476 48
r778 n476 n477 32
r779 n477 n478 19.199999999999999
r780 n478 n479 9.5999999999999996
r781 n479 n480 9.5999999999999996
r782 n480 n481 6.4000000000000004
r783 n481 n482 6.4000000000000004
r784 n482 n483 16
r785 n483 n484 28.800000000000001
r786 n484 n485 19.199999999999999
r787 n485 n486 35.200000000000003
r788 n486 n487 41.600000000000001
r789 n487 n488 28.800000000000001
r790 n488 n489 25.600000000000001
r791 n489 n490 9.5999999999999996
r792 n490 n491 6.4000000000000004
r793 n491 n492 22.399999999999999
r794 n492 n493 35.200000000000003
r795 n493 n494 19.199999999999999
r796 n494 n495 16
r797 n459 n496 10.24
r798 n460 n497 1.8962962962962964
r799 n496 n497 102.40000000000001
r800 n461 n498 25.600000000000001
r801 n497 n498 92.799999999999997
r802 n462 n499 3.388235294117647
r803 n463 n500 28.800000000000001
r804 n464 n501 19.199999999999999
r805 n500 n501 4
r806 n465 n502 23.039999999999999
r807 n501 n502 4.4000000000000004
r808 n466 n503 115.2
r809 n502 n503 2.3999999999999999
r810 n467 n504 8.861538461538462
r811 n503 n504 5.5999999999999996
r812 n468 n505 11.52
r813 n504 n505 9.1999999999999993
r814 n469 n506 23.039999999999999
r815 n505 n506 6
r816 n470 n507 23.039999999999999
r817 n506 n507 4
r818 n471 n508 115.2
r819 n507 n508 2.3999999999999999
r820 n472 n509 38.399999999999999
r821 n508 n509 1.6000000000000001
r822 n473 n510 115.2
r823 n509 n510 1.6000000000000001
r824 n474 n511 12.800000000000001
r825 n510 n511 4
r826 n475 n512 11.52
r827 n511 n512 7.5999999999999996
r828 n476 n513 23.039999999999999
r829 n512 n513 6
r830 n477 n514 23.039999999999999
r831 n513 n514 4
r832 n478 n515 115.2
r833 n514 n515 2.3999999999999999
r834 n479 n516 57.600000000000001
r835 n515 n516 1.2
r836 n480 n517 115.2
r837 n516 n517 1.2
r838 n481 n518 115.2
r839 n517 n518 0.80000000000000004
r840 n482 n519 115.2
r841 n518 n519 0.80000000000000004
r842 n483 n520 28.800000000000001
r843 n519 n520 2
r844 n484 n521 23.039999999999999
r845 n520 n521 3.6000000000000001
r846 n485 n522 115.2
r847 n521 n522 2.3999999999999999
r848 n486 n523 11.52
r849 n522 n523 4.4000000000000004
r850 n487 n524 38.399999999999999
r851 n523 n524 5.2000000000000002
r852 n488 n525 19.199999999999999
r853 n524 n525 3.6000000000000001
r854 n489 n526 57.600000000000001
r855 n525 n526 3.2000000000000002
r856 n490 n527 115.2
r857 n526 n527 1.2
r858 n491 n528 115.2
r859 n527 n528 0.80000000000000004
r860 n492 n529 19.199999999999999
r861 n528 n529 2.7999999999999998
r862 n493 n530 23.039999999999999
r863 n529 n530 4.4000000000000004
r864 n494 n531 115.2
r865 n530 n531 2.3999999999999999
r866 n495 n532 28.800000000000001
r867 n531 n532 2
r868 n496 n533 23.039999999999999
r869 n497 n534 4.2666666666666666
r870 n533 n534 12.800000000000001
r871 n498 n535 57.600000000000001
r872 n534 n535 11.6
r873 n499 n536 5.6470588235294121
r874 n500 n537 48
r875 n501 n538 32
r876 n537 n538 4.5714285714285712
r877 n502 n539 38.399999999999999
r878 n538 n539 5.0285714285714285
r879 n503 n540 192
r880 n539 n540 2.7428571428571429
r881 n504 n541 14.76923076923077
r882 n540 n541 6.4000000000000004
r883 n505 n542 19.199999999999999
r884 n541 n542 10.514285714285714
r885 n506 n543 38.399999999999999
r886 n542 n543 6.8571428571428568
r887 n507 n544 38.399999999999999
r888 n543 n544 4.5714285714285712
r889 n508 n545 192
r890 n544 n545 2.7428571428571429
r891 n509 n546 64
r892 n545 n546 1.8285714285714285
r893 n510 n547 192
r894 n546 n547 1.8285714285714285
r895 n511 n548 21.333333333333332
r896 n547 n548 4.5714285714285712
r897 n512 n549 19.199999999999999
r898 n548 n549 8.6857142857142851
r899 n513 n550 38.399999999999999
r900 n549 n550 6.8571428571428568
r901 n514 n551 38.399999999999999
r902 n550 n551 4.5714285714285712
r903 n515 n552 192
r904 n551 n552 2.7428571428571429
r905 n516 n553 96
r906 n552 n553 1.3714285714285714
r907 n517 n554 192
r908 n553 n554 1.3714285714285714
r909 n518 n555 192
r910 n554 n555 0.91428571428571426
r911 n519 n556 192
r912 n555 n556 0.91428571428571426
r913 n520 n557 48
r914 n556 n557 2.2857142857142856
r915 n521 n558 38.399999999999999
r916 n557 n558 4.1142857142857139
r917 n522 n559 192
r918 n558 n559 2.7428571428571429
r919 n523 n560 19.199999999999999
r920 n559 n560 5.0285714285714285
r921 n524 n561 64
r922 n560 n561 5.9428571428571431
r923 n525 n562 32
r924 n561 n562 4.1142857142857139
r925 n526 n563 96
r926 n562 n563 3.657142857142857
r927 n527 n564 192
r928 n563 n564 1.3714285714285714
r929 n528 n565 192
r930 n564 n565 0.91428571428571426
r931 n529 n566 32
r932 n565 n566 3.2000000000000002
r933 n530 n567 38.399999999999999
r934 n566 n567 5.0285714285714285
r935 n531 n568 192
r936 n567 n568 2.7428571428571429
r937 n532 n569 48
r938 n568 n569 2.2857142857142856
r939 n533 n570 38.399999999999999
r940 n534 n571 7.1111111111111107
r941 n570 n571 14.628571428571428
r942 n535 n572 96
r943 n571 n572 13.257142857142858
r944 n536 n573 3.0117647058823529
r945 n537 n574 25.600000000000001
r946 n538 n575 17.066666666666666
r947 n574 n575 32
r948 n539 n576 20.48
r949 n575 n576 35.200000000000003
r950 n540 n577 102.40000000000001
r951 n576 n577 19.199999999999999
r952 n541 n578 7.8769230769230774
r953 n577 n578 44.799999999999997
r954 n542 n579 10.24
r955 n578 n579 73.599999999999994
r956 n543 n580 20.48
r957 n579 n580 48
r958 n544 n581 20.48
r959 n580 n581 32
r960 n545 n582 102.40000000000001
r961 n581 n582 19.199999999999999
r962 n546 n583 34.133333333333333
r963 n582 n583 12.800000000000001
r964 n547 n584 102.40000000000001
r965 n583 n584 12.800000000000001
r966 n548 n585 11.377777777777778
r967 n584 n585 32
r968 n549 n586 10.24
r969 n585 n586 60.799999999999997
r970 n550 n587 20.48
r971 n586 n587 48
r972 n551 n588 20.48
r973 n587 n588 32
r974 n552 n589 102.40000000000001
r975 n588 n589 19.199999999999999
r976 n553 n590 51.200000000000003
r977 n589 n590 9.5999999999999996
r978 n554 n591 102.40000000000001
r979 n590 n591 9.5999999999999996
r980 n555 n592 102.40000000000001
r981 n591 n592 6.4000000000000004
r982 n556 n593 102.40000000000001
r983 n592 n593 6.4000000000000004
r984 n557 n594 25.600000000000001
r985 n593 n594 16
r986 n558 n595 20.48
r987 n594 n595 28.800000000000001
r988 n559 n596 102.40000000000001
r989 n595 n596 19.199999999999999
r990 n560 n597 10.24
r991 n596 n597 35.200000000000003
r992 n561 n598 34.133333333333333
r993 n597 n598 41.600000000000001
r994 n562 n599 17.066666666666666
r995 n598 n599 28.800000000000001
r996 n563 n600 51.200000000000003
r997 n599 n600 25.600000000000001
r998 n564 n601 102.40000000000001
r999 n600 n601 9.5999999999999996
r1000 n565 n602 102.40000000000001
r1001 n601 n602 6.4000000000000004
r1002 n566 n603 17.066666666666666
r1003 n602 n603 22.399999999999999
r1004 n567 n604 20.48
r1005 n603 n604 35.200000000000003
r1006 n568 n605 102.40000000000001
r1007 n604 n605 19.199999999999999
r1008 n569 n606 25.600000000000001
r1009 n605 n606 16
r1010 n570 n607 20.48
r1011 n571 n608 3.7925925925925927
r1012 n607 n608 102.40000000000001
r1013 n572 n609 51.200000000000003
r1014 n608 n609 92.799999999999997
r1015 n573 n610 1.1294117647058823
r1016 n607 n611 7.6799999999999997
r1017 n608 n612 1.4222222222222223
r1018 n611 n612 51.200000000000003
r1019 n609 n613 19.199999999999999
r1020 n612 n613 46.399999999999999
r1021 n610 n614 1.1294117647058823
r1022 n615 n616 60.799999999999997
r1023 n616 n617 96
r1024 n617 n618 48
r1025 n611 n619 7.6799999999999997
r1026 n612 n620 1.4222222222222223
r1027 n619 n620 102.40000000000001
r1028 n613 n621 19.199999999999999
r1029 n620 n621 92.799999999999997
r1030 n614 n622 0.56470588235294117
r1031 n615 n623 9.5999999999999996
r1032 n616 n624 1.1294117647058823
r1033 n623 n624 121.59999999999999
r1034 n617 n625 1.476923076923077
r1035 n624 n625 192
r1036 n618 n626 9.5999999999999996
r1037 n625 n626 96
r1038 n619 n627 3.8399999999999999
r1039 n620 n628 0.71111111111111114
r1040 n627 n628 204.80000000000001
r1041 n621 n629 9.5999999999999996
r1042 n628 n629 185.59999999999999
r1043 n622 n630 0.94117647058823528
r1044 n623 n631 16
r1045 n624 n632 1.8823529411764706
r1046 n631 n632 30.399999999999999
r1047 n625 n633 2.4615384615384617
r1048 n632 n633 48
r1049 n626 n634 16
r1050 n633 n634 24
r1051 n627 n635 6.4000000000000004
r1052 n628 n636 1.1851851851851851
r1053 n635 n636 51.200000000000003
r1054 n629 n637 16
r1055 n636 n637 46.399999999999999
r1056 n630 n638 1.1294117647058823
r1057 n631 n639 19.199999999999999
r1058 n632 n640 2.2588235294117647
r1059 n639 n640 60.799999999999997
r1060 n633 n641 2.953846153846154
r1061 n640 n641 96
r1062 n634 n642 19.199999999999999
r1063 n641 n642 48
r1064 n635 n643 7.6799999999999997
r1065 n636 n644 1.4222222222222223
r1066 n643 n644 102.40000000000001
r1067 n637 n645 19.199999999999999
r1068 n644 n645 92.799999999999997
r1069 n638 n646 1.3176470588235294
r1070 n639 n647 22.399999999999999
r1071 n640 n648 2.6352941176470588
r1072 n647 n648 24.32
r1073 n641 n649 3.4461538461538463
r1074 n648 n649 38.399999999999999
r1075 n642 n650 22.399999999999999
r1076 n649 n650 19.199999999999999
r1077 n643 n651 8.9600000000000009
r1078 n644 n652 1.6592592592592592
r1079 n651 n652 40.960000000000001
r1080 n645 n653 22.399999999999999
r1081 n652 n653 37.119999999999997
r1082 n646 n654 1.3176470588235294
r1083 n647 n655 22.399999999999999
r1084 n648 n656 2.6352941176470588
r1085 n655 n656 60.799999999999997
r1086 n649 n657 3.4461538461538463
r1087 n656 n657 96
r1088 n650 n658 22.399999999999999
r1089 n657 n658 48
r1090 n651 n659 8.9600000000000009
r1091 n652 n660 1.6592592592592592
r1092 n659 n660 102.40000000000001
r1093 n653 n661 22.399999999999999
r1094 n660 n661 92.799999999999997
r1095 n654 n662 0.75294117647058822
r1096 n655 n663 12.800000000000001
r1097 n656 n664 1.5058823529411764
r1098 n663 n664 60.799999999999997
r1099 n657 n665 1.9692307692307693
r1100 n664 n665 96
r1101 n658 n666 12.800000000000001
r1102 n665 n666 48
r1103 n659 n667 5.1200000000000001
r1104 n660 n668 0.94814814814814818
r1105 n667 n668 102.40000000000001
r1106 n661 n669 12.800000000000001
r1107 n668 n669 92.799999999999997
r1108 n662 n670 5.6470588235294121
r1109 n663 n671 96
r1110 n664 n672 11.294117647058824
r1111 n671 n672 4.3428571428571425
r1112 n665 n673 14.76923076923077
r1113 n672 n673 6.8571428571428568
r1114 n666 n674 96
r1115 n673 n674 3.4285714285714284
r1116 n667 n675 38.399999999999999
r1117 n668 n676 7.1111111111111107
r1118 n675 n676 7.3142857142857141
r1119 n669 n677 96
r1120 n676 n677 6.628571428571429
r1121 n670 n678 5.6470588235294121
r1122 n671 n679 96
r1123 n672 n680 11.294117647058824
r1124 n679 n680 60.799999999999997
r1125 n673 n681 14.76923076923077
r1126 n680 n681 96
r1127 n674 n682 96
r1128 n681 n682 48
r1129 n675 n683 38.399999999999999
r1130 n676 n684 7.1111111111111107
r1131 n683 n684 102.40000000000001
r1132 n677 n685 96
r1133 n684 n685 92.799999999999997
r1134 n678 n686 0.75294117647058822
r1135 n679 n687 12.800000000000001
r1136 n680 n688 1.5058823529411764
r1137 n687 n688 60.799999999999997
r1138 n681 n689 1.9692307692307693
r1139 n688 n689 96
r1140 n682 n690 12.800000000000001
r1141 n689 n690 48
r1142 n683 n691 5.1200000000000001
r1143 n684 n692 0.94814814814814818
r1144 n691 n692 102.40000000000001
r1145 n685 n693 12.800000000000001
r1146 n692 n693 92.799999999999997
r1147 n686 n694 0.75294117647058822
r1148 n687 n695 12.800000000000001
r1149 n688 n696 1.5058823529411764
r1150 n695 n696 60.799999999999997
r1151 n689 n697 1.9692307692307693
r1152 n696 n697 96
r1153 n690 n698 12.800000000000001
r1154 n697 n698 48
r1155 n691 n699 5.1200000000000001
r1156 n692 n700 0.94814814814814818
r1157 n699 n700 102.40000000000001
r1158 n693 n701 12.800000000000001
r1159 n700 n701 92.799999999999997
r1160 n694 n702 1.1294117647058823
r1161 n695 n703 19.199999999999999
r1162 n696 n704 2.2588235294117647
r1163 n703 n704 30.399999999999999
r1164 n697 n705 2.953846153846154
r1165 n704 n705 48
r1166 n698 n706 19.199999999999999
r1167 n705 n706 24
r1168 n699 n707 7.6799999999999997
r1169 n700 n708 1.4222222222222223
r1170 n707 n708 51.200000000000003
r1171 n701 n709 19.199999999999999
r1172 n708 n709 46.399999999999999
r1173 n702 n710 2.0705882352941178
r1174 n703 n711 35.200000000000003
r1175 n704 n712 4.1411764705882357
r1176 n711 n712 17.37142857142857
r1177 n705 n713 5.4153846153846157
r1178 n712 n713 27.428571428571427
r1179 n706 n714 35.200000000000003
r1180 n713 n714 13.714285714285714
r1181 n707 n715 14.08
r1182 n708 n716 2.6074074074074076
r1183 n715 n716 29.257142857142856
r1184 n709 n717 35.200000000000003
r1185 n716 n717 26.514285714285716
r1186 n710 n718 1.8823529411764706
r1187 n711 n719 32
r1188 n712 n720 3.7647058823529411
r1189 n719 n720 40.533333333333331
r1190 n713 n721 4.9230769230769234
r1191 n720 n721 64
r1192 n714 n722 32
r1193 n721 n722 32
r1194 n715 n723 12.800000000000001
r1195 n716 n724 2.3703703703703702
r1196 n723 n724 68.266666666666666
r1197 n717 n725 32
r1198 n724 n725 61.866666666666667
r1199 n718 n726 1.1294117647058823
r1200 n723 n727 7.6799999999999997
r1201 n724 n728 1.4222222222222223
r1202 n727 n728 68.266666666666666
r1203 n725 n729 19.199999999999999
r1204 n728 n729 61.866666666666667
r1205 n726 n730 0.94117647058823528
r1206 n731 n732 32
r1207 n732 n733 35.200000000000003
r1208 n733 n734 19.199999999999999
r1209 n734 n735 44.799999999999997
r1210 n735 n736 73.599999999999994
r1211 n736 n737 48
r1212 n737 n738 32
r1213 n738 n739 19.199999999999999
r1214 n739 n740 12.800000000000001
r1215 n740 n741 12.800000000000001
r1216 n741 n742 32
r1217 n742 n743 60.799999999999997
r1218 n743 n744 48
r1219 n744 n745 32
r1220 n745 n746 19.199999999999999
r1221 n746 n747 9.5999999999999996
r1222 n747 n748 9.5999999999999996
r1223 n748 n749 6.4000000000000004
r1224 n749 n750 6.4000000000000004
r1225 n750 n751 16
r1226 n751 n752 28.800000000000001
r1227 n752 n753 19.199999999999999
r1228 n753 n754 35.200000000000003
r1229 n754 n755 41.600000000000001
r1230 n755 n756 28.800000000000001
r1231 n756 n757 25.600000000000001
r1232 n757 n758 9.5999999999999996
r1233 n758 n759 6.4000000000000004
r1234 n759 n760 22.399999999999999
r1235 n760 n761 35.200000000000003
r1236 n761 n762 19.199999999999999
r1237 n762 n763 16
r1238 n727 n764 6.4000000000000004
r1239 n728 n765 1.1851851851851851
r1240 n764 n765 102.40000000000001
r1241 n729 n766 16
r1242 n765 n766 92.799999999999997
r1243 n730 n767 3.2000000000000002
r1244 n731 n768 27.199999999999999
r1245 n732 n769 18.133333333333333
r1246 n768 n769 4.2666666666666666
r1247 n733 n770 21.760000000000002
r1248 n769 n770 4.6933333333333334
r1249 n734 n771 108.8
r1250 n770 n771 2.5600000000000001
r1251 n735 n772 8.3692307692307697
r1252 n771 n772 5.9733333333333336
r1253 n736 n773 10.880000000000001
r1254 n772 n773 9.8133333333333326
r1255 n737 n774 21.760000000000002
r1256 n773 n774 6.4000000000000004
r1257 n738 n775 21.760000000000002
r1258 n774 n775 4.2666666666666666
r1259 n739 n776 108.8
r1260 n775 n776 2.5600000000000001
r1261 n740 n777 36.266666666666666
r1262 n776 n777 1.7066666666666668
r1263 n741 n778 108.8
r1264 n777 n778 1.7066666666666668
r1265 n742 n779 12.088888888888889
r1266 n778 n779 4.2666666666666666
r1267 n743 n780 10.880000000000001
r1268 n779 n780 8.1066666666666674
r1269 n744 n781 21.760000000000002
r1270 n780 n781 6.4000000000000004
r1271 n745 n782 21.760000000000002
r1272 n781 n782 4.2666666666666666
r1273 n746 n783 108.8
r1274 n782 n783 2.5600000000000001
r1275 n747 n784 54.399999999999999
r1276 n783 n784 1.28
r1277 n748 n785 108.8
r1278 n784 n785 1.28
r1279 n749 n786 108.8
r1280 n785 n786 0.85333333333333339
r1281 n750 n787 108.8
r1282 n786 n787 0.85333333333333339
r1283 n751 n788 27.199999999999999
r1284 n787 n788 2.1333333333333333
r1285 n752 n789 21.760000000000002
r1286 n788 n789 3.8399999999999999
r1287 n753 n790 108.8
r1288 n789 n790 2.5600000000000001
r1289 n754 n791 10.880000000000001
r1290 n790 n791 4.6933333333333334
r1291 n755 n792 36.266666666666666
r1292 n791 n792 5.5466666666666669
r1293 n756 n793 18.133333333333333
r1294 n792 n793 3.8399999999999999
r1295 n757 n794 54.399999999999999
r1296 n793 n794 3.4133333333333336
r1297 n758 n795 108.8
r1298 n794 n795 1.28
r1299 n759 n796 108.8
r1300 n795 n796 0.85333333333333339
r1301 n760 n797 18.133333333333333
r1302 n796 n797 2.9866666666666668
r1303 n761 n798 21.760000000000002
r1304 n797 n798 4.6933333333333334
r1305 n762 n799 108.8
r1306 n798 n799 2.5600000000000001
r1307 n763 n800 27.199999999999999
r1308 n799 n800 2.1333333333333333
r1309 n764 n801 21.760000000000002
r1310 n765 n802 4.0296296296296292
r1311 n801 n802 13.653333333333334
r1312 n766 n803 54.399999999999999
r1313 n802 n803 12.373333333333333
r1314 n767 n804 5.6470588235294121
r1315 n768 n805 48
r1316 n769 n806 32
r1317 n805 n806 4.2666666666666666
r1318 n770 n807 38.399999999999999
r1319 n806 n807 4.6933333333333334
r1320 n771 n808 192
r1321 n807 n808 2.5600000000000001
r1322 n772 n809 14.76923076923077
r1323 n808 n809 5.9733333333333336
r1324 n773 n810 19.199999999999999
r1325 n809 n810 9.8133333333333326
r1326 n774 n811 38.399999999999999
r1327 n810 n811 6.4000000000000004
r1328 n775 n812 38.399999999999999
r1329 n811 n812 4.2666666666666666
r1330 n776 n813 192
r1331 n812 n813 2.5600000000000001
r1332 n777 n814 64
r1333 n813 n814 1.7066666666666668
r1334 n778 n815 192
r1335 n814 n815 1.7066666666666668
r1336 n779 n816 21.333333333333332
r1337 n815 n816 4.2666666666666666
r1338 n780 n817 19.199999999999999
r1339 n816 n817 8.1066666666666674
r1340 n781 n818 38.399999999999999
r1341 n817 n818 6.4000000000000004
r1342 n782 n819 38.399999999999999
r1343 n818 n819 4.2666666666666666
r1344 n783 n820 192
r1345 n819 n820 2.5600000000000001
r1346 n784 n821 96
r1347 n820 n821 1.28
r1348 n785 n822 192
r1349 n821 n822 1.28
r1350 n786 n823 192
r1351 n822 n823 0.85333333333333339
r1352 n787 n824 192
r1353 n823 n824 0.85333333333333339
r1354 n788 n825 48
r1355 n824 n825 2.1333333333333333
r1356 n789 n826 38.399999999999999
r1357 n825 n826 3.8399999999999999
r1358 n790 n827 192
r1359 n826 n827 2.5600000000000001
r1360 n791 n828 19.199999999999999
r1361 n827 n828 4.6933333333333334
r1362 n792 n829 64
r1363 n828 n829 5.5466666666666669
r1364 n793 n830 32
r1365 n829 n830 3.8399999999999999
r1366 n794 n831 96
r1367 n830 n831 3.4133333333333336
r1368 n795 n832 192
r1369 n831 n832 1.28
r1370 n796 n833 192
r1371 n832 n833 0.85333333333333339
r1372 n797 n834 32
r1373 n833 n834 2.9866666666666668
r1374 n798 n835 38.399999999999999
r1375 n834 n835 4.6933333333333334
r1376 n799 n836 192
r1377 n835 n836 2.5600000000000001
r1378 n800 n837 48
r1379 n836 n837 2.1333333333333333
r1380 n801 n838 38.399999999999999
r1381 n802 n839 7.1111111111111107
r1382 n838 n839 13.653333333333334
r1383 n803 n840 96
r1384 n839 n840 12.373333333333333
r1385 n804 n841 3.2000000000000002
r1386 n805 n842 27.199999999999999
r1387 n806 n843 18.133333333333333
r1388 n842 n843 32
r1389 n807 n844 21.760000000000002
r1390 n843 n844 35.200000000000003
r1391 n808 n845 108.8
r1392 n844 n845 19.199999999999999
r1393 n809 n846 8.3692307692307697
r1394 n845 n846 44.799999999999997
r1395 n810 n847 10.880000000000001
r1396 n846 n847 73.599999999999994
r1397 n811 n848 21.760000000000002
r1398 n847 n848 48
r1399 n812 n849 21.760000000000002
r1400 n848 n849 32
r1401 n813 n850 108.8
r1402 n849 n850 19.199999999999999
r1403 n814 n851 36.266666666666666
r1404 n850 n851 12.800000000000001
r1405 n815 n852 108.8
r1406 n851 n852 12.800000000000001
r1407 n816 n853 12.088888888888889
r1408 n852 n853 32
r1409 n817 n854 10.880000000000001
r1410 n853 n854 60.799999999999997
r1411 n818 n855 21.760000000000002
r1412 n854 n855 48
r1413 n819 n856 21.760000000000002
r1414 n855 n856 32
r1415 n820 n857 108.8
r1416 n856 n857 19.199999999999999
r1417 n821 n858 54.399999999999999
r1418 n857 n858 9.5999999999999996
r1419 n822 n859 108.8
r1420 n858 n859 9.5999999999999996
r1421 n823 n860 108.8
r1422 n859 n860 6.4000000000000004
r1423 n824 n861 108.8
r1424 n860 n861 6.4000000000000004
r1425 n825 n862 27.199999999999999
r1426 n861 n862 16
r1427 n826 n863 21.760000000000002
r1428 n862 n863 28.800000000000001
r1429 n827 n864 108.8
r1430 n863 n864 19.199999999999999
r1431 n828 n865 10.880000000000001
r1432 n864 n865 35.200000000000003
r1433 n829 n866 36.266666666666666
r1434 n865 n866 41.600000000000001
r1435 n830 n867 18.133333333333333
r1436 n866 n867 28.800000000000001
r1437 n831 n868 54.399999999999999
r1438 n867 n868 25.600000000000001
r1439 n832 n869 108.8
r1440 n868 n869 9.5999999999999996
r1441 n833 n870 108.8
r1442 n869 n870 6.4000000000000004
r1443 n834 n871 18.133333333333333
r1444 n870 n871 22.399999999999999
r1445 n835 n872 21.760000000000002
r1446 n871 n872 35.200000000000003
r1447 n836 n873 108.8
r1448 n872 n873 19.199999999999999
r1449 n837 n874 27.199999999999999
r1450 n873 n874 16
r1451 n838 n875 21.760000000000002
r1452 n839 n876 4.0296296296296292
r1453 n875 n876 102.40000000000001
r1454 n840 n877 54.399999999999999
r1455 n876 n877 92.799999999999997
r1456 n841 n878 0.94117647058823528
r1457 n875 n879 6.4000000000000004
r1458 n876 n880 1.1851851851851851
r1459 n879 n880 68.266666666666666
r1460 n877 n881 16
r1461 n880 n881 61.866666666666667
r1462 n878 n882 1.1294117647058823
r1463 n879 n883 7.6799999999999997
r1464 n880 n884 1.4222222222222223
r1465 n883 n884 68.266666666666666
r1466 n881 n885 19.199999999999999
r1467 n884 n885 61.866666666666667
r1468 n882 n886 1.8823529411764706
r1469 n883 n887 12.800000000000001
r1470 n884 n888 2.3703703703703702
r1471 n887 n888 29.257142857142856
r1472 n885 n889 32
r1473 n888 n889 26.514285714285716
r1474 n886 n890 2.8235294117647061
r1475 n887 n891 19.199999999999999
r1476 n888 n892 3.5555555555555554
r1477 n891 n892 25.600000000000001
r1478 n889 n893 48
r1479 n892 n893 23.199999999999999
r1480 n890 n894 1.8823529411764706
r1481 n891 n895 12.800000000000001
r1482 n892 n896 2.3703703703703702
r1483 n895 n896 102.40000000000001
r1484 n893 n897 32
r1485 n896 n897 92.799999999999997
r1486 n894 n898 6.4000000000000004
r1487 n895 n899 43.520000000000003
r1488 n896 n900 8.0592592592592585
r1489 n899 n900 6.4000000000000004
r1490 n897 n901 108.8
r1491 n900 n901 5.7999999999999998
r1492 n898 n902 14.870588235294118
r1493 n899 n903 101.12
r1494 n900 n904 18.725925925925925
r1495 n903 n904 4.3574468085106384
r1496 n901 n905 252.80000000000001
r1497 n904 n905 3.9489361702127659
r1498 n902 n906 15.247058823529411
r1499 n906 n907 8.8470588235294123
r1500 n907 n908 9.9764705882352942
r1501 n908 n909 7.7176470588235295
r1502 n909 n910 6.4000000000000004
r1503 n910 n911 6.4000000000000004
r1504 n911 n912 4.5176470588235293
r1505 n912 n913 5.0823529411764703
r1506 n913 n914 1.8823529411764706
r1507 n914 n915 2.0705882352941178
r1508 n915 n916 1.1294117647058823
r1509 n916 n917 2.6352941176470588
r1510 n917 n918 4.3294117647058821
r1511 n918 n919 2.8235294117647061
r1512 n919 n920 1.8823529411764706
r1513 n920 n921 1.1294117647058823
r1514 n921 n922 0.75294117647058822
r1515 n922 n923 0.75294117647058822
r1516 n923 n924 1.8823529411764706
r1517 n924 n925 3.5764705882352943
r1518 n925 n926 2.8235294117647061
r1519 n926 n927 1.8823529411764706
r1520 n927 n928 1.1294117647058823
r1521 n928 n929 0.56470588235294117
r1522 n929 n930 0.56470588235294117
r1523 n930 n931 0.37647058823529411
r1524 n931 n932 0.37647058823529411
r1525 n932 n933 0.94117647058823528
r1526 n933 n934 1.6941176470588235
r1527 n934 n935 1.1294117647058823
r1528 n935 n936 2.0705882352941178
r1529 n936 n937 2.447058823529412
r1530 n937 n938 1.6941176470588235
r1531 n938 n939 1.5058823529411764
r1532 n939 n940 0.56470588235294117
r1533 n940 n941 0.37647058823529411
r1534 n941 n942 1.3176470588235294
r1535 n942 n943 2.0705882352941178
r1536 n943 n944 1.1294117647058823
r1537 n944 n945 0.94117647058823528
r1538 n945 n946 1.6941176470588235
r1539 n946 n947 1.5058823529411764
r1540 n947 n948 1.8823529411764706
r1541 n948 n949 2.447058823529412
r1542 n949 n950 3.0117647058823529
r1543 n950 n951 2.6352941176470588
r1544 n951 n952 2.0705882352941178
r1545 n952 n953 3.0117647058823529
r1546 n953 n954 2.447058823529412
r1547 n954 n955 2.2588235294117647
r1548 n955 n956 2.447058823529412
r1549 n956 n957 2.0705882352941178
r1550 n957 n958 1.5058823529411764
r1551 n958 n959 3.5764705882352943
r1552 n959 n960 5.6470588235294121
r1553 n960 n961 2.8235294117647061
r1554 n961 n962 0.75294117647058822
r1555 n962 n963 1.1294117647058823
r1556 n963 n964 1.6941176470588235
r1557 n964 n965 2.447058823529412
r1558 n965 n966 2.2588235294117647
r1559 n966 n967 3.2000000000000002
r1560 n967 n968 3.7647058823529411
r1561 n968 n969 6.4000000000000004
r1562 n969 n970 5.4588235294117649
r1563 n903 n971 103.68000000000001
r1564 n970 n971 1.3176470588235294
r1565 n904 n972 19.199999999999999
r1566 n971 n972 6.0235294117647058
r1567 n905 n973 259.19999999999999
r1568 n972 n973 5.4588235294117649
r1569 n974 n975 196.48000000000002
r1570 n975 n976 176
r1571 n976 n977 197.12
r1572 n977 n978 150.40000000000001
r1573 n978 n979 169.59999999999999
r1574 n979 n980 131.19999999999999
r1575 n980 n981 108.8
r1576 n981 n982 108.8
r1577 n982 n983 76.799999999999997
r1578 n983 n984 86.400000000000006
r1579 n984 n985 32
r1580 n985 n986 35.200000000000003
r1581 n986 n987 19.199999999999999
r1582 n987 n988 44.799999999999997
r1583 n988 n989 73.599999999999994
r1584 n989 n990 48
r1585 n990 n991 32
r1586 n991 n992 19.199999999999999
r1587 n992 n993 12.800000000000001
r1588 n993 n994 12.800000000000001
r1589 n994 n995 32
r1590 n995 n996 60.799999999999997
r1591 n996 n997 48
r1592 n997 n998 32
r1593 n998 n999 19.199999999999999
r1594 n999 n1000 9.5999999999999996
r1595 n1000 n1001 9.5999999999999996
r1596 n1001 n1002 6.4000000000000004
r1597 n1002 n1003 6.4000000000000004
r1598 n1003 n1004 16
r1599 n1004 n1005 28.800000000000001
r1600 n1005 n1006 19.199999999999999
r1601 n1006 n1007 35.200000000000003
r1602 n1007 n1008 41.600000000000001
r1603 n1008 n1009 28.800000000000001
r1604 n1009 n1010 25.600000000000001
r1605 n1010 n1011 9.5999999999999996
r1606 n1011 n1012 6.4000000000000004
r1607 n1012 n1013 22.399999999999999
r1608 n1013 n1014 35.200000000000003
r1609 n1014 n1015 19.199999999999999
r1610 n1015 n1016 16
r1611 n1016 n1017 28.800000000000001
r1612 n1017 n1018 25.600000000000001
r1613 n1018 n1019 32
r1614 n1019 n1020 41.600000000000001
r1615 n1020 n1021 51.200000000000003
r1616 n1021 n1022 44.799999999999997
r1617 n1022 n1023 35.200000000000003
r1618 n1023 n1024 51.200000000000003
r1619 n1024 n1025 41.600000000000001
r1620 n1025 n1026 38.399999999999999
r1621 n1026 n1027 41.600000000000001
r1622 n1027 n1028 35.200000000000003
r1623 n1028 n1029 25.600000000000001
r1624 n1029 n1030 60.799999999999997
r1625 n1030 n1031 96
r1626 n1031 n1032 48
r1627 n1032 n1033 12.800000000000001
r1628 n1033 n1034 19.199999999999999
r1629 n1034 n1035 28.800000000000001
r1630 n1035 n1036 41.600000000000001
r1631 n1036 n1037 38.399999999999999
r1632 n1037 n1038 54.399999999999999
r1633 n1038 n1039 64
r1634 n1039 n1040 108.8
r1635 n1040 n1041 92.799999999999997
r1636 n1041 n1042 22.399999999999999
r1637 n1042 n1043 102.40000000000001
r1638 n1043 n1044 92.799999999999997
r1639 n1044 n1045 108.8
r1640 n1045 n1046 211.19999999999999
r1641 n1046 n1047 217.59999999999999
r1642 n1047 n1048 217.59999999999999
r1643 n1048 n1049 217.59999999999999
r1644 n1049 n1050 217.59999999999999
r1645 n1050 n1051 217.59999999999999
r1646 n1051 n1052 217.59999999999999
r1647 n1052 n1053 217.59999999999999
r1648 n1053 n1054 217.59999999999999
r1649 n1054 n1055 217.59999999999999
r1650 n1055 n1056 217.59999999999999
r1651 n1056 n1057 217.59999999999999
r1652 n1057 n1058 217.59999999999999
r1653 n1058 n1059 217.59999999999999
r1654 n1059 n1060 217.59999999999999
r1655 n1060 n1061 217.59999999999999
r1656 n1061 n1062 217.59999999999999
r1657 n1062 n1063 217.59999999999999
r1658 n1063 n1064 217.59999999999999
r1659 n1064 n1065 217.59999999999999
r1660 n1065 n1066 217.59999999999999
r1661 n1066 n1067 217.59999999999999
r1662 n1067 n1068 144
r1663 n1068 n1069 108.8
r1664 n1069 n1070 80
r1665 n1070 n1071 102.40000000000001
r1666 n1071 n1072 102.40000000000001
r1667 n1072 n1073 80
r1668 n1073 n1074 108.8
r1669 n1074 n1075 144
r1670 n1075 n1076 217.59999999999999
r1671 n1076 n1077 217.59999999999999
r1672 n1077 n1078 217.59999999999999
r1673 n1078 n1079 217.59999999999999
r1674 n1079 n1080 217.59999999999999
r1675 n1080 n1081 217.59999999999999
r1676 n1081 n1082 217.59999999999999
r1677 n1082 n1083 217.59999999999999
r1678 n1083 n1084 217.59999999999999
r1679 n1084 n1085 217.59999999999999
r1680 n1085 n1086 217.59999999999999
r1681 n1086 n1087 217.59999999999999
r1682 n1087 n1088 217.59999999999999
r1683 n1088 n1089 217.59999999999999
r1684 n1089 n1090 217.59999999999999
r1685 n1090 n1091 217.59999999999999
r1686 n1091 n1092 217.59999999999999
r1687 n1092 n1093 217.59999999999999
r1688 n1093 n1094 217.59999999999999
r1689 n1094 n1095 217.59999999999999
r1690 n1095 n1096 217.59999999999999
r1691 n1096 n1097 217.59999999999999
r1692 n1097 n1098 195.19999999999999
r1693 n1098 n1099 108.8
r1694 n1099 n1100 131.19999999999999
r1695 n1100 n1101 217.59999999999999
r1696 n1101 n1102 217.59999999999999
r1697 n1102 n1103 217.59999999999999
r1698 n1103 n1104 195.19999999999999
r1699 n1104 n1105 108.8
r1700 n1105 n1106 80
r1701 n1106 n1107 108.8
r1702 n1107 n1108 96
r1703 n1108 n1109 108.8
r1704 n1109 n1110 80
r1705 n1110 n1111 108.8
r1706 n1111 n1112 201.59999999999999
r1707 n1112 n1113 217.59999999999999
r1708 n1113 n1114 217.59999999999999
r1709 n1114 n1115 236.80000000000001
r1710 n1115 n1116 236.80000000000001
r1711 n1116 n1117 217.59999999999999
r1712 n1117 n1118 217.59999999999999
r1713 n1118 n1119 163.19999999999999
r1714 n1119 n1120 108.8
r1715 n974 n1121 6.0235294117647058
r1716 n975 n1122 7.4744525547445253
r1717 n1121 n1122 13.098666666666668
r1718 n976 n1123 7.4202898550724639
r1719 n1122 n1123 11.733333333333333
r1720 n977 n1124 6.0235294117647058
r1721 n1123 n1124 13.141333333333334
r1722 n978 n1125 15.753846153846155
r1723 n1124 n1125 10.026666666666667
r1724 n979 n1126 5.1200000000000001
r1725 n1125 n1126 11.306666666666667
r1726 n980 n1127 204.80000000000001
r1727 n1126 n1127 8.7466666666666661
r1728 n981 n1128 6.2060606060606061
r1729 n1127 n1128 7.253333333333333
r1730 n982 n1129 204.80000000000001
r1731 n1128 n1129 7.253333333333333
r1732 n983 n1130 8.9043478260869566
r1733 n1129 n1130 5.1200000000000001
r1734 n984 n1131 51.200000000000003
r1735 n1130 n1131 5.7599999999999998
r1736 n985 n1132 34.133333333333333
r1737 n1131 n1132 2.1333333333333333
r1738 n986 n1133 40.960000000000001
r1739 n1132 n1133 2.3466666666666667
r1740 n987 n1134 204.80000000000001
r1741 n1133 n1134 1.28
r1742 n988 n1135 15.753846153846155
r1743 n1134 n1135 2.9866666666666668
r1744 n989 n1136 20.48
r1745 n1135 n1136 4.9066666666666663
r1746 n990 n1137 40.960000000000001
r1747 n1136 n1137 3.2000000000000002
r1748 n991 n1138 40.960000000000001
r1749 n1137 n1138 2.1333333333333333
r1750 n992 n1139 204.80000000000001
r1751 n1138 n1139 1.28
r1752 n993 n1140 68.266666666666666
r1753 n1139 n1140 0.85333333333333339
r1754 n994 n1141 204.80000000000001
r1755 n1140 n1141 0.85333333333333339
r1756 n995 n1142 22.755555555555556
r1757 n1141 n1142 2.1333333333333333
r1758 n996 n1143 20.48
r1759 n1142 n1143 4.0533333333333337
r1760 n997 n1144 40.960000000000001
r1761 n1143 n1144 3.2000000000000002
r1762 n998 n1145 40.960000000000001
r1763 n1144 n1145 2.1333333333333333
r1764 n999 n1146 204.80000000000001
r1765 n1145 n1146 1.28
r1766 n1000 n1147 102.40000000000001
r1767 n1146 n1147 0.64000000000000001
r1768 n1001 n1148 204.80000000000001
r1769 n1147 n1148 0.64000000000000001
r1770 n1002 n1149 204.80000000000001
r1771 n1148 n1149 0.42666666666666669
r1772 n1003 n1150 204.80000000000001
r1773 n1149 n1150 0.42666666666666669
r1774 n1004 n1151 51.200000000000003
r1775 n1150 n1151 1.0666666666666667
r1776 n1005 n1152 40.960000000000001
r1777 n1151 n1152 1.9199999999999999
r1778 n1006 n1153 204.80000000000001
r1779 n1152 n1153 1.28
r1780 n1007 n1154 20.48
r1781 n1153 n1154 2.3466666666666667
r1782 n1008 n1155 68.266666666666666
r1783 n1154 n1155 2.7733333333333334
r1784 n1009 n1156 34.133333333333333
r1785 n1155 n1156 1.9199999999999999
r1786 n1010 n1157 102.40000000000001
r1787 n1156 n1157 1.7066666666666668
r1788 n1011 n1158 204.80000000000001
r1789 n1157 n1158 0.64000000000000001
r1790 n1012 n1159 204.80000000000001
r1791 n1158 n1159 0.42666666666666669
r1792 n1013 n1160 34.133333333333333
r1793 n1159 n1160 1.4933333333333334
r1794 n1014 n1161 40.960000000000001
r1795 n1160 n1161 2.3466666666666667
r1796 n1015 n1162 204.80000000000001
r1797 n1161 n1162 1.28
r1798 n1016 n1163 51.200000000000003
r1799 n1162 n1163 1.0666666666666667
r1800 n1017 n1164 40.960000000000001
r1801 n1163 n1164 1.9199999999999999
r1802 n1018 n1165 68.266666666666666
r1803 n1164 n1165 1.7066666666666668
r1804 n1019 n1166 29.257142857142856
r1805 n1165 n1166 2.1333333333333333
r1806 n1020 n1167 34.133333333333333
r1807 n1166 n1167 2.7733333333333334
r1808 n1021 n1168 20.48
r1809 n1167 n1168 3.4133333333333336
r1810 n1022 n1169 51.200000000000003
r1811 n1168 n1169 2.9866666666666668
r1812 n1023 n1170 29.257142857142856
r1813 n1169 n1170 2.3466666666666667
r1814 n1024 n1171 22.755555555555556
r1815 n1170 n1171 3.4133333333333336
r1816 n1025 n1172 51.200000000000003
r1817 n1171 n1172 2.7733333333333334
r1818 n1026 n1173 25.600000000000001
r1819 n1172 n1173 2.5600000000000001
r1820 n1027 n1174 40.960000000000001
r1821 n1173 n1174 2.7733333333333334
r1822 n1028 n1175 34.133333333333333
r1823 n1174 n1175 2.3466666666666667
r1824 n1029 n1176 102.40000000000001
r1825 n1175 n1176 1.7066666666666668
r1826 n1030 n1177 12.047058823529412
r1827 n1176 n1177 4.0533333333333337
r1828 n1031 n1178 15.753846153846155
r1829 n1177 n1178 6.4000000000000004
r1830 n1032 n1179 102.40000000000001
r1831 n1178 n1179 3.2000000000000002
r1832 n1033 n1180 102.40000000000001
r1833 n1179 n1180 0.85333333333333339
r1834 n1034 n1181 51.200000000000003
r1835 n1180 n1181 1.28
r1836 n1035 n1182 40.960000000000001
r1837 n1181 n1182 1.9199999999999999
r1838 n1036 n1183 25.600000000000001
r1839 n1182 n1183 2.7733333333333334
r1840 n1037 n1184 51.200000000000003
r1841 n1183 n1184 2.5600000000000001
r1842 n1038 n1185 15.753846153846155
r1843 n1184 n1185 3.6266666666666665
r1844 n1039 n1186 29.257142857142856
r1845 n1185 n1186 4.2666666666666666
r1846 n1040 n1187 7.5851851851851855
r1847 n1186 n1187 7.253333333333333
r1848 n1041 n1188 102.40000000000001
r1849 n1187 n1188 6.1866666666666665
r1850 n1042 n1189 40.960000000000001
r1851 n1188 n1189 1.4933333333333334
r1852 n1043 n1190 7.5851851851851855
r1853 n1189 n1190 6.8266666666666671
r1854 n1044 n1191 102.40000000000001
r1855 n1190 n1191 6.1866666666666665
r1856 n1045 n1192 6.4000000000000004
r1857 n1191 n1192 7.253333333333333
r1858 n1046 n1193 6.0235294117647058
r1859 n1192 n1193 14.08
r1860 n1047 n1194 6.0235294117647058
r1861 n1193 n1194 14.506666666666666
r1862 n1048 n1195 6.0235294117647058
r1863 n1194 n1195 14.506666666666666
r1864 n1049 n1196 6.0235294117647058
r1865 n1195 n1196 14.506666666666666
r1866 n1050 n1197 6.0235294117647058
r1867 n1196 n1197 14.506666666666666
r1868 n1051 n1198 6.0235294117647058
r1869 n1197 n1198 14.506666666666666
r1870 n1052 n1199 6.0235294117647058
r1871 n1198 n1199 14.506666666666666
r1872 n1053 n1200 6.0235294117647058
r1873 n1199 n1200 14.506666666666666
r1874 n1054 n1201 6.0235294117647058
r1875 n1200 n1201 14.506666666666666
r1876 n1055 n1202 6.0235294117647058
r1877 n1201 n1202 14.506666666666666
r1878 n1056 n1203 6.0235294117647058
r1879 n1202 n1203 14.506666666666666
r1880 n1057 n1204 6.0235294117647058
r1881 n1203 n1204 14.506666666666666
r1882 n1058 n1205 6.0235294117647058
r1883 n1204 n1205 14.506666666666666
r1884 n1059 n1206 6.0235294117647058
r1885 n1205 n1206 14.506666666666666
r1886 n1060 n1207 6.0235294117647058
r1887 n1206 n1207 14.506666666666666
r1888 n1061 n1208 6.0235294117647058
r1889 n1207 n1208 14.506666666666666
r1890 n1062 n1209 6.0235294117647058
r1891 n1208 n1209 14.506666666666666
r1892 n1063 n1210 6.0235294117647058
r1893 n1209 n1210 14.506666666666666
r1894 n1064 n1211 6.0235294117647058
r1895 n1210 n1211 14.506666666666666
r1896 n1065 n1212 6.0235294117647058
r1897 n1211 n1212 14.506666666666666
r1898 n1066 n1213 6.0235294117647058
r1899 n1212 n1213 14.506666666666666
r1900 n1067 n1214 6.0235294117647058
r1901 n1213 n1214 14.506666666666666
r1902 n1068 n1215 18.618181818181817
r1903 n1214 n1215 9.5999999999999996
r1904 n1069 n1216 8.9043478260869566
r1905 n1215 n1216 7.253333333333333
r1906 n1070 n1217 102.40000000000001
r1907 n1216 n1217 5.333333333333333
r1908 n1071 n1218 6.8266666666666671
r1909 n1217 n1218 6.8266666666666671
r1910 n1072 n1219 102.40000000000001
r1911 n1218 n1219 6.8266666666666671
r1912 n1073 n1220 8.9043478260869566
r1913 n1219 n1220 5.333333333333333
r1914 n1074 n1221 18.618181818181817
r1915 n1220 n1221 7.253333333333333
r1916 n1075 n1222 6.0235294117647058
r1917 n1221 n1222 9.5999999999999996
r1918 n1076 n1223 6.0235294117647058
r1919 n1222 n1223 14.506666666666666
r1920 n1077 n1224 6.0235294117647058
r1921 n1223 n1224 14.506666666666666
r1922 n1078 n1225 6.0235294117647058
r1923 n1224 n1225 14.506666666666666
r1924 n1079 n1226 6.0235294117647058
r1925 n1225 n1226 14.506666666666666
r1926 n1080 n1227 6.0235294117647058
r1927 n1226 n1227 14.506666666666666
r1928 n1081 n1228 6.0235294117647058
r1929 n1227 n1228 14.506666666666666
r1930 n1082 n1229 6.0235294117647058
r1931 n1228 n1229 14.506666666666666
r1932 n1083 n1230 6.0235294117647058
r1933 n1229 n1230 14.506666666666666
r1934 n1084 n1231 6.0235294117647058
r1935 n1230 n1231 14.506666666666666
r1936 n1085 n1232 6.0235294117647058
r1937 n1231 n1232 14.506666666666666
r1938 n1086 n1233 6.0235294117647058
r1939 n1232 n1233 14.506666666666666
r1940 n1087 n1234 6.0235294117647058
r1941 n1233 n1234 14.506666666666666
r1942 n1088 n1235 6.0235294117647058
r1943 n1234 n1235 14.506666666666666
r1944 n1089 n1236 6.0235294117647058
r1945 n1235 n1236 14.506666666666666
r1946 n1090 n1237 6.0235294117647058
r1947 n1236 n1237 14.506666666666666
r1948 n1091 n1238 6.0235294117647058
r1949 n1237 n1238 14.506666666666666
r1950 n1092 n1239 6.0235294117647058
r1951 n1238 n1239 14.506666666666666
r1952 n1093 n1240 6.0235294117647058
r1953 n1239 n1240 14.506666666666666
r1954 n1094 n1241 6.0235294117647058
r1955 n1240 n1241 14.506666666666666
r1956 n1095 n1242 6.0235294117647058
r1957 n1241 n1242 14.506666666666666
r1958 n1096 n1243 6.0235294117647058
r1959 n1242 n1243 14.506666666666666
r1960 n1097 n1244 6.0235294117647058
r1961 n1243 n1244 14.506666666666666
r1962 n1098 n1245 7.5851851851851855
r1963 n1244 n1245 13.013333333333334
r1964 n1099 n1246 29.257142857142856
r1965 n1245 n1246 7.253333333333333
r1966 n1100 n1247 6.0235294117647058
r1967 n1246 n1247 8.7466666666666661
r1968 n1101 n1248 6.0235294117647058
r1969 n1247 n1248 14.506666666666666
r1970 n1102 n1249 6.0235294117647058
r1971 n1248 n1249 14.506666666666666
r1972 n1103 n1250 6.0235294117647058
r1973 n1249 n1250 14.506666666666666
r1974 n1104 n1251 7.5851851851851855
r1975 n1250 n1251 13.013333333333334
r1976 n1105 n1252 29.257142857142856
r1977 n1251 n1252 7.253333333333333
r1978 n1106 n1253 11.377777777777778
r1979 n1252 n1253 5.333333333333333
r1980 n1107 n1254 12.800000000000001
r1981 n1253 n1254 7.253333333333333
r1982 n1108 n1255 14.628571428571428
r1983 n1254 n1255 6.4000000000000004
r1984 n1109 n1256 10.24
r1985 n1255 n1256 7.253333333333333
r1986 n1110 n1257 40.960000000000001
r1987 n1256 n1257 5.333333333333333
r1988 n1111 n1258 7.0620689655172413
r1989 n1257 n1258 7.253333333333333
r1990 n1112 n1259 6.0235294117647058
r1991 n1258 n1259 13.44
r1992 n1113 n1260 6.0235294117647058
r1993 n1259 n1260 14.506666666666666
r1994 n1114 n1261 6.0235294117647058
r1995 n1260 n1261 14.506666666666666
r1996 n1115 n1262 5.1200000000000001
r1997 n1261 n1262 15.786666666666667
r1998 n1116 n1263 6.0235294117647058
r1999 n1262 n1263 15.786666666666667
r2000 n1117 n1264 6.0235294117647058
r2001 n1263 n1264 14.506666666666666
r2002 n1118 n1265 6.0235294117647058
r2003 n1264 n1265 14.506666666666666
r2004 n1119 n1266 12.047058823529412
r2005 n1265 n1266 10.880000000000001
r2006 n1120 n1267 12.047058823529412
r2007 n1266 n1267 7.253333333333333
r2008 n1121 n1268 6.0235294117647058
r2009 n1122 n1269 7.4744525547445253
r2010 n1268 n1269 196.48000000000002
r2011 n1123 n1270 7.4202898550724639
r2012 n1269 n1270 176
r2013 n1124 n1271 6.0235294117647058
r2014 n1270 n1271 197.12
r2015 n1125 n1272 15.753846153846155
r2016 n1271 n1272 150.40000000000001
r2017 n1126 n1273 5.1200000000000001
r2018 n1272 n1273 169.59999999999999
r2019 n1127 n1274 204.80000000000001
r2020 n1273 n1274 131.19999999999999
r2021 n1128 n1275 6.2060606060606061
r2022 n1274 n1275 108.8
r2023 n1129 n1276 204.80000000000001
r2024 n1275 n1276 108.8
r2025 n1130 n1277 8.9043478260869566
r2026 n1276 n1277 76.799999999999997
r2027 n1131 n1278 51.200000000000003
r2028 n1277 n1278 86.400000000000006
r2029 n1132 n1279 34.133333333333333
r2030 n1278 n1279 32
r2031 n1133 n1280 40.960000000000001
r2032 n1279 n1280 35.200000000000003
r2033 n1134 n1281 204.80000000000001
r2034 n1280 n1281 19.199999999999999
r2035 n1135 n1282 15.753846153846155
r2036 n1281 n1282 44.799999999999997
r2037 n1136 n1283 20.48
r2038 n1282 n1283 73.599999999999994
r2039 n1137 n1284 40.960000000000001
r2040 n1283 n1284 48
r2041 n1138 n1285 40.960000000000001
r2042 n1284 n1285 32
r2043 n1139 n1286 204.80000000000001
r2044 n1285 n1286 19.199999999999999
r2045 n1140 n1287 68.266666666666666
r2046 n1286 n1287 12.800000000000001
r2047 n1141 n1288 204.80000000000001
r2048 n1287 n1288 12.800000000000001
r2049 n1142 n1289 22.755555555555556
r2050 n1288 n1289 32
r2051 n1143 n1290 20.48
r2052 n1289 n1290 60.799999999999997
r2053 n1144 n1291 40.960000000000001
r2054 n1290 n1291 48
r2055 n1145 n1292 40.960000000000001
r2056 n1291 n1292 32
r2057 n1146 n1293 204.80000000000001
r2058 n1292 n1293 19.199999999999999
r2059 n1147 n1294 102.40000000000001
r2060 n1293 n1294 9.5999999999999996
r2061 n1148 n1295 204.80000000000001
r2062 n1294 n1295 9.5999999999999996
r2063 n1149 n1296 204.80000000000001
r2064 n1295 n1296 6.4000000000000004
r2065 n1150 n1297 204.80000000000001
r2066 n1296 n1297 6.4000000000000004
r2067 n1151 n1298 51.200000000000003
r2068 n1297 n1298 16
r2069 n1152 n1299 40.960000000000001
r2070 n1298 n1299 28.800000000000001
r2071 n1153 n1300 204.80000000000001
r2072 n1299 n1300 19.199999999999999
r2073 n1154 n1301 20.48
r2074 n1300 n1301 35.200000000000003
r2075 n1155 n1302 68.266666666666666
r2076 n1301 n1302 41.600000000000001
r2077 n1156 n1303 34.133333333333333
r2078 n1302 n1303 28.800000000000001
r2079 n1157 n1304 102.40000000000001
r2080 n1303 n1304 25.600000000000001
r2081 n1158 n1305 204.80000000000001
r2082 n1304 n1305 9.5999999999999996
r2083 n1159 n1306 204.80000000000001
r2084 n1305 n1306 6.4000000000000004
r2085 n1160 n1307 34.133333333333333
r2086 n1306 n1307 22.399999999999999
r2087 n1161 n1308 40.960000000000001
r2088 n1307 n1308 35.200000000000003
r2089 n1162 n1309 204.80000000000001
r2090 n1308 n1309 19.199999999999999
r2091 n1163 n1310 51.200000000000003
r2092 n1309 n1310 16
r2093 n1164 n1311 40.960000000000001
r2094 n1310 n1311 28.800000000000001
r2095 n1165 n1312 68.266666666666666
r2096 n1311 n1312 25.600000000000001
r2097 n1166 n1313 29.257142857142856
r2098 n1312 n1313 32
r2099 n1167 n1314 34.133333333333333
r2100 n1313 n1314 41.600000000000001
r2101 n1168 n1315 20.48
r2102 n1314 n1315 51.200000000000003
r2103 n1169 n1316 51.200000000000003
r2104 n1315 n1316 44.799999999999997
r2105 n1170 n1317 29.257142857142856
r2106 n1316 n1317 35.200000000000003
r2107 n1171 n1318 22.755555555555556
r2108 n1317 n1318 51.200000000000003
r2109 n1172 n1319 51.200000000000003
r2110 n1318 n1319 41.600000000000001
r2111 n1173 n1320 25.600000000000001
r2112 n1319 n1320 38.399999999999999
r2113 n1174 n1321 40.960000000000001
r2114 n1320 n1321 41.600000000000001
r2115 n1175 n1322 34.133333333333333
r2116 n1321 n1322 35.200000000000003
r2117 n1176 n1323 102.40000000000001
r2118 n1322 n1323 25.600000000000001
r2119 n1177 n1324 12.047058823529412
r2120 n1323 n1324 60.799999999999997
r2121 n1178 n1325 15.753846153846155
r2122 n1324 n1325 96
r2123 n1179 n1326 102.40000000000001
r2124 n1325 n1326 48
r2125 n1180 n1327 102.40000000000001
r2126 n1326 n1327 12.800000000000001
r2127 n1181 n1328 51.200000000000003
r2128 n1327 n1328 19.199999999999999
r2129 n1182 n1329 40.960000000000001
r2130 n1328 n1329 28.800000000000001
r2131 n1183 n1330 25.600000000000001
r2132 n1329 n1330 41.600000000000001
r2133 n1184 n1331 51.200000000000003
r2134 n1330 n1331 38.399999999999999
r2135 n1185 n1332 15.753846153846155
r2136 n1331 n1332 54.399999999999999
r2137 n1186 n1333 29.257142857142856
r2138 n1332 n1333 64
r2139 n1187 n1334 7.5851851851851855
r2140 n1333 n1334 108.8
r2141 n1188 n1335 102.40000000000001
r2142 n1334 n1335 92.799999999999997
r2143 n1189 n1336 40.960000000000001
r2144 n1335 n1336 22.399999999999999
r2145 n1190 n1337 7.5851851851851855
r2146 n1336 n1337 102.40000000000001
r2147 n1191 n1338 102.40000000000001
r2148 n1337 n1338 92.799999999999997
r2149 n1192 n1339 6.4000000000000004
r2150 n1338 n1339 108.8
r2151 n1193 n1340 6.0235294117647058
r2152 n1339 n1340 211.19999999999999
r2153 n1194 n1341 6.0235294117647058
r2154 n1340 n1341 217.59999999999999
r2155 n1195 n1342 6.0235294117647058
r2156 n1341 n1342 217.59999999999999
r2157 n1196 n1343 6.0235294117647058
r2158 n1342 n1343 217.59999999999999
r2159 n1197 n1344 6.0235294117647058
r2160 n1343 n1344 217.59999999999999
r2161 n1198 n1345 6.0235294117647058
r2162 n1344 n1345 217.59999999999999
r2163 n1199 n1346 6.0235294117647058
r2164 n1345 n1346 217.59999999999999
r2165 n1200 n1347 6.0235294117647058
r2166 n1346 n1347 217.59999999999999
r2167 n1201 n1348 6.0235294117647058
r2168 n1347 n1348 217.59999999999999
r2169 n1202 n1349 6.0235294117647058
r2170 n1348 n1349 217.59999999999999
r2171 n1203 n1350 6.0235294117647058
r2172 n1349 n1350 217.59999999999999
r2173 n1204 n1351 6.0235294117647058
r2174 n1350 n1351 217.59999999999999
r2175 n1205 n1352 6.0235294117647058
r2176 n1351 n1352 217.59999999999999
r2177 n1206 n1353 6.0235294117647058
r2178 n1352 n1353 217.59999999999999
r2179 n1207 n1354 6.0235294117647058
r2180 n1353 n1354 217.59999999999999
r2181 n1208 n1355 6.0235294117647058
r2182 n1354 n1355 217.59999999999999
r2183 n1209 n1356 6.0235294117647058
r2184 n1355 n1356 217.59999999999999
r2185 n1210 n1357 6.0235294117647058
r2186 n1356 n1357 217.59999999999999
r2187 n1211 n1358 6.0235294117647058
r2188 n1357 n1358 217.59999999999999
r2189 n1212 n1359 6.0235294117647058
r2190 n1358 n1359 217.59999999999999
r2191 n1213 n1360 6.0235294117647058
r2192 n1359 n1360 217.59999999999999
r2193 n1214 n1361 6.0235294117647058
r2194 n1360 n1361 217.59999999999999
r2195 n1215 n1362 18.618181818181817
r2196 n1361 n1362 144
r2197 n1216 n1363 8.9043478260869566
r2198 n1362 n1363 108.8
r2199 n1217 n1364 102.40000000000001
r2200 n1363 n1364 80
r2201 n1218 n1365 6.8266666666666671
r2202 n1364 n1365 102.40000000000001
r2203 n1219 n1366 102.40000000000001
r2204 n1365 n1366 102.40000000000001
r2205 n1220 n1367 8.9043478260869566
r2206 n1366 n1367 80
r2207 n1221 n1368 18.618181818181817
r2208 n1367 n1368 108.8
r2209 n1222 n1369 6.0235294117647058
r2210 n1368 n1369 144
r2211 n1223 n1370 6.0235294117647058
r2212 n1369 n1370 217.59999999999999
r2213 n1224 n1371 6.0235294117647058
r2214 n1370 n1371 217.59999999999999
r2215 n1225 n1372 6.0235294117647058
r2216 n1371 n1372 217.59999999999999
r2217 n1226 n1373 6.0235294117647058
r2218 n1372 n1373 217.59999999999999
r2219 n1227 n1374 6.0235294117647058
r2220 n1373 n1374 217.59999999999999
r2221 n1228 n1375 6.0235294117647058
r2222 n1374 n1375 217.59999999999999
r2223 n1229 n1376 6.0235294117647058
r2224 n1375 n1376 217.59999999999999
r2225 n1230 n1377 6.0235294117647058
r2226 n1376 n1377 217.59999999999999
r2227 n1231 n1378 6.0235294117647058
r2228 n1377 n1378 217.59999999999999
r2229 n1232 n1379 6.0235294117647058
r2230 n1378 n1379 217.59999999999999
r2231 n1233 n1380 6.0235294117647058
r2232 n1379 n1380 217.59999999999999
r2233 n1234 n1381 6.0235294117647058
r2234 n1380 n1381 217.59999999999999
r2235 n1235 n1382 6.0235294117647058
r2236 n1381 n1382 217.59999999999999
r2237 n1236 n1383 6.0235294117647058
r2238 n1382 n1383 217.59999999999999
r2239 n1237 n1384 6.0235294117647058
r2240 n1383 n1384 217.59999999999999
r2241 n1238 n1385 6.0235294117647058
r2242 n1384 n1385 217.59999999999999
r2243 n1239 n1386 6.0235294117647058
r2244 n1385 n1386 217.59999999999999
r2245 n1240 n1387 6.0235294117647058
r2246 n1386 n1387 217.59999999999999
r2247 n1241 n1388 6.0235294117647058
r2248 n1387 n1388 217.59999999999999
r2249 n1242 n1389 6.0235294117647058
r2250 n1388 n1389 217.59999999999999
r2251 n1243 n1390 6.0235294117647058
r2252 n1389 n1390 217.59999999999999
r2253 n1244 n1391 6.0235294117647058
r2254 n1390 n1391 217.59999999999999
r2255 n1245 n1392 7.5851851851851855
r2256 n1391 n1392 195.19999999999999
r2257 n1246 n1393 29.257142857142856
r2258 n1392 n1393 108.8
r2259 n1247 n1394 6.0235294117647058
r2260 n1393 n1394 131.19999999999999
r2261 n1248 n1395 6.0235294117647058
r2262 n1394 n1395 217.59999999999999
r2263 n1249 n1396 6.0235294117647058
r2264 n1395 n1396 217.59999999999999
r2265 n1250 n1397 6.0235294117647058
r2266 n1396 n1397 217.59999999999999
r2267 n1251 n1398 7.5851851851851855
r2268 n1397 n1398 195.19999999999999
r2269 n1252 n1399 29.257142857142856
r2270 n1398 n1399 108.8
r2271 n1253 n1400 11.377777777777778
r2272 n1399 n1400 80
r2273 n1254 n1401 12.800000000000001
r2274 n1400 n1401 108.8
r2275 n1255 n1402 14.628571428571428
r2276 n1401 n1402 96
r2277 n1256 n1403 10.24
r2278 n1402 n1403 108.8
r2279 n1257 n1404 40.960000000000001
r2280 n1403 n1404 80
r2281 n1258 n1405 7.0620689655172413
r2282 n1404 n1405 108.8
r2283 n1259 n1406 6.0235294117647058
r2284 n1405 n1406 201.59999999999999
r2285 n1260 n1407 6.0235294117647058
r2286 n1406 n1407 217.59999999999999
r2287 n1261 n1408 6.0235294117647058
r2288 n1407 n1408 217.59999999999999
r2289 n1262 n1409 5.1200000000000001
r2290 n1408 n1409 236.80000000000001
r2291 n1263 n1410 6.0235294117647058
r2292 n1409 n1410 236.80000000000001
r2293 n1264 n1411 6.0235294117647058
r2294 n1410 n1411 217.59999999999999
r2295 n1265 n1412 6.0235294117647058
r2296 n1411 n1412 217.59999999999999
r2297 n1266 n1413 12.047058823529412
r2298 n1412 n1413 163.19999999999999
r2299 n1267 n1414 12.047058823529412
r2300 n1413 n1414 108.8
r2301 n1268 n1415 2.447058823529412
r2302 n1413 n1416 4.8941176470588239
r2303 n1414 n1417 4.8941176470588239
r2304 n1416 n1417 19.781818181818181
r2305 n1415 n1418 2.447058823529412
r2306 n1416 n1419 4.8941176470588239
r2307 n1417 n1420 4.8941176470588239
r2308 n1419 n1420 108.8
r2309 n1418 n1421 6.7011764705882353
r2310 n1419 n1422 13.402352941176471
r2311 n1420 n1423 13.402352941176471
r2312 n1422 n1423 6.4761904761904763
r2313 n1421 n1424 12.611764705882353
r2314 n1422 n1425 25.223529411764705
r2315 n1423 n1426 25.223529411764705
r2316 n1425 n1426 6.5149700598802394
r2317 n1424 n1427 8.357647058823531
r2318 n1425 n1428 16.715294117647062
r2319 n1426 n1429 16.715294117647062
r2320 n1428 n1429 19.781818181818181
r2321 n1427 n1430 3.9529411764705884
r2322 n1428 n1431 7.9058823529411768
r2323 n1429 n1432 7.9058823529411768
r2324 n1431 n1432 21.760000000000002
r2325 n1430 n1433 2.2588235294117647
r2326 n1431 n1434 4.5176470588235293
r2327 n1432 n1435 4.5176470588235293
r2328 n1434 n1435 108.8
r2329 n1433 n1436 0.94117647058823528
r2330 n1434 n1437 1.8823529411764706
r2331 n1435 n1438 1.8823529411764706
r2332 n1437 n1438 72.533333333333331
r2333 n1436 n1439 1.5058823529411764
r2334 n1437 n1440 3.0117647058823529
r2335 n1438 n1441 3.0117647058823529
r2336 n1440 n1441 43.520000000000003
r2337 n1439 n1442 1.5058823529411764
r2338 n1440 n1443 3.0117647058823529
r2339 n1441 n1444 3.0117647058823529
r2340 n1443 n1444 72.533333333333331
r2341 n1442 n1445 0.94117647058823528
r2342 n1443 n1446 1.8823529411764706
r2343 n1444 n1447 1.8823529411764706
r2344 n1446 n1447 108.8
r2345 n1445 n1448 6.0235294117647058
r2346 n1446 n1449 12.047058823529412
r2347 n1447 n1450 12.047058823529412
r2348 n1449 n1450 7.253333333333333
r2349 n1448 n1451 6.0235294117647058
r2350 n1449 n1452 12.047058823529412
r2351 n1450 n1453 12.047058823529412
r2352 n1452 n1453 108.8
r2353 n1451 n1454 0.94117647058823528
r2354 n1452 n1455 1.8823529411764706
r2355 n1453 n1456 1.8823529411764706
r2356 n1455 n1456 72.533333333333331
r2357 n1454 n1457 1.5058823529411764
r2358 n1455 n1458 3.0117647058823529
r2359 n1456 n1459 3.0117647058823529
r2360 n1458 n1459 43.520000000000003
r2361 n1457 n1460 1.5058823529411764
r2362 n1458 n1461 3.0117647058823529
r2363 n1459 n1462 3.0117647058823529
r2364 n1461 n1462 72.533333333333331
r2365 n1460 n1463 0.94117647058823528
r2366 n1461 n1464 1.8823529411764706
r2367 n1462 n1465 1.8823529411764706
r2368 n1464 n1465 108.8
r2369 n1463 n1466 2.2588235294117647
r2370 n1464 n1467 4.5176470588235293
r2371 n1465 n1468 4.5176470588235293
r2372 n1467 n1468 21.760000000000002
r2373 n1466 n1469 3.9529411764705884
r2374 n1467 n1470 7.9058823529411768
r2375 n1468 n1471 7.9058823529411768
r2376 n1470 n1471 19.781818181818181
r2377 n1469 n1472 9.5999999999999996
r2378 n1470 n1473 19.199999999999999
r2379 n1471 n1474 19.199999999999999
r2380 n1473 n1474 5.4400000000000004
r2381 n1472 n1475 15.058823529411764
r2382 n1473 n1476 30.117647058823529
r2383 n1474 n1477 30.117647058823529
r2384 n1476 n1477 5.4400000000000004
r2385 n1475 n1478 13.929411764705883
r2386 n1478 n1479 11.55764705882353
r2387 n1479 n1480 10.352941176470589
r2388 n1480 n1481 11.595294117647059
r2389 n1481 n1482 8.8470588235294123
r2390 n1482 n1483 9.9764705882352942
r2391 n1483 n1484 7.7176470588235295
r2392 n1484 n1485 6.4000000000000004
r2393 n1485 n1486 6.4000000000000004
r2394 n1486 n1487 4.5176470588235293
r2395 n1487 n1488 5.0823529411764703
r2396 n1488 n1489 1.8823529411764706
r2397 n1489 n1490 2.0705882352941178
r2398 n1490 n1491 1.1294117647058823
r2399 n1491 n1492 2.6352941176470588
r2400 n1492 n1493 4.3294117647058821
r2401 n1493 n1494 2.8235294117647061
r2402 n1494 n1495 1.8823529411764706
r2403 n1495 n1496 1.1294117647058823
r2404 n1496 n1497 0.75294117647058822
r2405 n1497 n1498 0.75294117647058822
r2406 n1498 n1499 1.8823529411764706
r2407 n1499 n1500 3.5764705882352943
r2408 n1500 n1501 2.8235294117647061
r2409 n1501 n1502 1.8823529411764706
r2410 n1502 n1503 1.1294117647058823
r2411 n1503 n1504 0.56470588235294117
r2412 n1504 n1505 0.56470588235294117
r2413 n1505 n1506 0.37647058823529411
r2414 n1506 n1507 0.37647058823529411
r2415 n1507 n1508 0.94117647058823528
r2416 n1508 n1509 1.6941176470588235
r2417 n1509 n1510 1.1294117647058823
r2418 n1510 n1511 2.0705882352941178
r2419 n1511 n1512 2.447058823529412
r2420 n1512 n1513 1.6941176470588235
r2421 n1513 n1514 1.5058823529411764
r2422 n1514 n1515 0.56470588235294117
r2423 n1515 n1516 0.37647058823529411
r2424 n1516 n1517 1.3176470588235294
r2425 n1517 n1518 2.0705882352941178
r2426 n1518 n1519 1.1294117647058823
r2427 n1519 n1520 0.94117647058823528
r2428 n1520 n1521 1.6941176470588235
r2429 n1521 n1522 1.5058823529411764
r2430 n1522 n1523 1.8823529411764706
r2431 n1523 n1524 2.447058823529412
r2432 n1524 n1525 3.0117647058823529
r2433 n1525 n1526 2.6352941176470588
r2434 n1526 n1527 2.0705882352941178
r2435 n1527 n1528 3.0117647058823529
r2436 n1528 n1529 2.447058823529412
r2437 n1529 n1530 2.2588235294117647
r2438 n1530 n1531 2.447058823529412
r2439 n1531 n1532 2.0705882352941178
r2440 n1532 n1533 1.5058823529411764
r2441 n1533 n1534 3.5764705882352943
r2442 n1534 n1535 5.6470588235294121
r2443 n1535 n1536 2.8235294117647061
r2444 n1536 n1537 0.75294117647058822
r2445 n1537 n1538 1.1294117647058823
r2446 n1538 n1539 1.6941176470588235
r2447 n1539 n1540 2.447058823529412
r2448 n1540 n1541 2.2588235294117647
r2449 n1541 n1542 3.2000000000000002
r2450 n1542 n1543 3.7647058823529411
r2451 n1543 n1544 6.4000000000000004
r2452 n1544 n1545 5.4588235294117649
r2453 n1545 n1546 1.3176470588235294
r2454 n1546 n1547 6.0235294117647058
r2455 n1547 n1548 5.4588235294117649
r2456 n1548 n1549 6.4000000000000004
r2457 n1549 n1550 12.423529411764706
r2458 n1550 n1551 12.800000000000001
r2459 n1551 n1552 12.800000000000001
r2460 n1552 n1553 12.800000000000001
r2461 n1553 n1554 12.800000000000001
r2462 n1554 n1555 12.800000000000001
r2463 n1555 n1556 12.800000000000001
r2464 n1556 n1557 12.800000000000001
r2465 n1557 n1558 12.800000000000001
r2466 n1558 n1559 12.800000000000001
r2467 n1559 n1560 12.800000000000001
r2468 n1560 n1561 12.800000000000001
r2469 n1561 n1562 12.800000000000001
r2470 n1562 n1563 12.800000000000001
r2471 n1563 n1564 12.800000000000001
r2472 n1564 n1565 12.800000000000001
r2473 n1565 n1566 12.800000000000001
r2474 n1566 n1567 12.800000000000001
r2475 n1567 n1568 12.800000000000001
r2476 n1568 n1569 12.800000000000001
r2477 n1569 n1570 12.800000000000001
r2478 n1570 n1571 12.800000000000001
r2479 n1571 n1572 8.4705882352941178
r2480 n1572 n1573 6.4000000000000004
r2481 n1573 n1574 4.7058823529411766
r2482 n1574 n1575 6.0235294117647058
r2483 n1575 n1576 6.0235294117647058
r2484 n1576 n1577 4.7058823529411766
r2485 n1577 n1578 6.4000000000000004
r2486 n1578 n1579 8.4705882352941178
r2487 n1579 n1580 12.800000000000001
r2488 n1580 n1581 12.800000000000001
r2489 n1581 n1582 12.800000000000001
r2490 n1582 n1583 12.800000000000001
r2491 n1583 n1584 12.800000000000001
r2492 n1584 n1585 12.800000000000001
r2493 n1585 n1586 12.800000000000001
r2494 n1586 n1587 12.800000000000001
r2495 n1587 n1588 12.800000000000001
r2496 n1588 n1589 12.800000000000001
r2497 n1589 n1590 12.800000000000001
r2498 n1590 n1591 12.800000000000001
r2499 n1591 n1592 12.800000000000001
r2500 n1592 n1593 12.800000000000001
r2501 n1593 n1594 12.800000000000001
r2502 n1594 n1595 12.800000000000001
r2503 n1595 n1596 12.800000000000001
r2504 n1596 n1597 12.800000000000001
r2505 n1597 n1598 12.800000000000001
r2506 n1598 n1599 12.800000000000001
r2507 n1599 n1600 12.800000000000001
r2508 n1600 n1601 12.800000000000001
r2509 n1601 n1602 11.482352941176471
r2510 n1602 n1603 6.4000000000000004
r2511 n1603 n1604 7.7176470588235295
r2512 n1604 n1605 12.800000000000001
r2513 n1605 n1606 12.800000000000001
r2514 n1606 n1607 12.800000000000001
r2515 n1607 n1608 11.482352941176471
r2516 n1608 n1609 6.4000000000000004
r2517 n1609 n1610 4.7058823529411766
r2518 n1610 n1611 6.4000000000000004
r2519 n1611 n1612 5.6470588235294121
r2520 n1612 n1613 6.4000000000000004
r2521 n1613 n1614 4.7058823529411766
r2522 n1614 n1615 6.4000000000000004
r2523 n1615 n1616 11.858823529411765
r2524 n1616 n1617 12.800000000000001
r2525 n1617 n1618 12.800000000000001
r2526 n1618 n1619 13.929411764705883
r2527 n1619 n1620 13.929411764705883
r2528 n1620 n1621 12.800000000000001
r2529 n1621 n1622 12.800000000000001
r2530 n1476 n1623 27.858823529411765
r2531 n1622 n1623 9.5999999999999996
r2532 n1477 n1624 27.858823529411765
r2533 n1623 n1624 6.4000000000000004
r2534 vdd n1753 0.22321428571428573
r2535 n1753 n1754 22.035714285714285
r2536 n1754 n1755 43.959821428571431
r2537 n1755 n1756 44.071428571428569
r2538 n1756 n1757 44.071428571428569
r2539 n1757 n1758 44.071428571428569
r2540 n1758 n1759 44.071428571428569
r2541 n1759 n1760 44.071428571428569
r2542 n1760 n1761 44.071428571428569
r2543 n1761 n1762 44.071428571428569
r2544 n1762 n1763 44.071428571428569
r2545 n1763 n1764 44.071428571428569
r2546 n1764 n1765 44.071428571428569
r2547 n1765 n1766 44.071428571428569
r2548 n1766 n1767 44.071428571428569
r2549 n1767 n1768 44.071428571428569
r2550 n1768 n1769 44.071428571428569
r2551 n1769 n1770 44.071428571428569
r2552 n1770 n1771 44.071428571428569
r2553 n1771 n1772 44.071428571428569
r2554 n1772 n1773 43.959821428571431
r2555 n1773 n1774 22.035714285714285
r2556 n1774 n1782 0.20758928571428573
r2557 n1782 n1790 0.171875
r2558 n1790 n1798 0.171875
r2559 n1798 n1799 0.20669642857142856
r2560 n1799 n1800 0.22142857142857142
r2561 n1800 n1801 0.22142857142857142
r2562 n1801 n1802 0.22142857142857142
r2563 n1802 n1803 0.22142857142857142
r2564 n1803 n1804 0.22142857142857142
r2565 n1804 n1805 0.22187499999999999
r2566 n1805 n1806 0.22187499999999999
r2567 n1806 n1807 0.22142857142857142
r2568 n1807 n1808 0.22142857142857142
r2569 n1808 n1809 0.22142857142857142
r2570 n1809 n1810 0.22142857142857142
r2571 n1810 n1811 0.22142857142857142
r2572 n1811 n1812 0.22142857142857142
r2573 n1812 n1813 0.22142857142857142
r2574 n1813 n1814 0.22142857142857142
r2575 n1814 n1815 0.22142857142857142
r2576 n1815 n1816 0.22142857142857142
r2577 n1816 n1817 0.22142857142857142
r2578 n1817 n1818 0.22187499999999999
r2579 n1818 n1819 0.22187499999999999
r2580 n1819 n1820 0.22142857142857142
r2581 n1820 n1821 0.22142857142857142
r2582 n1821 n1822 0.22142857142857142
r2583 n1822 n1823 0.22142857142857142
r2584 n1823 n1824 0.22142857142857142
r2585 n1824 n1825 0.22142857142857142
r2586 n1825 n1826 0.22142857142857142
r2587 n1826 n1827 0.22142857142857142
r2588 n1827 n1828 0.22142857142857142
r2589 n1828 n1829 0.22142857142857142
r2590 n1829 n1830 0.22142857142857142
r2591 n1830 n1831 0.22187499999999999
r2592 n1831 n1832 0.22187499999999999
r2593 n1832 n1833 0.22142857142857142
r2594 n1833 n1834 0.22142857142857142
r2595 n1834 n1835 0.22142857142857142
r2596 n1835 n1836 0.22142857142857142
r2597 n1836 n1837 0.22142857142857142
r2598 n1837 n1838 0.22142857142857142
r2599 n1838 n1839 0.22142857142857142
r2600 n1839 n1840 0.22142857142857142
r2601 n1840 n1841 0.22142857142857142
r2602 n1841 n1842 0.22142857142857142
r2603 n1842 n1843 0.22142857142857142
r2604 n1843 n1844 0.22187499999999999
r2605 n1844 n1845 0.22187499999999999
r2606 n1845 n1846 0.22142857142857142
r2607 n1846 n1847 0.22142857142857142
r2608 n1847 n1848 0.22142857142857142
r2609 n1848 n1849 0.22142857142857142
r2610 n1849 n1850 0.22142857142857142
r2611 n1851 n1852 0.13437499999999999
r2612 n1852 n1853 0.109375
r2613 n1853 n1854 0.10000000000000001
r2614 n1854 n1855 0.10000000000000001
r2615 n1855 n1856 0.109375
r2616 n1856 n1857 0.13437499999999999
r2617 n1850 n1858 0.15535714285714286
r2618 n1851 n1859 0.26874999999999999
r2619 n1852 n1860 0.081439393939393936
r2620 n1859 n1860 0.11684782608695653
r2621 n1853 n1861 1.34375
r2622 n1860 n1861 0.095108695652173919
r2623 n1854 n1862 0.089583333333333334
r2624 n1861 n1862 0.086956521739130432
r2625 n1855 n1863 1.34375
r2626 n1862 n1863 0.086956521739130432
r2627 n1856 n1864 0.081439393939393936
r2628 n1863 n1864 0.095108695652173919
r2629 n1857 n1865 0.26874999999999999
r2630 n1864 n1865 0.11684782608695653
r2631 n1866 n1867 0.070652173913043473
r2632 n1858 n1868 0.095982142857142863
r2633 n1867 n1868 0.07880434782608696
r2634 n1868 n1869 0.07880434782608696
r2635 n1869 n1870 0.070652173913043473
r2636 n1859 n1871 0.15625
r2637 n1860 n1872 0.047348484848484848
r2638 n1871 n1872 1.34375
r2639 n1861 n1873 0.78125
r2640 n1872 n1873 1.09375
r2641 n1862 n1874 0.052083333333333336
r2642 n1873 n1874 1
r2643 n1863 n1875 0.78125
r2644 n1874 n1875 1
r2645 n1864 n1876 0.047348484848484848
r2646 n1875 n1876 1.09375
r2647 n1865 n1877 0.15625
r2648 n1876 n1877 1.34375
r2649 n1866 n1878 0.0625
r2650 n1867 n1879 1.5625
r2651 n1878 n1879 0.8125
r2652 n1868 n1880 0.055803571428571432
r2653 n1879 n1880 0.90625
r2654 n1869 n1881 1.5625
r2655 n1880 n1881 0.90625
r2656 n1870 n1882 0.0625
r2657 n1881 n1882 0.8125
r2658 n1871 n1883 0.20000000000000001
r2659 n1872 n1884 0.060606060606060608
r2660 n1883 n1884 0.089583333333333334
r2661 n1873 n1885 1
r2662 n1884 n1885 0.072916666666666671
r2663 n1874 n1886 0.066666666666666666
r2664 n1885 n1886 0.066666666666666666
r2665 n1875 n1887 1
r2666 n1886 n1887 0.066666666666666666
r2667 n1876 n1888 0.060606060606060608
r2668 n1887 n1888 0.072916666666666671
r2669 n1877 n1889 0.20000000000000001
r2670 n1888 n1889 0.089583333333333334
r2671 n1878 n1890 0.080000000000000002
r2672 n1879 n1891 2
r2673 n1890 n1891 0.054166666666666669
r2674 n1880 n1892 0.071428571428571425
r2675 n1891 n1892 0.060416666666666667
r2676 n1881 n1893 2
r2677 n1892 n1893 0.060416666666666667
r2678 n1882 n1894 0.080000000000000002
r2679 n1893 n1894 0.054166666666666669
r2680 n1883 n1895 0.20000000000000001
r2681 n1884 n1896 0.060606060606060608
r2682 n1895 n1896 1.34375
r2683 n1885 n1897 1
r2684 n1896 n1897 1.09375
r2685 n1886 n1898 0.066666666666666666
r2686 n1897 n1898 1
r2687 n1887 n1899 1
r2688 n1898 n1899 1
r2689 n1888 n1900 0.060606060606060608
r2690 n1899 n1900 1.09375
r2691 n1889 n1901 0.20000000000000001
r2692 n1900 n1901 1.34375
r2693 n1890 n1902 0.080000000000000002
r2694 n1891 n1903 2
r2695 n1902 n1903 0.8125
r2696 n1892 n1904 0.071428571428571425
r2697 n1903 n1904 0.90625
r2698 n1893 n1905 2
r2699 n1904 n1905 0.90625
r2700 n1894 n1906 0.080000000000000002
r2701 n1905 n1906 0.8125
r2702 n1895 n1907 0.15625
r2703 n1896 n1908 0.047348484848484848
r2704 n1907 n1908 0.11684782608695653
r2705 n1897 n1909 0.78125
r2706 n1908 n1909 0.095108695652173919
r2707 n1898 n1910 0.052083333333333336
r2708 n1909 n1910 0.086956521739130432
r2709 n1899 n1911 0.78125
r2710 n1910 n1911 0.086956521739130432
r2711 n1900 n1912 0.047348484848484848
r2712 n1911 n1912 0.095108695652173919
r2713 n1901 n1913 0.15625
r2714 n1912 n1913 0.11684782608695653
r2715 n1902 n1914 0.0625
r2716 n1903 n1915 1.5625
r2717 n1914 n1915 0.070652173913043473
r2718 n1904 n1916 0.055803571428571432
r2719 n1915 n1916 0.07880434782608696
r2720 n1905 n1917 1.5625
r2721 n1916 n1917 0.07880434782608696
r2722 n1906 n1918 0.0625
r2723 n1917 n1918 0.070652173913043473
r2724 n1907 n1919 0.26874999999999999
r2725 n1908 n1920 0.081439393939393936
r2726 n1919 n1920 0.13437499999999999
r2727 n1909 n1921 1.34375
r2728 n1920 n1921 0.109375
r2729 n1910 n1922 0.089583333333333334
r2730 n1921 n1922 0.10000000000000001
r2731 n1911 n1923 1.34375
r2732 n1922 n1923 0.10000000000000001
r2733 n1912 n1924 0.081439393939393936
r2734 n1923 n1924 0.109375
r2735 n1913 n1925 0.26874999999999999
r2736 n1924 n1925 0.13437499999999999
r2737 n1926 n1927 0.46875
r2738 n1927 n1928 0.3125
r2739 n1928 n1929 0.1875
r2740 n1929 n1930 0.09375
r2741 n1930 n1931 0.09375
r2742 n1931 n1932 0.0625
r2743 n1932 n1933 0.0625
r2744 n1933 n1934 0.15625
r2745 n1934 n1935 0.28125
r2746 n1935 n1936 0.1875
r2747 n1936 n1937 0.34375
r2748 n1937 n1938 0.40625
r2749 n1938 n1939 0.28125
r2750 n1939 n1940 0.25
r2751 n1940 n1941 0.09375
r2752 n1941 n1942 0.0625
r2753 n1942 n1943 0.21875
r2754 n1943 n1944 0.34375
r2755 n1944 n1945 0.1875
r2756 n1945 n1946 0.15625
r2757 n1946 n1947 0.28125
r2758 n1926 n1948 0.081250000000000003
r2759 n1927 n1949 0.16250000000000001
r2760 n1948 n1949 0.085227272727272721
r2761 n1928 n1950 0.16250000000000001
r2762 n1949 n1950 0.056818181818181816
r2763 n1929 n1951 0.8125
r2764 n1950 n1951 0.034090909090909088
r2765 n1930 n1952 0.40625
r2766 n1951 n1952 0.017045454545454544
r2767 n1931 n1953 0.8125
r2768 n1952 n1953 0.017045454545454544
r2769 n1932 n1954 0.8125
r2770 n1953 n1954 0.011363636363636364
r2771 n1933 n1955 0.8125
r2772 n1954 n1955 0.011363636363636364
r2773 n1934 n1956 0.203125
r2774 n1955 n1956 0.028409090909090908
r2775 n1935 n1957 0.16250000000000001
r2776 n1956 n1957 0.05113636363636364
r2777 n1936 n1958 0.8125
r2778 n1957 n1958 0.034090909090909088
r2779 n1937 n1959 0.081250000000000003
r2780 n1958 n1959 0.0625
r2781 n1938 n1960 0.27083333333333331
r2782 n1959 n1960 0.073863636363636367
r2783 n1939 n1961 0.13541666666666666
r2784 n1960 n1961 0.05113636363636364
r2785 n1940 n1962 0.40625
r2786 n1961 n1962 0.045454545454545456
r2787 n1941 n1963 0.8125
r2788 n1962 n1963 0.017045454545454544
r2789 n1942 n1964 0.8125
r2790 n1963 n1964 0.011363636363636364
r2791 n1943 n1965 0.13541666666666666
r2792 n1964 n1965 0.039772727272727272
r2793 n1944 n1966 0.16250000000000001
r2794 n1965 n1966 0.0625
r2795 n1945 n1967 0.8125
r2796 n1966 n1967 0.034090909090909088
r2797 n1946 n1968 0.203125
r2798 n1967 n1968 0.028409090909090908
r2799 n1947 n1969 0.16250000000000001
r2800 n1968 n1969 0.05113636363636364
r2801 n1948 n1970 0.081250000000000003
r2802 n1949 n1971 0.16250000000000001
r2803 n1970 n1971 0.46875
r2804 n1950 n1972 0.16250000000000001
r2805 n1971 n1972 0.3125
r2806 n1951 n1973 0.8125
r2807 n1972 n1973 0.1875
r2808 n1952 n1974 0.40625
r2809 n1973 n1974 0.09375
r2810 n1953 n1975 0.8125
r2811 n1974 n1975 0.09375
r2812 n1954 n1976 0.8125
r2813 n1975 n1976 0.0625
r2814 n1955 n1977 0.8125
r2815 n1976 n1977 0.0625
r2816 n1956 n1978 0.203125
r2817 n1977 n1978 0.15625
r2818 n1957 n1979 0.16250000000000001
r2819 n1978 n1979 0.28125
r2820 n1958 n1980 0.8125
r2821 n1979 n1980 0.1875
r2822 n1959 n1981 0.081250000000000003
r2823 n1980 n1981 0.34375
r2824 n1960 n1982 0.27083333333333331
r2825 n1981 n1982 0.40625
r2826 n1961 n1983 0.13541666666666666
r2827 n1982 n1983 0.28125
r2828 n1962 n1984 0.40625
r2829 n1983 n1984 0.25
r2830 n1963 n1985 0.8125
r2831 n1984 n1985 0.09375
r2832 n1964 n1986 0.8125
r2833 n1985 n1986 0.0625
r2834 n1965 n1987 0.13541666666666666
r2835 n1986 n1987 0.21875
r2836 n1966 n1988 0.16250000000000001
r2837 n1987 n1988 0.34375
r2838 n1967 n1989 0.8125
r2839 n1988 n1989 0.1875
r2840 n1968 n1990 0.203125
r2841 n1989 n1990 0.15625
r2842 n1969 n1991 0.16250000000000001
r2843 n1990 n1991 0.28125
r2844 n1970 n1992 0.20000000000000001
r2845 n1971 n1993 0.40000000000000002
r2846 n1992 n1993 0.03125
r2847 n1972 n1994 0.40000000000000002
r2848 n1993 n1994 0.020833333333333332
r2849 n1973 n1995 2
r2850 n1994 n1995 0.012500000000000001
r2851 n1974 n1996 1
r2852 n1995 n1996 0.0062500000000000003
r2853 n1975 n1997 2
r2854 n1996 n1997 0.0062500000000000003
r2855 n1976 n1998 2
r2856 n1997 n1998 0.0041666666666666666
r2857 n1977 n1999 2
r2858 n1998 n1999 0.0041666666666666666
r2859 n1978 n2000 0.5
r2860 n1999 n2000 0.010416666666666666
r2861 n1979 n2001 0.40000000000000002
r2862 n2000 n2001 0.018749999999999999
r2863 n1980 n2002 2
r2864 n2001 n2002 0.012500000000000001
r2865 n1981 n2003 0.20000000000000001
r2866 n2002 n2003 0.022916666666666665
r2867 n1982 n2004 0.66666666666666663
r2868 n2003 n2004 0.027083333333333334
r2869 n1983 n2005 0.33333333333333331
r2870 n2004 n2005 0.018749999999999999
r2871 n1984 n2006 1
r2872 n2005 n2006 0.016666666666666666
r2873 n1985 n2007 2
r2874 n2006 n2007 0.0062500000000000003
r2875 n1986 n2008 2
r2876 n2007 n2008 0.0041666666666666666
r2877 n1987 n2009 0.33333333333333331
r2878 n2008 n2009 0.014583333333333334
r2879 n1988 n2010 0.40000000000000002
r2880 n2009 n2010 0.022916666666666665
r2881 n1989 n2011 2
r2882 n2010 n2011 0.012500000000000001
r2883 n1990 n2012 0.5
r2884 n2011 n2012 0.010416666666666666
r2885 n1991 n2013 0.40000000000000002
r2886 n2012 n2013 0.018749999999999999
r2887 n1992 n2014 0.20000000000000001
r2888 n1993 n2015 0.40000000000000002
r2889 n2014 n2015 0.46875
r2890 n1994 n2016 0.40000000000000002
r2891 n2015 n2016 0.3125
r2892 n1995 n2017 2
r2893 n2016 n2017 0.1875
r2894 n1996 n2018 1
r2895 n2017 n2018 0.09375
r2896 n1997 n2019 2
r2897 n2018 n2019 0.09375
r2898 n1998 n2020 2
r2899 n2019 n2020 0.0625
r2900 n1999 n2021 2
r2901 n2020 n2021 0.0625
r2902 n2000 n2022 0.5
r2903 n2021 n2022 0.15625
r2904 n2001 n2023 0.40000000000000002
r2905 n2022 n2023 0.28125
r2906 n2002 n2024 2
r2907 n2023 n2024 0.1875
r2908 n2003 n2025 0.20000000000000001
r2909 n2024 n2025 0.34375
r2910 n2004 n2026 0.66666666666666663
r2911 n2025 n2026 0.40625
r2912 n2005 n2027 0.33333333333333331
r2913 n2026 n2027 0.28125
r2914 n2006 n2028 1
r2915 n2027 n2028 0.25
r2916 n2007 n2029 2
r2917 n2028 n2029 0.09375
r2918 n2008 n2030 2
r2919 n2029 n2030 0.0625
r2920 n2009 n2031 0.33333333333333331
r2921 n2030 n2031 0.21875
r2922 n2010 n2032 0.40000000000000002
r2923 n2031 n2032 0.34375
r2924 n2011 n2033 2
r2925 n2032 n2033 0.1875
r2926 n2012 n2034 0.5
r2927 n2033 n2034 0.15625
r2928 n2013 n2035 0.40000000000000002
r2929 n2034 n2035 0.28125
r2930 n2014 n2036 0.081250000000000003
r2931 n2015 n2037 0.16250000000000001
r2932 n2036 n2037 0.085227272727272721
r2933 n2016 n2038 0.16250000000000001
r2934 n2037 n2038 0.056818181818181816
r2935 n2017 n2039 0.8125
r2936 n2038 n2039 0.034090909090909088
r2937 n2018 n2040 0.40625
r2938 n2039 n2040 0.017045454545454544
r2939 n2019 n2041 0.8125
r2940 n2040 n2041 0.017045454545454544
r2941 n2020 n2042 0.8125
r2942 n2041 n2042 0.011363636363636364
r2943 n2021 n2043 0.8125
r2944 n2042 n2043 0.011363636363636364
r2945 n2022 n2044 0.203125
r2946 n2043 n2044 0.028409090909090908
r2947 n2023 n2045 0.16250000000000001
r2948 n2044 n2045 0.05113636363636364
r2949 n2024 n2046 0.8125
r2950 n2045 n2046 0.034090909090909088
r2951 n2025 n2047 0.081250000000000003
r2952 n2046 n2047 0.0625
r2953 n2026 n2048 0.27083333333333331
r2954 n2047 n2048 0.073863636363636367
r2955 n2027 n2049 0.13541666666666666
r2956 n2048 n2049 0.05113636363636364
r2957 n2028 n2050 0.40625
r2958 n2049 n2050 0.045454545454545456
r2959 n2029 n2051 0.8125
r2960 n2050 n2051 0.017045454545454544
r2961 n2030 n2052 0.8125
r2962 n2051 n2052 0.011363636363636364
r2963 n2031 n2053 0.13541666666666666
r2964 n2052 n2053 0.039772727272727272
r2965 n2032 n2054 0.16250000000000001
r2966 n2053 n2054 0.0625
r2967 n2033 n2055 0.8125
r2968 n2054 n2055 0.034090909090909088
r2969 n2034 n2056 0.203125
r2970 n2055 n2056 0.028409090909090908
r2971 n2035 n2057 0.16250000000000001
r2972 n2056 n2057 0.05113636363636364
r2973 n2036 n2058 0.081250000000000003
r2974 n2037 n2059 0.16250000000000001
r2975 n2058 n2059 0.46875
r2976 n2038 n2060 0.16250000000000001
r2977 n2059 n2060 0.3125
r2978 n2039 n2061 0.8125
r2979 n2060 n2061 0.1875
r2980 n2040 n2062 0.40625
r2981 n2061 n2062 0.09375
r2982 n2041 n2063 0.8125
r2983 n2062 n2063 0.09375
r2984 n2042 n2064 0.8125
r2985 n2063 n2064 0.0625
r2986 n2043 n2065 0.8125
r2987 n2064 n2065 0.0625
r2988 n2044 n2066 0.203125
r2989 n2065 n2066 0.15625
r2990 n2045 n2067 0.16250000000000001
r2991 n2066 n2067 0.28125
r2992 n2046 n2068 0.8125
r2993 n2067 n2068 0.1875
r2994 n2047 n2069 0.081250000000000003
r2995 n2068 n2069 0.34375
r2996 n2048 n2070 0.27083333333333331
r2997 n2069 n2070 0.40625
r2998 n2049 n2071 0.13541666666666666
r2999 n2070 n2071 0.28125
r3000 n2050 n2072 0.40625
r3001 n2071 n2072 0.25
r3002 n2051 n2073 0.8125
r3003 n2072 n2073 0.09375
r3004 n2052 n2074 0.8125
r3005 n2073 n2074 0.0625
r3006 n2053 n2075 0.13541666666666666
r3007 n2074 n2075 0.21875
r3008 n2054 n2076 0.16250000000000001
r3009 n2075 n2076 0.34375
r3010 n2055 n2077 0.8125
r3011 n2076 n2077 0.1875
r3012 n2056 n2078 0.203125
r3013 n2077 n2078 0.15625
r3014 n2057 n2079 0.16250000000000001
r3015 n2078 n2079 0.28125
r3016 n2080 n2081 0.46875
r3017 n2081 n2082 0.3125
r3018 n2082 n2083 0.1875
r3019 n2083 n2084 0.125
r3020 n2084 n2085 0.125
r3021 n2085 n2086 0.3125
r3022 n2086 n2087 0.59375
r3023 n2087 n2088 0.46875
r3024 n2088 n2089 0.3125
r3025 n2089 n2090 0.1875
r3026 n2090 n2091 0.09375
r3027 n2091 n2092 0.09375
r3028 n2092 n2093 0.0625
r3029 n2093 n2094 0.0625
r3030 n2094 n2095 0.15625
r3031 n2095 n2096 0.28125
r3032 n2096 n2097 0.1875
r3033 n2097 n2098 0.34375
r3034 n2080 n2099 0.043749999999999997
r3035 n2081 n2100 0.087499999999999994
r3036 n2099 n2100 0.1875
r3037 n2082 n2101 0.087499999999999994
r3038 n2100 n2101 0.125
r3039 n2083 n2102 0.4375
r3040 n2101 n2102 0.074999999999999997
r3041 n2084 n2103 0.14583333333333334
r3042 n2102 n2103 0.050000000000000003
r3043 n2085 n2104 0.4375
r3044 n2103 n2104 0.050000000000000003
r3045 n2086 n2105 0.048611111111111112
r3046 n2104 n2105 0.125
r3047 n2087 n2106 0.043749999999999997
r3048 n2105 n2106 0.23749999999999999
r3049 n2088 n2107 0.087499999999999994
r3050 n2106 n2107 0.1875
r3051 n2089 n2108 0.087499999999999994
r3052 n2107 n2108 0.125
r3053 n2090 n2109 0.4375
r3054 n2108 n2109 0.074999999999999997
r3055 n2091 n2110 0.21875
r3056 n2109 n2110 0.037499999999999999
r3057 n2092 n2111 0.4375
r3058 n2110 n2111 0.037499999999999999
r3059 n2093 n2112 0.4375
r3060 n2111 n2112 0.025000000000000001
r3061 n2094 n2113 0.4375
r3062 n2112 n2113 0.025000000000000001
r3063 n2095 n2114 0.109375
r3064 n2113 n2114 0.0625
r3065 n2096 n2115 0.087499999999999994
r3066 n2114 n2115 0.1125
r3067 n2097 n2116 0.4375
r3068 n2115 n2116 0.074999999999999997
r3069 n2098 n2117 0.043749999999999997
r3070 n2116 n2117 0.13750000000000001
r3071 n2118 n2119 0.11458333333333333
r3072 n2119 n2120 0.0625
r3073 n2120 n2121 0.14583333333333334
r3074 n2099 n2122 0.068750000000000006
r3075 n2121 n2122 0.23958333333333334
r3076 n2100 n2123 0.13750000000000001
r3077 n2122 n2123 0.15625
r3078 n2101 n2124 0.13750000000000001
r3079 n2123 n2124 0.10416666666666667
r3080 n2102 n2125 0.6875
r3081 n2124 n2125 0.0625
r3082 n2103 n2126 0.22916666666666666
r3083 n2125 n2126 0.041666666666666664
r3084 n2104 n2127 0.6875
r3085 n2126 n2127 0.041666666666666664
r3086 n2105 n2128 0.076388888888888895
r3087 n2127 n2128 0.10416666666666667
r3088 n2106 n2129 0.068750000000000006
r3089 n2128 n2129 0.19791666666666666
r3090 n2107 n2130 0.13750000000000001
r3091 n2129 n2130 0.15625
r3092 n2108 n2131 0.13750000000000001
r3093 n2130 n2131 0.10416666666666667
r3094 n2109 n2132 0.6875
r3095 n2131 n2132 0.0625
r3096 n2110 n2133 0.34375
r3097 n2132 n2133 0.03125
r3098 n2111 n2134 0.6875
r3099 n2133 n2134 0.03125
r3100 n2112 n2135 0.6875
r3101 n2134 n2135 0.020833333333333332
r3102 n2113 n2136 0.6875
r3103 n2135 n2136 0.020833333333333332
r3104 n2114 n2137 0.171875
r3105 n2136 n2137 0.052083333333333336
r3106 n2115 n2138 0.13750000000000001
r3107 n2137 n2138 0.09375
r3108 n2116 n2139 0.6875
r3109 n2138 n2139 0.0625
r3110 n2117 n2140 0.068750000000000006
r3111 n2139 n2140 0.11458333333333333
r3112 n2140 n2141 0.13541666666666666
r3113 n2141 n2142 0.09375
r3114 n2142 n2143 0.083333333333333329
r3115 n2143 n2144 0.03125
r3116 n2144 n2145 0.020833333333333332
r3117 n2145 n2146 0.072916666666666671
r3118 n2146 n2147 0.11458333333333333
r3119 n2147 n2148 0.0625
r3120 n2118 n2149 0.083333333333333329
r3121 n2119 n2150 0.10000000000000001
r3122 n2149 n2150 0.34375
r3123 n2120 n2151 0.5
r3124 n2150 n2151 0.1875
r3125 n2121 n2152 0.038461538461538464
r3126 n2151 n2152 0.4375
r3127 n2122 n2153 0.050000000000000003
r3128 n2152 n2153 0.71875
r3129 n2123 n2154 0.10000000000000001
r3130 n2153 n2154 0.46875
r3131 n2124 n2155 0.10000000000000001
r3132 n2154 n2155 0.3125
r3133 n2125 n2156 0.5
r3134 n2155 n2156 0.1875
r3135 n2126 n2157 0.16666666666666666
r3136 n2156 n2157 0.125
r3137 n2127 n2158 0.5
r3138 n2157 n2158 0.125
r3139 n2128 n2159 0.055555555555555552
r3140 n2158 n2159 0.3125
r3141 n2129 n2160 0.050000000000000003
r3142 n2159 n2160 0.59375
r3143 n2130 n2161 0.10000000000000001
r3144 n2160 n2161 0.46875
r3145 n2131 n2162 0.10000000000000001
r3146 n2161 n2162 0.3125
r3147 n2132 n2163 0.5
r3148 n2162 n2163 0.1875
r3149 n2133 n2164 0.25
r3150 n2163 n2164 0.09375
r3151 n2134 n2165 0.5
r3152 n2164 n2165 0.09375
r3153 n2135 n2166 0.5
r3154 n2165 n2166 0.0625
r3155 n2136 n2167 0.5
r3156 n2166 n2167 0.0625
r3157 n2137 n2168 0.125
r3158 n2167 n2168 0.15625
r3159 n2138 n2169 0.10000000000000001
r3160 n2168 n2169 0.28125
r3161 n2139 n2170 0.5
r3162 n2169 n2170 0.1875
r3163 n2140 n2171 0.050000000000000003
r3164 n2170 n2171 0.34375
r3165 n2141 n2172 0.16666666666666666
r3166 n2171 n2172 0.40625
r3167 n2142 n2173 0.083333333333333329
r3168 n2172 n2173 0.28125
r3169 n2143 n2174 0.25
r3170 n2173 n2174 0.25
r3171 n2144 n2175 0.5
r3172 n2174 n2175 0.09375
r3173 n2145 n2176 0.5
r3174 n2175 n2176 0.0625
r3175 n2146 n2177 0.083333333333333329
r3176 n2176 n2177 0.21875
r3177 n2147 n2178 0.10000000000000001
r3178 n2177 n2178 0.34375
r3179 n2148 n2179 0.5
r3180 n2178 n2179 0.1875
r3181 n2149 n2180 0.1875
r3182 n2150 n2181 0.22500000000000001
r3183 n2180 n2181 0.04296875
r3184 n2151 n2182 1.125
r3185 n2181 n2182 0.0234375
r3186 n2152 n2183 0.086538461538461536
r3187 n2182 n2183 0.0546875
r3188 n2153 n2184 0.1125
r3189 n2183 n2184 0.08984375
r3190 n2154 n2185 0.22500000000000001
r3191 n2184 n2185 0.05859375
r3192 n2155 n2186 0.22500000000000001
r3193 n2185 n2186 0.0390625
r3194 n2156 n2187 1.125
r3195 n2186 n2187 0.0234375
r3196 n2157 n2188 0.375
r3197 n2187 n2188 0.015625
r3198 n2158 n2189 1.125
r3199 n2188 n2189 0.015625
r3200 n2159 n2190 0.125
r3201 n2189 n2190 0.0390625
r3202 n2160 n2191 0.1125
r3203 n2190 n2191 0.07421875
r3204 n2161 n2192 0.22500000000000001
r3205 n2191 n2192 0.05859375
r3206 n2162 n2193 0.22500000000000001
r3207 n2192 n2193 0.0390625
r3208 n2163 n2194 1.125
r3209 n2193 n2194 0.0234375
r3210 n2164 n2195 0.5625
r3211 n2194 n2195 0.01171875
r3212 n2165 n2196 1.125
r3213 n2195 n2196 0.01171875
r3214 n2166 n2197 1.125
r3215 n2196 n2197 0.0078125
r3216 n2167 n2198 1.125
r3217 n2197 n2198 0.0078125
r3218 n2168 n2199 0.28125
r3219 n2198 n2199 0.01953125
r3220 n2169 n2200 0.22500000000000001
r3221 n2199 n2200 0.03515625
r3222 n2170 n2201 1.125
r3223 n2200 n2201 0.0234375
r3224 n2171 n2202 0.1125
r3225 n2201 n2202 0.04296875
r3226 n2172 n2203 0.375
r3227 n2202 n2203 0.05078125
r3228 n2173 n2204 0.1875
r3229 n2203 n2204 0.03515625
r3230 n2174 n2205 0.5625
r3231 n2204 n2205 0.03125
r3232 n2175 n2206 1.125
r3233 n2205 n2206 0.01171875
r3234 n2176 n2207 1.125
r3235 n2206 n2207 0.0078125
r3236 n2177 n2208 0.1875
r3237 n2207 n2208 0.02734375
r3238 n2178 n2209 0.22500000000000001
r3239 n2208 n2209 0.04296875
r3240 n2179 n2210 1.125
r3241 n2209 n2210 0.0234375
r3242 n2180 n2211 0.3125
r3243 n2181 n2212 0.375
r3244 n2211 n2212 0.049107142857142856
r3245 n2182 n2213 1.875
r3246 n2212 n2213 0.026785714285714284
r3247 n2183 n2214 0.14423076923076922
r3248 n2213 n2214 0.0625
r3249 n2184 n2215 0.1875
r3250 n2214 n2215 0.10267857142857142
r3251 n2185 n2216 0.375
r3252 n2215 n2216 0.066964285714285712
r3253 n2186 n2217 0.375
r3254 n2216 n2217 0.044642857142857144
r3255 n2187 n2218 1.875
r3256 n2217 n2218 0.026785714285714284
r3257 n2188 n2219 0.625
r3258 n2218 n2219 0.017857142857142856
r3259 n2189 n2220 1.875
r3260 n2219 n2220 0.017857142857142856
r3261 n2190 n2221 0.20833333333333334
r3262 n2220 n2221 0.044642857142857144
r3263 n2191 n2222 0.1875
r3264 n2221 n2222 0.084821428571428575
r3265 n2192 n2223 0.375
r3266 n2222 n2223 0.066964285714285712
r3267 n2193 n2224 0.375
r3268 n2223 n2224 0.044642857142857144
r3269 n2194 n2225 1.875
r3270 n2224 n2225 0.026785714285714284
r3271 n2195 n2226 0.9375
r3272 n2225 n2226 0.013392857142857142
r3273 n2196 n2227 1.875
r3274 n2226 n2227 0.013392857142857142
r3275 n2197 n2228 1.875
r3276 n2227 n2228 0.0089285714285714281
r3277 n2198 n2229 1.875
r3278 n2228 n2229 0.0089285714285714281
r3279 n2199 n2230 0.46875
r3280 n2229 n2230 0.022321428571428572
r3281 n2200 n2231 0.375
r3282 n2230 n2231 0.040178571428571432
r3283 n2201 n2232 1.875
r3284 n2231 n2232 0.026785714285714284
r3285 n2202 n2233 0.1875
r3286 n2232 n2233 0.049107142857142856
r3287 n2203 n2234 0.625
r3288 n2233 n2234 0.058035714285714288
r3289 n2204 n2235 0.3125
r3290 n2234 n2235 0.040178571428571432
r3291 n2205 n2236 0.9375
r3292 n2235 n2236 0.035714285714285712
r3293 n2206 n2237 1.875
r3294 n2236 n2237 0.013392857142857142
r3295 n2207 n2238 1.875
r3296 n2237 n2238 0.0089285714285714281
r3297 n2208 n2239 0.3125
r3298 n2238 n2239 0.03125
r3299 n2209 n2240 0.375
r3300 n2239 n2240 0.049107142857142856
r3301 n2210 n2241 1.875
r3302 n2240 n2241 0.026785714285714284
r3303 n2211 n2242 0.16666666666666666
r3304 n2212 n2243 0.20000000000000001
r3305 n2242 n2243 0.34375
r3306 n2213 n2244 1
r3307 n2243 n2244 0.1875
r3308 n2214 n2245 0.076923076923076927
r3309 n2244 n2245 0.4375
r3310 n2215 n2246 0.10000000000000001
r3311 n2245 n2246 0.71875
r3312 n2216 n2247 0.20000000000000001
r3313 n2246 n2247 0.46875
r3314 n2217 n2248 0.20000000000000001
r3315 n2247 n2248 0.3125
r3316 n2218 n2249 1
r3317 n2248 n2249 0.1875
r3318 n2219 n2250 0.33333333333333331
r3319 n2249 n2250 0.125
r3320 n2220 n2251 1
r3321 n2250 n2251 0.125
r3322 n2221 n2252 0.1111111111111111
r3323 n2251 n2252 0.3125
r3324 n2222 n2253 0.10000000000000001
r3325 n2252 n2253 0.59375
r3326 n2223 n2254 0.20000000000000001
r3327 n2253 n2254 0.46875
r3328 n2224 n2255 0.20000000000000001
r3329 n2254 n2255 0.3125
r3330 n2225 n2256 1
r3331 n2255 n2256 0.1875
r3332 n2226 n2257 0.5
r3333 n2256 n2257 0.09375
r3334 n2227 n2258 1
r3335 n2257 n2258 0.09375
r3336 n2228 n2259 1
r3337 n2258 n2259 0.0625
r3338 n2229 n2260 1
r3339 n2259 n2260 0.0625
r3340 n2230 n2261 0.25
r3341 n2260 n2261 0.15625
r3342 n2231 n2262 0.20000000000000001
r3343 n2261 n2262 0.28125
r3344 n2232 n2263 1
r3345 n2262 n2263 0.1875
r3346 n2233 n2264 0.10000000000000001
r3347 n2263 n2264 0.34375
r3348 n2234 n2265 0.33333333333333331
r3349 n2264 n2265 0.40625
r3350 n2235 n2266 0.16666666666666666
r3351 n2265 n2266 0.28125
r3352 n2236 n2267 0.5
r3353 n2266 n2267 0.25
r3354 n2237 n2268 1
r3355 n2267 n2268 0.09375
r3356 n2238 n2269 1
r3357 n2268 n2269 0.0625
r3358 n2239 n2270 0.16666666666666666
r3359 n2269 n2270 0.21875
r3360 n2240 n2271 0.20000000000000001
r3361 n2270 n2271 0.34375
r3362 n2241 n2272 1
r3363 n2271 n2272 0.1875
r3364 n2242 n2273 0.0625
r3365 n2243 n2274 0.074999999999999997
r3366 n2273 n2274 0.171875
r3367 n2244 n2275 0.375
r3368 n2274 n2275 0.09375
r3369 n2245 n2276 0.028846153846153848
r3370 n2275 n2276 0.21875
r3371 n2246 n2277 0.037499999999999999
r3372 n2276 n2277 0.359375
r3373 n2247 n2278 0.074999999999999997
r3374 n2277 n2278 0.234375
r3375 n2248 n2279 0.074999999999999997
r3376 n2278 n2279 0.15625
r3377 n2249 n2280 0.375
r3378 n2279 n2280 0.09375
r3379 n2250 n2281 0.125
r3380 n2280 n2281 0.0625
r3381 n2251 n2282 0.375
r3382 n2281 n2282 0.0625
r3383 n2252 n2283 0.041666666666666664
r3384 n2282 n2283 0.15625
r3385 n2253 n2284 0.037499999999999999
r3386 n2283 n2284 0.296875
r3387 n2254 n2285 0.074999999999999997
r3388 n2284 n2285 0.234375
r3389 n2255 n2286 0.074999999999999997
r3390 n2285 n2286 0.15625
r3391 n2256 n2287 0.375
r3392 n2286 n2287 0.09375
r3393 n2257 n2288 0.1875
r3394 n2287 n2288 0.046875
r3395 n2258 n2289 0.375
r3396 n2288 n2289 0.046875
r3397 n2259 n2290 0.375
r3398 n2289 n2290 0.03125
r3399 n2260 n2291 0.375
r3400 n2290 n2291 0.03125
r3401 n2261 n2292 0.09375
r3402 n2291 n2292 0.078125
r3403 n2262 n2293 0.074999999999999997
r3404 n2292 n2293 0.140625
r3405 n2263 n2294 0.375
r3406 n2293 n2294 0.09375
r3407 n2264 n2295 0.037499999999999999
r3408 n2294 n2295 0.171875
r3409 n2265 n2296 0.125
r3410 n2295 n2296 0.203125
r3411 n2266 n2297 0.0625
r3412 n2296 n2297 0.140625
r3413 n2267 n2298 0.1875
r3414 n2297 n2298 0.125
r3415 n2268 n2299 0.375
r3416 n2298 n2299 0.046875
r3417 n2269 n2300 0.375
r3418 n2299 n2300 0.03125
r3419 n2270 n2301 0.0625
r3420 n2300 n2301 0.109375
r3421 n2271 n2302 0.074999999999999997
r3422 n2301 n2302 0.171875
r3423 n2272 n2303 0.375
r3424 n2302 n2303 0.09375
r3425 n2304 n2305 0.125
r3426 n2305 n2306 0.296875
r3427 n2306 n2307 0.46875
r3428 n2307 n2308 0.234375
r3429 n2308 n2309 0.0625
r3430 n2309 n2310 0.09375
r3431 n2273 n2311 0.0625
r3432 n2274 n2312 0.074999999999999997
r3433 n2311 n2312 0.34375
r3434 n2275 n2313 0.375
r3435 n2312 n2313 0.1875
r3436 n2276 n2314 0.028846153846153848
r3437 n2313 n2314 0.4375
r3438 n2277 n2315 0.037499999999999999
r3439 n2314 n2315 0.71875
r3440 n2278 n2316 0.074999999999999997
r3441 n2315 n2316 0.46875
r3442 n2279 n2317 0.074999999999999997
r3443 n2316 n2317 0.3125
r3444 n2280 n2318 0.375
r3445 n2317 n2318 0.1875
r3446 n2281 n2319 0.125
r3447 n2318 n2319 0.125
r3448 n2282 n2320 0.375
r3449 n2319 n2320 0.125
r3450 n2283 n2321 0.041666666666666664
r3451 n2320 n2321 0.3125
r3452 n2284 n2322 0.037499999999999999
r3453 n2321 n2322 0.59375
r3454 n2285 n2323 0.074999999999999997
r3455 n2322 n2323 0.46875
r3456 n2286 n2324 0.074999999999999997
r3457 n2323 n2324 0.3125
r3458 n2287 n2325 0.375
r3459 n2324 n2325 0.1875
r3460 n2288 n2326 0.1875
r3461 n2325 n2326 0.09375
r3462 n2289 n2327 0.375
r3463 n2326 n2327 0.09375
r3464 n2290 n2328 0.375
r3465 n2327 n2328 0.0625
r3466 n2291 n2329 0.375
r3467 n2328 n2329 0.0625
r3468 n2292 n2330 0.09375
r3469 n2329 n2330 0.15625
r3470 n2293 n2331 0.074999999999999997
r3471 n2330 n2331 0.28125
r3472 n2294 n2332 0.375
r3473 n2331 n2332 0.1875
r3474 n2295 n2333 0.037499999999999999
r3475 n2332 n2333 0.34375
r3476 n2296 n2334 0.125
r3477 n2333 n2334 0.40625
r3478 n2297 n2335 0.0625
r3479 n2334 n2335 0.28125
r3480 n2298 n2336 0.1875
r3481 n2335 n2336 0.25
r3482 n2299 n2337 0.375
r3483 n2336 n2337 0.09375
r3484 n2300 n2338 0.375
r3485 n2337 n2338 0.0625
r3486 n2301 n2339 0.0625
r3487 n2338 n2339 0.21875
r3488 n2302 n2340 0.074999999999999997
r3489 n2339 n2340 0.34375
r3490 n2303 n2341 0.375
r3491 n2340 n2341 0.1875
r3492 n2304 n2342 0.0625
r3493 n2305 n2343 0.1875
r3494 n2342 n2343 0.25
r3495 n2306 n2344 0.022058823529411766
r3496 n2343 n2344 0.59375
r3497 n2307 n2345 0.028846153846153848
r3498 n2344 n2345 0.9375
r3499 n2308 n2346 0.1875
r3500 n2345 n2346 0.46875
r3501 n2309 n2347 0.1875
r3502 n2346 n2347 0.125
r3503 n2310 n2348 0.09375
r3504 n2347 n2348 0.1875
r3505 n2315 n2349 0.018749999999999999
r3506 n2316 n2350 0.037499999999999999
r3507 n2349 n2350 0.9375
r3508 n2317 n2351 0.037499999999999999
r3509 n2350 n2351 0.625
r3510 n2318 n2352 0.1875
r3511 n2351 n2352 0.375
r3512 n2319 n2353 0.0625
r3513 n2352 n2353 0.25
r3514 n2320 n2354 0.1875
r3515 n2353 n2354 0.25
r3516 n2321 n2355 0.020833333333333332
r3517 n2354 n2355 0.625
r3518 n2322 n2356 0.018749999999999999
r3519 n2355 n2356 1.1875
r3520 n2323 n2357 0.037499999999999999
r3521 n2356 n2357 0.9375
r3522 n2324 n2358 0.037499999999999999
r3523 n2357 n2358 0.625
r3524 n2325 n2359 0.1875
r3525 n2358 n2359 0.375
r3526 n2326 n2360 0.09375
r3527 n2359 n2360 0.1875
r3528 n2327 n2361 0.1875
r3529 n2360 n2361 0.1875
r3530 n2328 n2362 0.1875
r3531 n2361 n2362 0.125
r3532 n2329 n2363 0.1875
r3533 n2362 n2363 0.125
r3534 n2330 n2364 0.046875
r3535 n2363 n2364 0.3125
r3536 n2331 n2365 0.037499999999999999
r3537 n2364 n2365 0.5625
r3538 n2332 n2366 0.1875
r3539 n2365 n2366 0.375
r3540 n2333 n2367 0.018749999999999999
r3541 n2366 n2367 0.6875
r3542 n2342 n2368 0.03125
r3543 n2343 n2369 0.09375
r3544 n2368 n2369 0.5
r3545 n2344 n2370 0.011029411764705883
r3546 n2369 n2370 1.1875
r3547 n2345 n2371 0.014423076923076924
r3548 n2370 n2371 1.875
r3549 n2346 n2372 0.09375
r3550 n2371 n2372 0.9375
r3551 n2347 n2373 0.09375
r3552 n2372 n2373 0.25
r3553 n2348 n2374 0.046875
r3554 n2373 n2374 0.375
r3555 n2349 n2375 0.03125
r3556 n2350 n2376 0.0625
r3557 n2375 n2376 0.234375
r3558 n2351 n2377 0.0625
r3559 n2376 n2377 0.15625
r3560 n2352 n2378 0.3125
r3561 n2377 n2378 0.09375
r3562 n2353 n2379 0.10416666666666667
r3563 n2378 n2379 0.0625
r3564 n2354 n2380 0.3125
r3565 n2379 n2380 0.0625
r3566 n2355 n2381 0.034722222222222224
r3567 n2380 n2381 0.15625
r3568 n2356 n2382 0.03125
r3569 n2381 n2382 0.296875
r3570 n2357 n2383 0.0625
r3571 n2382 n2383 0.234375
r3572 n2358 n2384 0.0625
r3573 n2383 n2384 0.15625
r3574 n2359 n2385 0.3125
r3575 n2384 n2385 0.09375
r3576 n2360 n2386 0.15625
r3577 n2385 n2386 0.046875
r3578 n2361 n2387 0.3125
r3579 n2386 n2387 0.046875
r3580 n2362 n2388 0.3125
r3581 n2387 n2388 0.03125
r3582 n2363 n2389 0.3125
r3583 n2388 n2389 0.03125
r3584 n2364 n2390 0.078125
r3585 n2389 n2390 0.078125
r3586 n2365 n2391 0.0625
r3587 n2390 n2391 0.140625
r3588 n2366 n2392 0.3125
r3589 n2391 n2392 0.09375
r3590 n2367 n2393 0.03125
r3591 n2392 n2393 0.171875
r3592 n2394 n2395 0.1875
r3593 n2395 n2396 0.203125
r3594 n2368 n2397 0.052083333333333336
r3595 n2396 n2397 0.171875
r3596 n2369 n2398 0.15625
r3597 n2397 n2398 0.125
r3598 n2370 n2399 0.018382352941176471
r3599 n2398 n2399 0.296875
r3600 n2371 n2400 0.02403846153846154
r3601 n2399 n2400 0.46875
r3602 n2372 n2401 0.15625
r3603 n2400 n2401 0.234375
r3604 n2373 n2402 0.15625
r3605 n2401 n2402 0.0625
r3606 n2374 n2403 0.078125
r3607 n2402 n2403 0.09375
r3608 n2403 n2404 0.140625
r3609 n2404 n2405 0.203125
r3610 n2405 n2406 0.1875
r3611 n2375 n2407 0.037499999999999999
r3612 n2376 n2408 0.074999999999999997
r3613 n2407 n2408 0.46875
r3614 n2377 n2409 0.074999999999999997
r3615 n2408 n2409 0.3125
r3616 n2378 n2410 0.375
r3617 n2409 n2410 0.1875
r3618 n2379 n2411 0.125
r3619 n2410 n2411 0.125
r3620 n2380 n2412 0.375
r3621 n2411 n2412 0.125
r3622 n2381 n2413 0.041666666666666664
r3623 n2412 n2413 0.3125
r3624 n2382 n2414 0.037499999999999999
r3625 n2413 n2414 0.59375
r3626 n2383 n2415 0.074999999999999997
r3627 n2414 n2415 0.46875
r3628 n2384 n2416 0.074999999999999997
r3629 n2415 n2416 0.3125
r3630 n2385 n2417 0.375
r3631 n2416 n2417 0.1875
r3632 n2386 n2418 0.1875
r3633 n2417 n2418 0.09375
r3634 n2387 n2419 0.375
r3635 n2418 n2419 0.09375
r3636 n2388 n2420 0.375
r3637 n2419 n2420 0.0625
r3638 n2389 n2421 0.375
r3639 n2420 n2421 0.0625
r3640 n2390 n2422 0.09375
r3641 n2421 n2422 0.15625
r3642 n2391 n2423 0.074999999999999997
r3643 n2422 n2423 0.28125
r3644 n2392 n2424 0.375
r3645 n2423 n2424 0.1875
r3646 n2393 n2425 0.037499999999999999
r3647 n2424 n2425 0.34375
r3648 n2394 n2426 0.09375
r3649 n2395 n2427 0.046875
r3650 n2426 n2427 0.375
r3651 n2396 n2428 0.074999999999999997
r3652 n2427 n2428 0.40625
r3653 n2397 n2429 0.0625
r3654 n2428 n2429 0.34375
r3655 n2398 n2430 0.1875
r3656 n2429 n2430 0.25
r3657 n2399 n2431 0.022058823529411766
r3658 n2430 n2431 0.59375
r3659 n2400 n2432 0.028846153846153848
r3660 n2431 n2432 0.9375
r3661 n2401 n2433 0.1875
r3662 n2432 n2433 0.46875
r3663 n2402 n2434 0.1875
r3664 n2433 n2434 0.125
r3665 n2403 n2435 0.09375
r3666 n2434 n2435 0.1875
r3667 n2404 n2436 0.074999999999999997
r3668 n2435 n2436 0.28125
r3669 n2405 n2437 0.046875
r3670 n2436 n2437 0.40625
r3671 n2406 n2438 0.09375
r3672 n2437 n2438 0.375
r3673 n2426 n2439 0.109375
r3674 n2427 n2440 0.0546875
r3675 n2439 n2440 0.14999999999999999
r3676 n2428 n2441 0.087499999999999994
r3677 n2440 n2441 0.16250000000000001
r3678 n2429 n2442 0.072916666666666671
r3679 n2441 n2442 0.13750000000000001
r3680 n2430 n2443 0.21875
r3681 n2442 n2443 0.10000000000000001
r3682 n2431 n2444 0.025735294117647058
r3683 n2443 n2444 0.23749999999999999
r3684 n2432 n2445 0.033653846153846152
r3685 n2444 n2445 0.375
r3686 n2433 n2446 0.21875
r3687 n2445 n2446 0.1875
r3688 n2434 n2447 0.21875
r3689 n2446 n2447 0.050000000000000003
r3690 n2435 n2448 0.109375
r3691 n2447 n2448 0.074999999999999997
r3692 n2436 n2449 0.087499999999999994
r3693 n2448 n2449 0.1125
r3694 n2437 n2450 0.0546875
r3695 n2449 n2450 0.16250000000000001
r3696 n2438 n2451 0.109375
r3697 n2450 n2451 0.14999999999999999
r3698 n2439 n2452 0.109375
r3699 n2440 n2453 0.0546875
r3700 n2452 n2453 0.375
r3701 n2441 n2454 0.087499999999999994
r3702 n2453 n2454 0.40625
r3703 n2442 n2455 0.072916666666666671
r3704 n2454 n2455 0.34375
r3705 n2443 n2456 0.21875
r3706 n2455 n2456 0.25
r3707 n2444 n2457 0.025735294117647058
r3708 n2456 n2457 0.59375
r3709 n2445 n2458 0.033653846153846152
r3710 n2457 n2458 0.9375
r3711 n2446 n2459 0.21875
r3712 n2458 n2459 0.46875
r3713 n2447 n2460 0.21875
r3714 n2459 n2460 0.125
r3715 n2448 n2461 0.109375
r3716 n2460 n2461 0.1875
r3717 n2449 n2462 0.087499999999999994
r3718 n2461 n2462 0.28125
r3719 n2450 n2463 0.0546875
r3720 n2462 n2463 0.40625
r3721 n2451 n2464 0.109375
r3722 n2463 n2464 0.375
r3723 n2452 n2465 0.0625
r3724 n2453 n2466 0.03125
r3725 n2465 n2466 0.375
r3726 n2454 n2467 0.050000000000000003
r3727 n2466 n2467 0.40625
r3728 n2455 n2468 0.041666666666666664
r3729 n2467 n2468 0.34375
r3730 n2456 n2469 0.125
r3731 n2468 n2469 0.25
r3732 n2457 n2470 0.014705882352941176
r3733 n2469 n2470 0.59375
r3734 n2458 n2471 0.019230769230769232
r3735 n2470 n2471 0.9375
r3736 n2459 n2472 0.125
r3737 n2471 n2472 0.46875
r3738 n2460 n2473 0.125
r3739 n2472 n2473 0.125
r3740 n2461 n2474 0.0625
r3741 n2473 n2474 0.1875
r3742 n2462 n2475 0.050000000000000003
r3743 n2474 n2475 0.28125
r3744 n2463 n2476 0.03125
r3745 n2475 n2476 0.40625
r3746 n2464 n2477 0.0625
r3747 n2476 n2477 0.375
r3748 n2465 n2478 0.46875
r3749 n2466 n2479 0.234375
r3750 n2478 n2479 0.026785714285714284
r3751 n2467 n2480 0.375
r3752 n2479 n2480 0.029017857142857144
r3753 n2468 n2481 0.3125
r3754 n2480 n2481 0.024553571428571428
r3755 n2469 n2482 0.9375
r3756 n2481 n2482 0.017857142857142856
r3757 n2470 n2483 0.11029411764705882
r3758 n2482 n2483 0.042410714285714288
r3759 n2471 n2484 0.14423076923076922
r3760 n2483 n2484 0.066964285714285712
r3761 n2472 n2485 0.9375
r3762 n2484 n2485 0.033482142857142856
r3763 n2473 n2486 0.9375
r3764 n2485 n2486 0.0089285714285714281
r3765 n2474 n2487 0.46875
r3766 n2486 n2487 0.013392857142857142
r3767 n2475 n2488 0.375
r3768 n2487 n2488 0.020089285714285716
r3769 n2476 n2489 0.234375
r3770 n2488 n2489 0.029017857142857144
r3771 n2477 n2490 0.46875
r3772 n2489 n2490 0.026785714285714284
r3773 n2478 n2491 0.46875
r3774 n2479 n2492 0.234375
r3775 n2491 n2492 0.375
r3776 n2480 n2493 0.375
r3777 n2492 n2493 0.40625
r3778 n2481 n2494 0.3125
r3779 n2493 n2494 0.34375
r3780 n2482 n2495 0.9375
r3781 n2494 n2495 0.25
r3782 n2483 n2496 0.11029411764705882
r3783 n2495 n2496 0.59375
r3784 n2484 n2497 0.14423076923076922
r3785 n2496 n2497 0.9375
r3786 n2485 n2498 0.9375
r3787 n2497 n2498 0.46875
r3788 n2486 n2499 0.9375
r3789 n2498 n2499 0.125
r3790 n2487 n2500 0.46875
r3791 n2499 n2500 0.1875
r3792 n2488 n2501 0.375
r3793 n2500 n2501 0.28125
r3794 n2489 n2502 0.234375
r3795 n2501 n2502 0.40625
r3796 n2490 n2503 0.46875
r3797 n2502 n2503 0.375
r3798 n2491 n2504 0.0625
r3799 n2492 n2505 0.03125
r3800 n2504 n2505 0.375
r3801 n2493 n2506 0.050000000000000003
r3802 n2505 n2506 0.40625
r3803 n2494 n2507 0.041666666666666664
r3804 n2506 n2507 0.34375
r3805 n2495 n2508 0.125
r3806 n2507 n2508 0.25
r3807 n2496 n2509 0.014705882352941176
r3808 n2508 n2509 0.59375
r3809 n2497 n2510 0.019230769230769232
r3810 n2509 n2510 0.9375
r3811 n2498 n2511 0.125
r3812 n2510 n2511 0.46875
r3813 n2499 n2512 0.125
r3814 n2511 n2512 0.125
r3815 n2500 n2513 0.0625
r3816 n2512 n2513 0.1875
r3817 n2501 n2514 0.050000000000000003
r3818 n2513 n2514 0.28125
r3819 n2502 n2515 0.03125
r3820 n2514 n2515 0.40625
r3821 n2503 n2516 0.0625
r3822 n2515 n2516 0.375
r3823 n2504 n2517 0.0625
r3824 n2505 n2518 0.03125
r3825 n2517 n2518 0.375
r3826 n2506 n2519 0.050000000000000003
r3827 n2518 n2519 0.40625
r3828 n2507 n2520 0.041666666666666664
r3829 n2519 n2520 0.34375
r3830 n2508 n2521 0.125
r3831 n2520 n2521 0.25
r3832 n2509 n2522 0.014705882352941176
r3833 n2521 n2522 0.59375
r3834 n2510 n2523 0.019230769230769232
r3835 n2522 n2523 0.9375
r3836 n2511 n2524 0.125
r3837 n2523 n2524 0.46875
r3838 n2512 n2525 0.125
r3839 n2524 n2525 0.125
r3840 n2513 n2526 0.0625
r3841 n2525 n2526 0.1875
r3842 n2514 n2527 0.050000000000000003
r3843 n2526 n2527 0.28125
r3844 n2515 n2528 0.03125
r3845 n2527 n2528 0.40625
r3846 n2516 n2529 0.0625
r3847 n2528 n2529 0.375
r3848 n2517 n2530 0.09375
r3849 n2518 n2531 0.046875
r3850 n2530 n2531 0.1875
r3851 n2519 n2532 0.074999999999999997
r3852 n2531 n2532 0.203125
r3853 n2520 n2533 0.0625
r3854 n2532 n2533 0.171875
r3855 n2521 n2534 0.1875
r3856 n2533 n2534 0.125
r3857 n2522 n2535 0.022058823529411766
r3858 n2534 n2535 0.296875
r3859 n2523 n2536 0.028846153846153848
r3860 n2535 n2536 0.46875
r3861 n2524 n2537 0.1875
r3862 n2536 n2537 0.234375
r3863 n2525 n2538 0.1875
r3864 n2537 n2538 0.0625
r3865 n2526 n2539 0.09375
r3866 n2538 n2539 0.09375
r3867 n2527 n2540 0.074999999999999997
r3868 n2539 n2540 0.140625
r3869 n2528 n2541 0.046875
r3870 n2540 n2541 0.203125
r3871 n2529 n2542 0.09375
r3872 n2541 n2542 0.1875
r3873 n2543 n2544 0.13392857142857142
r3874 n2544 n2545 0.089285714285714288
r3875 n2545 n2546 0.053571428571428568
r3876 n2546 n2547 0.035714285714285712
r3877 n2547 n2548 0.035714285714285712
r3878 n2548 n2549 0.089285714285714288
r3879 n2549 n2550 0.16964285714285715
r3880 n2550 n2551 0.13392857142857142
r3881 n2551 n2552 0.089285714285714288
r3882 n2552 n2553 0.053571428571428568
r3883 n2553 n2554 0.026785714285714284
r3884 n2554 n2555 0.026785714285714284
r3885 n2555 n2556 0.017857142857142856
r3886 n2556 n2557 0.017857142857142856
r3887 n2557 n2558 0.044642857142857144
r3888 n2558 n2559 0.080357142857142863
r3889 n2559 n2560 0.053571428571428568
r3890 n2560 n2561 0.098214285714285712
r3891 n2530 n2562 0.171875
r3892 n2531 n2563 0.0859375
r3893 n2562 n2563 0.10714285714285714
r3894 n2532 n2564 0.13750000000000001
r3895 n2563 n2564 0.11607142857142858
r3896 n2533 n2565 0.11458333333333333
r3897 n2564 n2565 0.098214285714285712
r3898 n2534 n2566 0.34375
r3899 n2565 n2566 0.071428571428571425
r3900 n2535 n2567 0.040441176470588237
r3901 n2566 n2567 0.16964285714285715
r3902 n2536 n2568 0.052884615384615384
r3903 n2567 n2568 0.26785714285714285
r3904 n2537 n2569 0.34375
r3905 n2568 n2569 0.13392857142857142
r3906 n2538 n2570 0.34375
r3907 n2569 n2570 0.035714285714285712
r3908 n2539 n2571 0.171875
r3909 n2570 n2571 0.053571428571428568
r3910 n2540 n2572 0.13750000000000001
r3911 n2571 n2572 0.080357142857142863
r3912 n2541 n2573 0.0859375
r3913 n2572 n2573 0.11607142857142858
r3914 n2542 n2574 0.171875
r3915 n2573 n2574 0.10714285714285714
r3916 n2575 n2576 0.22916666666666666
r3917 n2576 n2577 0.125
r3918 n2577 n2578 0.29166666666666669
r3919 n2543 n2579 0.0625
r3920 n2578 n2579 0.47916666666666669
r3921 n2544 n2580 0.125
r3922 n2579 n2580 0.3125
r3923 n2545 n2581 0.125
r3924 n2580 n2581 0.20833333333333334
r3925 n2546 n2582 0.625
r3926 n2581 n2582 0.125
r3927 n2547 n2583 0.20833333333333334
r3928 n2582 n2583 0.083333333333333329
r3929 n2548 n2584 0.625
r3930 n2583 n2584 0.083333333333333329
r3931 n2549 n2585 0.069444444444444448
r3932 n2584 n2585 0.20833333333333334
r3933 n2550 n2586 0.0625
r3934 n2585 n2586 0.39583333333333331
r3935 n2551 n2587 0.125
r3936 n2586 n2587 0.3125
r3937 n2552 n2588 0.125
r3938 n2587 n2588 0.20833333333333334
r3939 n2553 n2589 0.625
r3940 n2588 n2589 0.125
r3941 n2554 n2590 0.3125
r3942 n2589 n2590 0.0625
r3943 n2555 n2591 0.625
r3944 n2590 n2591 0.0625
r3945 n2556 n2592 0.625
r3946 n2591 n2592 0.041666666666666664
r3947 n2557 n2593 0.625
r3948 n2592 n2593 0.041666666666666664
r3949 n2558 n2594 0.15625
r3950 n2593 n2594 0.10416666666666667
r3951 n2559 n2595 0.125
r3952 n2594 n2595 0.1875
r3953 n2560 n2596 0.625
r3954 n2595 n2596 0.125
r3955 n2561 n2597 0.0625
r3956 n2596 n2597 0.22916666666666666
r3957 n2597 n2598 0.27083333333333331
r3958 n2598 n2599 0.1875
r3959 n2599 n2600 0.16666666666666666
r3960 n2600 n2601 0.0625
r3961 n2601 n2602 0.041666666666666664
r3962 n2602 n2603 0.14583333333333334
r3963 n2603 n2604 0.22916666666666666
r3964 n2604 n2605 0.125
r3965 n2565 n2606 0.10416666666666667
r3966 n2566 n2607 0.3125
r3967 n2606 n2607 0.16666666666666666
r3968 n2567 n2608 0.036764705882352942
r3969 n2607 n2608 0.39583333333333331
r3970 n2568 n2609 0.04807692307692308
r3971 n2608 n2609 0.625
r3972 n2569 n2610 0.3125
r3973 n2609 n2610 0.3125
r3974 n2570 n2611 0.3125
r3975 n2610 n2611 0.083333333333333329
r3976 n2571 n2612 0.15625
r3977 n2611 n2612 0.125
r3978 n2575 n2613 0.0625
r3979 n2576 n2614 0.074999999999999997
r3980 n2613 n2614 0.22916666666666666
r3981 n2577 n2615 0.375
r3982 n2614 n2615 0.125
r3983 n2578 n2616 0.028846153846153848
r3984 n2615 n2616 0.29166666666666669
r3985 n2579 n2617 0.037499999999999999
r3986 n2616 n2617 0.47916666666666669
r3987 n2580 n2618 0.074999999999999997
r3988 n2617 n2618 0.3125
r3989 n2581 n2619 0.074999999999999997
r3990 n2618 n2619 0.20833333333333334
r3991 n2582 n2620 0.375
r3992 n2619 n2620 0.125
r3993 n2583 n2621 0.125
r3994 n2620 n2621 0.083333333333333329
r3995 n2584 n2622 0.375
r3996 n2621 n2622 0.083333333333333329
r3997 n2585 n2623 0.041666666666666664
r3998 n2622 n2623 0.20833333333333334
r3999 n2586 n2624 0.037499999999999999
r4000 n2623 n2624 0.39583333333333331
r4001 n2587 n2625 0.074999999999999997
r4002 n2624 n2625 0.3125
r4003 n2588 n2626 0.074999999999999997
r4004 n2625 n2626 0.20833333333333334
r4005 n2589 n2627 0.375
r4006 n2626 n2627 0.125
r4007 n2590 n2628 0.1875
r4008 n2627 n2628 0.0625
r4009 n2591 n2629 0.375
r4010 n2628 n2629 0.0625
r4011 n2592 n2630 0.375
r4012 n2629 n2630 0.041666666666666664
r4013 n2593 n2631 0.375
r4014 n2630 n2631 0.041666666666666664
r4015 n2594 n2632 0.09375
r4016 n2631 n2632 0.10416666666666667
r4017 n2595 n2633 0.074999999999999997
r4018 n2632 n2633 0.1875
r4019 n2596 n2634 0.375
r4020 n2633 n2634 0.125
r4021 n2597 n2635 0.037499999999999999
r4022 n2634 n2635 0.22916666666666666
r4023 n2598 n2636 0.125
r4024 n2635 n2636 0.27083333333333331
r4025 n2599 n2637 0.0625
r4026 n2636 n2637 0.1875
r4027 n2600 n2638 0.1875
r4028 n2637 n2638 0.16666666666666666
r4029 n2601 n2639 0.375
r4030 n2638 n2639 0.0625
r4031 n2602 n2640 0.375
r4032 n2639 n2640 0.041666666666666664
r4033 n2603 n2641 0.0625
r4034 n2640 n2641 0.14583333333333334
r4035 n2604 n2642 0.074999999999999997
r4036 n2641 n2642 0.22916666666666666
r4037 n2605 n2643 0.375
r4038 n2642 n2643 0.125
r4039 n2606 n2644 0.0625
r4040 n2607 n2645 0.1875
r4041 n2644 n2645 0.16666666666666666
r4042 n2608 n2646 0.022058823529411766
r4043 n2645 n2646 0.39583333333333331
r4044 n2609 n2647 0.028846153846153848
r4045 n2646 n2647 0.625
r4046 n2610 n2648 0.1875
r4047 n2647 n2648 0.3125
r4048 n2611 n2649 0.1875
r4049 n2648 n2649 0.083333333333333329
r4050 n2612 n2650 0.09375
r4051 n2649 n2650 0.125
r4052 n2613 n2651 0.052083333333333336
r4053 n2614 n2652 0.0625
r4054 n2651 n2652 0.34375
r4055 n2615 n2653 0.3125
r4056 n2652 n2653 0.1875
r4057 n2616 n2654 0.02403846153846154
r4058 n2653 n2654 0.4375
r4059 n2617 n2655 0.03125
r4060 n2654 n2655 0.71875
r4061 n2618 n2656 0.0625
r4062 n2655 n2656 0.46875
r4063 n2619 n2657 0.0625
r4064 n2656 n2657 0.3125
r4065 n2620 n2658 0.3125
r4066 n2657 n2658 0.1875
r4067 n2621 n2659 0.10416666666666667
r4068 n2658 n2659 0.125
r4069 n2622 n2660 0.3125
r4070 n2659 n2660 0.125
r4071 n2623 n2661 0.034722222222222224
r4072 n2660 n2661 0.3125
r4073 n2624 n2662 0.03125
r4074 n2661 n2662 0.59375
r4075 n2625 n2663 0.0625
r4076 n2662 n2663 0.46875
r4077 n2626 n2664 0.0625
r4078 n2663 n2664 0.3125
r4079 n2627 n2665 0.3125
r4080 n2664 n2665 0.1875
r4081 n2628 n2666 0.15625
r4082 n2665 n2666 0.09375
r4083 n2629 n2667 0.3125
r4084 n2666 n2667 0.09375
r4085 n2630 n2668 0.3125
r4086 n2667 n2668 0.0625
r4087 n2631 n2669 0.3125
r4088 n2668 n2669 0.0625
r4089 n2632 n2670 0.078125
r4090 n2669 n2670 0.15625
r4091 n2633 n2671 0.0625
r4092 n2670 n2671 0.28125
r4093 n2634 n2672 0.3125
r4094 n2671 n2672 0.1875
r4095 n2635 n2673 0.03125
r4096 n2672 n2673 0.34375
r4097 n2636 n2674 0.10416666666666667
r4098 n2673 n2674 0.40625
r4099 n2637 n2675 0.052083333333333336
r4100 n2674 n2675 0.28125
r4101 n2638 n2676 0.15625
r4102 n2675 n2676 0.25
r4103 n2639 n2677 0.3125
r4104 n2676 n2677 0.09375
r4105 n2640 n2678 0.3125
r4106 n2677 n2678 0.0625
r4107 n2641 n2679 0.052083333333333336
r4108 n2678 n2679 0.21875
r4109 n2642 n2680 0.0625
r4110 n2679 n2680 0.34375
r4111 n2643 n2681 0.3125
r4112 n2680 n2681 0.1875
r4113 n2651 n2682 0.17708333333333334
r4114 n2652 n2683 0.21249999999999999
r4115 n2682 n2683 0.04583333333333333
r4116 n2653 n2684 1.0625
r4117 n2683 n2684 0.025000000000000001
r4118 n2654 n2685 0.081730769230769232
r4119 n2684 n2685 0.058333333333333334
r4120 n2655 n2686 0.10625
r4121 n2685 n2686 0.09583333333333334
r4122 n2656 n2687 0.21249999999999999
r4123 n2686 n2687 0.0625
r4124 n2657 n2688 0.21249999999999999
r4125 n2687 n2688 0.041666666666666664
r4126 n2658 n2689 1.0625
r4127 n2688 n2689 0.025000000000000001
r4128 n2659 n2690 0.35416666666666669
r4129 n2689 n2690 0.016666666666666666
r4130 n2660 n2691 1.0625
r4131 n2690 n2691 0.016666666666666666
r4132 n2661 n2692 0.11805555555555555
r4133 n2691 n2692 0.041666666666666664
r4134 n2662 n2693 0.10625
r4135 n2692 n2693 0.079166666666666663
r4136 n2663 n2694 0.21249999999999999
r4137 n2693 n2694 0.0625
r4138 n2664 n2695 0.21249999999999999
r4139 n2694 n2695 0.041666666666666664
r4140 n2665 n2696 1.0625
r4141 n2695 n2696 0.025000000000000001
r4142 n2666 n2697 0.53125
r4143 n2696 n2697 0.012500000000000001
r4144 n2667 n2698 1.0625
r4145 n2697 n2698 0.012500000000000001
r4146 n2668 n2699 1.0625
r4147 n2698 n2699 0.0083333333333333332
r4148 n2669 n2700 1.0625
r4149 n2699 n2700 0.0083333333333333332
r4150 n2670 n2701 0.265625
r4151 n2700 n2701 0.020833333333333332
r4152 n2671 n2702 0.21249999999999999
r4153 n2701 n2702 0.037499999999999999
r4154 n2672 n2703 1.0625
r4155 n2702 n2703 0.025000000000000001
r4156 n2673 n2704 0.10625
r4157 n2703 n2704 0.04583333333333333
r4158 n2674 n2705 0.35416666666666669
r4159 n2704 n2705 0.054166666666666669
r4160 n2675 n2706 0.17708333333333334
r4161 n2705 n2706 0.037499999999999999
r4162 n2676 n2707 0.53125
r4163 n2706 n2707 0.033333333333333333
r4164 n2677 n2708 1.0625
r4165 n2707 n2708 0.012500000000000001
r4166 n2678 n2709 1.0625
r4167 n2708 n2709 0.0083333333333333332
r4168 n2679 n2710 0.17708333333333334
r4169 n2709 n2710 0.029166666666666667
r4170 n2680 n2711 0.21249999999999999
r4171 n2710 n2711 0.04583333333333333
r4172 n2681 n2712 1.0625
r4173 n2711 n2712 0.025000000000000001
r4174 n2682 n2713 0.3125
r4175 n2683 n2714 0.375
r4176 n2713 n2714 0.04583333333333333
r4177 n2684 n2715 1.875
r4178 n2714 n2715 0.025000000000000001
r4179 n2685 n2716 0.14423076923076922
r4180 n2715 n2716 0.058333333333333334
r4181 n2686 n2717 0.1875
r4182 n2716 n2717 0.09583333333333334
r4183 n2687 n2718 0.375
r4184 n2717 n2718 0.0625
r4185 n2688 n2719 0.375
r4186 n2718 n2719 0.041666666666666664
r4187 n2689 n2720 1.875
r4188 n2719 n2720 0.025000000000000001
r4189 n2690 n2721 0.625
r4190 n2720 n2721 0.016666666666666666
r4191 n2691 n2722 1.875
r4192 n2721 n2722 0.016666666666666666
r4193 n2692 n2723 0.20833333333333334
r4194 n2722 n2723 0.041666666666666664
r4195 n2693 n2724 0.1875
r4196 n2723 n2724 0.079166666666666663
r4197 n2694 n2725 0.375
r4198 n2724 n2725 0.0625
r4199 n2695 n2726 0.375
r4200 n2725 n2726 0.041666666666666664
r4201 n2696 n2727 1.875
r4202 n2726 n2727 0.025000000000000001
r4203 n2697 n2728 0.9375
r4204 n2727 n2728 0.012500000000000001
r4205 n2698 n2729 1.875
r4206 n2728 n2729 0.012500000000000001
r4207 n2699 n2730 1.875
r4208 n2729 n2730 0.0083333333333333332
r4209 n2700 n2731 1.875
r4210 n2730 n2731 0.0083333333333333332
r4211 n2701 n2732 0.46875
r4212 n2731 n2732 0.020833333333333332
r4213 n2702 n2733 0.375
r4214 n2732 n2733 0.037499999999999999
r4215 n2703 n2734 1.875
r4216 n2733 n2734 0.025000000000000001
r4217 n2704 n2735 0.1875
r4218 n2734 n2735 0.04583333333333333
r4219 n2705 n2736 0.625
r4220 n2735 n2736 0.054166666666666669
r4221 n2706 n2737 0.3125
r4222 n2736 n2737 0.037499999999999999
r4223 n2707 n2738 0.9375
r4224 n2737 n2738 0.033333333333333333
r4225 n2708 n2739 1.875
r4226 n2738 n2739 0.012500000000000001
r4227 n2709 n2740 1.875
r4228 n2739 n2740 0.0083333333333333332
r4229 n2710 n2741 0.3125
r4230 n2740 n2741 0.029166666666666667
r4231 n2711 n2742 0.375
r4232 n2741 n2742 0.04583333333333333
r4233 n2712 n2743 1.875
r4234 n2742 n2743 0.025000000000000001
r4235 n2713 n2744 0.17708333333333334
r4236 n2714 n2745 0.21249999999999999
r4237 n2744 n2745 0.34375
r4238 n2715 n2746 1.0625
r4239 n2745 n2746 0.1875
r4240 n2716 n2747 0.081730769230769232
r4241 n2746 n2747 0.4375
r4242 n2717 n2748 0.10625
r4243 n2747 n2748 0.71875
r4244 n2718 n2749 0.21249999999999999
r4245 n2748 n2749 0.46875
r4246 n2719 n2750 0.21249999999999999
r4247 n2749 n2750 0.3125
r4248 n2720 n2751 1.0625
r4249 n2750 n2751 0.1875
r4250 n2721 n2752 0.35416666666666669
r4251 n2751 n2752 0.125
r4252 n2722 n2753 1.0625
r4253 n2752 n2753 0.125
r4254 n2723 n2754 0.11805555555555555
r4255 n2753 n2754 0.3125
r4256 n2724 n2755 0.10625
r4257 n2754 n2755 0.59375
r4258 n2725 n2756 0.21249999999999999
r4259 n2755 n2756 0.46875
r4260 n2726 n2757 0.21249999999999999
r4261 n2756 n2757 0.3125
r4262 n2727 n2758 1.0625
r4263 n2757 n2758 0.1875
r4264 n2728 n2759 0.53125
r4265 n2758 n2759 0.09375
r4266 n2729 n2760 1.0625
r4267 n2759 n2760 0.09375
r4268 n2730 n2761 1.0625
r4269 n2760 n2761 0.0625
r4270 n2731 n2762 1.0625
r4271 n2761 n2762 0.0625
r4272 n2732 n2763 0.265625
r4273 n2762 n2763 0.15625
r4274 n2733 n2764 0.21249999999999999
r4275 n2763 n2764 0.28125
r4276 n2734 n2765 1.0625
r4277 n2764 n2765 0.1875
r4278 n2735 n2766 0.10625
r4279 n2765 n2766 0.34375
r4280 n2736 n2767 0.35416666666666669
r4281 n2766 n2767 0.40625
r4282 n2737 n2768 0.17708333333333334
r4283 n2767 n2768 0.28125
r4284 n2738 n2769 0.53125
r4285 n2768 n2769 0.25
r4286 n2739 n2770 1.0625
r4287 n2769 n2770 0.09375
r4288 n2740 n2771 1.0625
r4289 n2770 n2771 0.0625
r4290 n2741 n2772 0.17708333333333334
r4291 n2771 n2772 0.21875
r4292 n2742 n2773 0.21249999999999999
r4293 n2772 n2773 0.34375
r4294 n2743 n2774 1.0625
r4295 n2773 n2774 0.1875
r4296 n2744 n2775 0.052083333333333336
r4297 n2745 n2776 0.0625
r4298 n2775 n2776 0.22916666666666666
r4299 n2746 n2777 0.3125
r4300 n2776 n2777 0.125
r4301 n2747 n2778 0.02403846153846154
r4302 n2777 n2778 0.29166666666666669
r4303 n2748 n2779 0.03125
r4304 n2778 n2779 0.47916666666666669
r4305 n2749 n2780 0.0625
r4306 n2779 n2780 0.3125
r4307 n2750 n2781 0.0625
r4308 n2780 n2781 0.20833333333333334
r4309 n2751 n2782 0.3125
r4310 n2781 n2782 0.125
r4311 n2752 n2783 0.10416666666666667
r4312 n2782 n2783 0.083333333333333329
r4313 n2753 n2784 0.3125
r4314 n2783 n2784 0.083333333333333329
r4315 n2754 n2785 0.034722222222222224
r4316 n2784 n2785 0.20833333333333334
r4317 n2755 n2786 0.03125
r4318 n2785 n2786 0.39583333333333331
r4319 n2756 n2787 0.0625
r4320 n2786 n2787 0.3125
r4321 n2757 n2788 0.0625
r4322 n2787 n2788 0.20833333333333334
r4323 n2758 n2789 0.3125
r4324 n2788 n2789 0.125
r4325 n2759 n2790 0.15625
r4326 n2789 n2790 0.0625
r4327 n2760 n2791 0.3125
r4328 n2790 n2791 0.0625
r4329 n2761 n2792 0.3125
r4330 n2791 n2792 0.041666666666666664
r4331 n2762 n2793 0.3125
r4332 n2792 n2793 0.041666666666666664
r4333 n2763 n2794 0.078125
r4334 n2793 n2794 0.10416666666666667
r4335 n2764 n2795 0.0625
r4336 n2794 n2795 0.1875
r4337 n2765 n2796 0.3125
r4338 n2795 n2796 0.125
r4339 n2766 n2797 0.03125
r4340 n2796 n2797 0.22916666666666666
r4341 n2767 n2798 0.10416666666666667
r4342 n2797 n2798 0.27083333333333331
r4343 n2768 n2799 0.052083333333333336
r4344 n2798 n2799 0.1875
r4345 n2769 n2800 0.15625
r4346 n2799 n2800 0.16666666666666666
r4347 n2770 n2801 0.3125
r4348 n2800 n2801 0.0625
r4349 n2771 n2802 0.3125
r4350 n2801 n2802 0.041666666666666664
r4351 n2772 n2803 0.052083333333333336
r4352 n2802 n2803 0.14583333333333334
r4353 n2773 n2804 0.0625
r4354 n2803 n2804 0.22916666666666666
r4355 n2774 n2805 0.3125
r4356 n2804 n2805 0.125
r4357 n2775 n2806 0.0625
r4358 n2776 n2807 0.074999999999999997
r4359 n2806 n2807 0.22916666666666666
r4360 n2777 n2808 0.375
r4361 n2807 n2808 0.125
r4362 n2778 n2809 0.028846153846153848
r4363 n2808 n2809 0.29166666666666669
r4364 n2779 n2810 0.037499999999999999
r4365 n2809 n2810 0.47916666666666669
r4366 n2780 n2811 0.074999999999999997
r4367 n2810 n2811 0.3125
r4368 n2781 n2812 0.074999999999999997
r4369 n2811 n2812 0.20833333333333334
r4370 n2782 n2813 0.375
r4371 n2812 n2813 0.125
r4372 n2783 n2814 0.125
r4373 n2813 n2814 0.083333333333333329
r4374 n2784 n2815 0.375
r4375 n2814 n2815 0.083333333333333329
r4376 n2785 n2816 0.041666666666666664
r4377 n2815 n2816 0.20833333333333334
r4378 n2786 n2817 0.037499999999999999
r4379 n2816 n2817 0.39583333333333331
r4380 n2787 n2818 0.074999999999999997
r4381 n2817 n2818 0.3125
r4382 n2788 n2819 0.074999999999999997
r4383 n2818 n2819 0.20833333333333334
r4384 n2789 n2820 0.375
r4385 n2819 n2820 0.125
r4386 n2790 n2821 0.1875
r4387 n2820 n2821 0.0625
r4388 n2791 n2822 0.375
r4389 n2821 n2822 0.0625
r4390 n2792 n2823 0.375
r4391 n2822 n2823 0.041666666666666664
r4392 n2793 n2824 0.375
r4393 n2823 n2824 0.041666666666666664
r4394 n2794 n2825 0.09375
r4395 n2824 n2825 0.10416666666666667
r4396 n2795 n2826 0.074999999999999997
r4397 n2825 n2826 0.1875
r4398 n2796 n2827 0.375
r4399 n2826 n2827 0.125
r4400 n2797 n2828 0.037499999999999999
r4401 n2827 n2828 0.22916666666666666
r4402 n2798 n2829 0.125
r4403 n2828 n2829 0.27083333333333331
r4404 n2799 n2830 0.0625
r4405 n2829 n2830 0.1875
r4406 n2800 n2831 0.1875
r4407 n2830 n2831 0.16666666666666666
r4408 n2801 n2832 0.375
r4409 n2831 n2832 0.0625
r4410 n2802 n2833 0.375
r4411 n2832 n2833 0.041666666666666664
r4412 n2803 n2834 0.0625
r4413 n2833 n2834 0.14583333333333334
r4414 n2804 n2835 0.074999999999999997
r4415 n2834 n2835 0.22916666666666666
r4416 n2805 n2836 0.375
r4417 n2835 n2836 0.125
r4418 n2810 n2837 0.0625
r4419 n2811 n2838 0.125
r4420 n2837 n2838 0.13392857142857142
r4421 n2812 n2839 0.125
r4422 n2838 n2839 0.089285714285714288
r4423 n2813 n2840 0.625
r4424 n2839 n2840 0.053571428571428568
r4425 n2814 n2841 0.20833333333333334
r4426 n2840 n2841 0.035714285714285712
r4427 n2815 n2842 0.625
r4428 n2841 n2842 0.035714285714285712
r4429 n2816 n2843 0.069444444444444448
r4430 n2842 n2843 0.089285714285714288
r4431 n2817 n2844 0.0625
r4432 n2843 n2844 0.16964285714285715
r4433 n2818 n2845 0.125
r4434 n2844 n2845 0.13392857142857142
r4435 n2819 n2846 0.125
r4436 n2845 n2846 0.089285714285714288
r4437 n2820 n2847 0.625
r4438 n2846 n2847 0.053571428571428568
r4439 n2821 n2848 0.3125
r4440 n2847 n2848 0.026785714285714284
r4441 n2822 n2849 0.625
r4442 n2848 n2849 0.026785714285714284
r4443 n2823 n2850 0.625
r4444 n2849 n2850 0.017857142857142856
r4445 n2824 n2851 0.625
r4446 n2850 n2851 0.017857142857142856
r4447 n2825 n2852 0.15625
r4448 n2851 n2852 0.044642857142857144
r4449 n2826 n2853 0.125
r4450 n2852 n2853 0.080357142857142863
r4451 n2827 n2854 0.625
r4452 n2853 n2854 0.053571428571428568
r4453 n2828 n2855 0.0625
r4454 n2854 n2855 0.098214285714285712
r4455 n2856 n2857 0.78125
r4456 n2857 n2858 1
r4457 n2858 n2859 1
r4458 n2859 n2860 0.78125
r4459 n2856 n2861 0.035326086956521736
r4460 n2857 n2862 0.40625
r4461 n2861 n2862 0.14204545454545456
r4462 n2858 n2863 0.027083333333333334
r4463 n2862 n2863 0.18181818181818182
r4464 n2859 n2864 0.40625
r4465 n2863 n2864 0.18181818181818182
r4466 n2860 n2865 0.035326086956521736
r4467 n2864 n2865 0.14204545454545456
r4468 n2861 n2866 0.035326086956521736
r4469 n2862 n2867 0.40625
r4470 n2866 n2867 0.78125
r4471 n2863 n2868 0.027083333333333334
r4472 n2867 n2868 1
r4473 n2864 n2869 0.40625
r4474 n2868 n2869 1
r4475 n2865 n2870 0.035326086956521736
r4476 n2869 n2870 0.78125
r4477 n2866 n2871 0.086956521739130432
r4478 n2867 n2872 1
r4479 n2871 n2872 0.052083333333333336
r4480 n2868 n2873 0.066666666666666666
r4481 n2872 n2873 0.066666666666666666
r4482 n2869 n2874 1
r4483 n2873 n2874 0.066666666666666666
r4484 n2870 n2875 0.086956521739130432
r4485 n2874 n2875 0.052083333333333336
r4486 n2871 n2876 0.086956521739130432
r4487 n2872 n2877 1
r4488 n2876 n2877 0.78125
r4489 n2873 n2878 0.066666666666666666
r4490 n2877 n2878 1
r4491 n2874 n2879 1
r4492 n2878 n2879 1
r4493 n2875 n2880 0.086956521739130432
r4494 n2879 n2880 0.78125
r4495 n2876 n2881 0.035326086956521736
r4496 n2877 n2882 0.40625
r4497 n2881 n2882 0.14204545454545456
r4498 n2878 n2883 0.027083333333333334
r4499 n2882 n2883 0.18181818181818182
r4500 n2879 n2884 0.40625
r4501 n2883 n2884 0.18181818181818182
r4502 n2880 n2885 0.035326086956521736
r4503 n2884 n2885 0.14204545454545456
r4504 n2881 n2886 0.035326086956521736
r4505 n2882 n2887 0.40625
r4506 n2886 n2887 0.78125
r4507 n2883 n2888 0.027083333333333334
r4508 n2887 n2888 1
r4509 n2884 n2889 0.40625
r4510 n2888 n2889 1
r4511 n2885 n2890 0.035326086956521736
r4512 n2889 n2890 0.78125
r4513 n2891 n2892 0.3125
r4514 n2892 n2893 0.1875
r4515 n2893 n2894 0.09375
r4516 n2894 n2895 0.09375
r4517 n2895 n2896 0.0625
r4518 n2896 n2897 0.0625
r4519 n2897 n2898 0.15625
r4520 n2898 n2899 0.28125
r4521 n2899 n2900 0.1875
r4522 n2900 n2901 0.34375
r4523 n2901 n2902 0.40625
r4524 n2902 n2903 0.28125
r4525 n2903 n2904 0.25
r4526 n2904 n2905 0.09375
r4527 n2905 n2906 0.0625
r4528 n2906 n2907 0.21875
r4529 n2907 n2908 0.34375
r4530 n2908 n2909 0.1875
r4531 n2909 n2910 0.15625
r4532 n2910 n2911 0.28125
r4533 n2911 n2912 0.25
r4534 n2912 n2913 0.3125
r4535 n2914 n2915 0.78125
r4536 n2915 n2916 1.0625
r4537 n2916 n2917 0.9375
r4538 n2917 n2918 1.0625
r4539 n2918 n2919 0.78125
r4540 n2891 n2920 0.0625
r4541 n2892 n2921 0.0625
r4542 n2920 n2921 0.20833333333333334
r4543 n2893 n2922 0.3125
r4544 n2921 n2922 0.125
r4545 n2894 n2923 0.15625
r4546 n2922 n2923 0.0625
r4547 n2895 n2924 0.3125
r4548 n2923 n2924 0.0625
r4549 n2896 n2925 0.3125
r4550 n2924 n2925 0.041666666666666664
r4551 n2897 n2926 0.3125
r4552 n2925 n2926 0.041666666666666664
r4553 n2898 n2927 0.078125
r4554 n2926 n2927 0.10416666666666667
r4555 n2899 n2928 0.0625
r4556 n2927 n2928 0.1875
r4557 n2900 n2929 0.3125
r4558 n2928 n2929 0.125
r4559 n2901 n2930 0.03125
r4560 n2929 n2930 0.22916666666666666
r4561 n2902 n2931 0.10416666666666667
r4562 n2930 n2931 0.27083333333333331
r4563 n2903 n2932 0.052083333333333336
r4564 n2931 n2932 0.1875
r4565 n2904 n2933 0.15625
r4566 n2932 n2933 0.16666666666666666
r4567 n2905 n2934 0.3125
r4568 n2933 n2934 0.0625
r4569 n2906 n2935 0.3125
r4570 n2934 n2935 0.041666666666666664
r4571 n2907 n2936 0.052083333333333336
r4572 n2935 n2936 0.14583333333333334
r4573 n2908 n2937 0.0625
r4574 n2936 n2937 0.22916666666666666
r4575 n2909 n2938 0.3125
r4576 n2937 n2938 0.125
r4577 n2910 n2939 0.078125
r4578 n2938 n2939 0.10416666666666667
r4579 n2911 n2940 0.0625
r4580 n2939 n2940 0.1875
r4581 n2912 n2941 0.10416666666666667
r4582 n2940 n2941 0.16666666666666666
r4583 n2913 n2942 0.044642857142857144
r4584 n2941 n2942 0.20833333333333334
r4585 n2914 n2943 0.044642857142857144
r4586 n2915 n2944 0.017361111111111112
r4587 n2943 n2944 0.52083333333333337
r4588 n2916 n2945 0.01953125
r4589 n2944 n2945 0.70833333333333337
r4590 n2917 n2946 0.022321428571428572
r4591 n2945 n2946 0.625
r4592 n2918 n2947 0.015625
r4593 n2946 n2947 0.70833333333333337
r4594 n2919 n2948 0.0625
r4595 n2947 n2948 0.52083333333333337
r4596 n2920 t_r1_a 0.10000000000000001
r4597 n2921 t_r1_a 0.10000000000000001
r4598 n2922 t_r1_a 0.5
r4599 n2923 t_r1_a 0.25
r4600 n2924 t_r1_a 0.5
r4601 n2925 t_r1_a 0.5
r4602 n2926 t_r1_a 0.5
r4603 n2927 t_r1_a 0.125
r4604 n2928 t_r1_a 0.10000000000000001
r4605 n2929 t_r1_a 0.5
r4606 n2930 t_r1_a 0.050000000000000003
r4607 n2931 t_r1_a 0.16666666666666666
r4608 n2932 t_r1_a 0.083333333333333329
r4609 n2933 t_r1_a 0.25
r4610 n2934 t_r1_a 0.5
r4611 n2935 t_r1_a 0.5
r4612 n2936 t_r1_a 0.083333333333333329
r4613 n2937 t_r1_a 0.10000000000000001
r4614 n2938 t_r1_a 0.5
r4615 n2939 t_r1_a 0.125
r4616 n2940 t_r1_a 0.10000000000000001
r4617 n2941 t_r1_a 0.16666666666666666
r4618 n2942 t_r1_a 0.071428571428571425
r4619 n2943 t_r1_b 0.071428571428571425
r4620 n2944 t_r1_b 0.027777777777777776
r4621 n2945 t_r1_b 0.03125
r4622 n2946 t_r1_b 0.035714285714285712
r4623 n2947 t_r1_b 0.025000000000000001
r4624 n2948 t_r1_b 0.10000000000000001
r4625 t_r1_a n3516 0.10000000000000001
r4626 t_r1_a n3517 0.10000000000000001
r4627 n3516 n3517 0.20833333333333334
r4628 t_r1_a n3518 0.5
r4629 n3517 n3518 0.125
r4630 t_r1_a n3519 0.25
r4631 n3518 n3519 0.0625
r4632 t_r1_a n3520 0.5
r4633 n3519 n3520 0.0625
r4634 t_r1_a n3521 0.5
r4635 n3520 n3521 0.041666666666666664
r4636 t_r1_a n3522 0.5
r4637 n3521 n3522 0.041666666666666664
r4638 t_r1_a n3523 0.125
r4639 n3522 n3523 0.10416666666666667
r4640 t_r1_a n3524 0.10000000000000001
r4641 n3523 n3524 0.1875
r4642 t_r1_a n3525 0.5
r4643 n3524 n3525 0.125
r4644 t_r1_a n3526 0.050000000000000003
r4645 n3525 n3526 0.22916666666666666
r4646 t_r1_a n3527 0.16666666666666666
r4647 n3526 n3527 0.27083333333333331
r4648 t_r1_a n3528 0.083333333333333329
r4649 n3527 n3528 0.1875
r4650 t_r1_a n3529 0.25
r4651 n3528 n3529 0.16666666666666666
r4652 t_r1_a n3530 0.5
r4653 n3529 n3530 0.0625
r4654 t_r1_a n3531 0.5
r4655 n3530 n3531 0.041666666666666664
r4656 t_r1_a n3532 0.083333333333333329
r4657 n3531 n3532 0.14583333333333334
r4658 t_r1_a n3533 0.10000000000000001
r4659 n3532 n3533 0.22916666666666666
r4660 t_r1_a n3534 0.5
r4661 n3533 n3534 0.125
r4662 t_r1_a n3535 0.125
r4663 n3534 n3535 0.10416666666666667
r4664 t_r1_a n3536 0.10000000000000001
r4665 n3535 n3536 0.1875
r4666 t_r1_a n3537 0.16666666666666666
r4667 n3536 n3537 0.16666666666666666
r4668 t_r1_a n3538 0.071428571428571425
r4669 n3537 n3538 0.20833333333333334
r4670 t_r1_b n3539 0.071428571428571425
r4671 t_r1_b n3540 0.027777777777777776
r4672 n3539 n3540 0.52083333333333337
r4673 t_r1_b n3541 0.03125
r4674 n3540 n3541 0.70833333333333337
r4675 t_r1_b n3542 0.035714285714285712
r4676 n3541 n3542 0.625
r4677 t_r1_b n3543 0.025000000000000001
r4678 n3542 n3543 0.70833333333333337
r4679 t_r1_b n3544 0.10000000000000001
r4680 n3543 n3544 0.52083333333333337
r4681 n3516 n3545 0.0625
r4682 n3517 n3546 0.0625
r4683 n3545 n3546 0.3125
r4684 n3518 n3547 0.3125
r4685 n3546 n3547 0.1875
r4686 n3519 n3548 0.15625
r4687 n3547 n3548 0.09375
r4688 n3520 n3549 0.3125
r4689 n3548 n3549 0.09375
r4690 n3521 n3550 0.3125
r4691 n3549 n3550 0.0625
r4692 n3522 n3551 0.3125
r4693 n3550 n3551 0.0625
r4694 n3523 n3552 0.078125
r4695 n3551 n3552 0.15625
r4696 n3524 n3553 0.0625
r4697 n3552 n3553 0.28125
r4698 n3525 n3554 0.3125
r4699 n3553 n3554 0.1875
r4700 n3526 n3555 0.03125
r4701 n3554 n3555 0.34375
r4702 n3527 n3556 0.10416666666666667
r4703 n3555 n3556 0.40625
r4704 n3528 n3557 0.052083333333333336
r4705 n3556 n3557 0.28125
r4706 n3529 n3558 0.15625
r4707 n3557 n3558 0.25
r4708 n3530 n3559 0.3125
r4709 n3558 n3559 0.09375
r4710 n3531 n3560 0.3125
r4711 n3559 n3560 0.0625
r4712 n3532 n3561 0.052083333333333336
r4713 n3560 n3561 0.21875
r4714 n3533 n3562 0.0625
r4715 n3561 n3562 0.34375
r4716 n3534 n3563 0.3125
r4717 n3562 n3563 0.1875
r4718 n3535 n3564 0.078125
r4719 n3563 n3564 0.15625
r4720 n3536 n3565 0.0625
r4721 n3564 n3565 0.28125
r4722 n3537 n3566 0.10416666666666667
r4723 n3565 n3566 0.25
r4724 n3538 n3567 0.044642857142857144
r4725 n3566 n3567 0.3125
r4726 n3539 n3568 0.044642857142857144
r4727 n3540 n3569 0.017361111111111112
r4728 n3568 n3569 0.78125
r4729 n3541 n3570 0.01953125
r4730 n3569 n3570 1.0625
r4731 n3542 n3571 0.022321428571428572
r4732 n3570 n3571 0.9375
r4733 n3543 n3572 0.015625
r4734 n3571 n3572 1.0625
r4735 n3544 n3573 0.0625
r4736 n3572 n3573 0.78125
r4737 n3574 n3575 0.13437499999999999
r4738 n3575 n3576 0.109375
r4739 n3576 n3577 0.10000000000000001
r4740 n3577 n3578 0.10000000000000001
r4741 n3578 n3579 0.109375
r4742 n3579 n3580 0.13437499999999999
r4743 n3599 n3600 0.0625
r4744 n3600 n3601 0.109375
r4745 n3601 n3602 0.081250000000000003
r4746 n3602 n3603 0.090624999999999997
r4747 n3603 n3604 0.090624999999999997
r4748 n3604 n3605 0.081250000000000003
r4749 n3605 n3606 0.109375
r4750 n3606 n3607 0.0625
r4751 n3574 n3608 0.26874999999999999
r4752 n3575 n3609 0.081439393939393936
r4753 n3608 n3609 0.11684782608695653
r4754 n3576 n3610 1.34375
r4755 n3609 n3610 0.095108695652173919
r4756 n3577 n3611 0.089583333333333334
r4757 n3610 n3611 0.086956521739130432
r4758 n3578 n3612 1.34375
r4759 n3611 n3612 0.086956521739130432
r4760 n3579 n3613 0.081439393939393936
r4761 n3612 n3613 0.095108695652173919
r4762 n3580 n3614 0.26874999999999999
r4763 n3613 n3614 0.11684782608695653
r4764 n3599 n3633 0.26874999999999999
r4765 n3600 n3634 0.26874999999999999
r4766 n3633 n3634 0.05434782608695652
r4767 n3601 n3635 0.1075
r4768 n3634 n3635 0.095108695652173919
r4769 n3602 n3636 2.6875
r4770 n3635 n3636 0.070652173913043473
r4771 n3603 n3637 0.095982142857142863
r4772 n3636 n3637 0.07880434782608696
r4773 n3604 n3638 2.6875
r4774 n3637 n3638 0.07880434782608696
r4775 n3605 n3639 0.1075
r4776 n3638 n3639 0.070652173913043473
r4777 n3606 n3640 0.26874999999999999
r4778 n3639 n3640 0.095108695652173919
r4779 n3607 n3641 0.26874999999999999
r4780 n3640 n3641 0.05434782608695652
r4781 n3608 n3642 0.15625
r4782 n3609 n3643 0.047348484848484848
r4783 n3642 n3643 1.34375
r4784 n3610 n3644 0.78125
r4785 n3643 n3644 1.09375
r4786 n3611 n3645 0.052083333333333336
r4787 n3644 n3645 1
r4788 n3612 n3646 0.78125
r4789 n3645 n3646 1
r4790 n3613 n3647 0.047348484848484848
r4791 n3646 n3647 1.09375
r4792 n3614 n3648 0.15625
r4793 n3647 n3648 1.34375
r4794 n3633 n3667 0.15625
r4795 n3634 n3668 0.15625
r4796 n3667 n3668 0.625
r4797 n3635 n3669 0.0625
r4798 n3668 n3669 1.09375
r4799 n3636 n3670 1.5625
r4800 n3669 n3670 0.8125
r4801 n3637 n3671 0.055803571428571432
r4802 n3670 n3671 0.90625
r4803 n3638 n3672 1.5625
r4804 n3671 n3672 0.90625
r4805 n3639 n3673 0.0625
r4806 n3672 n3673 0.8125
r4807 n3640 n3674 0.15625
r4808 n3673 n3674 1.09375
r4809 n3641 n3675 0.15625
r4810 n3674 n3675 0.625
r4811 n3642 n3676 0.20000000000000001
r4812 n3643 n3677 0.060606060606060608
r4813 n3676 n3677 0.089583333333333334
r4814 n3644 n3678 1
r4815 n3677 n3678 0.072916666666666671
r4816 n3645 n3679 0.066666666666666666
r4817 n3678 n3679 0.066666666666666666
r4818 n3646 n3680 1
r4819 n3679 n3680 0.066666666666666666
r4820 n3647 n3681 0.060606060606060608
r4821 n3680 n3681 0.072916666666666671
r4822 n3648 n3682 0.20000000000000001
r4823 n3681 n3682 0.089583333333333334
r4824 n3667 n3701 0.20000000000000001
r4825 n3668 n3702 0.20000000000000001
r4826 n3701 n3702 0.041666666666666664
r4827 n3669 n3703 0.080000000000000002
r4828 n3702 n3703 0.072916666666666671
r4829 n3670 n3704 2
r4830 n3703 n3704 0.054166666666666669
r4831 n3671 n3705 0.071428571428571425
r4832 n3704 n3705 0.060416666666666667
r4833 n3672 n3706 2
r4834 n3705 n3706 0.060416666666666667
r4835 n3673 n3707 0.080000000000000002
r4836 n3706 n3707 0.054166666666666669
r4837 n3674 n3708 0.20000000000000001
r4838 n3707 n3708 0.072916666666666671
r4839 n3675 n3709 0.20000000000000001
r4840 n3708 n3709 0.041666666666666664
r4841 n3676 n3710 0.20000000000000001
r4842 n3677 n3711 0.060606060606060608
r4843 n3710 n3711 1.34375
r4844 n3678 n3712 1
r4845 n3711 n3712 1.09375
r4846 n3679 n3713 0.066666666666666666
r4847 n3712 n3713 1
r4848 n3680 n3714 1
r4849 n3713 n3714 1
r4850 n3681 n3715 0.060606060606060608
r4851 n3714 n3715 1.09375
r4852 n3682 n3716 0.20000000000000001
r4853 n3715 n3716 1.34375
r4854 n3701 n3735 0.20000000000000001
r4855 n3702 n3736 0.20000000000000001
r4856 n3735 n3736 0.625
r4857 n3703 n3737 0.080000000000000002
r4858 n3736 n3737 1.09375
r4859 n3704 n3738 2
r4860 n3737 n3738 0.8125
r4861 n3705 n3739 0.071428571428571425
r4862 n3738 n3739 0.90625
r4863 n3706 n3740 2
r4864 n3739 n3740 0.90625
r4865 n3707 n3741 0.080000000000000002
r4866 n3740 n3741 0.8125
r4867 n3708 n3742 0.20000000000000001
r4868 n3741 n3742 1.09375
r4869 n3709 n3743 0.20000000000000001
r4870 n3742 n3743 0.625
r4871 n3710 n3744 0.15625
r4872 n3711 n3745 0.047348484848484848
r4873 n3744 n3745 0.11684782608695653
r4874 n3712 n3746 0.78125
r4875 n3745 n3746 0.095108695652173919
r4876 n3713 n3747 0.052083333333333336
r4877 n3746 n3747 0.086956521739130432
r4878 n3714 n3748 0.78125
r4879 n3747 n3748 0.086956521739130432
r4880 n3715 n3749 0.047348484848484848
r4881 n3748 n3749 0.095108695652173919
r4882 n3716 n3750 0.15625
r4883 n3749 n3750 0.11684782608695653
r4884 n3735 n3769 0.15625
r4885 n3736 n3770 0.15625
r4886 n3769 n3770 0.05434782608695652
r4887 n3737 n3771 0.0625
r4888 n3770 n3771 0.095108695652173919
r4889 n3738 n3772 1.5625
r4890 n3771 n3772 0.070652173913043473
r4891 n3739 n3773 0.055803571428571432
r4892 n3772 n3773 0.07880434782608696
r4893 n3740 n3774 1.5625
r4894 n3773 n3774 0.07880434782608696
r4895 n3741 n3775 0.0625
r4896 n3774 n3775 0.070652173913043473
r4897 n3742 n3776 0.15625
r4898 n3775 n3776 0.095108695652173919
r4899 n3743 n3777 0.15625
r4900 n3776 n3777 0.05434782608695652
r4901 n3744 n3778 0.26874999999999999
r4902 n3745 n3779 0.081439393939393936
r4903 n3778 n3779 0.13437499999999999
r4904 n3746 n3780 1.34375
r4905 n3779 n3780 0.109375
r4906 n3747 n3781 0.089583333333333334
r4907 n3780 n3781 0.10000000000000001
r4908 n3748 n3782 1.34375
r4909 n3781 n3782 0.10000000000000001
r4910 n3749 n3783 0.081439393939393936
r4911 n3782 n3783 0.109375
r4912 n3750 n3784 0.26874999999999999
r4913 n3783 n3784 0.13437499999999999
r4914 n3769 n3803 0.26874999999999999
r4915 n3770 n3804 0.26874999999999999
r4916 n3803 n3804 0.0625
r4917 n3771 n3805 0.1075
r4918 n3804 n3805 0.109375
r4919 n3772 n3806 2.6875
r4920 n3805 n3806 0.081250000000000003
r4921 n3773 n3807 0.095982142857142863
r4922 n3806 n3807 0.090624999999999997
r4923 n3774 n3808 2.6875
r4924 n3807 n3808 0.090624999999999997
r4925 n3775 n3809 0.1075
r4926 n3808 n3809 0.081250000000000003
r4927 n3776 n3810 0.26874999999999999
r4928 n3809 n3810 0.109375
r4929 n3777 n3811 0.26874999999999999
r4930 n3810 n3811 0.0625
r4931 n3779 n3812 0.12878787878787878
r4932 n3780 n3813 2.125
r4933 n3812 n3813 0.045572916666666664
r4934 n3781 n3814 0.14166666666666666
r4935 n3813 n3814 0.041666666666666664
r4936 n3782 n3815 2.125
r4937 n3814 n3815 0.041666666666666664
r4938 n3783 n3816 0.12878787878787878
r4939 n3815 n3816 0.045572916666666664
r4940 in n3817 0.84999999999999998
r4941 in n3818 0.70833333333333337
r4942 n3817 n3818 0.014322916666666666
r4943 in n3819 2.125
r4944 n3818 n3819 0.010416666666666666
r4945 in n3820 0.25
r4946 n3819 n3820 0.024739583333333332
r4947 in n3821 0.32692307692307693
r4948 n3820 n3821 0.0390625
r4949 in n3822 2.125
r4950 n3821 n3822 0.01953125
r4951 in n3823 2.125
r4952 n3822 n3823 0.005208333333333333
r4953 in n3824 1.0625
r4954 n3823 n3824 0.0078125
r4955 in n3825 0.84999999999999998
r4956 n3824 n3825 0.01171875
r4957 n3804 n3826 0.42499999999999999
r4958 n3805 n3827 0.17000000000000001
r4959 n3826 n3827 0.045572916666666664
r4960 n3806 n3828 4.25
r4961 n3827 n3828 0.033854166666666664
r4962 n3807 n3829 0.15178571428571427
r4963 n3828 n3829 0.037760416666666664
r4964 n3808 n3830 4.25
r4965 n3829 n3830 0.037760416666666664
r4966 n3809 n3831 0.17000000000000001
r4967 n3830 n3831 0.033854166666666664
r4968 n3810 n3832 0.42499999999999999
r4969 n3831 n3832 0.045572916666666664
r4970 n3812 n3833 0.18181818181818182
r4971 n3813 n3834 3
r4972 n3833 n3834 0.045572916666666664
r4973 n3814 n3835 0.20000000000000001
r4974 n3834 n3835 0.041666666666666664
r4975 n3815 n3836 3
r4976 n3835 n3836 0.041666666666666664
r4977 n3816 n3837 0.18181818181818182
r4978 n3836 n3837 0.045572916666666664
r4979 n3817 n3838 1.2
r4980 n3818 n3839 1
r4981 n3838 n3839 0.014322916666666666
r4982 n3819 n3840 3
r4983 n3839 n3840 0.010416666666666666
r4984 n3820 n3841 0.35294117647058826
r4985 n3840 n3841 0.024739583333333332
r4986 n3821 n3842 0.46153846153846156
r4987 n3841 n3842 0.0390625
r4988 n3822 n3843 3
r4989 n3842 n3843 0.01953125
r4990 n3823 n3844 3
r4991 n3843 n3844 0.005208333333333333
r4992 n3824 n3845 1.5
r4993 n3844 n3845 0.0078125
r4994 n3825 n3846 1.2
r4995 n3845 n3846 0.01171875
r4996 n3826 n3847 0.59999999999999998
r4997 n3827 n3848 0.23999999999999999
r4998 n3847 n3848 0.045572916666666664
r4999 n3828 n3849 6
r5000 n3848 n3849 0.033854166666666664
r5001 n3829 n3850 0.21428571428571427
r5002 n3849 n3850 0.037760416666666664
r5003 n3830 n3851 6
r5004 n3850 n3851 0.037760416666666664
r5005 n3831 n3852 0.23999999999999999
r5006 n3851 n3852 0.033854166666666664
r5007 n3832 n3853 0.59999999999999998
r5008 n3852 n3853 0.045572916666666664
r5009 n3833 n3854 0.18181818181818182
r5010 n3834 n3855 3
r5011 n3854 n3855 0.045572916666666664
r5012 n3835 n3856 0.20000000000000001
r5013 n3855 n3856 0.041666666666666664
r5014 n3836 n3857 3
r5015 n3856 n3857 0.041666666666666664
r5016 n3837 n3858 0.18181818181818182
r5017 n3857 n3858 0.045572916666666664
r5018 n3838 n3859 1.2
r5019 n3839 n3860 1
r5020 n3859 n3860 0.014322916666666666
r5021 n3840 n3861 3
r5022 n3860 n3861 0.010416666666666666
r5023 n3841 n3862 0.35294117647058826
r5024 n3861 n3862 0.024739583333333332
r5025 n3842 n3863 0.46153846153846156
r5026 n3862 n3863 0.0390625
r5027 n3843 n3864 3
r5028 n3863 n3864 0.01953125
r5029 n3844 n3865 3
r5030 n3864 n3865 0.005208333333333333
r5031 n3845 n3866 1.5
r5032 n3865 n3866 0.0078125
r5033 n3846 n3867 1.2
r5034 n3866 n3867 0.01171875
r5035 n3847 n3868 0.59999999999999998
r5036 n3848 n3869 0.23999999999999999
r5037 n3868 n3869 0.045572916666666664
r5038 n3849 n3870 6
r5039 n3869 n3870 0.033854166666666664
r5040 n3850 n3871 0.21428571428571427
r5041 n3870 n3871 0.037760416666666664
r5042 n3851 n3872 6
r5043 n3871 n3872 0.037760416666666664
r5044 n3852 n3873 0.23999999999999999
r5045 n3872 n3873 0.033854166666666664
r5046 n3853 n3874 0.59999999999999998
r5047 n3873 n3874 0.045572916666666664
r5048 n3854 n3875 0.094696969696969696
r5049 n3855 n3876 1.5625
r5050 n3875 n3876 1.09375
r5051 n3856 n3877 0.10416666666666667
r5052 n3876 n3877 1
r5053 n3857 n3878 1.5625
r5054 n3877 n3878 1
r5055 n3858 n3879 0.094696969696969696
r5056 n3878 n3879 1.09375
r5057 n3880 n3881 0.46875
r5058 n3881 n3882 0.3125
r5059 n3882 n3883 0.1875
r5060 n3883 n3884 0.09375
r5061 n3884 n3885 0.09375
r5062 n3885 n3886 0.0625
r5063 n3886 n3887 0.0625
r5064 n3887 n3888 0.15625
r5065 n3888 n3889 0.28125
r5066 n3889 n3890 0.1875
r5067 n3890 n3891 0.34375
r5068 n3891 n3892 0.40625
r5069 n3892 n3893 0.28125
r5070 n3893 n3894 0.25
r5071 n3894 n3895 0.09375
r5072 n3895 n3896 0.0625
r5073 n3896 n3897 0.21875
r5074 n3897 n3898 0.34375
r5075 n3898 n3899 0.1875
r5076 n3899 n3900 0.15625
r5077 n3900 n3901 0.28125
r5078 n3859 n3902 0.625
r5079 n3860 n3903 0.52083333333333337
r5080 n3902 n3903 0.34375
r5081 n3861 n3904 1.5625
r5082 n3903 n3904 0.25
r5083 n3862 n3905 0.18382352941176472
r5084 n3904 n3905 0.59375
r5085 n3863 n3906 0.24038461538461539
r5086 n3905 n3906 0.9375
r5087 n3864 n3907 1.5625
r5088 n3906 n3907 0.46875
r5089 n3865 n3908 1.5625
r5090 n3907 n3908 0.125
r5091 n3866 n3909 0.78125
r5092 n3908 n3909 0.1875
r5093 n3867 n3910 0.625
r5094 n3909 n3910 0.28125
r5095 n3868 n3911 0.3125
r5096 n3869 n3912 0.125
r5097 n3911 n3912 1.09375
r5098 n3870 n3913 3.125
r5099 n3912 n3913 0.8125
r5100 n3871 n3914 0.11160714285714286
r5101 n3913 n3914 0.90625
r5102 n3872 n3915 3.125
r5103 n3914 n3915 0.90625
r5104 n3873 n3916 0.125
r5105 n3915 n3916 0.8125
r5106 n3874 n3917 0.3125
r5107 n3916 n3917 1.09375
r5108 n3875 n3918 0.02462121212121212
r5109 n3876 n3919 0.40625
r5110 n3918 n3919 0.19886363636363635
r5111 n3877 n3920 0.027083333333333334
r5112 n3919 n3920 0.18181818181818182
r5113 n3878 n3921 0.40625
r5114 n3920 n3921 0.18181818181818182
r5115 n3879 n3922 0.02462121212121212
r5116 n3921 n3922 0.19886363636363635
r5117 n3922 n3923 0.24431818181818182
r5118 n3923 n3924 0.28977272727272729
r5119 n3924 n3925 0.46590909090909088
r5120 n3925 n3926 0.46590909090909088
r5121 n3926 n3927 0.42613636363636365
r5122 n3927 n3928 0.34886363636363638
r5123 n3928 n3929 0.3125
r5124 n3929 n3930 0.34999999999999998
r5125 n3930 n3931 0.26704545454545453
r5126 n3931 n3932 0.30113636363636365
r5127 n3932 n3933 0.23295454545454544
r5128 n3933 n3934 0.19318181818181818
r5129 n3934 n3935 0.19318181818181818
r5130 n3935 n3936 0.13636363636363635
r5131 n3936 n3937 0.15340909090909091
r5132 n3937 n3938 0.056818181818181816
r5133 n3938 n3939 0.0625
r5134 n3939 n3940 0.034090909090909088
r5135 n3940 n3941 0.079545454545454544
r5136 n3941 n3942 0.13068181818181818
r5137 n3942 n3943 0.085227272727272721
r5138 n3943 n3944 0.056818181818181816
r5139 n3944 n3945 0.034090909090909088
r5140 n3945 n3946 0.022727272727272728
r5141 n3946 n3947 0.022727272727272728
r5142 n3947 n3948 0.056818181818181816
r5143 n3880 n3949 0.081250000000000003
r5144 n3948 n3949 0.10795454545454546
r5145 n3881 n3950 0.16250000000000001
r5146 n3949 n3950 0.085227272727272721
r5147 n3882 n3951 0.16250000000000001
r5148 n3950 n3951 0.056818181818181816
r5149 n3883 n3952 0.8125
r5150 n3951 n3952 0.034090909090909088
r5151 n3884 n3953 0.40625
r5152 n3952 n3953 0.017045454545454544
r5153 n3885 n3954 0.8125
r5154 n3953 n3954 0.017045454545454544
r5155 n3886 n3955 0.8125
r5156 n3954 n3955 0.011363636363636364
r5157 n3887 n3956 0.8125
r5158 n3955 n3956 0.011363636363636364
r5159 n3888 n3957 0.203125
r5160 n3956 n3957 0.028409090909090908
r5161 n3889 n3958 0.16250000000000001
r5162 n3957 n3958 0.05113636363636364
r5163 n3890 n3959 0.8125
r5164 n3958 n3959 0.034090909090909088
r5165 n3891 n3960 0.081250000000000003
r5166 n3959 n3960 0.0625
r5167 n3892 n3961 0.27083333333333331
r5168 n3960 n3961 0.073863636363636367
r5169 n3893 n3962 0.13541666666666666
r5170 n3961 n3962 0.05113636363636364
r5171 n3894 n3963 0.40625
r5172 n3962 n3963 0.045454545454545456
r5173 n3895 n3964 0.8125
r5174 n3963 n3964 0.017045454545454544
r5175 n3896 n3965 0.8125
r5176 n3964 n3965 0.011363636363636364
r5177 n3897 n3966 0.13541666666666666
r5178 n3965 n3966 0.039772727272727272
r5179 n3898 n3967 0.16250000000000001
r5180 n3966 n3967 0.0625
r5181 n3899 n3968 0.8125
r5182 n3967 n3968 0.034090909090909088
r5183 n3900 n3969 0.203125
r5184 n3968 n3969 0.028409090909090908
r5185 n3901 n3970 0.16250000000000001
r5186 n3969 n3970 0.05113636363636364
r5187 n3902 n3971 0.16250000000000001
r5188 n3903 n3972 0.13541666666666666
r5189 n3971 n3972 0.0625
r5190 n3904 n3973 0.40625
r5191 n3972 n3973 0.045454545454545456
r5192 n3905 n3974 0.04779411764705882
r5193 n3973 n3974 0.10795454545454546
r5194 n3906 n3975 0.0625
r5195 n3974 n3975 0.17045454545454544
r5196 n3907 n3976 0.40625
r5197 n3975 n3976 0.085227272727272721
r5198 n3908 n3977 0.40625
r5199 n3976 n3977 0.022727272727272728
r5200 n3909 n3978 0.203125
r5201 n3977 n3978 0.034090909090909088
r5202 n3910 n3979 0.16250000000000001
r5203 n3978 n3979 0.05113636363636364
r5204 n3911 n3980 0.081250000000000003
r5205 n3912 n3981 0.032500000000000001
r5206 n3980 n3981 0.19886363636363635
r5207 n3913 n3982 0.8125
r5208 n3981 n3982 0.14772727272727273
r5209 n3914 n3983 0.029017857142857144
r5210 n3982 n3983 0.16477272727272727
r5211 n3915 n3984 0.8125
r5212 n3983 n3984 0.16477272727272727
r5213 n3916 n3985 0.032500000000000001
r5214 n3984 n3985 0.14772727272727273
r5215 n3917 n3986 0.081250000000000003
r5216 n3985 n3986 0.19886363636363635
r5217 n3918 n3987 0.02462121212121212
r5218 n3919 n3988 0.40625
r5219 n3987 n3988 1.09375
r5220 n3920 n3989 0.027083333333333334
r5221 n3988 n3989 1
r5222 n3921 n3990 0.40625
r5223 n3989 n3990 1
r5224 n3922 n3991 0.02462121212121212
r5225 n3990 n3991 1.09375
r5226 n3923 n3992 0.081250000000000003
r5227 n3991 n3992 1.34375
r5228 n3924 n3993 0.019817073170731708
r5229 n3992 n3993 1.59375
r5230 n3925 n3994 0.019817073170731708
r5231 n3993 n3994 2.5625
r5232 n3926 n3995 0.019817073170731708
r5233 n3994 n3995 2.5625
r5234 n3927 n3996 0.02389705882352941
r5235 n3995 n3996 2.34375
r5236 n3928 n3997 0.029653284671532845
r5237 n3996 n3997 1.91875
r5238 n3929 n3998 0.029438405797101448
r5239 n3997 n3998 1.71875
r5240 n3930 n3999 0.02389705882352941
r5241 n3998 n3999 1.925
r5242 n3931 n4000 0.0625
r5243 n3999 n4000 1.46875
r5244 n3932 n4001 0.020312500000000001
r5245 n4000 n4001 1.65625
r5246 n3933 n4002 0.8125
r5247 n4001 n4002 1.28125
r5248 n3934 n4003 0.02462121212121212
r5249 n4002 n4003 1.0625
r5250 n3935 n4004 0.8125
r5251 n4003 n4004 1.0625
r5252 n3936 n4005 0.035326086956521736
r5253 n4004 n4005 0.75
r5254 n3937 n4006 0.203125
r5255 n4005 n4006 0.84375
r5256 n3938 n4007 0.13541666666666666
r5257 n4006 n4007 0.3125
r5258 n3939 n4008 0.16250000000000001
r5259 n4007 n4008 0.34375
r5260 n3940 n4009 0.8125
r5261 n4008 n4009 0.1875
r5262 n3941 n4010 0.0625
r5263 n4009 n4010 0.4375
r5264 n3942 n4011 0.081250000000000003
r5265 n4010 n4011 0.71875
r5266 n3943 n4012 0.16250000000000001
r5267 n4011 n4012 0.46875
r5268 n3944 n4013 0.16250000000000001
r5269 n4012 n4013 0.3125
r5270 n3945 n4014 0.8125
r5271 n4013 n4014 0.1875
r5272 n3946 n4015 0.27083333333333331
r5273 n4014 n4015 0.125
r5274 n3947 n4016 0.8125
r5275 n4015 n4016 0.125
r5276 n3948 n4017 0.090277777777777776
r5277 n4016 n4017 0.3125
r5278 n3949 n4018 0.081250000000000003
r5279 n4017 n4018 0.59375
r5280 n3950 n4019 0.16250000000000001
r5281 n4018 n4019 0.46875
r5282 n3951 n4020 0.16250000000000001
r5283 n4019 n4020 0.3125
r5284 n3952 n4021 0.8125
r5285 n4020 n4021 0.1875
r5286 n3953 n4022 0.40625
r5287 n4021 n4022 0.09375
r5288 n3954 n4023 0.8125
r5289 n4022 n4023 0.09375
r5290 n3955 n4024 0.8125
r5291 n4023 n4024 0.0625
r5292 n3956 n4025 0.8125
r5293 n4024 n4025 0.0625
r5294 n3957 n4026 0.203125
r5295 n4025 n4026 0.15625
r5296 n3958 n4027 0.16250000000000001
r5297 n4026 n4027 0.28125
r5298 n3959 n4028 0.8125
r5299 n4027 n4028 0.1875
r5300 n3960 n4029 0.081250000000000003
r5301 n4028 n4029 0.34375
r5302 n3961 n4030 0.27083333333333331
r5303 n4029 n4030 0.40625
r5304 n3962 n4031 0.13541666666666666
r5305 n4030 n4031 0.28125
r5306 n3963 n4032 0.40625
r5307 n4031 n4032 0.25
r5308 n3964 n4033 0.8125
r5309 n4032 n4033 0.09375
r5310 n3965 n4034 0.8125
r5311 n4033 n4034 0.0625
r5312 n3966 n4035 0.13541666666666666
r5313 n4034 n4035 0.21875
r5314 n3967 n4036 0.16250000000000001
r5315 n4035 n4036 0.34375
r5316 n3968 n4037 0.8125
r5317 n4036 n4037 0.1875
r5318 n3969 n4038 0.203125
r5319 n4037 n4038 0.15625
r5320 n3970 n4039 0.16250000000000001
r5321 n4038 n4039 0.28125
r5322 n3971 n4040 0.16250000000000001
r5323 n3972 n4041 0.13541666666666666
r5324 n4040 n4041 0.34375
r5325 n3973 n4042 0.40625
r5326 n4041 n4042 0.25
r5327 n3974 n4043 0.04779411764705882
r5328 n4042 n4043 0.59375
r5329 n3975 n4044 0.0625
r5330 n4043 n4044 0.9375
r5331 n3976 n4045 0.40625
r5332 n4044 n4045 0.46875
r5333 n3977 n4046 0.40625
r5334 n4045 n4046 0.125
r5335 n3978 n4047 0.203125
r5336 n4046 n4047 0.1875
r5337 n3979 n4048 0.16250000000000001
r5338 n4047 n4048 0.28125
r5339 n3980 n4049 0.081250000000000003
r5340 n3981 n4050 0.032500000000000001
r5341 n4049 n4050 1.09375
r5342 n3982 n4051 0.8125
r5343 n4050 n4051 0.8125
r5344 n3983 n4052 0.029017857142857144
r5345 n4051 n4052 0.90625
r5346 n3984 n4053 0.8125
r5347 n4052 n4053 0.90625
r5348 n3985 n4054 0.032500000000000001
r5349 n4053 n4054 0.8125
r5350 n3986 n4055 0.081250000000000003
r5351 n4054 n4055 1.09375
r5352 n3987 n4056 0.060606060606060608
r5353 n3988 n4057 1
r5354 n4056 n4057 0.072916666666666671
r5355 n3989 n4058 0.066666666666666666
r5356 n4057 n4058 0.066666666666666666
r5357 n3990 n4059 1
r5358 n4058 n4059 0.066666666666666666
r5359 n3991 n4060 0.060606060606060608
r5360 n4059 n4060 0.072916666666666671
r5361 n3992 n4061 0.20000000000000001
r5362 n4060 n4061 0.089583333333333334
r5363 n3993 n4062 0.04878048780487805
r5364 n4061 n4062 0.10625
r5365 n3994 n4063 0.04878048780487805
r5366 n4062 n4063 0.17083333333333334
r5367 n3995 n4064 0.04878048780487805
r5368 n4063 n4064 0.17083333333333334
r5369 n3996 n4065 0.058823529411764705
r5370 n4064 n4065 0.15625
r5371 n3997 n4066 0.072992700729927001
r5372 n4065 n4066 0.12791666666666668
r5373 n3998 n4067 0.072463768115942032
r5374 n4066 n4067 0.11458333333333333
r5375 n3999 n4068 0.058823529411764705
r5376 n4067 n4068 0.12833333333333333
r5377 n4000 n4069 0.15384615384615385
r5378 n4068 n4069 0.097916666666666666
r5379 n4001 n4070 0.050000000000000003
r5380 n4069 n4070 0.11041666666666666
r5381 n4002 n4071 2
r5382 n4070 n4071 0.085416666666666669
r5383 n4003 n4072 0.060606060606060608
r5384 n4071 n4072 0.070833333333333331
r5385 n4004 n4073 2
r5386 n4072 n4073 0.070833333333333331
r5387 n4005 n4074 0.086956521739130432
r5388 n4073 n4074 0.050000000000000003
r5389 n4006 n4075 0.5
r5390 n4074 n4075 0.056250000000000001
r5391 n4007 n4076 0.33333333333333331
r5392 n4075 n4076 0.020833333333333332
r5393 n4008 n4077 0.40000000000000002
r5394 n4076 n4077 0.022916666666666665
r5395 n4009 n4078 2
r5396 n4077 n4078 0.012500000000000001
r5397 n4010 n4079 0.15384615384615385
r5398 n4078 n4079 0.029166666666666667
r5399 n4011 n4080 0.20000000000000001
r5400 n4079 n4080 0.04791666666666667
r5401 n4012 n4081 0.40000000000000002
r5402 n4080 n4081 0.03125
r5403 n4013 n4082 0.40000000000000002
r5404 n4081 n4082 0.020833333333333332
r5405 n4014 n4083 2
r5406 n4082 n4083 0.012500000000000001
r5407 n4015 n4084 0.66666666666666663
r5408 n4083 n4084 0.0083333333333333332
r5409 n4016 n4085 2
r5410 n4084 n4085 0.0083333333333333332
r5411 n4017 n4086 0.22222222222222221
r5412 n4085 n4086 0.020833333333333332
r5413 n4018 n4087 0.20000000000000001
r5414 n4086 n4087 0.039583333333333331
r5415 n4019 n4088 0.40000000000000002
r5416 n4087 n4088 0.03125
r5417 n4020 n4089 0.40000000000000002
r5418 n4088 n4089 0.020833333333333332
r5419 n4021 n4090 2
r5420 n4089 n4090 0.012500000000000001
r5421 n4022 n4091 1
r5422 n4090 n4091 0.0062500000000000003
r5423 n4023 n4092 2
r5424 n4091 n4092 0.0062500000000000003
r5425 n4024 n4093 2
r5426 n4092 n4093 0.0041666666666666666
r5427 n4025 n4094 2
r5428 n4093 n4094 0.0041666666666666666
r5429 n4026 n4095 0.5
r5430 n4094 n4095 0.010416666666666666
r5431 n4027 n4096 0.40000000000000002
r5432 n4095 n4096 0.018749999999999999
r5433 n4028 n4097 2
r5434 n4096 n4097 0.012500000000000001
r5435 n4029 n4098 0.20000000000000001
r5436 n4097 n4098 0.022916666666666665
r5437 n4030 n4099 0.66666666666666663
r5438 n4098 n4099 0.027083333333333334
r5439 n4031 n4100 0.33333333333333331
r5440 n4099 n4100 0.018749999999999999
r5441 n4032 n4101 1
r5442 n4100 n4101 0.016666666666666666
r5443 n4033 n4102 2
r5444 n4101 n4102 0.0062500000000000003
r5445 n4034 n4103 2
r5446 n4102 n4103 0.0041666666666666666
r5447 n4035 n4104 0.33333333333333331
r5448 n4103 n4104 0.014583333333333334
r5449 n4036 n4105 0.40000000000000002
r5450 n4104 n4105 0.022916666666666665
r5451 n4037 n4106 2
r5452 n4105 n4106 0.012500000000000001
r5453 n4038 n4107 0.5
r5454 n4106 n4107 0.010416666666666666
r5455 n4039 n4108 0.40000000000000002
r5456 n4107 n4108 0.018749999999999999
r5457 n4040 n4109 0.40000000000000002
r5458 n4041 n4110 0.33333333333333331
r5459 n4109 n4110 0.022916666666666665
r5460 n4042 n4111 1
r5461 n4110 n4111 0.016666666666666666
r5462 n4043 n4112 0.11764705882352941
r5463 n4111 n4112 0.039583333333333331
r5464 n4044 n4113 0.15384615384615385
r5465 n4112 n4113 0.0625
r5466 n4045 n4114 1
r5467 n4113 n4114 0.03125
r5468 n4046 n4115 1
r5469 n4114 n4115 0.0083333333333333332
r5470 n4047 n4116 0.5
r5471 n4115 n4116 0.012500000000000001
r5472 n4048 n4117 0.40000000000000002
r5473 n4116 n4117 0.018749999999999999
r5474 n4049 n4118 0.20000000000000001
r5475 n4050 n4119 0.080000000000000002
r5476 n4118 n4119 0.072916666666666671
r5477 n4051 n4120 2
r5478 n4119 n4120 0.054166666666666669
r5479 n4052 n4121 0.071428571428571425
r5480 n4120 n4121 0.060416666666666667
r5481 n4053 n4122 2
r5482 n4121 n4122 0.060416666666666667
r5483 n4054 n4123 0.080000000000000002
r5484 n4122 n4123 0.054166666666666669
r5485 n4055 n4124 0.20000000000000001
r5486 n4123 n4124 0.072916666666666671
r5487 n4056 n4125 0.060606060606060608
r5488 n4057 n4126 1
r5489 n4125 n4126 1.09375
r5490 n4058 n4127 0.066666666666666666
r5491 n4126 n4127 1
r5492 n4059 n4128 1
r5493 n4127 n4128 1
r5494 n4060 n4129 0.060606060606060608
r5495 n4128 n4129 1.09375
r5496 n4061 n4130 0.20000000000000001
r5497 n4129 n4130 1.34375
r5498 n4062 n4131 0.04878048780487805
r5499 n4130 n4131 1.59375
r5500 n4063 n4132 0.04878048780487805
r5501 n4131 n4132 2.5625
r5502 n4064 n4133 0.04878048780487805
r5503 n4132 n4133 2.5625
r5504 n4065 n4134 0.058823529411764705
r5505 n4133 n4134 2.34375
r5506 n4066 n4135 0.072992700729927001
r5507 n4134 n4135 1.91875
r5508 n4067 n4136 0.072463768115942032
r5509 n4135 n4136 1.71875
r5510 n4068 n4137 0.058823529411764705
r5511 n4136 n4137 1.925
r5512 n4069 n4138 0.15384615384615385
r5513 n4137 n4138 1.46875
r5514 n4070 n4139 0.050000000000000003
r5515 n4138 n4139 1.65625
r5516 n4071 n4140 2
r5517 n4139 n4140 1.28125
r5518 n4072 n4141 0.060606060606060608
r5519 n4140 n4141 1.0625
r5520 n4073 n4142 2
r5521 n4141 n4142 1.0625
r5522 n4074 n4143 0.086956521739130432
r5523 n4142 n4143 0.75
r5524 n4075 n4144 0.5
r5525 n4143 n4144 0.84375
r5526 n4076 n4145 0.33333333333333331
r5527 n4144 n4145 0.3125
r5528 n4077 n4146 0.40000000000000002
r5529 n4145 n4146 0.34375
r5530 n4078 n4147 2
r5531 n4146 n4147 0.1875
r5532 n4079 n4148 0.15384615384615385
r5533 n4147 n4148 0.4375
r5534 n4080 n4149 0.20000000000000001
r5535 n4148 n4149 0.71875
r5536 n4081 n4150 0.40000000000000002
r5537 n4149 n4150 0.46875
r5538 n4082 n4151 0.40000000000000002
r5539 n4150 n4151 0.3125
r5540 n4083 n4152 2
r5541 n4151 n4152 0.1875
r5542 n4084 n4153 0.66666666666666663
r5543 n4152 n4153 0.125
r5544 n4085 n4154 2
r5545 n4153 n4154 0.125
r5546 n4086 n4155 0.22222222222222221
r5547 n4154 n4155 0.3125
r5548 n4087 n4156 0.20000000000000001
r5549 n4155 n4156 0.59375
r5550 n4088 n4157 0.40000000000000002
r5551 n4156 n4157 0.46875
r5552 n4089 n4158 0.40000000000000002
r5553 n4157 n4158 0.3125
r5554 n4090 n4159 2
r5555 n4158 n4159 0.1875
r5556 n4091 n4160 1
r5557 n4159 n4160 0.09375
r5558 n4092 n4161 2
r5559 n4160 n4161 0.09375
r5560 n4093 n4162 2
r5561 n4161 n4162 0.0625
r5562 n4094 n4163 2
r5563 n4162 n4163 0.0625
r5564 n4095 n4164 0.5
r5565 n4163 n4164 0.15625
r5566 n4096 n4165 0.40000000000000002
r5567 n4164 n4165 0.28125
r5568 n4097 n4166 2
r5569 n4165 n4166 0.1875
r5570 n4098 n4167 0.20000000000000001
r5571 n4166 n4167 0.34375
r5572 n4099 n4168 0.66666666666666663
r5573 n4167 n4168 0.40625
r5574 n4100 n4169 0.33333333333333331
r5575 n4168 n4169 0.28125
r5576 n4101 n4170 1
r5577 n4169 n4170 0.25
r5578 n4102 n4171 2
r5579 n4170 n4171 0.09375
r5580 n4103 n4172 2
r5581 n4171 n4172 0.0625
r5582 n4104 n4173 0.33333333333333331
r5583 n4172 n4173 0.21875
r5584 n4105 n4174 0.40000000000000002
r5585 n4173 n4174 0.34375
r5586 n4106 n4175 2
r5587 n4174 n4175 0.1875
r5588 n4107 n4176 0.5
r5589 n4175 n4176 0.15625
r5590 n4108 n4177 0.40000000000000002
r5591 n4176 n4177 0.28125
r5592 n4109 n4178 0.40000000000000002
r5593 n4110 n4179 0.33333333333333331
r5594 n4178 n4179 0.34375
r5595 n4111 n4180 1
r5596 n4179 n4180 0.25
r5597 n4112 n4181 0.11764705882352941
r5598 n4180 n4181 0.59375
r5599 n4113 n4182 0.15384615384615385
r5600 n4181 n4182 0.9375
r5601 n4114 n4183 1
r5602 n4182 n4183 0.46875
r5603 n4115 n4184 1
r5604 n4183 n4184 0.125
r5605 n4116 n4185 0.5
r5606 n4184 n4185 0.1875
r5607 n4117 n4186 0.40000000000000002
r5608 n4185 n4186 0.28125
r5609 n4118 n4187 0.20000000000000001
r5610 n4119 n4188 0.080000000000000002
r5611 n4187 n4188 1.09375
r5612 n4120 n4189 2
r5613 n4188 n4189 0.8125
r5614 n4121 n4190 0.071428571428571425
r5615 n4189 n4190 0.90625
r5616 n4122 n4191 2
r5617 n4190 n4191 0.90625
r5618 n4123 n4192 0.080000000000000002
r5619 n4191 n4192 0.8125
r5620 n4124 n4193 0.20000000000000001
r5621 n4192 n4193 1.09375
r5622 n4125 n4194 0.02462121212121212
r5623 n4126 n4195 0.40625
r5624 n4194 n4195 0.19886363636363635
r5625 n4127 n4196 0.027083333333333334
r5626 n4195 n4196 0.18181818181818182
r5627 n4128 n4197 0.40625
r5628 n4196 n4197 0.18181818181818182
r5629 n4129 n4198 0.02462121212121212
r5630 n4197 n4198 0.19886363636363635
r5631 n4130 n4199 0.081250000000000003
r5632 n4198 n4199 0.24431818181818182
r5633 n4131 n4200 0.019817073170731708
r5634 n4199 n4200 0.28977272727272729
r5635 n4132 n4201 0.019817073170731708
r5636 n4200 n4201 0.46590909090909088
r5637 n4133 n4202 0.019817073170731708
r5638 n4201 n4202 0.46590909090909088
r5639 n4134 n4203 0.02389705882352941
r5640 n4202 n4203 0.42613636363636365
r5641 n4135 n4204 0.029653284671532845
r5642 n4203 n4204 0.34886363636363638
r5643 n4136 n4205 0.029438405797101448
r5644 n4204 n4205 0.3125
r5645 n4137 n4206 0.02389705882352941
r5646 n4205 n4206 0.34999999999999998
r5647 n4138 n4207 0.0625
r5648 n4206 n4207 0.26704545454545453
r5649 n4139 n4208 0.020312500000000001
r5650 n4207 n4208 0.30113636363636365
r5651 n4140 n4209 0.8125
r5652 n4208 n4209 0.23295454545454544
r5653 n4141 n4210 0.02462121212121212
r5654 n4209 n4210 0.19318181818181818
r5655 n4142 n4211 0.8125
r5656 n4210 n4211 0.19318181818181818
r5657 n4143 n4212 0.035326086956521736
r5658 n4211 n4212 0.13636363636363635
r5659 n4144 n4213 0.203125
r5660 n4212 n4213 0.15340909090909091
r5661 n4145 n4214 0.13541666666666666
r5662 n4213 n4214 0.056818181818181816
r5663 n4146 n4215 0.16250000000000001
r5664 n4214 n4215 0.0625
r5665 n4147 n4216 0.8125
r5666 n4215 n4216 0.034090909090909088
r5667 n4148 n4217 0.0625
r5668 n4216 n4217 0.079545454545454544
r5669 n4149 n4218 0.081250000000000003
r5670 n4217 n4218 0.13068181818181818
r5671 n4150 n4219 0.16250000000000001
r5672 n4218 n4219 0.085227272727272721
r5673 n4151 n4220 0.16250000000000001
r5674 n4219 n4220 0.056818181818181816
r5675 n4152 n4221 0.8125
r5676 n4220 n4221 0.034090909090909088
r5677 n4153 n4222 0.27083333333333331
r5678 n4221 n4222 0.022727272727272728
r5679 n4154 n4223 0.8125
r5680 n4222 n4223 0.022727272727272728
r5681 n4155 n4224 0.090277777777777776
r5682 n4223 n4224 0.056818181818181816
r5683 n4156 n4225 0.081250000000000003
r5684 n4224 n4225 0.10795454545454546
r5685 n4157 n4226 0.16250000000000001
r5686 n4225 n4226 0.085227272727272721
r5687 n4158 n4227 0.16250000000000001
r5688 n4226 n4227 0.056818181818181816
r5689 n4159 n4228 0.8125
r5690 n4227 n4228 0.034090909090909088
r5691 n4160 n4229 0.40625
r5692 n4228 n4229 0.017045454545454544
r5693 n4161 n4230 0.8125
r5694 n4229 n4230 0.017045454545454544
r5695 n4162 n4231 0.8125
r5696 n4230 n4231 0.011363636363636364
r5697 n4163 n4232 0.8125
r5698 n4231 n4232 0.011363636363636364
r5699 n4164 n4233 0.203125
r5700 n4232 n4233 0.028409090909090908
r5701 n4165 n4234 0.16250000000000001
r5702 n4233 n4234 0.05113636363636364
r5703 n4166 n4235 0.8125
r5704 n4234 n4235 0.034090909090909088
r5705 n4167 n4236 0.081250000000000003
r5706 n4235 n4236 0.0625
r5707 n4168 n4237 0.27083333333333331
r5708 n4236 n4237 0.073863636363636367
r5709 n4169 n4238 0.13541666666666666
r5710 n4237 n4238 0.05113636363636364
r5711 n4170 n4239 0.40625
r5712 n4238 n4239 0.045454545454545456
r5713 n4171 n4240 0.8125
r5714 n4239 n4240 0.017045454545454544
r5715 n4172 n4241 0.8125
r5716 n4240 n4241 0.011363636363636364
r5717 n4173 n4242 0.13541666666666666
r5718 n4241 n4242 0.039772727272727272
r5719 n4174 n4243 0.16250000000000001
r5720 n4242 n4243 0.0625
r5721 n4175 n4244 0.8125
r5722 n4243 n4244 0.034090909090909088
r5723 n4176 n4245 0.203125
r5724 n4244 n4245 0.028409090909090908
r5725 n4177 n4246 0.16250000000000001
r5726 n4245 n4246 0.05113636363636364
r5727 n4178 n4247 0.16250000000000001
r5728 n4179 n4248 0.13541666666666666
r5729 n4247 n4248 0.0625
r5730 n4180 n4249 0.40625
r5731 n4248 n4249 0.045454545454545456
r5732 n4181 n4250 0.04779411764705882
r5733 n4249 n4250 0.10795454545454546
r5734 n4182 n4251 0.0625
r5735 n4250 n4251 0.17045454545454544
r5736 n4183 n4252 0.40625
r5737 n4251 n4252 0.085227272727272721
r5738 n4184 n4253 0.40625
r5739 n4252 n4253 0.022727272727272728
r5740 n4185 n4254 0.203125
r5741 n4253 n4254 0.034090909090909088
r5742 n4186 n4255 0.16250000000000001
r5743 n4254 n4255 0.05113636363636364
r5744 n4187 n4256 0.081250000000000003
r5745 n4188 n4257 0.032500000000000001
r5746 n4256 n4257 0.19886363636363635
r5747 n4189 n4258 0.8125
r5748 n4257 n4258 0.14772727272727273
r5749 n4190 n4259 0.029017857142857144
r5750 n4258 n4259 0.16477272727272727
r5751 n4191 n4260 0.8125
r5752 n4259 n4260 0.16477272727272727
r5753 n4192 n4261 0.032500000000000001
r5754 n4260 n4261 0.14772727272727273
r5755 n4193 n4262 0.081250000000000003
r5756 n4261 n4262 0.19886363636363635
r5757 n4194 n4263 0.02462121212121212
r5758 n4195 n4264 0.40625
r5759 n4263 n4264 1.09375
r5760 n4196 n4265 0.027083333333333334
r5761 n4264 n4265 1
r5762 n4197 n4266 0.40625
r5763 n4265 n4266 1
r5764 n4198 n4267 0.02462121212121212
r5765 n4266 n4267 1.09375
r5766 n4225 n4268 0.081250000000000003
r5767 n4226 n4269 0.16250000000000001
r5768 n4268 n4269 0.46875
r5769 n4227 n4270 0.16250000000000001
r5770 n4269 n4270 0.3125
r5771 n4228 n4271 0.8125
r5772 n4270 n4271 0.1875
r5773 n4229 n4272 0.40625
r5774 n4271 n4272 0.09375
r5775 n4230 n4273 0.8125
r5776 n4272 n4273 0.09375
r5777 n4231 n4274 0.8125
r5778 n4273 n4274 0.0625
r5779 n4232 n4275 0.8125
r5780 n4274 n4275 0.0625
r5781 n4233 n4276 0.203125
r5782 n4275 n4276 0.15625
r5783 n4234 n4277 0.16250000000000001
r5784 n4276 n4277 0.28125
r5785 n4235 n4278 0.8125
r5786 n4277 n4278 0.1875
r5787 n4236 n4279 0.081250000000000003
r5788 n4278 n4279 0.34375
r5789 n4237 n4280 0.27083333333333331
r5790 n4279 n4280 0.40625
r5791 n4238 n4281 0.13541666666666666
r5792 n4280 n4281 0.28125
r5793 n4239 n4282 0.40625
r5794 n4281 n4282 0.25
r5795 n4240 n4283 0.8125
r5796 n4282 n4283 0.09375
r5797 n4241 n4284 0.8125
r5798 n4283 n4284 0.0625
r5799 n4242 n4285 0.13541666666666666
r5800 n4284 n4285 0.21875
r5801 n4243 n4286 0.16250000000000001
r5802 n4285 n4286 0.34375
r5803 n4244 n4287 0.8125
r5804 n4286 n4287 0.1875
r5805 n4245 n4288 0.203125
r5806 n4287 n4288 0.15625
r5807 n4246 n4289 0.16250000000000001
r5808 n4288 n4289 0.28125
r5809 n4247 n4290 0.16250000000000001
r5810 n4248 n4291 0.13541666666666666
r5811 n4290 n4291 0.34375
r5812 n4249 n4292 0.40625
r5813 n4291 n4292 0.25
r5814 n4250 n4293 0.04779411764705882
r5815 n4292 n4293 0.59375
r5816 n4251 n4294 0.0625
r5817 n4293 n4294 0.9375
r5818 n4252 n4295 0.40625
r5819 n4294 n4295 0.46875
r5820 n4253 n4296 0.40625
r5821 n4295 n4296 0.125
r5822 n4254 n4297 0.203125
r5823 n4296 n4297 0.1875
r5824 n4255 n4298 0.16250000000000001
r5825 n4297 n4298 0.28125
r5826 n4256 n4299 0.081250000000000003
r5827 n4257 n4300 0.032500000000000001
r5828 n4299 n4300 1.09375
r5829 n4258 n4301 0.8125
r5830 n4300 n4301 0.8125
r5831 n4259 n4302 0.029017857142857144
r5832 n4301 n4302 0.90625
r5833 n4260 n4303 0.8125
r5834 n4302 n4303 0.90625
r5835 n4261 n4304 0.032500000000000001
r5836 n4303 n4304 0.8125
r5837 n4262 n4305 0.081250000000000003
r5838 n4304 n4305 1.09375
r5839 n4263 n4306 0.070075757575757569
r5840 n4264 n4307 1.15625
r5841 n4306 n4307 0.0625
r5842 n4265 n4308 0.077083333333333337
r5843 n4307 n4308 0.057142857142857141
r5844 n4266 n4309 1.15625
r5845 n4308 n4309 0.057142857142857141
r5846 n4267 n4310 0.070075757575757569
r5847 n4309 n4310 0.0625
r5848 n4290 n4311 0.46250000000000002
r5849 n4291 n4312 0.38541666666666669
r5850 n4311 n4312 0.019642857142857142
r5851 n4292 n4313 1.15625
r5852 n4312 n4313 0.014285714285714285
r5853 n4293 n4314 0.13602941176470587
r5854 n4313 n4314 0.033928571428571426
r5855 n4294 n4315 0.17788461538461539
r5856 n4314 n4315 0.053571428571428568
r5857 n4295 n4316 1.15625
r5858 n4315 n4316 0.026785714285714284
r5859 n4296 n4317 1.15625
r5860 n4316 n4317 0.0071428571428571426
r5861 n4297 n4318 0.578125
r5862 n4317 n4318 0.010714285714285714
r5863 n4298 n4319 0.46250000000000002
r5864 n4318 n4319 0.01607142857142857
r5865 n4299 n4320 0.23125000000000001
r5866 n4300 n4321 0.092499999999999999
r5867 n4320 n4321 0.0625
r5868 n4301 n4322 2.3125
r5869 n4321 n4322 0.04642857142857143
r5870 n4302 n4323 0.082589285714285712
r5871 n4322 n4323 0.051785714285714289
r5872 n4303 n4324 2.3125
r5873 n4323 n4324 0.051785714285714289
r5874 n4304 n4325 0.092499999999999999
r5875 n4324 n4325 0.04642857142857143
r5876 n4305 n4326 0.23125000000000001
r5877 n4325 n4326 0.0625
r5878 n4306 n4327 0.13068181818181818
r5879 n4307 n4328 2.15625
r5880 n4327 n4328 0.064338235294117641
r5881 n4308 n4329 0.14374999999999999
r5882 n4328 n4329 0.058823529411764705
r5883 n4309 n4330 2.15625
r5884 n4329 n4330 0.058823529411764705
r5885 n4310 n4331 0.13068181818181818
r5886 n4330 n4331 0.064338235294117641
r5887 n4311 n4332 0.86250000000000004
r5888 n4312 n4333 0.71875
r5889 n4332 n4333 0.020220588235294119
r5890 n4313 n4334 2.15625
r5891 n4333 n4334 0.014705882352941176
r5892 n4314 n4335 0.25367647058823528
r5893 n4334 n4335 0.034926470588235295
r5894 n4315 n4336 0.33173076923076922
r5895 n4335 n4336 0.05514705882352941
r5896 n4316 n4337 2.15625
r5897 n4336 n4337 0.027573529411764705
r5898 n4317 n4338 2.15625
r5899 n4337 n4338 0.0073529411764705881
r5900 n4318 n4339 1.078125
r5901 n4338 n4339 0.011029411764705883
r5902 n4319 n4340 0.86250000000000004
r5903 n4339 n4340 0.016544117647058824
r5904 n4320 n4341 0.43125000000000002
r5905 n4321 n4342 0.17249999999999999
r5906 n4341 n4342 0.064338235294117641
r5907 n4322 n4343 4.3125
r5908 n4342 n4343 0.04779411764705882
r5909 n4323 n4344 0.15401785714285715
r5910 n4343 n4344 0.053308823529411763
r5911 n4324 n4345 4.3125
r5912 n4344 n4345 0.053308823529411763
r5913 n4325 n4346 0.17249999999999999
r5914 n4345 n4346 0.04779411764705882
r5915 n4326 n4347 0.43125000000000002
r5916 n4346 n4347 0.064338235294117641
r5917 n4327 n4348 0.077651515151515152
r5918 n4328 n4349 1.28125
r5919 n4348 n4349 0.3125
r5920 n4329 n4350 0.085416666666666669
r5921 n4349 n4350 0.2857142857142857
r5922 n4330 n4351 1.28125
r5923 n4350 n4351 0.2857142857142857
r5924 n4331 n4352 0.077651515151515152
r5925 n4351 n4352 0.3125
r5926 n4332 n4353 0.51249999999999996
r5927 n4333 n4354 0.42708333333333331
r5928 n4353 n4354 0.098214285714285712
r5929 n4334 n4355 1.28125
r5930 n4354 n4355 0.071428571428571425
r5931 n4335 n4356 0.15073529411764705
r5932 n4355 n4356 0.16964285714285715
r5933 n4336 n4357 0.19711538461538461
r5934 n4356 n4357 0.26785714285714285
r5935 n4337 n4358 1.28125
r5936 n4357 n4358 0.13392857142857142
r5937 n4338 n4359 1.28125
r5938 n4358 n4359 0.035714285714285712
r5939 n4339 n4360 0.640625
r5940 n4359 n4360 0.053571428571428568
r5941 n4340 n4361 0.51249999999999996
r5942 n4360 n4361 0.080357142857142863
r5943 n4341 n4362 0.25624999999999998
r5944 n4342 n4363 0.10249999999999999
r5945 n4362 n4363 0.3125
r5946 n4343 n4364 2.5625
r5947 n4363 n4364 0.23214285714285715
r5948 n4344 n4365 0.091517857142857137
r5949 n4364 n4365 0.25892857142857145
r5950 n4345 n4366 2.5625
r5951 n4365 n4366 0.25892857142857145
r5952 n4346 n4367 0.10249999999999999
r5953 n4366 n4367 0.23214285714285715
r5954 n4347 n4368 0.25624999999999998
r5955 n4367 n4368 0.3125
r5956 n4348 n4369 0.017045454545454544
r5957 n4349 n4370 0.28125
r5958 n4369 n4370 1.09375
r5959 n4350 n4371 0.018749999999999999
r5960 n4370 n4371 1
r5961 n4351 n4372 0.28125
r5962 n4371 n4372 1
r5963 n4352 n4373 0.017045454545454544
r5964 n4372 n4373 1.09375
r5965 n4374 n4375 0.46875
r5966 n4375 n4376 0.3125
r5967 n4376 n4377 0.1875
r5968 n4377 n4378 0.125
r5969 n4378 n4379 0.125
r5970 n4379 n4380 0.3125
r5971 n4380 n4381 0.59375
r5972 n4381 n4382 0.46875
r5973 n4382 n4383 0.3125
r5974 n4383 n4384 0.1875
r5975 n4384 n4385 0.09375
r5976 n4385 n4386 0.09375
r5977 n4386 n4387 0.0625
r5978 n4387 n4388 0.0625
r5979 n4388 n4389 0.15625
r5980 n4389 n4390 0.28125
r5981 n4390 n4391 0.1875
r5982 n4391 n4392 0.34375
r5983 n4353 n4393 0.1125
r5984 n4354 n4394 0.09375
r5985 n4393 n4394 0.34375
r5986 n4355 n4395 0.28125
r5987 n4394 n4395 0.25
r5988 n4356 n4396 0.033088235294117647
r5989 n4395 n4396 0.59375
r5990 n4357 n4397 0.043269230769230768
r5991 n4396 n4397 0.9375
r5992 n4358 n4398 0.28125
r5993 n4397 n4398 0.46875
r5994 n4359 n4399 0.28125
r5995 n4398 n4399 0.125
r5996 n4360 n4400 0.140625
r5997 n4399 n4400 0.1875
r5998 n4361 n4401 0.1125
r5999 n4400 n4401 0.28125
r6000 n4362 n4402 0.056250000000000001
r6001 n4363 n4403 0.022499999999999999
r6002 n4402 n4403 1.09375
r6003 n4364 n4404 0.5625
r6004 n4403 n4404 0.8125
r6005 n4365 n4405 0.020089285714285716
r6006 n4404 n4405 0.90625
r6007 n4366 n4406 0.5625
r6008 n4405 n4406 0.90625
r6009 n4367 n4407 0.022499999999999999
r6010 n4406 n4407 0.8125
r6011 n4368 n4408 0.056250000000000001
r6012 n4407 n4408 1.09375
r6013 n4369 n4409 0.013257575757575758
r6014 n4370 n4410 0.21875
r6015 n4409 n4410 0.4375
r6016 n4371 n4411 0.014583333333333334
r6017 n4410 n4411 0.40000000000000002
r6018 n4372 n4412 0.21875
r6019 n4411 n4412 0.40000000000000002
r6020 n4373 n4413 0.013257575757575758
r6021 n4412 n4413 0.4375
r6022 n4413 n4414 0.53749999999999998
r6023 n4414 n4415 0.63749999999999996
r6024 n4415 n4416 1.0249999999999999
r6025 n4416 n4417 1.0249999999999999
r6026 n4417 n4418 0.9375
r6027 n4418 n4419 0.76749999999999996
r6028 n4419 n4420 0.6875
r6029 n4420 n4421 0.77000000000000002
r6030 n4421 n4422 0.58750000000000002
r6031 n4422 n4423 0.66249999999999998
r6032 n4423 n4424 0.51249999999999996
r6033 n4424 n4425 0.42499999999999999
r6034 n4425 n4426 0.42499999999999999
r6035 n4426 n4427 0.29999999999999999
r6036 n4427 n4428 0.33750000000000002
r6037 n4428 n4429 0.125
r6038 n4429 n4430 0.13750000000000001
r6039 n4430 n4431 0.074999999999999997
r6040 n4431 n4432 0.17499999999999999
r6041 n4374 n4433 0.043749999999999997
r6042 n4432 n4433 0.28749999999999998
r6043 n4375 n4434 0.087499999999999994
r6044 n4433 n4434 0.1875
r6045 n4376 n4435 0.087499999999999994
r6046 n4434 n4435 0.125
r6047 n4377 n4436 0.4375
r6048 n4435 n4436 0.074999999999999997
r6049 n4378 n4437 0.14583333333333334
r6050 n4436 n4437 0.050000000000000003
r6051 n4379 n4438 0.4375
r6052 n4437 n4438 0.050000000000000003
r6053 n4380 n4439 0.048611111111111112
r6054 n4438 n4439 0.125
r6055 n4381 n4440 0.043749999999999997
r6056 n4439 n4440 0.23749999999999999
r6057 n4382 n4441 0.087499999999999994
r6058 n4440 n4441 0.1875
r6059 n4383 n4442 0.087499999999999994
r6060 n4441 n4442 0.125
r6061 n4384 n4443 0.4375
r6062 n4442 n4443 0.074999999999999997
r6063 n4385 n4444 0.21875
r6064 n4443 n4444 0.037499999999999999
r6065 n4386 n4445 0.4375
r6066 n4444 n4445 0.037499999999999999
r6067 n4387 n4446 0.4375
r6068 n4445 n4446 0.025000000000000001
r6069 n4388 n4447 0.4375
r6070 n4446 n4447 0.025000000000000001
r6071 n4389 n4448 0.109375
r6072 n4447 n4448 0.0625
r6073 n4390 n4449 0.087499999999999994
r6074 n4448 n4449 0.1125
r6075 n4391 n4450 0.4375
r6076 n4449 n4450 0.074999999999999997
r6077 n4392 n4451 0.043749999999999997
r6078 n4450 n4451 0.13750000000000001
r6079 n4393 n4452 0.087499999999999994
r6080 n4394 n4453 0.072916666666666671
r6081 n4452 n4453 0.13750000000000001
r6082 n4395 n4454 0.21875
r6083 n4453 n4454 0.10000000000000001
r6084 n4396 n4455 0.025735294117647058
r6085 n4454 n4455 0.23749999999999999
r6086 n4397 n4456 0.033653846153846152
r6087 n4455 n4456 0.375
r6088 n4398 n4457 0.21875
r6089 n4456 n4457 0.1875
r6090 n4399 n4458 0.21875
r6091 n4457 n4458 0.050000000000000003
r6092 n4400 n4459 0.109375
r6093 n4458 n4459 0.074999999999999997
r6094 n4401 n4460 0.087499999999999994
r6095 n4459 n4460 0.1125
r6096 n4402 n4461 0.043749999999999997
r6097 n4403 n4462 0.017500000000000002
r6098 n4461 n4462 0.4375
r6099 n4404 n4463 0.4375
r6100 n4462 n4463 0.32500000000000001
r6101 n4405 n4464 0.015625
r6102 n4463 n4464 0.36249999999999999
r6103 n4406 n4465 0.4375
r6104 n4464 n4465 0.36249999999999999
r6105 n4407 n4466 0.017500000000000002
r6106 n4465 n4466 0.32500000000000001
r6107 n4408 n4467 0.043749999999999997
r6108 n4466 n4467 0.4375
r6109 n4409 n4468 0.020833333333333332
r6110 n4410 n4469 0.34375
r6111 n4468 n4469 0.36458333333333331
r6112 n4411 n4470 0.022916666666666665
r6113 n4469 n4470 0.33333333333333331
r6114 n4412 n4471 0.34375
r6115 n4470 n4471 0.33333333333333331
r6116 n4413 n4472 0.020833333333333332
r6117 n4471 n4472 0.36458333333333331
r6118 n4414 n4473 0.068750000000000006
r6119 n4472 n4473 0.44791666666666669
r6120 n4415 n4474 0.01676829268292683
r6121 n4473 n4474 0.53125
r6122 n4416 n4475 0.01676829268292683
r6123 n4474 n4475 0.85416666666666663
r6124 n4417 n4476 0.01676829268292683
r6125 n4475 n4476 0.85416666666666663
r6126 n4418 n4477 0.020220588235294119
r6127 n4476 n4477 0.78125
r6128 n4419 n4478 0.025091240875912409
r6129 n4477 n4478 0.63958333333333328
r6130 n4420 n4479 0.024909420289855072
r6131 n4478 n4479 0.57291666666666663
r6132 n4421 n4480 0.020220588235294119
r6133 n4479 n4480 0.64166666666666672
r6134 n4422 n4481 0.052884615384615384
r6135 n4480 n4481 0.48958333333333331
r6136 n4423 n4482 0.017187500000000001
r6137 n4481 n4482 0.55208333333333337
r6138 n4424 n4483 0.6875
r6139 n4482 n4483 0.42708333333333331
r6140 n4425 n4484 0.020833333333333332
r6141 n4483 n4484 0.35416666666666669
r6142 n4426 n4485 0.6875
r6143 n4484 n4485 0.35416666666666669
r6144 n4427 n4486 0.029891304347826088
r6145 n4485 n4486 0.25
r6146 n4428 n4487 0.171875
r6147 n4486 n4487 0.28125
r6148 n4429 n4488 0.11458333333333333
r6149 n4487 n4488 0.10416666666666667
r6150 n4430 n4489 0.13750000000000001
r6151 n4488 n4489 0.11458333333333333
r6152 n4431 n4490 0.6875
r6153 n4489 n4490 0.0625
r6154 n4432 n4491 0.052884615384615384
r6155 n4490 n4491 0.14583333333333334
r6156 n4433 n4492 0.068750000000000006
r6157 n4491 n4492 0.23958333333333334
r6158 n4434 n4493 0.13750000000000001
r6159 n4492 n4493 0.15625
r6160 n4435 n4494 0.13750000000000001
r6161 n4493 n4494 0.10416666666666667
r6162 n4436 n4495 0.6875
r6163 n4494 n4495 0.0625
r6164 n4437 n4496 0.22916666666666666
r6165 n4495 n4496 0.041666666666666664
r6166 n4438 n4497 0.6875
r6167 n4496 n4497 0.041666666666666664
r6168 n4439 n4498 0.076388888888888895
r6169 n4497 n4498 0.10416666666666667
r6170 n4440 n4499 0.068750000000000006
r6171 n4498 n4499 0.19791666666666666
r6172 n4441 n4500 0.13750000000000001
r6173 n4499 n4500 0.15625
r6174 n4442 n4501 0.13750000000000001
r6175 n4500 n4501 0.10416666666666667
r6176 n4443 n4502 0.6875
r6177 n4501 n4502 0.0625
r6178 n4444 n4503 0.34375
r6179 n4502 n4503 0.03125
r6180 n4445 n4504 0.6875
r6181 n4503 n4504 0.03125
r6182 n4446 n4505 0.6875
r6183 n4504 n4505 0.020833333333333332
r6184 n4447 n4506 0.6875
r6185 n4505 n4506 0.020833333333333332
r6186 n4448 n4507 0.171875
r6187 n4506 n4507 0.052083333333333336
r6188 n4449 n4508 0.13750000000000001
r6189 n4507 n4508 0.09375
r6190 n4450 n4509 0.6875
r6191 n4508 n4509 0.0625
r6192 n4451 n4510 0.068750000000000006
r6193 n4509 n4510 0.11458333333333333
r6194 n4452 n4511 0.13750000000000001
r6195 n4453 n4512 0.11458333333333333
r6196 n4511 n4512 0.11458333333333333
r6197 n4454 n4513 0.34375
r6198 n4512 n4513 0.083333333333333329
r6199 n4455 n4514 0.040441176470588237
r6200 n4513 n4514 0.19791666666666666
r6201 n4456 n4515 0.052884615384615384
r6202 n4514 n4515 0.3125
r6203 n4457 n4516 0.34375
r6204 n4515 n4516 0.15625
r6205 n4458 n4517 0.34375
r6206 n4516 n4517 0.041666666666666664
r6207 n4459 n4518 0.171875
r6208 n4517 n4518 0.0625
r6209 n4460 n4519 0.13750000000000001
r6210 n4518 n4519 0.09375
r6211 n4461 n4520 0.068750000000000006
r6212 n4462 n4521 0.0275
r6213 n4520 n4521 0.36458333333333331
r6214 n4463 n4522 0.6875
r6215 n4521 n4522 0.27083333333333331
r6216 n4464 n4523 0.024553571428571428
r6217 n4522 n4523 0.30208333333333331
r6218 n4465 n4524 0.6875
r6219 n4523 n4524 0.30208333333333331
r6220 n4466 n4525 0.0275
r6221 n4524 n4525 0.27083333333333331
r6222 n4467 n4526 0.068750000000000006
r6223 n4525 n4526 0.36458333333333331
r6224 n4468 n4527 0.015151515151515152
r6225 n4469 n4528 0.25
r6226 n4527 n4528 1.09375
r6227 n4470 n4529 0.016666666666666666
r6228 n4528 n4529 1
r6229 n4471 n4530 0.25
r6230 n4529 n4530 1
r6231 n4472 n4531 0.015151515151515152
r6232 n4530 n4531 1.09375
r6233 n4473 n4532 0.050000000000000003
r6234 n4531 n4532 1.34375
r6235 n4474 n4533 0.012195121951219513
r6236 n4532 n4533 1.59375
r6237 n4475 n4534 0.012195121951219513
r6238 n4533 n4534 2.5625
r6239 n4476 n4535 0.012195121951219513
r6240 n4534 n4535 2.5625
r6241 n4477 n4536 0.014705882352941176
r6242 n4535 n4536 2.34375
r6243 n4478 n4537 0.01824817518248175
r6244 n4536 n4537 1.91875
r6245 n4479 n4538 0.018115942028985508
r6246 n4537 n4538 1.71875
r6247 n4480 n4539 0.014705882352941176
r6248 n4538 n4539 1.925
r6249 n4481 n4540 0.038461538461538464
r6250 n4539 n4540 1.46875
r6251 n4482 n4541 0.012500000000000001
r6252 n4540 n4541 1.65625
r6253 n4483 n4542 0.5
r6254 n4541 n4542 1.28125
r6255 n4484 n4543 0.015151515151515152
r6256 n4542 n4543 1.0625
r6257 n4485 n4544 0.5
r6258 n4543 n4544 1.0625
r6259 n4486 n4545 0.021739130434782608
r6260 n4544 n4545 0.75
r6261 n4487 n4546 0.125
r6262 n4545 n4546 0.84375
r6263 n4488 n4547 0.083333333333333329
r6264 n4546 n4547 0.3125
r6265 n4489 n4548 0.10000000000000001
r6266 n4547 n4548 0.34375
r6267 n4490 n4549 0.5
r6268 n4548 n4549 0.1875
r6269 n4491 n4550 0.038461538461538464
r6270 n4549 n4550 0.4375
r6271 n4492 n4551 0.050000000000000003
r6272 n4550 n4551 0.71875
r6273 n4493 n4552 0.10000000000000001
r6274 n4551 n4552 0.46875
r6275 n4494 n4553 0.10000000000000001
r6276 n4552 n4553 0.3125
r6277 n4495 n4554 0.5
r6278 n4553 n4554 0.1875
r6279 n4496 n4555 0.16666666666666666
r6280 n4554 n4555 0.125
r6281 n4497 n4556 0.5
r6282 n4555 n4556 0.125
r6283 n4498 n4557 0.055555555555555552
r6284 n4556 n4557 0.3125
r6285 n4499 n4558 0.050000000000000003
r6286 n4557 n4558 0.59375
r6287 n4500 n4559 0.10000000000000001
r6288 n4558 n4559 0.46875
r6289 n4501 n4560 0.10000000000000001
r6290 n4559 n4560 0.3125
r6291 n4502 n4561 0.5
r6292 n4560 n4561 0.1875
r6293 n4503 n4562 0.25
r6294 n4561 n4562 0.09375
r6295 n4504 n4563 0.5
r6296 n4562 n4563 0.09375
r6297 n4505 n4564 0.5
r6298 n4563 n4564 0.0625
r6299 n4506 n4565 0.5
r6300 n4564 n4565 0.0625
r6301 n4507 n4566 0.125
r6302 n4565 n4566 0.15625
r6303 n4508 n4567 0.10000000000000001
r6304 n4566 n4567 0.28125
r6305 n4509 n4568 0.5
r6306 n4567 n4568 0.1875
r6307 n4510 n4569 0.050000000000000003
r6308 n4568 n4569 0.34375
r6309 n4511 n4570 0.10000000000000001
r6310 n4512 n4571 0.083333333333333329
r6311 n4570 n4571 0.34375
r6312 n4513 n4572 0.25
r6313 n4571 n4572 0.25
r6314 n4514 n4573 0.029411764705882353
r6315 n4572 n4573 0.59375
r6316 n4515 n4574 0.038461538461538464
r6317 n4573 n4574 0.9375
r6318 n4516 n4575 0.25
r6319 n4574 n4575 0.46875
r6320 n4517 n4576 0.25
r6321 n4575 n4576 0.125
r6322 n4518 n4577 0.125
r6323 n4576 n4577 0.1875
r6324 n4519 n4578 0.10000000000000001
r6325 n4577 n4578 0.28125
r6326 n4520 n4579 0.050000000000000003
r6327 n4521 n4580 0.02
r6328 n4579 n4580 1.09375
r6329 n4522 n4581 0.5
r6330 n4580 n4581 0.8125
r6331 n4523 n4582 0.017857142857142856
r6332 n4581 n4582 0.90625
r6333 n4524 n4583 0.5
r6334 n4582 n4583 0.90625
r6335 n4525 n4584 0.02
r6336 n4583 n4584 0.8125
r6337 n4526 n4585 0.050000000000000003
r6338 n4584 n4585 1.09375
r6339 n4527 n4586 0.034090909090909088
r6340 n4528 n4587 0.5625
r6341 n4586 n4587 0.13671875
r6342 n4529 n4588 0.037499999999999999
r6343 n4587 n4588 0.125
r6344 n4530 n4589 0.5625
r6345 n4588 n4589 0.125
r6346 n4531 n4590 0.034090909090909088
r6347 n4589 n4590 0.13671875
r6348 n4532 n4591 0.1125
r6349 n4590 n4591 0.16796875
r6350 n4533 n4592 0.027439024390243903
r6351 n4591 n4592 0.19921875
r6352 n4534 n4593 0.027439024390243903
r6353 n4592 n4593 0.3203125
r6354 n4535 n4594 0.027439024390243903
r6355 n4593 n4594 0.3203125
r6356 n4536 n4595 0.033088235294117647
r6357 n4594 n4595 0.29296875
r6358 n4537 n4596 0.04105839416058394
r6359 n4595 n4596 0.23984374999999999
r6360 n4538 n4597 0.040760869565217392
r6361 n4596 n4597 0.21484375
r6362 n4539 n4598 0.033088235294117647
r6363 n4597 n4598 0.24062500000000001
r6364 n4540 n4599 0.086538461538461536
r6365 n4598 n4599 0.18359375
r6366 n4541 n4600 0.028125000000000001
r6367 n4599 n4600 0.20703125
r6368 n4542 n4601 1.125
r6369 n4600 n4601 0.16015625
r6370 n4543 n4602 0.034090909090909088
r6371 n4601 n4602 0.1328125
r6372 n4544 n4603 1.125
r6373 n4602 n4603 0.1328125
r6374 n4545 n4604 0.048913043478260872
r6375 n4603 n4604 0.09375
r6376 n4546 n4605 0.28125
r6377 n4604 n4605 0.10546875
r6378 n4547 n4606 0.1875
r6379 n4605 n4606 0.0390625
r6380 n4548 n4607 0.22500000000000001
r6381 n4606 n4607 0.04296875
r6382 n4549 n4608 1.125
r6383 n4607 n4608 0.0234375
r6384 n4550 n4609 0.086538461538461536
r6385 n4608 n4609 0.0546875
r6386 n4551 n4610 0.1125
r6387 n4609 n4610 0.08984375
r6388 n4552 n4611 0.22500000000000001
r6389 n4610 n4611 0.05859375
r6390 n4553 n4612 0.22500000000000001
r6391 n4611 n4612 0.0390625
r6392 n4554 n4613 1.125
r6393 n4612 n4613 0.0234375
r6394 n4555 n4614 0.375
r6395 n4613 n4614 0.015625
r6396 n4556 n4615 1.125
r6397 n4614 n4615 0.015625
r6398 n4557 n4616 0.125
r6399 n4615 n4616 0.0390625
r6400 n4558 n4617 0.1125
r6401 n4616 n4617 0.07421875
r6402 n4559 n4618 0.22500000000000001
r6403 n4617 n4618 0.05859375
r6404 n4560 n4619 0.22500000000000001
r6405 n4618 n4619 0.0390625
r6406 n4561 n4620 1.125
r6407 n4619 n4620 0.0234375
r6408 n4562 n4621 0.5625
r6409 n4620 n4621 0.01171875
r6410 n4563 n4622 1.125
r6411 n4621 n4622 0.01171875
r6412 n4564 n4623 1.125
r6413 n4622 n4623 0.0078125
r6414 n4565 n4624 1.125
r6415 n4623 n4624 0.0078125
r6416 n4566 n4625 0.28125
r6417 n4624 n4625 0.01953125
r6418 n4567 n4626 0.22500000000000001
r6419 n4625 n4626 0.03515625
r6420 n4568 n4627 1.125
r6421 n4626 n4627 0.0234375
r6422 n4569 n4628 0.1125
r6423 n4627 n4628 0.04296875
r6424 n4570 n4629 0.22500000000000001
r6425 n4571 n4630 0.1875
r6426 n4629 n4630 0.04296875
r6427 n4572 n4631 0.5625
r6428 n4630 n4631 0.03125
r6429 n4573 n4632 0.066176470588235295
r6430 n4631 n4632 0.07421875
r6431 n4574 n4633 0.086538461538461536
r6432 n4632 n4633 0.1171875
r6433 n4575 n4634 0.5625
r6434 n4633 n4634 0.05859375
r6435 n4576 n4635 0.5625
r6436 n4634 n4635 0.015625
r6437 n4577 n4636 0.28125
r6438 n4635 n4636 0.0234375
r6439 n4578 n4637 0.22500000000000001
r6440 n4636 n4637 0.03515625
r6441 n4579 n4638 0.1125
r6442 n4580 n4639 0.044999999999999998
r6443 n4638 n4639 0.13671875
r6444 n4581 n4640 1.125
r6445 n4639 n4640 0.1015625
r6446 n4582 n4641 0.040178571428571432
r6447 n4640 n4641 0.11328125
r6448 n4583 n4642 1.125
r6449 n4641 n4642 0.11328125
r6450 n4584 n4643 0.044999999999999998
r6451 n4642 n4643 0.1015625
r6452 n4585 n4644 0.1125
r6453 n4643 n4644 0.13671875
r6454 n4586 n4645 0.056818181818181816
r6455 n4587 n4646 0.9375
r6456 n4645 n4646 0.15625
r6457 n4588 n4647 0.0625
r6458 n4646 n4647 0.14285714285714285
r6459 n4589 n4648 0.9375
r6460 n4647 n4648 0.14285714285714285
r6461 n4590 n4649 0.056818181818181816
r6462 n4648 n4649 0.15625
r6463 n4591 n4650 0.1875
r6464 n4649 n4650 0.19196428571428573
r6465 n4592 n4651 0.04573170731707317
r6466 n4650 n4651 0.22767857142857142
r6467 n4593 n4652 0.04573170731707317
r6468 n4651 n4652 0.36607142857142855
r6469 n4594 n4653 0.04573170731707317
r6470 n4652 n4653 0.36607142857142855
r6471 n4595 n4654 0.05514705882352941
r6472 n4653 n4654 0.33482142857142855
r6473 n4596 n4655 0.068430656934306569
r6474 n4654 n4655 0.27410714285714288
r6475 n4597 n4656 0.067934782608695649
r6476 n4655 n4656 0.24553571428571427
r6477 n4598 n4657 0.05514705882352941
r6478 n4656 n4657 0.27500000000000002
r6479 n4599 n4658 0.14423076923076922
r6480 n4657 n4658 0.20982142857142858
r6481 n4600 n4659 0.046875
r6482 n4658 n4659 0.23660714285714285
r6483 n4601 n4660 1.875
r6484 n4659 n4660 0.18303571428571427
r6485 n4602 n4661 0.056818181818181816
r6486 n4660 n4661 0.15178571428571427
r6487 n4603 n4662 1.875
r6488 n4661 n4662 0.15178571428571427
r6489 n4604 n4663 0.081521739130434784
r6490 n4662 n4663 0.10714285714285714
r6491 n4605 n4664 0.46875
r6492 n4663 n4664 0.12053571428571429
r6493 n4606 n4665 0.3125
r6494 n4664 n4665 0.044642857142857144
r6495 n4607 n4666 0.375
r6496 n4665 n4666 0.049107142857142856
r6497 n4608 n4667 1.875
r6498 n4666 n4667 0.026785714285714284
r6499 n4609 n4668 0.14423076923076922
r6500 n4667 n4668 0.0625
r6501 n4610 n4669 0.1875
r6502 n4668 n4669 0.10267857142857142
r6503 n4611 n4670 0.375
r6504 n4669 n4670 0.066964285714285712
r6505 n4612 n4671 0.375
r6506 n4670 n4671 0.044642857142857144
r6507 n4613 n4672 1.875
r6508 n4671 n4672 0.026785714285714284
r6509 n4614 n4673 0.625
r6510 n4672 n4673 0.017857142857142856
r6511 n4615 n4674 1.875
r6512 n4673 n4674 0.017857142857142856
r6513 n4616 n4675 0.20833333333333334
r6514 n4674 n4675 0.044642857142857144
r6515 n4617 n4676 0.1875
r6516 n4675 n4676 0.084821428571428575
r6517 n4618 n4677 0.375
r6518 n4676 n4677 0.066964285714285712
r6519 n4619 n4678 0.375
r6520 n4677 n4678 0.044642857142857144
r6521 n4620 n4679 1.875
r6522 n4678 n4679 0.026785714285714284
r6523 n4621 n4680 0.9375
r6524 n4679 n4680 0.013392857142857142
r6525 n4622 n4681 1.875
r6526 n4680 n4681 0.013392857142857142
r6527 n4623 n4682 1.875
r6528 n4681 n4682 0.0089285714285714281
r6529 n4624 n4683 1.875
r6530 n4682 n4683 0.0089285714285714281
r6531 n4625 n4684 0.46875
r6532 n4683 n4684 0.022321428571428572
r6533 n4626 n4685 0.375
r6534 n4684 n4685 0.040178571428571432
r6535 n4627 n4686 1.875
r6536 n4685 n4686 0.026785714285714284
r6537 n4628 n4687 0.1875
r6538 n4686 n4687 0.049107142857142856
r6539 n4629 n4688 0.375
r6540 n4630 n4689 0.3125
r6541 n4688 n4689 0.049107142857142856
r6542 n4631 n4690 0.9375
r6543 n4689 n4690 0.035714285714285712
r6544 n4632 n4691 0.11029411764705882
r6545 n4690 n4691 0.084821428571428575
r6546 n4633 n4692 0.14423076923076922
r6547 n4691 n4692 0.13392857142857142
r6548 n4634 n4693 0.9375
r6549 n4692 n4693 0.066964285714285712
r6550 n4635 n4694 0.9375
r6551 n4693 n4694 0.017857142857142856
r6552 n4636 n4695 0.46875
r6553 n4694 n4695 0.026785714285714284
r6554 n4637 n4696 0.375
r6555 n4695 n4696 0.040178571428571432
r6556 n4638 n4697 0.1875
r6557 n4639 n4698 0.074999999999999997
r6558 n4697 n4698 0.15625
r6559 n4640 n4699 1.875
r6560 n4698 n4699 0.11607142857142858
r6561 n4641 n4700 0.066964285714285712
r6562 n4699 n4700 0.12946428571428573
r6563 n4642 n4701 1.875
r6564 n4700 n4701 0.12946428571428573
r6565 n4643 n4702 0.074999999999999997
r6566 n4701 n4702 0.11607142857142858
r6567 n4644 n4703 0.1875
r6568 n4702 n4703 0.15625
r6569 n4645 n4704 0.030303030303030304
r6570 n4646 n4705 0.5
r6571 n4704 n4705 1.09375
r6572 n4647 n4706 0.033333333333333333
r6573 n4705 n4706 1
r6574 n4648 n4707 0.5
r6575 n4706 n4707 1
r6576 n4649 n4708 0.030303030303030304
r6577 n4707 n4708 1.09375
r6578 n4650 n4709 0.10000000000000001
r6579 n4708 n4709 1.34375
r6580 n4651 n4710 0.024390243902439025
r6581 n4709 n4710 1.59375
r6582 n4652 n4711 0.024390243902439025
r6583 n4710 n4711 2.5625
r6584 n4653 n4712 0.024390243902439025
r6585 n4711 n4712 2.5625
r6586 n4654 n4713 0.029411764705882353
r6587 n4712 n4713 2.34375
r6588 n4655 n4714 0.036496350364963501
r6589 n4713 n4714 1.91875
r6590 n4656 n4715 0.036231884057971016
r6591 n4714 n4715 1.71875
r6592 n4657 n4716 0.029411764705882353
r6593 n4715 n4716 1.925
r6594 n4658 n4717 0.076923076923076927
r6595 n4716 n4717 1.46875
r6596 n4659 n4718 0.025000000000000001
r6597 n4717 n4718 1.65625
r6598 n4660 n4719 1
r6599 n4718 n4719 1.28125
r6600 n4661 n4720 0.030303030303030304
r6601 n4719 n4720 1.0625
r6602 n4662 n4721 1
r6603 n4720 n4721 1.0625
r6604 n4663 n4722 0.043478260869565216
r6605 n4721 n4722 0.75
r6606 n4664 n4723 0.25
r6607 n4722 n4723 0.84375
r6608 n4665 n4724 0.16666666666666666
r6609 n4723 n4724 0.3125
r6610 n4666 n4725 0.20000000000000001
r6611 n4724 n4725 0.34375
r6612 n4667 n4726 1
r6613 n4725 n4726 0.1875
r6614 n4668 n4727 0.076923076923076927
r6615 n4726 n4727 0.4375
r6616 n4669 n4728 0.10000000000000001
r6617 n4727 n4728 0.71875
r6618 n4670 n4729 0.20000000000000001
r6619 n4728 n4729 0.46875
r6620 n4671 n4730 0.20000000000000001
r6621 n4729 n4730 0.3125
r6622 n4672 n4731 1
r6623 n4730 n4731 0.1875
r6624 n4673 n4732 0.33333333333333331
r6625 n4731 n4732 0.125
r6626 n4674 n4733 1
r6627 n4732 n4733 0.125
r6628 n4675 n4734 0.1111111111111111
r6629 n4733 n4734 0.3125
r6630 n4676 n4735 0.10000000000000001
r6631 n4734 n4735 0.59375
r6632 n4677 n4736 0.20000000000000001
r6633 n4735 n4736 0.46875
r6634 n4678 n4737 0.20000000000000001
r6635 n4736 n4737 0.3125
r6636 n4679 n4738 1
r6637 n4737 n4738 0.1875
r6638 n4680 n4739 0.5
r6639 n4738 n4739 0.09375
r6640 n4681 n4740 1
r6641 n4739 n4740 0.09375
r6642 n4682 n4741 1
r6643 n4740 n4741 0.0625
r6644 n4683 n4742 1
r6645 n4741 n4742 0.0625
r6646 n4684 n4743 0.25
r6647 n4742 n4743 0.15625
r6648 n4685 n4744 0.20000000000000001
r6649 n4743 n4744 0.28125
r6650 n4686 n4745 1
r6651 n4744 n4745 0.1875
r6652 n4687 n4746 0.10000000000000001
r6653 n4745 n4746 0.34375
r6654 n4688 n4747 0.20000000000000001
r6655 n4689 n4748 0.16666666666666666
r6656 n4747 n4748 0.34375
r6657 n4690 n4749 0.5
r6658 n4748 n4749 0.25
r6659 n4691 n4750 0.058823529411764705
r6660 n4749 n4750 0.59375
r6661 n4692 n4751 0.076923076923076927
r6662 n4750 n4751 0.9375
r6663 n4693 n4752 0.5
r6664 n4751 n4752 0.46875
r6665 n4694 n4753 0.5
r6666 n4752 n4753 0.125
r6667 n4695 n4754 0.25
r6668 n4753 n4754 0.1875
r6669 n4696 n4755 0.20000000000000001
r6670 n4754 n4755 0.28125
r6671 n4697 n4756 0.10000000000000001
r6672 n4698 n4757 0.040000000000000001
r6673 n4756 n4757 1.09375
r6674 n4699 n4758 1
r6675 n4757 n4758 0.8125
r6676 n4700 n4759 0.035714285714285712
r6677 n4758 n4759 0.90625
r6678 n4701 n4760 1
r6679 n4759 n4760 0.90625
r6680 n4702 n4761 0.040000000000000001
r6681 n4760 n4761 0.8125
r6682 n4703 n4762 0.10000000000000001
r6683 n4761 n4762 1.09375
r6684 n4704 n4763 0.011363636363636364
r6685 n4705 n4764 0.1875
r6686 n4763 n4764 0.546875
r6687 n4706 n4765 0.012500000000000001
r6688 n4764 n4765 0.5
r6689 n4707 n4766 0.1875
r6690 n4765 n4766 0.5
r6691 n4708 n4767 0.011363636363636364
r6692 n4766 n4767 0.546875
r6693 n4709 n4768 0.037499999999999999
r6694 n4767 n4768 0.671875
r6695 n4710 n4769 0.0091463414634146336
r6696 n4768 n4769 0.796875
r6697 n4711 n4770 0.0091463414634146336
r6698 n4769 n4770 1.28125
r6699 n4712 n4771 0.0091463414634146336
r6700 n4770 n4771 1.28125
r6701 n4713 n4772 0.011029411764705883
r6702 n4771 n4772 1.171875
r6703 n4714 n4773 0.013686131386861315
r6704 n4772 n4773 0.95937499999999998
r6705 n4715 n4774 0.01358695652173913
r6706 n4773 n4774 0.859375
r6707 n4716 n4775 0.011029411764705883
r6708 n4774 n4775 0.96250000000000002
r6709 n4717 n4776 0.028846153846153848
r6710 n4775 n4776 0.734375
r6711 n4718 n4777 0.0093749999999999997
r6712 n4776 n4777 0.828125
r6713 n4719 n4778 0.375
r6714 n4777 n4778 0.640625
r6715 n4720 n4779 0.011363636363636364
r6716 n4778 n4779 0.53125
r6717 n4721 n4780 0.375
r6718 n4779 n4780 0.53125
r6719 n4722 n4781 0.016304347826086956
r6720 n4780 n4781 0.375
r6721 n4723 n4782 0.09375
r6722 n4781 n4782 0.421875
r6723 n4724 n4783 0.0625
r6724 n4782 n4783 0.15625
r6725 n4725 n4784 0.074999999999999997
r6726 n4783 n4784 0.171875
r6727 n4726 n4785 0.375
r6728 n4784 n4785 0.09375
r6729 n4727 n4786 0.028846153846153848
r6730 n4785 n4786 0.21875
r6731 n4728 n4787 0.037499999999999999
r6732 n4786 n4787 0.359375
r6733 n4729 n4788 0.074999999999999997
r6734 n4787 n4788 0.234375
r6735 n4730 n4789 0.074999999999999997
r6736 n4788 n4789 0.15625
r6737 n4731 n4790 0.375
r6738 n4789 n4790 0.09375
r6739 n4732 n4791 0.125
r6740 n4790 n4791 0.0625
r6741 n4733 n4792 0.375
r6742 n4791 n4792 0.0625
r6743 n4734 n4793 0.041666666666666664
r6744 n4792 n4793 0.15625
r6745 n4735 n4794 0.037499999999999999
r6746 n4793 n4794 0.296875
r6747 n4736 n4795 0.074999999999999997
r6748 n4794 n4795 0.234375
r6749 n4737 n4796 0.074999999999999997
r6750 n4795 n4796 0.15625
r6751 n4738 n4797 0.375
r6752 n4796 n4797 0.09375
r6753 n4739 n4798 0.1875
r6754 n4797 n4798 0.046875
r6755 n4740 n4799 0.375
r6756 n4798 n4799 0.046875
r6757 n4741 n4800 0.375
r6758 n4799 n4800 0.03125
r6759 n4742 n4801 0.375
r6760 n4800 n4801 0.03125
r6761 n4743 n4802 0.09375
r6762 n4801 n4802 0.078125
r6763 n4744 n4803 0.074999999999999997
r6764 n4802 n4803 0.140625
r6765 n4745 n4804 0.375
r6766 n4803 n4804 0.09375
r6767 n4746 n4805 0.037499999999999999
r6768 n4804 n4805 0.171875
r6769 n4747 n4806 0.074999999999999997
r6770 n4748 n4807 0.0625
r6771 n4806 n4807 0.171875
r6772 n4749 n4808 0.1875
r6773 n4807 n4808 0.125
r6774 n4750 n4809 0.022058823529411766
r6775 n4808 n4809 0.296875
r6776 n4751 n4810 0.028846153846153848
r6777 n4809 n4810 0.46875
r6778 n4752 n4811 0.1875
r6779 n4810 n4811 0.234375
r6780 n4753 n4812 0.1875
r6781 n4811 n4812 0.0625
r6782 n4754 n4813 0.09375
r6783 n4812 n4813 0.09375
r6784 n4755 n4814 0.074999999999999997
r6785 n4813 n4814 0.140625
r6786 n4756 n4815 0.037499999999999999
r6787 n4757 n4816 0.014999999999999999
r6788 n4815 n4816 0.546875
r6789 n4758 n4817 0.375
r6790 n4816 n4817 0.40625
r6791 n4759 n4818 0.013392857142857142
r6792 n4817 n4818 0.453125
r6793 n4760 n4819 0.375
r6794 n4818 n4819 0.453125
r6795 n4761 n4820 0.014999999999999999
r6796 n4819 n4820 0.40625
r6797 n4762 n4821 0.037499999999999999
r6798 n4820 n4821 0.546875
r6799 n4763 n4822 0.011363636363636364
r6800 n4764 n4823 0.1875
r6801 n4822 n4823 1.09375
r6802 n4765 n4824 0.012500000000000001
r6803 n4823 n4824 1
r6804 n4766 n4825 0.1875
r6805 n4824 n4825 1
r6806 n4767 n4826 0.011363636363636364
r6807 n4825 n4826 1.09375
r6808 n4768 n4827 0.037499999999999999
r6809 n4826 n4827 1.34375
r6810 n4769 n4828 0.0091463414634146336
r6811 n4827 n4828 1.59375
r6812 n4770 n4829 0.0091463414634146336
r6813 n4828 n4829 2.5625
r6814 n4771 n4830 0.0091463414634146336
r6815 n4829 n4830 2.5625
r6816 n4772 n4831 0.011029411764705883
r6817 n4830 n4831 2.34375
r6818 n4773 n4832 0.013686131386861315
r6819 n4831 n4832 1.91875
r6820 n4774 n4833 0.01358695652173913
r6821 n4832 n4833 1.71875
r6822 n4775 n4834 0.011029411764705883
r6823 n4833 n4834 1.925
r6824 n4776 n4835 0.028846153846153848
r6825 n4834 n4835 1.46875
r6826 n4777 n4836 0.0093749999999999997
r6827 n4835 n4836 1.65625
r6828 n4778 n4837 0.375
r6829 n4836 n4837 1.28125
r6830 n4779 n4838 0.011363636363636364
r6831 n4837 n4838 1.0625
r6832 n4780 n4839 0.375
r6833 n4838 n4839 1.0625
r6834 n4781 n4840 0.016304347826086956
r6835 n4839 n4840 0.75
r6836 n4782 n4841 0.09375
r6837 n4840 n4841 0.84375
r6838 n4783 n4842 0.0625
r6839 n4841 n4842 0.3125
r6840 n4784 n4843 0.074999999999999997
r6841 n4842 n4843 0.34375
r6842 n4785 n4844 0.375
r6843 n4843 n4844 0.1875
r6844 n4786 n4845 0.028846153846153848
r6845 n4844 n4845 0.4375
r6846 n4787 n4846 0.037499999999999999
r6847 n4845 n4846 0.71875
r6848 n4788 n4847 0.074999999999999997
r6849 n4846 n4847 0.46875
r6850 n4789 n4848 0.074999999999999997
r6851 n4847 n4848 0.3125
r6852 n4790 n4849 0.375
r6853 n4848 n4849 0.1875
r6854 n4791 n4850 0.125
r6855 n4849 n4850 0.125
r6856 n4792 n4851 0.375
r6857 n4850 n4851 0.125
r6858 n4793 n4852 0.041666666666666664
r6859 n4851 n4852 0.3125
r6860 n4794 n4853 0.037499999999999999
r6861 n4852 n4853 0.59375
r6862 n4795 n4854 0.074999999999999997
r6863 n4853 n4854 0.46875
r6864 n4796 n4855 0.074999999999999997
r6865 n4854 n4855 0.3125
r6866 n4797 n4856 0.375
r6867 n4855 n4856 0.1875
r6868 n4798 n4857 0.1875
r6869 n4856 n4857 0.09375
r6870 n4799 n4858 0.375
r6871 n4857 n4858 0.09375
r6872 n4800 n4859 0.375
r6873 n4858 n4859 0.0625
r6874 n4801 n4860 0.375
r6875 n4859 n4860 0.0625
r6876 n4802 n4861 0.09375
r6877 n4860 n4861 0.15625
r6878 n4803 n4862 0.074999999999999997
r6879 n4861 n4862 0.28125
r6880 n4804 n4863 0.375
r6881 n4862 n4863 0.1875
r6882 n4805 n4864 0.037499999999999999
r6883 n4863 n4864 0.34375
r6884 n4806 n4865 0.074999999999999997
r6885 n4807 n4866 0.0625
r6886 n4865 n4866 0.34375
r6887 n4808 n4867 0.1875
r6888 n4866 n4867 0.25
r6889 n4809 n4868 0.022058823529411766
r6890 n4867 n4868 0.59375
r6891 n4810 n4869 0.028846153846153848
r6892 n4868 n4869 0.9375
r6893 n4811 n4870 0.1875
r6894 n4869 n4870 0.46875
r6895 n4812 n4871 0.1875
r6896 n4870 n4871 0.125
r6897 n4813 n4872 0.09375
r6898 n4871 n4872 0.1875
r6899 n4814 n4873 0.074999999999999997
r6900 n4872 n4873 0.28125
r6901 n4815 n4874 0.037499999999999999
r6902 n4816 n4875 0.014999999999999999
r6903 n4874 n4875 1.09375
r6904 n4817 n4876 0.375
r6905 n4875 n4876 0.8125
r6906 n4818 n4877 0.013392857142857142
r6907 n4876 n4877 0.90625
r6908 n4819 n4878 0.375
r6909 n4877 n4878 0.90625
r6910 n4820 n4879 0.014999999999999999
r6911 n4878 n4879 0.8125
r6912 n4821 n4880 0.037499999999999999
r6913 n4879 n4880 1.09375
r6914 n4822 n4881 0.005681818181818182
r6915 n4823 n4882 0.09375
r6916 n4881 n4882 2.1875
r6917 n4824 n4883 0.0062500000000000003
r6918 n4882 n4883 2
r6919 n4825 n4884 0.09375
r6920 n4883 n4884 2
r6921 n4826 n4885 0.005681818181818182
r6922 n4884 n4885 2.1875
r6923 n4827 n4886 0.018749999999999999
r6924 n4885 n4886 2.6875
r6925 n4828 n4887 0.0045731707317073168
r6926 n4886 n4887 3.1875
r6927 n4829 n4888 0.0045731707317073168
r6928 n4887 n4888 5.125
r6929 n4830 n4889 0.0045731707317073168
r6930 n4888 n4889 5.125
r6931 n4831 n4890 0.0055147058823529415
r6932 n4889 n4890 4.6875
r6933 n4832 n4891 0.0068430656934306573
r6934 n4890 n4891 3.8374999999999999
r6935 n4833 n4892 0.006793478260869565
r6936 n4891 n4892 3.4375
r6937 n4834 n4893 0.0055147058823529415
r6938 n4892 n4893 3.8500000000000001
r6939 n4835 n4894 0.014423076923076924
r6940 n4893 n4894 2.9375
r6941 n4836 n4895 0.0046874999999999998
r6942 n4894 n4895 3.3125
r6943 n4837 n4896 0.1875
r6944 n4895 n4896 2.5625
r6945 n4838 n4897 0.005681818181818182
r6946 n4896 n4897 2.125
r6947 n4839 n4898 0.1875
r6948 n4897 n4898 2.125
r6949 n4840 n4899 0.008152173913043478
r6950 n4898 n4899 1.5
r6951 n4841 n4900 0.046875
r6952 n4899 n4900 1.6875
r6953 n4842 n4901 0.03125
r6954 n4900 n4901 0.625
r6955 n4843 n4902 0.037499999999999999
r6956 n4901 n4902 0.6875
r6957 n4844 n4903 0.1875
r6958 n4902 n4903 0.375
r6959 n4845 n4904 0.014423076923076924
r6960 n4903 n4904 0.875
r6961 n4846 n4905 0.018749999999999999
r6962 n4904 n4905 1.4375
r6963 n4847 n4906 0.037499999999999999
r6964 n4905 n4906 0.9375
r6965 n4848 n4907 0.037499999999999999
r6966 n4906 n4907 0.625
r6967 n4849 n4908 0.1875
r6968 n4907 n4908 0.375
r6969 n4850 n4909 0.0625
r6970 n4908 n4909 0.25
r6971 n4851 n4910 0.1875
r6972 n4909 n4910 0.25
r6973 n4852 n4911 0.020833333333333332
r6974 n4910 n4911 0.625
r6975 n4853 n4912 0.018749999999999999
r6976 n4911 n4912 1.1875
r6977 n4854 n4913 0.037499999999999999
r6978 n4912 n4913 0.9375
r6979 n4855 n4914 0.037499999999999999
r6980 n4913 n4914 0.625
r6981 n4856 n4915 0.1875
r6982 n4914 n4915 0.375
r6983 n4857 n4916 0.09375
r6984 n4915 n4916 0.1875
r6985 n4858 n4917 0.1875
r6986 n4916 n4917 0.1875
r6987 n4859 n4918 0.1875
r6988 n4917 n4918 0.125
r6989 n4860 n4919 0.1875
r6990 n4918 n4919 0.125
r6991 n4861 n4920 0.046875
r6992 n4919 n4920 0.3125
r6993 n4862 n4921 0.037499999999999999
r6994 n4920 n4921 0.5625
r6995 n4863 n4922 0.1875
r6996 n4921 n4922 0.375
r6997 n4864 n4923 0.018749999999999999
r6998 n4922 n4923 0.6875
r6999 n4865 n4924 0.037499999999999999
r7000 n4866 n4925 0.03125
r7001 n4924 n4925 0.6875
r7002 n4867 n4926 0.09375
r7003 n4925 n4926 0.5
r7004 n4868 n4927 0.011029411764705883
r7005 n4926 n4927 1.1875
r7006 n4869 n4928 0.014423076923076924
r7007 n4927 n4928 1.875
r7008 n4870 n4929 0.09375
r7009 n4928 n4929 0.9375
r7010 n4871 n4930 0.09375
r7011 n4929 n4930 0.25
r7012 n4872 n4931 0.046875
r7013 n4930 n4931 0.375
r7014 n4873 n4932 0.037499999999999999
r7015 n4931 n4932 0.5625
r7016 n4874 n4933 0.018749999999999999
r7017 n4875 n4934 0.0074999999999999997
r7018 n4933 n4934 2.1875
r7019 n4876 n4935 0.1875
r7020 n4934 n4935 1.625
r7021 n4877 n4936 0.0066964285714285711
r7022 n4935 n4936 1.8125
r7023 n4878 n4937 0.1875
r7024 n4936 n4937 1.8125
r7025 n4879 n4938 0.0074999999999999997
r7026 n4937 n4938 1.625
r7027 n4880 n4939 0.018749999999999999
r7028 n4938 n4939 2.1875
r7029 n4881 n4940 0.00946969696969697
r7030 n4882 n4941 0.15625
r7031 n4940 n4941 0.546875
r7032 n4883 n4942 0.010416666666666666
r7033 n4941 n4942 0.5
r7034 n4884 n4943 0.15625
r7035 n4942 n4943 0.5
r7036 n4885 n4944 0.00946969696969697
r7037 n4943 n4944 0.546875
r7038 n4886 n4945 0.03125
r7039 n4944 n4945 0.671875
r7040 n4887 n4946 0.007621951219512195
r7041 n4945 n4946 0.796875
r7042 n4888 n4947 0.007621951219512195
r7043 n4946 n4947 1.28125
r7044 n4889 n4948 0.007621951219512195
r7045 n4947 n4948 1.28125
r7046 n4890 n4949 0.0091911764705882356
r7047 n4948 n4949 1.171875
r7048 n4891 n4950 0.011405109489051095
r7049 n4949 n4950 0.95937499999999998
r7050 n4892 n4951 0.011322463768115942
r7051 n4950 n4951 0.859375
r7052 n4893 n4952 0.0091911764705882356
r7053 n4951 n4952 0.96250000000000002
r7054 n4894 n4953 0.02403846153846154
r7055 n4952 n4953 0.734375
r7056 n4895 n4954 0.0078125
r7057 n4953 n4954 0.828125
r7058 n4896 n4955 0.3125
r7059 n4954 n4955 0.640625
r7060 n4897 n4956 0.00946969696969697
r7061 n4955 n4956 0.53125
r7062 n4898 n4957 0.3125
r7063 n4956 n4957 0.53125
r7064 n4899 n4958 0.01358695652173913
r7065 n4957 n4958 0.375
r7066 n4900 n4959 0.078125
r7067 n4958 n4959 0.421875
r7068 n4901 n4960 0.052083333333333336
r7069 n4959 n4960 0.15625
r7070 n4902 n4961 0.0625
r7071 n4960 n4961 0.171875
r7072 n4903 n4962 0.3125
r7073 n4961 n4962 0.09375
r7074 n4904 n4963 0.02403846153846154
r7075 n4962 n4963 0.21875
r7076 n4905 n4964 0.03125
r7077 n4963 n4964 0.359375
r7078 n4906 n4965 0.0625
r7079 n4964 n4965 0.234375
r7080 n4907 n4966 0.0625
r7081 n4965 n4966 0.15625
r7082 n4908 n4967 0.3125
r7083 n4966 n4967 0.09375
r7084 n4909 n4968 0.10416666666666667
r7085 n4967 n4968 0.0625
r7086 n4910 n4969 0.3125
r7087 n4968 n4969 0.0625
r7088 n4911 n4970 0.034722222222222224
r7089 n4969 n4970 0.15625
r7090 n4912 n4971 0.03125
r7091 n4970 n4971 0.296875
r7092 n4913 n4972 0.0625
r7093 n4971 n4972 0.234375
r7094 n4914 n4973 0.0625
r7095 n4972 n4973 0.15625
r7096 n4915 n4974 0.3125
r7097 n4973 n4974 0.09375
r7098 n4916 n4975 0.15625
r7099 n4974 n4975 0.046875
r7100 n4917 n4976 0.3125
r7101 n4975 n4976 0.046875
r7102 n4918 n4977 0.3125
r7103 n4976 n4977 0.03125
r7104 n4919 n4978 0.3125
r7105 n4977 n4978 0.03125
r7106 n4920 n4979 0.078125
r7107 n4978 n4979 0.078125
r7108 n4921 n4980 0.0625
r7109 n4979 n4980 0.140625
r7110 n4922 n4981 0.3125
r7111 n4980 n4981 0.09375
r7112 n4923 n4982 0.03125
r7113 n4981 n4982 0.171875
r7114 n4983 n4984 0.1875
r7115 n4924 n4985 0.0625
r7116 n4984 n4985 0.203125
r7117 n4925 n4986 0.052083333333333336
r7118 n4985 n4986 0.171875
r7119 n4926 n4987 0.15625
r7120 n4986 n4987 0.125
r7121 n4927 n4988 0.018382352941176471
r7122 n4987 n4988 0.296875
r7123 n4928 n4989 0.02403846153846154
r7124 n4988 n4989 0.46875
r7125 n4929 n4990 0.15625
r7126 n4989 n4990 0.234375
r7127 n4930 n4991 0.15625
r7128 n4990 n4991 0.0625
r7129 n4931 n4992 0.078125
r7130 n4991 n4992 0.09375
r7131 n4932 n4993 0.0625
r7132 n4992 n4993 0.140625
r7133 n4993 n4994 0.203125
r7134 n4994 n4995 0.1875
r7135 n4933 n4996 0.03125
r7136 n4934 n4997 0.012500000000000001
r7137 n4996 n4997 0.546875
r7138 n4935 n4998 0.3125
r7139 n4997 n4998 0.40625
r7140 n4936 n4999 0.011160714285714286
r7141 n4998 n4999 0.453125
r7142 n4937 n5000 0.3125
r7143 n4999 n5000 0.453125
r7144 n4938 n5001 0.012500000000000001
r7145 n5000 n5001 0.40625
r7146 n4939 n5002 0.03125
r7147 n5001 n5002 0.546875
r7148 n4940 n5003 0.011363636363636364
r7149 n4941 n5004 0.1875
r7150 n5003 n5004 1.09375
r7151 n4942 n5005 0.012500000000000001
r7152 n5004 n5005 1
r7153 n4943 n5006 0.1875
r7154 n5005 n5006 1
r7155 n4944 n5007 0.011363636363636364
r7156 n5006 n5007 1.09375
r7157 n4964 n5008 0.037499999999999999
r7158 n4965 n5009 0.074999999999999997
r7159 n5008 n5009 0.46875
r7160 n4966 n5010 0.074999999999999997
r7161 n5009 n5010 0.3125
r7162 n4967 n5011 0.375
r7163 n5010 n5011 0.1875
r7164 n4968 n5012 0.125
r7165 n5011 n5012 0.125
r7166 n4969 n5013 0.375
r7167 n5012 n5013 0.125
r7168 n4970 n5014 0.041666666666666664
r7169 n5013 n5014 0.3125
r7170 n4971 n5015 0.037499999999999999
r7171 n5014 n5015 0.59375
r7172 n4972 n5016 0.074999999999999997
r7173 n5015 n5016 0.46875
r7174 n4973 n5017 0.074999999999999997
r7175 n5016 n5017 0.3125
r7176 n4974 n5018 0.375
r7177 n5017 n5018 0.1875
r7178 n4975 n5019 0.1875
r7179 n5018 n5019 0.09375
r7180 n4976 n5020 0.375
r7181 n5019 n5020 0.09375
r7182 n4977 n5021 0.375
r7183 n5020 n5021 0.0625
r7184 n4978 n5022 0.375
r7185 n5021 n5022 0.0625
r7186 n4979 n5023 0.09375
r7187 n5022 n5023 0.15625
r7188 n4980 n5024 0.074999999999999997
r7189 n5023 n5024 0.28125
r7190 n4981 n5025 0.375
r7191 n5024 n5025 0.1875
r7192 n4982 n5026 0.037499999999999999
r7193 n5025 n5026 0.34375
r7194 n4983 n5027 0.09375
r7195 n4984 n5028 0.046875
r7196 n5027 n5028 0.375
r7197 n4985 n5029 0.074999999999999997
r7198 n5028 n5029 0.40625
r7199 n4986 n5030 0.0625
r7200 n5029 n5030 0.34375
r7201 n4987 n5031 0.1875
r7202 n5030 n5031 0.25
r7203 n4988 n5032 0.022058823529411766
r7204 n5031 n5032 0.59375
r7205 n4989 n5033 0.028846153846153848
r7206 n5032 n5033 0.9375
r7207 n4990 n5034 0.1875
r7208 n5033 n5034 0.46875
r7209 n4991 n5035 0.1875
r7210 n5034 n5035 0.125
r7211 n4992 n5036 0.09375
r7212 n5035 n5036 0.1875
r7213 n4993 n5037 0.074999999999999997
r7214 n5036 n5037 0.28125
r7215 n4994 n5038 0.046875
r7216 n5037 n5038 0.40625
r7217 n4995 n5039 0.09375
r7218 n5038 n5039 0.375
r7219 n4996 n5040 0.037499999999999999
r7220 n4997 n5041 0.014999999999999999
r7221 n5040 n5041 1.09375
r7222 n4998 n5042 0.375
r7223 n5041 n5042 0.8125
r7224 n4999 n5043 0.013392857142857142
r7225 n5042 n5043 0.90625
r7226 n5000 n5044 0.375
r7227 n5043 n5044 0.90625
r7228 n5001 n5045 0.014999999999999999
r7229 n5044 n5045 0.8125
r7230 n5002 n5046 0.037499999999999999
r7231 n5045 n5046 1.09375
r7232 n5003 n5047 0.013257575757575758
r7233 n5004 n5048 0.21875
r7234 n5047 n5048 0.4375
r7235 n5005 n5049 0.014583333333333334
r7236 n5048 n5049 0.40000000000000002
r7237 n5006 n5050 0.21875
r7238 n5049 n5050 0.40000000000000002
r7239 n5007 n5051 0.013257575757575758
r7240 n5050 n5051 0.4375
r7241 n5027 n5052 0.109375
r7242 n5028 n5053 0.0546875
r7243 n5052 n5053 0.14999999999999999
r7244 n5029 n5054 0.087499999999999994
r7245 n5053 n5054 0.16250000000000001
r7246 n5030 n5055 0.072916666666666671
r7247 n5054 n5055 0.13750000000000001
r7248 n5031 n5056 0.21875
r7249 n5055 n5056 0.10000000000000001
r7250 n5032 n5057 0.025735294117647058
r7251 n5056 n5057 0.23749999999999999
r7252 n5033 n5058 0.033653846153846152
r7253 n5057 n5058 0.375
r7254 n5034 n5059 0.21875
r7255 n5058 n5059 0.1875
r7256 n5035 n5060 0.21875
r7257 n5059 n5060 0.050000000000000003
r7258 n5036 n5061 0.109375
r7259 n5060 n5061 0.074999999999999997
r7260 n5037 n5062 0.087499999999999994
r7261 n5061 n5062 0.1125
r7262 n5038 n5063 0.0546875
r7263 n5062 n5063 0.16250000000000001
r7264 n5039 n5064 0.109375
r7265 n5063 n5064 0.14999999999999999
r7266 n5040 n5065 0.043749999999999997
r7267 n5041 n5066 0.017500000000000002
r7268 n5065 n5066 0.4375
r7269 n5042 n5067 0.4375
r7270 n5066 n5067 0.32500000000000001
r7271 n5043 n5068 0.015625
r7272 n5067 n5068 0.36249999999999999
r7273 n5044 n5069 0.4375
r7274 n5068 n5069 0.36249999999999999
r7275 n5045 n5070 0.017500000000000002
r7276 n5069 n5070 0.32500000000000001
r7277 n5046 n5071 0.043749999999999997
r7278 n5070 n5071 0.4375
r7279 n5047 n5072 0.013257575757575758
r7280 n5048 n5073 0.21875
r7281 n5072 n5073 1.09375
r7282 n5049 n5074 0.014583333333333334
r7283 n5073 n5074 1
r7284 n5050 n5075 0.21875
r7285 n5074 n5075 1
r7286 n5051 n5076 0.013257575757575758
r7287 n5075 n5076 1.09375
r7288 n5052 n5077 0.109375
r7289 n5053 n5078 0.0546875
r7290 n5077 n5078 0.375
r7291 n5054 n5079 0.087499999999999994
r7292 n5078 n5079 0.40625
r7293 n5055 n5080 0.072916666666666671
r7294 n5079 n5080 0.34375
r7295 n5056 n5081 0.21875
r7296 n5080 n5081 0.25
r7297 n5057 n5082 0.025735294117647058
r7298 n5081 n5082 0.59375
r7299 n5058 n5083 0.033653846153846152
r7300 n5082 n5083 0.9375
r7301 n5059 n5084 0.21875
r7302 n5083 n5084 0.46875
r7303 n5060 n5085 0.21875
r7304 n5084 n5085 0.125
r7305 n5061 n5086 0.109375
r7306 n5085 n5086 0.1875
r7307 n5062 n5087 0.087499999999999994
r7308 n5086 n5087 0.28125
r7309 n5063 n5088 0.0546875
r7310 n5087 n5088 0.40625
r7311 n5064 n5089 0.109375
r7312 n5088 n5089 0.375
r7313 n5065 n5090 0.043749999999999997
r7314 n5066 n5091 0.017500000000000002
r7315 n5090 n5091 1.09375
r7316 n5067 n5092 0.4375
r7317 n5091 n5092 0.8125
r7318 n5068 n5093 0.015625
r7319 n5092 n5093 0.90625
r7320 n5069 n5094 0.4375
r7321 n5093 n5094 0.90625
r7322 n5070 n5095 0.017500000000000002
r7323 n5094 n5095 0.8125
r7324 n5071 n5096 0.043749999999999997
r7325 n5095 n5096 1.09375
r7326 n5072 n5097 0.007575757575757576
r7327 n5073 n5098 0.125
r7328 n5097 n5098 1.09375
r7329 n5074 n5099 0.0083333333333333332
r7330 n5098 n5099 1
r7331 n5075 n5100 0.125
r7332 n5099 n5100 1
r7333 n5076 n5101 0.007575757575757576
r7334 n5100 n5101 1.09375
r7335 n5077 n5102 0.0625
r7336 n5078 n5103 0.03125
r7337 n5102 n5103 0.375
r7338 n5079 n5104 0.050000000000000003
r7339 n5103 n5104 0.40625
r7340 n5080 n5105 0.041666666666666664
r7341 n5104 n5105 0.34375
r7342 n5081 n5106 0.125
r7343 n5105 n5106 0.25
r7344 n5082 n5107 0.014705882352941176
r7345 n5106 n5107 0.59375
r7346 n5083 n5108 0.019230769230769232
r7347 n5107 n5108 0.9375
r7348 n5084 n5109 0.125
r7349 n5108 n5109 0.46875
r7350 n5085 n5110 0.125
r7351 n5109 n5110 0.125
r7352 n5086 n5111 0.0625
r7353 n5110 n5111 0.1875
r7354 n5087 n5112 0.050000000000000003
r7355 n5111 n5112 0.28125
r7356 n5088 n5113 0.03125
r7357 n5112 n5113 0.40625
r7358 n5089 n5114 0.0625
r7359 n5113 n5114 0.375
r7360 n5090 n5115 0.025000000000000001
r7361 n5091 n5116 0.01
r7362 n5115 n5116 1.09375
r7363 n5092 n5117 0.25
r7364 n5116 n5117 0.8125
r7365 n5093 n5118 0.0089285714285714281
r7366 n5117 n5118 0.90625
r7367 n5094 n5119 0.25
r7368 n5118 n5119 0.90625
r7369 n5095 n5120 0.01
r7370 n5119 n5120 0.8125
r7371 n5096 n5121 0.025000000000000001
r7372 n5120 n5121 1.09375
r7373 n5097 n5122 0.056818181818181816
r7374 n5098 n5123 0.9375
r7375 n5122 n5123 0.078125
r7376 n5099 n5124 0.0625
r7377 n5123 n5124 0.071428571428571425
r7378 n5100 n5125 0.9375
r7379 n5124 n5125 0.071428571428571425
r7380 n5101 n5126 0.056818181818181816
r7381 n5125 n5126 0.078125
r7382 n5102 n5127 0.46875
r7383 n5103 n5128 0.234375
r7384 n5127 n5128 0.026785714285714284
r7385 n5104 n5129 0.375
r7386 n5128 n5129 0.029017857142857144
r7387 n5105 n5130 0.3125
r7388 n5129 n5130 0.024553571428571428
r7389 n5106 n5131 0.9375
r7390 n5130 n5131 0.017857142857142856
r7391 n5107 n5132 0.11029411764705882
r7392 n5131 n5132 0.042410714285714288
r7393 n5108 n5133 0.14423076923076922
r7394 n5132 n5133 0.066964285714285712
r7395 n5109 n5134 0.9375
r7396 n5133 n5134 0.033482142857142856
r7397 n5110 n5135 0.9375
r7398 n5134 n5135 0.0089285714285714281
r7399 n5111 n5136 0.46875
r7400 n5135 n5136 0.013392857142857142
r7401 n5112 n5137 0.375
r7402 n5136 n5137 0.020089285714285716
r7403 n5113 n5138 0.234375
r7404 n5137 n5138 0.029017857142857144
r7405 n5114 n5139 0.46875
r7406 n5138 n5139 0.026785714285714284
r7407 n5115 n5140 0.1875
r7408 n5116 n5141 0.074999999999999997
r7409 n5140 n5141 0.078125
r7410 n5117 n5142 1.875
r7411 n5141 n5142 0.058035714285714288
r7412 n5118 n5143 0.066964285714285712
r7413 n5142 n5143 0.064732142857142863
r7414 n5119 n5144 1.875
r7415 n5143 n5144 0.064732142857142863
r7416 n5120 n5145 0.074999999999999997
r7417 n5144 n5145 0.058035714285714288
r7418 n5121 n5146 0.1875
r7419 n5145 n5146 0.078125
r7420 n5122 n5147 0.056818181818181816
r7421 n5123 n5148 0.9375
r7422 n5147 n5148 1.09375
r7423 n5124 n5149 0.0625
r7424 n5148 n5149 1
r7425 n5125 n5150 0.9375
r7426 n5149 n5150 1
r7427 n5126 n5151 0.056818181818181816
r7428 n5150 n5151 1.09375
r7429 n5152 n5153 0.46875
r7430 n5153 n5154 0.3125
r7431 n5154 n5155 0.1875
r7432 n5155 n5156 0.125
r7433 n5156 n5157 0.125
r7434 n5157 n5158 0.3125
r7435 n5158 n5159 0.59375
r7436 n5159 n5160 0.46875
r7437 n5160 n5161 0.3125
r7438 n5161 n5162 0.1875
r7439 n5162 n5163 0.09375
r7440 n5163 n5164 0.09375
r7441 n5164 n5165 0.0625
r7442 n5165 n5166 0.0625
r7443 n5166 n5167 0.15625
r7444 n5167 n5168 0.28125
r7445 n5168 n5169 0.1875
r7446 n5169 n5170 0.34375
r7447 n5127 n5171 0.46875
r7448 n5128 n5172 0.234375
r7449 n5171 n5172 0.375
r7450 n5129 n5173 0.375
r7451 n5172 n5173 0.40625
r7452 n5130 n5174 0.3125
r7453 n5173 n5174 0.34375
r7454 n5131 n5175 0.9375
r7455 n5174 n5175 0.25
r7456 n5132 n5176 0.11029411764705882
r7457 n5175 n5176 0.59375
r7458 n5133 n5177 0.14423076923076922
r7459 n5176 n5177 0.9375
r7460 n5134 n5178 0.9375
r7461 n5177 n5178 0.46875
r7462 n5135 n5179 0.9375
r7463 n5178 n5179 0.125
r7464 n5136 n5180 0.46875
r7465 n5179 n5180 0.1875
r7466 n5137 n5181 0.375
r7467 n5180 n5181 0.28125
r7468 n5138 n5182 0.234375
r7469 n5181 n5182 0.40625
r7470 n5139 n5183 0.46875
r7471 n5182 n5183 0.375
r7472 n5140 n5184 0.1875
r7473 n5141 n5185 0.074999999999999997
r7474 n5184 n5185 1.09375
r7475 n5142 n5186 1.875
r7476 n5185 n5186 0.8125
r7477 n5143 n5187 0.066964285714285712
r7478 n5186 n5187 0.90625
r7479 n5144 n5188 1.875
r7480 n5187 n5188 0.90625
r7481 n5145 n5189 0.074999999999999997
r7482 n5188 n5189 0.8125
r7483 n5146 n5190 0.1875
r7484 n5189 n5190 1.09375
r7485 n5147 n5191 0.007575757575757576
r7486 n5148 n5192 0.125
r7487 n5191 n5192 1.09375
r7488 n5149 n5193 0.0083333333333333332
r7489 n5192 n5193 1
r7490 n5150 n5194 0.125
r7491 n5193 n5194 1
r7492 n5151 n5195 0.007575757575757576
r7493 n5194 n5195 1.09375
r7494 n5152 n5196 0.025000000000000001
r7495 n5153 n5197 0.050000000000000003
r7496 n5196 n5197 0.46875
r7497 n5154 n5198 0.050000000000000003
r7498 n5197 n5198 0.3125
r7499 n5155 n5199 0.25
r7500 n5198 n5199 0.1875
r7501 n5156 n5200 0.083333333333333329
r7502 n5199 n5200 0.125
r7503 n5157 n5201 0.25
r7504 n5200 n5201 0.125
r7505 n5158 n5202 0.027777777777777776
r7506 n5201 n5202 0.3125
r7507 n5159 n5203 0.025000000000000001
r7508 n5202 n5203 0.59375
r7509 n5160 n5204 0.050000000000000003
r7510 n5203 n5204 0.46875
r7511 n5161 n5205 0.050000000000000003
r7512 n5204 n5205 0.3125
r7513 n5162 n5206 0.25
r7514 n5205 n5206 0.1875
r7515 n5163 n5207 0.125
r7516 n5206 n5207 0.09375
r7517 n5164 n5208 0.25
r7518 n5207 n5208 0.09375
r7519 n5165 n5209 0.25
r7520 n5208 n5209 0.0625
r7521 n5166 n5210 0.25
r7522 n5209 n5210 0.0625
r7523 n5167 n5211 0.0625
r7524 n5210 n5211 0.15625
r7525 n5168 n5212 0.050000000000000003
r7526 n5211 n5212 0.28125
r7527 n5169 n5213 0.25
r7528 n5212 n5213 0.1875
r7529 n5170 n5214 0.025000000000000001
r7530 n5213 n5214 0.34375
r7531 n5171 n5215 0.0625
r7532 n5172 n5216 0.03125
r7533 n5215 n5216 0.375
r7534 n5173 n5217 0.050000000000000003
r7535 n5216 n5217 0.40625
r7536 n5174 n5218 0.041666666666666664
r7537 n5217 n5218 0.34375
r7538 n5175 n5219 0.125
r7539 n5218 n5219 0.25
r7540 n5176 n5220 0.014705882352941176
r7541 n5219 n5220 0.59375
r7542 n5177 n5221 0.019230769230769232
r7543 n5220 n5221 0.9375
r7544 n5178 n5222 0.125
r7545 n5221 n5222 0.46875
r7546 n5179 n5223 0.125
r7547 n5222 n5223 0.125
r7548 n5180 n5224 0.0625
r7549 n5223 n5224 0.1875
r7550 n5181 n5225 0.050000000000000003
r7551 n5224 n5225 0.28125
r7552 n5182 n5226 0.03125
r7553 n5225 n5226 0.40625
r7554 n5183 n5227 0.0625
r7555 n5226 n5227 0.375
r7556 n5184 n5228 0.025000000000000001
r7557 n5185 n5229 0.01
r7558 n5228 n5229 1.09375
r7559 n5186 n5230 0.25
r7560 n5229 n5230 0.8125
r7561 n5187 n5231 0.0089285714285714281
r7562 n5230 n5231 0.90625
r7563 n5188 n5232 0.25
r7564 n5231 n5232 0.90625
r7565 n5189 n5233 0.01
r7566 n5232 n5233 0.8125
r7567 n5190 n5234 0.025000000000000001
r7568 n5233 n5234 1.09375
r7569 n5191 n5235 0.007575757575757576
r7570 n5192 n5236 0.125
r7571 n5235 n5236 1.09375
r7572 n5193 n5237 0.0083333333333333332
r7573 n5236 n5237 1
r7574 n5194 n5238 0.125
r7575 n5237 n5238 1
r7576 n5195 n5239 0.007575757575757576
r7577 n5238 n5239 1.09375
r7578 n5196 n5240 0.025000000000000001
r7579 n5197 n5241 0.050000000000000003
r7580 n5240 n5241 0.46875
r7581 n5198 n5242 0.050000000000000003
r7582 n5241 n5242 0.3125
r7583 n5199 n5243 0.25
r7584 n5242 n5243 0.1875
r7585 n5200 n5244 0.083333333333333329
r7586 n5243 n5244 0.125
r7587 n5201 n5245 0.25
r7588 n5244 n5245 0.125
r7589 n5202 n5246 0.027777777777777776
r7590 n5245 n5246 0.3125
r7591 n5203 n5247 0.025000000000000001
r7592 n5246 n5247 0.59375
r7593 n5204 n5248 0.050000000000000003
r7594 n5247 n5248 0.46875
r7595 n5205 n5249 0.050000000000000003
r7596 n5248 n5249 0.3125
r7597 n5206 n5250 0.25
r7598 n5249 n5250 0.1875
r7599 n5207 n5251 0.125
r7600 n5250 n5251 0.09375
r7601 n5208 n5252 0.25
r7602 n5251 n5252 0.09375
r7603 n5209 n5253 0.25
r7604 n5252 n5253 0.0625
r7605 n5210 n5254 0.25
r7606 n5253 n5254 0.0625
r7607 n5211 n5255 0.0625
r7608 n5254 n5255 0.15625
r7609 n5212 n5256 0.050000000000000003
r7610 n5255 n5256 0.28125
r7611 n5213 n5257 0.25
r7612 n5256 n5257 0.1875
r7613 n5214 n5258 0.025000000000000001
r7614 n5257 n5258 0.34375
r7615 n5215 n5259 0.0625
r7616 n5216 n5260 0.03125
r7617 n5259 n5260 0.375
r7618 n5217 n5261 0.050000000000000003
r7619 n5260 n5261 0.40625
r7620 n5218 n5262 0.041666666666666664
r7621 n5261 n5262 0.34375
r7622 n5219 n5263 0.125
r7623 n5262 n5263 0.25
r7624 n5220 n5264 0.014705882352941176
r7625 n5263 n5264 0.59375
r7626 n5221 n5265 0.019230769230769232
r7627 n5264 n5265 0.9375
r7628 n5222 n5266 0.125
r7629 n5265 n5266 0.46875
r7630 n5223 n5267 0.125
r7631 n5266 n5267 0.125
r7632 n5224 n5268 0.0625
r7633 n5267 n5268 0.1875
r7634 n5225 n5269 0.050000000000000003
r7635 n5268 n5269 0.28125
r7636 n5226 n5270 0.03125
r7637 n5269 n5270 0.40625
r7638 n5227 n5271 0.0625
r7639 n5270 n5271 0.375
r7640 n5228 n5272 0.025000000000000001
r7641 n5229 n5273 0.01
r7642 n5272 n5273 1.09375
r7643 n5230 n5274 0.25
r7644 n5273 n5274 0.8125
r7645 n5231 n5275 0.0089285714285714281
r7646 n5274 n5275 0.90625
r7647 n5232 n5276 0.25
r7648 n5275 n5276 0.90625
r7649 n5233 n5277 0.01
r7650 n5276 n5277 0.8125
r7651 n5234 n5278 0.025000000000000001
r7652 n5277 n5278 1.09375
r7653 n5235 n5279 0.011363636363636364
r7654 n5236 n5280 0.1875
r7655 n5279 n5280 0.546875
r7656 n5237 n5281 0.012500000000000001
r7657 n5280 n5281 0.5
r7658 n5238 n5282 0.1875
r7659 n5281 n5282 0.5
r7660 n5239 n5283 0.011363636363636364
r7661 n5282 n5283 0.546875
r7662 n5240 n5284 0.037499999999999999
r7663 n5241 n5285 0.074999999999999997
r7664 n5284 n5285 0.234375
r7665 n5242 n5286 0.074999999999999997
r7666 n5285 n5286 0.15625
r7667 n5243 n5287 0.375
r7668 n5286 n5287 0.09375
r7669 n5244 n5288 0.125
r7670 n5287 n5288 0.0625
r7671 n5245 n5289 0.375
r7672 n5288 n5289 0.0625
r7673 n5246 n5290 0.041666666666666664
r7674 n5289 n5290 0.15625
r7675 n5247 n5291 0.037499999999999999
r7676 n5290 n5291 0.296875
r7677 n5248 n5292 0.074999999999999997
r7678 n5291 n5292 0.234375
r7679 n5249 n5293 0.074999999999999997
r7680 n5292 n5293 0.15625
r7681 n5250 n5294 0.375
r7682 n5293 n5294 0.09375
r7683 n5251 n5295 0.1875
r7684 n5294 n5295 0.046875
r7685 n5252 n5296 0.375
r7686 n5295 n5296 0.046875
r7687 n5253 n5297 0.375
r7688 n5296 n5297 0.03125
r7689 n5254 n5298 0.375
r7690 n5297 n5298 0.03125
r7691 n5255 n5299 0.09375
r7692 n5298 n5299 0.078125
r7693 n5256 n5300 0.074999999999999997
r7694 n5299 n5300 0.140625
r7695 n5257 n5301 0.375
r7696 n5300 n5301 0.09375
r7697 n5258 n5302 0.037499999999999999
r7698 n5301 n5302 0.171875
r7699 n5259 n5303 0.09375
r7700 n5260 n5304 0.046875
r7701 n5303 n5304 0.1875
r7702 n5261 n5305 0.074999999999999997
r7703 n5304 n5305 0.203125
r7704 n5262 n5306 0.0625
r7705 n5305 n5306 0.171875
r7706 n5263 n5307 0.1875
r7707 n5306 n5307 0.125
r7708 n5264 n5308 0.022058823529411766
r7709 n5307 n5308 0.296875
r7710 n5265 n5309 0.028846153846153848
r7711 n5308 n5309 0.46875
r7712 n5266 n5310 0.1875
r7713 n5309 n5310 0.234375
r7714 n5267 n5311 0.1875
r7715 n5310 n5311 0.0625
r7716 n5268 n5312 0.09375
r7717 n5311 n5312 0.09375
r7718 n5269 n5313 0.074999999999999997
r7719 n5312 n5313 0.140625
r7720 n5270 n5314 0.046875
r7721 n5313 n5314 0.203125
r7722 n5271 n5315 0.09375
r7723 n5314 n5315 0.1875
r7724 n5272 n5316 0.037499999999999999
r7725 n5273 n5317 0.014999999999999999
r7726 n5316 n5317 0.546875
r7727 n5274 n5318 0.375
r7728 n5317 n5318 0.40625
r7729 n5275 n5319 0.013392857142857142
r7730 n5318 n5319 0.453125
r7731 n5276 n5320 0.375
r7732 n5319 n5320 0.453125
r7733 n5277 n5321 0.014999999999999999
r7734 n5320 n5321 0.40625
r7735 n5278 n5322 0.037499999999999999
r7736 n5321 n5322 0.546875
r7737 n5279 n5323 0.020833333333333332
r7738 n5280 n5324 0.34375
r7739 n5323 n5324 0.3125
r7740 n5281 n5325 0.022916666666666665
r7741 n5324 n5325 0.2857142857142857
r7742 n5282 n5326 0.34375
r7743 n5325 n5326 0.2857142857142857
r7744 n5283 n5327 0.020833333333333332
r7745 n5326 n5327 0.3125
r7746 n5284 n5328 0.068750000000000006
r7747 n5285 n5329 0.13750000000000001
r7748 n5328 n5329 0.13392857142857142
r7749 n5286 n5330 0.13750000000000001
r7750 n5329 n5330 0.089285714285714288
r7751 n5287 n5331 0.6875
r7752 n5330 n5331 0.053571428571428568
r7753 n5288 n5332 0.22916666666666666
r7754 n5331 n5332 0.035714285714285712
r7755 n5289 n5333 0.6875
r7756 n5332 n5333 0.035714285714285712
r7757 n5290 n5334 0.076388888888888895
r7758 n5333 n5334 0.089285714285714288
r7759 n5291 n5335 0.068750000000000006
r7760 n5334 n5335 0.16964285714285715
r7761 n5292 n5336 0.13750000000000001
r7762 n5335 n5336 0.13392857142857142
r7763 n5293 n5337 0.13750000000000001
r7764 n5336 n5337 0.089285714285714288
r7765 n5294 n5338 0.6875
r7766 n5337 n5338 0.053571428571428568
r7767 n5295 n5339 0.34375
r7768 n5338 n5339 0.026785714285714284
r7769 n5296 n5340 0.6875
r7770 n5339 n5340 0.026785714285714284
r7771 n5297 n5341 0.6875
r7772 n5340 n5341 0.017857142857142856
r7773 n5298 n5342 0.6875
r7774 n5341 n5342 0.017857142857142856
r7775 n5299 n5343 0.171875
r7776 n5342 n5343 0.044642857142857144
r7777 n5300 n5344 0.13750000000000001
r7778 n5343 n5344 0.080357142857142863
r7779 n5301 n5345 0.6875
r7780 n5344 n5345 0.053571428571428568
r7781 n5302 n5346 0.068750000000000006
r7782 n5345 n5346 0.098214285714285712
r7783 n5303 n5347 0.171875
r7784 n5304 n5348 0.0859375
r7785 n5347 n5348 0.10714285714285714
r7786 n5305 n5349 0.13750000000000001
r7787 n5348 n5349 0.11607142857142858
r7788 n5306 n5350 0.11458333333333333
r7789 n5349 n5350 0.098214285714285712
r7790 n5307 n5351 0.34375
r7791 n5350 n5351 0.071428571428571425
r7792 n5308 n5352 0.040441176470588237
r7793 n5351 n5352 0.16964285714285715
r7794 n5309 n5353 0.052884615384615384
r7795 n5352 n5353 0.26785714285714285
r7796 n5310 n5354 0.34375
r7797 n5353 n5354 0.13392857142857142
r7798 n5311 n5355 0.34375
r7799 n5354 n5355 0.035714285714285712
r7800 n5312 n5356 0.171875
r7801 n5355 n5356 0.053571428571428568
r7802 n5313 n5357 0.13750000000000001
r7803 n5356 n5357 0.080357142857142863
r7804 n5314 n5358 0.0859375
r7805 n5357 n5358 0.11607142857142858
r7806 n5315 n5359 0.171875
r7807 n5358 n5359 0.10714285714285714
r7808 n5316 n5360 0.068750000000000006
r7809 n5317 n5361 0.0275
r7810 n5360 n5361 0.3125
r7811 n5318 n5362 0.6875
r7812 n5361 n5362 0.23214285714285715
r7813 n5319 n5363 0.024553571428571428
r7814 n5362 n5363 0.25892857142857145
r7815 n5320 n5364 0.6875
r7816 n5363 n5364 0.25892857142857145
r7817 n5321 n5365 0.0275
r7818 n5364 n5365 0.23214285714285715
r7819 n5322 n5366 0.068750000000000006
r7820 n5365 n5366 0.3125
r7821 n5323 n5367 0.01893939393939394
r7822 n5324 n5368 0.3125
r7823 n5367 n5368 0.72916666666666663
r7824 n5325 n5369 0.020833333333333332
r7825 n5368 n5369 0.66666666666666663
r7826 n5326 n5370 0.3125
r7827 n5369 n5370 0.66666666666666663
r7828 n5327 n5371 0.01893939393939394
r7829 n5370 n5371 0.72916666666666663
r7830 n5328 n5372 0.0625
r7831 n5329 n5373 0.125
r7832 n5372 n5373 0.3125
r7833 n5330 n5374 0.125
r7834 n5373 n5374 0.20833333333333334
r7835 n5331 n5375 0.625
r7836 n5374 n5375 0.125
r7837 n5332 n5376 0.20833333333333334
r7838 n5375 n5376 0.083333333333333329
r7839 n5333 n5377 0.625
r7840 n5376 n5377 0.083333333333333329
r7841 n5334 n5378 0.069444444444444448
r7842 n5377 n5378 0.20833333333333334
r7843 n5335 n5379 0.0625
r7844 n5378 n5379 0.39583333333333331
r7845 n5336 n5380 0.125
r7846 n5379 n5380 0.3125
r7847 n5337 n5381 0.125
r7848 n5380 n5381 0.20833333333333334
r7849 n5338 n5382 0.625
r7850 n5381 n5382 0.125
r7851 n5339 n5383 0.3125
r7852 n5382 n5383 0.0625
r7853 n5340 n5384 0.625
r7854 n5383 n5384 0.0625
r7855 n5341 n5385 0.625
r7856 n5384 n5385 0.041666666666666664
r7857 n5342 n5386 0.625
r7858 n5385 n5386 0.041666666666666664
r7859 n5343 n5387 0.15625
r7860 n5386 n5387 0.10416666666666667
r7861 n5344 n5388 0.125
r7862 n5387 n5388 0.1875
r7863 n5345 n5389 0.625
r7864 n5388 n5389 0.125
r7865 n5346 n5390 0.0625
r7866 n5389 n5390 0.22916666666666666
r7867 n5360 n5391 0.0625
r7868 n5361 n5392 0.025000000000000001
r7869 n5391 n5392 0.72916666666666663
r7870 n5362 n5393 0.625
r7871 n5392 n5393 0.54166666666666663
r7872 n5363 n5394 0.022321428571428572
r7873 n5393 n5394 0.60416666666666663
r7874 n5364 n5395 0.625
r7875 n5394 n5395 0.60416666666666663
r7876 n5365 n5396 0.025000000000000001
r7877 n5395 n5396 0.54166666666666663
r7878 n5366 n5397 0.0625
r7879 n5396 n5397 0.72916666666666663
r7880 n5367 n5398 0.011363636363636364
r7881 n5368 n5399 0.1875
r7882 n5398 n5399 0.72916666666666663
r7883 n5369 n5400 0.012500000000000001
r7884 n5399 n5400 0.66666666666666663
r7885 n5370 n5401 0.1875
r7886 n5400 n5401 0.66666666666666663
r7887 n5371 n5402 0.011363636363636364
r7888 n5401 n5402 0.72916666666666663
r7889 n5372 n5403 0.037499999999999999
r7890 n5373 n5404 0.074999999999999997
r7891 n5403 n5404 0.3125
r7892 n5374 n5405 0.074999999999999997
r7893 n5404 n5405 0.20833333333333334
r7894 n5375 n5406 0.375
r7895 n5405 n5406 0.125
r7896 n5376 n5407 0.125
r7897 n5406 n5407 0.083333333333333329
r7898 n5377 n5408 0.375
r7899 n5407 n5408 0.083333333333333329
r7900 n5378 n5409 0.041666666666666664
r7901 n5408 n5409 0.20833333333333334
r7902 n5379 n5410 0.037499999999999999
r7903 n5409 n5410 0.39583333333333331
r7904 n5380 n5411 0.074999999999999997
r7905 n5410 n5411 0.3125
r7906 n5381 n5412 0.074999999999999997
r7907 n5411 n5412 0.20833333333333334
r7908 n5382 n5413 0.375
r7909 n5412 n5413 0.125
r7910 n5383 n5414 0.1875
r7911 n5413 n5414 0.0625
r7912 n5384 n5415 0.375
r7913 n5414 n5415 0.0625
r7914 n5385 n5416 0.375
r7915 n5415 n5416 0.041666666666666664
r7916 n5386 n5417 0.375
r7917 n5416 n5417 0.041666666666666664
r7918 n5387 n5418 0.09375
r7919 n5417 n5418 0.10416666666666667
r7920 n5388 n5419 0.074999999999999997
r7921 n5418 n5419 0.1875
r7922 n5389 n5420 0.375
r7923 n5419 n5420 0.125
r7924 n5390 n5421 0.037499999999999999
r7925 n5420 n5421 0.22916666666666666
r7926 n5391 n5422 0.037499999999999999
r7927 n5392 n5423 0.014999999999999999
r7928 n5422 n5423 0.72916666666666663
r7929 n5393 n5424 0.375
r7930 n5423 n5424 0.54166666666666663
r7931 n5394 n5425 0.013392857142857142
r7932 n5424 n5425 0.60416666666666663
r7933 n5395 n5426 0.375
r7934 n5425 n5426 0.60416666666666663
r7935 n5396 n5427 0.014999999999999999
r7936 n5426 n5427 0.54166666666666663
r7937 n5397 n5428 0.037499999999999999
r7938 n5427 n5428 0.72916666666666663
r7939 n5398 n5429 0.00946969696969697
r7940 n5399 n5430 0.15625
r7941 n5429 n5430 1.09375
r7942 n5400 n5431 0.010416666666666666
r7943 n5430 n5431 1
r7944 n5401 n5432 0.15625
r7945 n5431 n5432 1
r7946 n5402 n5433 0.00946969696969697
r7947 n5432 n5433 1.09375
r7948 n5403 n5434 0.03125
r7949 n5404 n5435 0.0625
r7950 n5434 n5435 0.46875
r7951 n5405 n5436 0.0625
r7952 n5435 n5436 0.3125
r7953 n5406 n5437 0.3125
r7954 n5436 n5437 0.1875
r7955 n5407 n5438 0.10416666666666667
r7956 n5437 n5438 0.125
r7957 n5408 n5439 0.3125
r7958 n5438 n5439 0.125
r7959 n5409 n5440 0.034722222222222224
r7960 n5439 n5440 0.3125
r7961 n5410 n5441 0.03125
r7962 n5440 n5441 0.59375
r7963 n5411 n5442 0.0625
r7964 n5441 n5442 0.46875
r7965 n5412 n5443 0.0625
r7966 n5442 n5443 0.3125
r7967 n5413 n5444 0.3125
r7968 n5443 n5444 0.1875
r7969 n5414 n5445 0.15625
r7970 n5444 n5445 0.09375
r7971 n5415 n5446 0.3125
r7972 n5445 n5446 0.09375
r7973 n5416 n5447 0.3125
r7974 n5446 n5447 0.0625
r7975 n5417 n5448 0.3125
r7976 n5447 n5448 0.0625
r7977 n5418 n5449 0.078125
r7978 n5448 n5449 0.15625
r7979 n5419 n5450 0.0625
r7980 n5449 n5450 0.28125
r7981 n5420 n5451 0.3125
r7982 n5450 n5451 0.1875
r7983 n5421 n5452 0.03125
r7984 n5451 n5452 0.34375
r7985 n5422 n5453 0.03125
r7986 n5423 n5454 0.012500000000000001
r7987 n5453 n5454 1.09375
r7988 n5424 n5455 0.3125
r7989 n5454 n5455 0.8125
r7990 n5425 n5456 0.011160714285714286
r7991 n5455 n5456 0.90625
r7992 n5426 n5457 0.3125
r7993 n5456 n5457 0.90625
r7994 n5427 n5458 0.012500000000000001
r7995 n5457 n5458 0.8125
r7996 n5428 n5459 0.03125
r7997 n5458 n5459 1.09375
r7998 n5429 n5460 0.032196969696969696
r7999 n5430 n5461 0.53125
r8000 n5460 n5461 0.14583333333333334
r8001 n5431 n5462 0.035416666666666666
r8002 n5461 n5462 0.13333333333333333
r8003 n5432 n5463 0.53125
r8004 n5462 n5463 0.13333333333333333
r8005 n5433 n5464 0.032196969696969696
r8006 n5463 n5464 0.14583333333333334
r8007 n5434 n5465 0.10625
r8008 n5435 n5466 0.21249999999999999
r8009 n5465 n5466 0.0625
r8010 n5436 n5467 0.21249999999999999
r8011 n5466 n5467 0.041666666666666664
r8012 n5437 n5468 1.0625
r8013 n5467 n5468 0.025000000000000001
r8014 n5438 n5469 0.35416666666666669
r8015 n5468 n5469 0.016666666666666666
r8016 n5439 n5470 1.0625
r8017 n5469 n5470 0.016666666666666666
r8018 n5440 n5471 0.11805555555555555
r8019 n5470 n5471 0.041666666666666664
r8020 n5441 n5472 0.10625
r8021 n5471 n5472 0.079166666666666663
r8022 n5442 n5473 0.21249999999999999
r8023 n5472 n5473 0.0625
r8024 n5443 n5474 0.21249999999999999
r8025 n5473 n5474 0.041666666666666664
r8026 n5444 n5475 1.0625
r8027 n5474 n5475 0.025000000000000001
r8028 n5445 n5476 0.53125
r8029 n5475 n5476 0.012500000000000001
r8030 n5446 n5477 1.0625
r8031 n5476 n5477 0.012500000000000001
r8032 n5447 n5478 1.0625
r8033 n5477 n5478 0.0083333333333333332
r8034 n5448 n5479 1.0625
r8035 n5478 n5479 0.0083333333333333332
r8036 n5449 n5480 0.265625
r8037 n5479 n5480 0.020833333333333332
r8038 n5450 n5481 0.21249999999999999
r8039 n5480 n5481 0.037499999999999999
r8040 n5451 n5482 1.0625
r8041 n5481 n5482 0.025000000000000001
r8042 n5452 n5483 0.10625
r8043 n5482 n5483 0.04583333333333333
r8044 n5453 n5484 0.10625
r8045 n5454 n5485 0.042500000000000003
r8046 n5484 n5485 0.14583333333333334
r8047 n5455 n5486 1.0625
r8048 n5485 n5486 0.10833333333333334
r8049 n5456 n5487 0.037946428571428568
r8050 n5486 n5487 0.12083333333333333
r8051 n5457 n5488 1.0625
r8052 n5487 n5488 0.12083333333333333
r8053 n5458 n5489 0.042500000000000003
r8054 n5488 n5489 0.10833333333333334
r8055 n5459 n5490 0.10625
r8056 n5489 n5490 0.14583333333333334
r8057 n5460 n5491 0.056818181818181816
r8058 n5461 n5492 0.9375
r8059 n5491 n5492 0.14583333333333334
r8060 n5462 n5493 0.0625
r8061 n5492 n5493 0.13333333333333333
r8062 n5463 n5494 0.9375
r8063 n5493 n5494 0.13333333333333333
r8064 n5464 n5495 0.056818181818181816
r8065 n5494 n5495 0.14583333333333334
r8066 n5465 n5496 0.1875
r8067 n5466 n5497 0.375
r8068 n5496 n5497 0.0625
r8069 n5467 n5498 0.375
r8070 n5497 n5498 0.041666666666666664
r8071 n5468 n5499 1.875
r8072 n5498 n5499 0.025000000000000001
r8073 n5469 n5500 0.625
r8074 n5499 n5500 0.016666666666666666
r8075 n5470 n5501 1.875
r8076 n5500 n5501 0.016666666666666666
r8077 n5471 n5502 0.20833333333333334
r8078 n5501 n5502 0.041666666666666664
r8079 n5472 n5503 0.1875
r8080 n5502 n5503 0.079166666666666663
r8081 n5473 n5504 0.375
r8082 n5503 n5504 0.0625
r8083 n5474 n5505 0.375
r8084 n5504 n5505 0.041666666666666664
r8085 n5475 n5506 1.875
r8086 n5505 n5506 0.025000000000000001
r8087 n5476 n5507 0.9375
r8088 n5506 n5507 0.012500000000000001
r8089 n5477 n5508 1.875
r8090 n5507 n5508 0.012500000000000001
r8091 n5478 n5509 1.875
r8092 n5508 n5509 0.0083333333333333332
r8093 n5479 n5510 1.875
r8094 n5509 n5510 0.0083333333333333332
r8095 n5480 n5511 0.46875
r8096 n5510 n5511 0.020833333333333332
r8097 n5481 n5512 0.375
r8098 n5511 n5512 0.037499999999999999
r8099 n5482 n5513 1.875
r8100 n5512 n5513 0.025000000000000001
r8101 n5483 n5514 0.1875
r8102 n5513 n5514 0.04583333333333333
r8103 n5484 n5515 0.1875
r8104 n5485 n5516 0.074999999999999997
r8105 n5515 n5516 0.14583333333333334
r8106 n5486 n5517 1.875
r8107 n5516 n5517 0.10833333333333334
r8108 n5487 n5518 0.066964285714285712
r8109 n5517 n5518 0.12083333333333333
r8110 n5488 n5519 1.875
r8111 n5518 n5519 0.12083333333333333
r8112 n5489 n5520 0.074999999999999997
r8113 n5519 n5520 0.10833333333333334
r8114 n5490 n5521 0.1875
r8115 n5520 n5521 0.14583333333333334
r8116 n5491 n5522 0.032196969696969696
r8117 n5492 n5523 0.53125
r8118 n5522 n5523 1.09375
r8119 n5493 n5524 0.035416666666666666
r8120 n5523 n5524 1
r8121 n5494 n5525 0.53125
r8122 n5524 n5525 1
r8123 n5495 n5526 0.032196969696969696
r8124 n5525 n5526 1.09375
r8125 n5496 n5527 0.10625
r8126 n5497 n5528 0.21249999999999999
r8127 n5527 n5528 0.46875
r8128 n5498 n5529 0.21249999999999999
r8129 n5528 n5529 0.3125
r8130 n5499 n5530 1.0625
r8131 n5529 n5530 0.1875
r8132 n5500 n5531 0.35416666666666669
r8133 n5530 n5531 0.125
r8134 n5501 n5532 1.0625
r8135 n5531 n5532 0.125
r8136 n5502 n5533 0.11805555555555555
r8137 n5532 n5533 0.3125
r8138 n5503 n5534 0.10625
r8139 n5533 n5534 0.59375
r8140 n5504 n5535 0.21249999999999999
r8141 n5534 n5535 0.46875
r8142 n5505 n5536 0.21249999999999999
r8143 n5535 n5536 0.3125
r8144 n5506 n5537 1.0625
r8145 n5536 n5537 0.1875
r8146 n5507 n5538 0.53125
r8147 n5537 n5538 0.09375
r8148 n5508 n5539 1.0625
r8149 n5538 n5539 0.09375
r8150 n5509 n5540 1.0625
r8151 n5539 n5540 0.0625
r8152 n5510 n5541 1.0625
r8153 n5540 n5541 0.0625
r8154 n5511 n5542 0.265625
r8155 n5541 n5542 0.15625
r8156 n5512 n5543 0.21249999999999999
r8157 n5542 n5543 0.28125
r8158 n5513 n5544 1.0625
r8159 n5543 n5544 0.1875
r8160 n5514 n5545 0.10625
r8161 n5544 n5545 0.34375
r8162 n5515 n5546 0.10625
r8163 n5516 n5547 0.042500000000000003
r8164 n5546 n5547 1.09375
r8165 n5517 n5548 1.0625
r8166 n5547 n5548 0.8125
r8167 n5518 n5549 0.037946428571428568
r8168 n5548 n5549 0.90625
r8169 n5519 n5550 1.0625
r8170 n5549 n5550 0.90625
r8171 n5520 n5551 0.042500000000000003
r8172 n5550 n5551 0.8125
r8173 n5521 n5552 0.10625
r8174 n5551 n5552 1.09375
r8175 n5522 n5553 0.00946969696969697
r8176 n5523 n5554 0.15625
r8177 n5553 n5554 0.72916666666666663
r8178 n5524 n5555 0.010416666666666666
r8179 n5554 n5555 0.66666666666666663
r8180 n5525 n5556 0.15625
r8181 n5555 n5556 0.66666666666666663
r8182 n5526 n5557 0.00946969696969697
r8183 n5556 n5557 0.72916666666666663
r8184 n5527 n5558 0.03125
r8185 n5528 n5559 0.0625
r8186 n5558 n5559 0.3125
r8187 n5529 n5560 0.0625
r8188 n5559 n5560 0.20833333333333334
r8189 n5530 n5561 0.3125
r8190 n5560 n5561 0.125
r8191 n5531 n5562 0.10416666666666667
r8192 n5561 n5562 0.083333333333333329
r8193 n5532 n5563 0.3125
r8194 n5562 n5563 0.083333333333333329
r8195 n5533 n5564 0.034722222222222224
r8196 n5563 n5564 0.20833333333333334
r8197 n5534 n5565 0.03125
r8198 n5564 n5565 0.39583333333333331
r8199 n5535 n5566 0.0625
r8200 n5565 n5566 0.3125
r8201 n5536 n5567 0.0625
r8202 n5566 n5567 0.20833333333333334
r8203 n5537 n5568 0.3125
r8204 n5567 n5568 0.125
r8205 n5538 n5569 0.15625
r8206 n5568 n5569 0.0625
r8207 n5539 n5570 0.3125
r8208 n5569 n5570 0.0625
r8209 n5540 n5571 0.3125
r8210 n5570 n5571 0.041666666666666664
r8211 n5541 n5572 0.3125
r8212 n5571 n5572 0.041666666666666664
r8213 n5542 n5573 0.078125
r8214 n5572 n5573 0.10416666666666667
r8215 n5543 n5574 0.0625
r8216 n5573 n5574 0.1875
r8217 n5544 n5575 0.3125
r8218 n5574 n5575 0.125
r8219 n5545 n5576 0.03125
r8220 n5575 n5576 0.22916666666666666
r8221 n5546 n5577 0.03125
r8222 n5547 n5578 0.012500000000000001
r8223 n5577 n5578 0.72916666666666663
r8224 n5548 n5579 0.3125
r8225 n5578 n5579 0.54166666666666663
r8226 n5549 n5580 0.011160714285714286
r8227 n5579 n5580 0.60416666666666663
r8228 n5550 n5581 0.3125
r8229 n5580 n5581 0.60416666666666663
r8230 n5551 n5582 0.012500000000000001
r8231 n5581 n5582 0.54166666666666663
r8232 n5552 n5583 0.03125
r8233 n5582 n5583 0.72916666666666663
r8234 n5553 n5584 0.011363636363636364
r8235 n5554 n5585 0.1875
r8236 n5584 n5585 0.72916666666666663
r8237 n5555 n5586 0.012500000000000001
r8238 n5585 n5586 0.66666666666666663
r8239 n5556 n5587 0.1875
r8240 n5586 n5587 0.66666666666666663
r8241 n5557 n5588 0.011363636363636364
r8242 n5587 n5588 0.72916666666666663
r8243 n5558 n5589 0.037499999999999999
r8244 n5559 n5590 0.074999999999999997
r8245 n5589 n5590 0.3125
r8246 n5560 n5591 0.074999999999999997
r8247 n5590 n5591 0.20833333333333334
r8248 n5561 n5592 0.375
r8249 n5591 n5592 0.125
r8250 n5562 n5593 0.125
r8251 n5592 n5593 0.083333333333333329
r8252 n5563 n5594 0.375
r8253 n5593 n5594 0.083333333333333329
r8254 n5564 n5595 0.041666666666666664
r8255 n5594 n5595 0.20833333333333334
r8256 n5565 n5596 0.037499999999999999
r8257 n5595 n5596 0.39583333333333331
r8258 n5566 n5597 0.074999999999999997
r8259 n5596 n5597 0.3125
r8260 n5567 n5598 0.074999999999999997
r8261 n5597 n5598 0.20833333333333334
r8262 n5568 n5599 0.375
r8263 n5598 n5599 0.125
r8264 n5569 n5600 0.1875
r8265 n5599 n5600 0.0625
r8266 n5570 n5601 0.375
r8267 n5600 n5601 0.0625
r8268 n5571 n5602 0.375
r8269 n5601 n5602 0.041666666666666664
r8270 n5572 n5603 0.375
r8271 n5602 n5603 0.041666666666666664
r8272 n5573 n5604 0.09375
r8273 n5603 n5604 0.10416666666666667
r8274 n5574 n5605 0.074999999999999997
r8275 n5604 n5605 0.1875
r8276 n5575 n5606 0.375
r8277 n5605 n5606 0.125
r8278 n5576 n5607 0.037499999999999999
r8279 n5606 n5607 0.22916666666666666
r8280 n5577 n5608 0.037499999999999999
r8281 n5578 n5609 0.014999999999999999
r8282 n5608 n5609 0.72916666666666663
r8283 n5579 n5610 0.375
r8284 n5609 n5610 0.54166666666666663
r8285 n5580 n5611 0.013392857142857142
r8286 n5610 n5611 0.60416666666666663
r8287 n5581 n5612 0.375
r8288 n5611 n5612 0.60416666666666663
r8289 n5582 n5613 0.014999999999999999
r8290 n5612 n5613 0.54166666666666663
r8291 n5583 n5614 0.037499999999999999
r8292 n5613 n5614 0.72916666666666663
r8293 n5584 n5615 0.01893939393939394
r8294 n5585 n5616 0.3125
r8295 n5615 n5616 0.3125
r8296 n5586 n5617 0.020833333333333332
r8297 n5616 n5617 0.2857142857142857
r8298 n5587 n5618 0.3125
r8299 n5617 n5618 0.2857142857142857
r8300 n5588 n5619 0.01893939393939394
r8301 n5618 n5619 0.3125
r8302 n5589 n5620 0.0625
r8303 n5590 n5621 0.125
r8304 n5620 n5621 0.13392857142857142
r8305 n5591 n5622 0.125
r8306 n5621 n5622 0.089285714285714288
r8307 n5592 n5623 0.625
r8308 n5622 n5623 0.053571428571428568
r8309 n5593 n5624 0.20833333333333334
r8310 n5623 n5624 0.035714285714285712
r8311 n5594 n5625 0.625
r8312 n5624 n5625 0.035714285714285712
r8313 n5595 n5626 0.069444444444444448
r8314 n5625 n5626 0.089285714285714288
r8315 n5596 n5627 0.0625
r8316 n5626 n5627 0.16964285714285715
r8317 n5597 n5628 0.125
r8318 n5627 n5628 0.13392857142857142
r8319 n5598 n5629 0.125
r8320 n5628 n5629 0.089285714285714288
r8321 n5599 n5630 0.625
r8322 n5629 n5630 0.053571428571428568
r8323 n5600 n5631 0.3125
r8324 n5630 n5631 0.026785714285714284
r8325 n5601 n5632 0.625
r8326 n5631 n5632 0.026785714285714284
r8327 n5602 n5633 0.625
r8328 n5632 n5633 0.017857142857142856
r8329 n5603 n5634 0.625
r8330 n5633 n5634 0.017857142857142856
r8331 n5604 n5635 0.15625
r8332 n5634 n5635 0.044642857142857144
r8333 n5605 n5636 0.125
r8334 n5635 n5636 0.080357142857142863
r8335 n5606 n5637 0.625
r8336 n5636 n5637 0.053571428571428568
r8337 n5607 n5638 0.0625
r8338 n5637 n5638 0.098214285714285712
r8339 n5608 n5639 0.0625
r8340 n5609 n5640 0.025000000000000001
r8341 n5639 n5640 0.3125
r8342 n5610 n5641 0.625
r8343 n5640 n5641 0.23214285714285715
r8344 n5611 n5642 0.022321428571428572
r8345 n5641 n5642 0.25892857142857145
r8346 n5612 n5643 0.625
r8347 n5642 n5643 0.25892857142857145
r8348 n5613 n5644 0.025000000000000001
r8349 n5643 n5644 0.23214285714285715
r8350 n5614 n5645 0.0625
r8351 n5644 n5645 0.3125
r8352 n5615 n5646 0.028409090909090908
r8353 n5616 n5647 0.46875
r8354 n5646 n5647 0.2734375
r8355 n5617 n5648 0.03125
r8356 n5647 n5648 0.25
r8357 n5618 n5649 0.46875
r8358 n5648 n5649 0.25
r8359 n5619 n5650 0.028409090909090908
r8360 n5649 n5650 0.2734375
r8361 n5620 n5651 0.09375
r8362 n5621 n5652 0.1875
r8363 n5651 n5652 0.1171875
r8364 n5622 n5653 0.1875
r8365 n5652 n5653 0.078125
r8366 n5623 n5654 0.9375
r8367 n5653 n5654 0.046875
r8368 n5624 n5655 0.3125
r8369 n5654 n5655 0.03125
r8370 n5625 n5656 0.9375
r8371 n5655 n5656 0.03125
r8372 n5626 n5657 0.10416666666666667
r8373 n5656 n5657 0.078125
r8374 n5627 n5658 0.09375
r8375 n5657 n5658 0.1484375
r8376 n5628 n5659 0.1875
r8377 n5658 n5659 0.1171875
r8378 n5629 n5660 0.1875
r8379 n5659 n5660 0.078125
r8380 n5630 n5661 0.9375
r8381 n5660 n5661 0.046875
r8382 n5631 n5662 0.46875
r8383 n5661 n5662 0.0234375
r8384 n5632 n5663 0.9375
r8385 n5662 n5663 0.0234375
r8386 n5633 n5664 0.9375
r8387 n5663 n5664 0.015625
r8388 n5634 n5665 0.9375
r8389 n5664 n5665 0.015625
r8390 n5635 n5666 0.234375
r8391 n5665 n5666 0.0390625
r8392 n5636 n5667 0.1875
r8393 n5666 n5667 0.0703125
r8394 n5637 n5668 0.9375
r8395 n5667 n5668 0.046875
r8396 n5638 n5669 0.09375
r8397 n5668 n5669 0.0859375
r8398 n5639 n5670 0.09375
r8399 n5640 n5671 0.037499999999999999
r8400 n5670 n5671 0.2734375
r8401 n5641 n5672 0.9375
r8402 n5671 n5672 0.203125
r8403 n5642 n5673 0.033482142857142856
r8404 n5672 n5673 0.2265625
r8405 n5643 n5674 0.9375
r8406 n5673 n5674 0.2265625
r8407 n5644 n5675 0.037499999999999999
r8408 n5674 n5675 0.203125
r8409 n5645 n5676 0.09375
r8410 n5675 n5676 0.2734375
r8411 n5646 n5677 0.01893939393939394
r8412 n5647 n5678 0.3125
r8413 n5677 n5678 1.09375
r8414 n5648 n5679 0.020833333333333332
r8415 n5678 n5679 1
r8416 n5649 n5680 0.3125
r8417 n5679 n5680 1
r8418 n5650 n5681 0.01893939393939394
r8419 n5680 n5681 1.09375
r8420 n5651 n5682 0.0625
r8421 n5652 n5683 0.125
r8422 n5682 n5683 0.46875
r8423 n5653 n5684 0.125
r8424 n5683 n5684 0.3125
r8425 n5654 n5685 0.625
r8426 n5684 n5685 0.1875
r8427 n5655 n5686 0.20833333333333334
r8428 n5685 n5686 0.125
r8429 n5656 n5687 0.625
r8430 n5686 n5687 0.125
r8431 n5657 n5688 0.069444444444444448
r8432 n5687 n5688 0.3125
r8433 n5658 n5689 0.0625
r8434 n5688 n5689 0.59375
r8435 n5659 n5690 0.125
r8436 n5689 n5690 0.46875
r8437 n5660 n5691 0.125
r8438 n5690 n5691 0.3125
r8439 n5661 n5692 0.625
r8440 n5691 n5692 0.1875
r8441 n5662 n5693 0.3125
r8442 n5692 n5693 0.09375
r8443 n5663 n5694 0.625
r8444 n5693 n5694 0.09375
r8445 n5664 n5695 0.625
r8446 n5694 n5695 0.0625
r8447 n5665 n5696 0.625
r8448 n5695 n5696 0.0625
r8449 n5666 n5697 0.15625
r8450 n5696 n5697 0.15625
r8451 n5667 n5698 0.125
r8452 n5697 n5698 0.28125
r8453 n5668 n5699 0.625
r8454 n5698 n5699 0.1875
r8455 n5669 n5700 0.0625
r8456 n5699 n5700 0.34375
r8457 n5670 n5701 0.0625
r8458 n5671 n5702 0.025000000000000001
r8459 n5701 n5702 1.09375
r8460 n5672 n5703 0.625
r8461 n5702 n5703 0.8125
r8462 n5673 n5704 0.022321428571428572
r8463 n5703 n5704 0.90625
r8464 n5674 n5705 0.625
r8465 n5704 n5705 0.90625
r8466 n5675 n5706 0.025000000000000001
r8467 n5705 n5706 0.8125
r8468 n5676 n5707 0.0625
r8469 n5706 n5707 1.09375
r8470 n5677 n5708 0.064393939393939392
r8471 n5678 n5709 1.0625
r8472 n5708 n5709 0.068359375
r8473 n5679 n5710 0.070833333333333331
r8474 n5709 n5710 0.0625
r8475 n5680 n5711 1.0625
r8476 n5710 n5711 0.0625
r8477 n5681 n5712 0.064393939393939392
r8478 n5711 n5712 0.068359375
r8479 n5701 n5713 0.21249999999999999
r8480 n5702 n5714 0.085000000000000006
r8481 n5713 n5714 0.068359375
r8482 n5703 n5715 2.125
r8483 n5714 n5715 0.05078125
r8484 n5704 n5716 0.075892857142857137
r8485 n5715 n5716 0.056640625
r8486 n5705 n5717 2.125
r8487 n5716 n5717 0.056640625
r8488 n5706 n5718 0.085000000000000006
r8489 n5717 n5718 0.05078125
r8490 n5707 n5719 0.21249999999999999
r8491 n5718 n5719 0.068359375
r8492 n5708 n5720 0.14962121212121213
r8493 n5709 n5721 2.46875
r8494 n5720 n5721 0.046542553191489359
r8495 n5710 n5722 0.16458333333333333
r8496 n5721 n5722 0.042553191489361701
r8497 n5711 n5723 2.46875
r8498 n5722 n5723 0.042553191489361701
r8499 n5712 n5724 0.14962121212121213
r8500 n5723 n5724 0.046542553191489359
r8501 n5713 n5725 0.49375000000000002
r8502 n5714 n5726 0.19750000000000001
r8503 n5725 n5726 0.046542553191489359
r8504 n5715 n5727 4.9375
r8505 n5726 n5727 0.034574468085106384
r8506 n5716 n5728 0.17633928571428573
r8507 n5727 n5728 0.038563829787234043
r8508 n5717 n5729 4.9375
r8509 n5728 n5729 0.038563829787234043
r8510 n5718 n5730 0.19750000000000001
r8511 n5729 n5730 0.034574468085106384
r8512 n5719 n5731 0.49375000000000002
r8513 n5730 n5731 0.046542553191489359
r8514 n5720 n5732 0.15340909090909091
r8515 n5721 n5733 2.53125
r8516 n5732 n5733 0.064338235294117641
r8517 n5722 n5734 0.16875000000000001
r8518 n5733 n5734 0.058823529411764705
r8519 n5723 n5735 2.53125
r8520 n5734 n5735 0.058823529411764705
r8521 n5724 n5736 0.15340909090909091
r8522 n5735 n5736 0.064338235294117641
r8523 n5725 n5737 0.50624999999999998
r8524 n5726 n5738 0.20250000000000001
r8525 n5737 n5738 0.064338235294117641
r8526 n5727 n5739 5.0625
r8527 n5738 n5739 0.04779411764705882
r8528 n5728 n5740 0.18080357142857142
r8529 n5739 n5740 0.053308823529411763
r8530 n5729 n5741 5.0625
r8531 n5740 n5741 0.053308823529411763
r8532 n5730 n5742 0.20250000000000001
r8533 n5741 n5742 0.04779411764705882
r8534 n5731 n5743 0.50624999999999998
r8535 n5742 n5743 0.064338235294117641
r8536 n5732 n5744 0.15643939393939393
r8537 n5733 n5745 2.5812499999999998
r8538 n5744 n5745 0.045010288065843625
r8539 n5734 n5746 0.17208333333333334
r8540 n5745 n5746 0.041152263374485597
r8541 n5735 n5747 2.5812499999999998
r8542 n5746 n5747 0.041152263374485597
r8543 n5736 n5748 0.15643939393939393
r8544 n5747 n5748 0.045010288065843625
r8545 n5737 n5749 0.51624999999999999
r8546 n5738 n5750 0.20649999999999999
r8547 n5749 n5750 0.045010288065843625
r8548 n5739 n5751 5.1624999999999996
r8549 n5750 n5751 0.033436213991769548
r8550 n5740 n5752 0.18437500000000001
r8551 n5751 n5752 0.037294238683127569
r8552 n5741 n5753 5.1624999999999996
r8553 n5752 n5753 0.037294238683127569
r8554 n5742 n5754 0.20649999999999999
r8555 n5753 n5754 0.033436213991769548
r8556 n5743 n5755 0.51624999999999999
r8557 n5754 n5755 0.045010288065843625
r8558 n5744 n5756 0.18446969696969698
r8559 n5745 n5757 3.0437500000000002
r8560 n5756 n5757 0.044825819672131145
r8561 n5746 n5758 0.20291666666666666
r8562 n5757 n5758 0.040983606557377046
r8563 n5747 n5759 3.0437500000000002
r8564 n5758 n5759 0.040983606557377046
r8565 n5748 n5760 0.18446969696969698
r8566 n5759 n5760 0.044825819672131145
r8567 n5749 n5761 0.60875000000000001
r8568 n5750 n5762 0.24349999999999999
r8569 n5761 n5762 0.044825819672131145
r8570 n5751 n5763 6.0875000000000004
r8571 n5762 n5763 0.033299180327868855
r8572 n5752 n5764 0.21741071428571429
r8573 n5763 n5764 0.037141393442622954
r8574 n5753 n5765 6.0875000000000004
r8575 n5764 n5765 0.037141393442622954
r8576 n5754 n5766 0.24349999999999999
r8577 n5765 n5766 0.033299180327868855
r8578 n5755 n5767 0.60875000000000001
r8579 n5766 n5767 0.044825819672131145
r8580 n5756 n5768 0.18446969696969698
r8581 n5757 n5769 3.0437500000000002
r8582 n5768 n5769 0.045010288065843625
r8583 n5758 n5770 0.20291666666666666
r8584 n5769 n5770 0.041152263374485597
r8585 n5759 n5771 3.0437500000000002
r8586 n5770 n5771 0.041152263374485597
r8587 n5760 n5772 0.18446969696969698
r8588 n5771 n5772 0.045010288065843625
r8589 n5761 n5773 0.60875000000000001
r8590 n5762 n5774 0.24349999999999999
r8591 n5773 n5774 0.045010288065843625
r8592 n5763 n5775 6.0875000000000004
r8593 n5774 n5775 0.033436213991769548
r8594 n5764 n5776 0.21741071428571429
r8595 n5775 n5776 0.037294238683127569
r8596 n5765 n5777 6.0875000000000004
r8597 n5776 n5777 0.037294238683127569
r8598 n5766 n5778 0.24349999999999999
r8599 n5777 n5778 0.033436213991769548
r8600 n5767 n5779 0.60875000000000001
r8601 n5778 n5779 0.045010288065843625
r8602 n5768 n5780 0.18409090909090908
r8603 n5769 n5781 3.0375000000000001
r8604 n5780 n5781 0.045010288065843625
r8605 n5770 n5782 0.20250000000000001
r8606 n5781 n5782 0.041152263374485597
r8607 n5771 n5783 3.0375000000000001
r8608 n5782 n5783 0.041152263374485597
r8609 n5772 n5784 0.18409090909090908
r8610 n5783 n5784 0.045010288065843625
r8611 n5773 n5785 0.60750000000000004
r8612 n5774 n5786 0.24299999999999999
r8613 n5785 n5786 0.045010288065843625
r8614 n5775 n5787 6.0750000000000002
r8615 n5786 n5787 0.033436213991769548
r8616 n5776 n5788 0.21696428571428572
r8617 n5787 n5788 0.037294238683127569
r8618 n5777 n5789 6.0750000000000002
r8619 n5788 n5789 0.037294238683127569
r8620 n5778 n5790 0.24299999999999999
r8621 n5789 n5790 0.033436213991769548
r8622 n5779 n5791 0.60750000000000004
r8623 n5790 n5791 0.045010288065843625
r8624 n5780 n5792 0.18446969696969698
r8625 n5781 n5793 3.0437500000000002
r8626 n5792 n5793 0.044825819672131145
r8627 n5782 n5794 0.20291666666666666
r8628 n5793 n5794 0.040983606557377046
r8629 n5783 n5795 3.0437500000000002
r8630 n5794 n5795 0.040983606557377046
r8631 n5784 n5796 0.18446969696969698
r8632 n5795 n5796 0.044825819672131145
r8633 n5785 n5797 0.60875000000000001
r8634 n5786 n5798 0.24349999999999999
r8635 n5797 n5798 0.044825819672131145
r8636 n5787 n5799 6.0875000000000004
r8637 n5798 n5799 0.033299180327868855
r8638 n5788 n5800 0.21741071428571429
r8639 n5799 n5800 0.037141393442622954
r8640 n5789 n5801 6.0875000000000004
r8641 n5800 n5801 0.037141393442622954
r8642 n5790 n5802 0.24349999999999999
r8643 n5801 n5802 0.033299180327868855
r8644 n5791 n5803 0.60875000000000001
r8645 n5802 n5803 0.044825819672131145
r8646 n5792 n5804 0.18446969696969698
r8647 n5793 n5805 3.0437500000000002
r8648 n5804 n5805 0.045010288065843625
r8649 n5794 n5806 0.20291666666666666
r8650 n5805 n5806 0.041152263374485597
r8651 n5795 n5807 3.0437500000000002
r8652 n5806 n5807 0.041152263374485597
r8653 n5796 n5808 0.18446969696969698
r8654 n5807 n5808 0.045010288065843625
r8655 n5797 n5809 0.60875000000000001
r8656 n5798 n5810 0.24349999999999999
r8657 n5809 n5810 0.045010288065843625
r8658 n5799 n5811 6.0875000000000004
r8659 n5810 n5811 0.033436213991769548
r8660 n5800 n5812 0.21741071428571429
r8661 n5811 n5812 0.037294238683127569
r8662 n5801 n5813 6.0875000000000004
r8663 n5812 n5813 0.037294238683127569
r8664 n5802 n5814 0.24349999999999999
r8665 n5813 n5814 0.033436213991769548
r8666 n5803 n5815 0.60875000000000001
r8667 n5814 n5815 0.045010288065843625
r8668 n5804 n5816 0.09583333333333334
r8669 n5805 n5817 1.58125
r8670 n5816 n5817 1.09375
r8671 n5806 n5818 0.10541666666666667
r8672 n5817 n5818 1
r8673 n5807 n5819 1.58125
r8674 n5818 n5819 1
r8675 n5808 n5820 0.09583333333333334
r8676 n5819 n5820 1.09375
r8677 n5821 n5822 0.78125
r8678 n5822 n5823 1
r8679 n5823 n5824 1
r8680 n5824 n5825 0.78125
r8681 n5809 n5826 0.31624999999999998
r8682 n5810 n5827 0.1265
r8683 n5826 n5827 1.09375
r8684 n5811 n5828 3.1625000000000001
r8685 n5827 n5828 0.8125
r8686 n5812 n5829 0.11294642857142857
r8687 n5828 n5829 0.90625
r8688 n5813 n5830 3.1625000000000001
r8689 n5829 n5830 0.90625
r8690 n5814 n5831 0.1265
r8691 n5830 n5831 0.8125
r8692 n5815 n5832 0.31624999999999998
r8693 n5831 n5832 1.09375
r8694 n5816 n5833 0.02462121212121212
r8695 n5817 n5834 0.40625
r8696 n5833 n5834 0.19886363636363635
r8697 n5818 n5835 0.027083333333333334
r8698 n5834 n5835 0.18181818181818182
r8699 n5819 n5836 0.40625
r8700 n5835 n5836 0.18181818181818182
r8701 n5820 n5837 0.02462121212121212
r8702 n5836 n5837 0.19886363636363635
r8703 n5837 n5838 0.24431818181818182
r8704 n5838 n5839 0.28977272727272729
r8705 n5839 n5840 0.46590909090909088
r8706 n5840 n5841 0.46590909090909088
r8707 n5841 n5842 0.42613636363636365
r8708 n5842 n5843 0.34886363636363638
r8709 n5843 n5844 0.3125
r8710 n5844 n5845 0.34999999999999998
r8711 n5845 n5846 0.26704545454545453
r8712 n5846 n5847 0.30113636363636365
r8713 n5847 n5848 0.23295454545454544
r8714 n5848 n5849 0.19318181818181818
r8715 n5849 n5850 0.19318181818181818
r8716 n5850 n5851 0.13636363636363635
r8717 n5851 n5852 0.15340909090909091
r8718 n5852 n5853 0.056818181818181816
r8719 n5853 n5854 0.0625
r8720 n5854 n5855 0.034090909090909088
r8721 n5855 n5856 0.079545454545454544
r8722 n5856 n5857 0.13068181818181818
r8723 n5857 n5858 0.085227272727272721
r8724 n5858 n5859 0.056818181818181816
r8725 n5859 n5860 0.034090909090909088
r8726 n5860 n5861 0.022727272727272728
r8727 n5861 n5862 0.022727272727272728
r8728 n5862 n5863 0.056818181818181816
r8729 n5863 n5864 0.10795454545454546
r8730 n5864 n5865 0.085227272727272721
r8731 n5865 n5866 0.056818181818181816
r8732 n5866 n5867 0.034090909090909088
r8733 n5867 n5868 0.017045454545454544
r8734 n5868 n5869 0.017045454545454544
r8735 n5869 n5870 0.011363636363636364
r8736 n5870 n5871 0.011363636363636364
r8737 n5871 n5872 0.028409090909090908
r8738 n5872 n5873 0.05113636363636364
r8739 n5873 n5874 0.034090909090909088
r8740 n5874 n5875 0.0625
r8741 n5875 n5876 0.073863636363636367
r8742 n5876 n5877 0.05113636363636364
r8743 n5877 n5878 0.045454545454545456
r8744 n5878 n5879 0.017045454545454544
r8745 n5879 n5880 0.011363636363636364
r8746 n5880 n5881 0.039772727272727272
r8747 n5881 n5882 0.0625
r8748 n5882 n5883 0.034090909090909088
r8749 n5883 n5884 0.028409090909090908
r8750 n5884 n5885 0.05113636363636364
r8751 n5885 n5886 0.045454545454545456
r8752 n5886 n5887 0.056818181818181816
r8753 n5887 n5888 0.073863636363636367
r8754 n5888 n5889 0.090909090909090912
r8755 n5889 n5890 0.079545454545454544
r8756 n5890 n5891 0.0625
r8757 n5891 n5892 0.090909090909090912
r8758 n5892 n5893 0.073863636363636367
r8759 n5893 n5894 0.068181818181818177
r8760 n5894 n5895 0.073863636363636367
r8761 n5895 n5896 0.0625
r8762 n5896 n5897 0.045454545454545456
r8763 n5897 n5898 0.10795454545454546
r8764 n5898 n5899 0.17045454545454544
r8765 n5899 n5900 0.085227272727272721
r8766 n5900 n5901 0.022727272727272728
r8767 n5901 n5902 0.034090909090909088
r8768 n5902 n5903 0.05113636363636364
r8769 n5903 n5904 0.073863636363636367
r8770 n5904 n5905 0.068181818181818177
r8771 n5905 n5906 0.096590909090909088
r8772 n5906 n5907 0.11363636363636363
r8773 n5907 n5908 0.19318181818181818
r8774 n5908 n5909 0.16477272727272727
r8775 n5909 n5910 0.039772727272727272
r8776 n5910 n5911 0.18181818181818182
r8777 n5911 n5912 0.16477272727272727
r8778 n5912 n5913 0.19318181818181818
r8779 n5913 n5914 0.375
r8780 n5914 n5915 0.38636363636363635
r8781 n5915 n5916 0.38636363636363635
r8782 n5916 n5917 0.38636363636363635
r8783 n5917 n5918 0.38636363636363635
r8784 n5918 n5919 0.38636363636363635
r8785 n5919 n5920 0.38636363636363635
r8786 n5920 n5921 0.38636363636363635
r8787 n5921 n5922 0.38636363636363635
r8788 n5922 n5923 0.38636363636363635
r8789 n5923 n5924 0.38636363636363635
r8790 n5924 n5925 0.38636363636363635
r8791 n5925 n5926 0.38636363636363635
r8792 n5926 n5927 0.38636363636363635
r8793 n5927 n5928 0.38636363636363635
r8794 n5928 n5929 0.38636363636363635
r8795 n5929 n5930 0.38636363636363635
r8796 n5930 n5931 0.38636363636363635
r8797 n5931 n5932 0.38636363636363635
r8798 n5932 n5933 0.38636363636363635
r8799 n5933 n5934 0.38636363636363635
r8800 n5934 n5935 0.38636363636363635
r8801 n5935 n5936 0.25568181818181818
r8802 n5821 n5937 0.035326086956521736
r8803 n5936 n5937 0.19318181818181818
r8804 n5822 n5938 0.40625
r8805 n5937 n5938 0.14204545454545456
r8806 n5823 n5939 0.027083333333333334
r8807 n5938 n5939 0.18181818181818182
r8808 n5824 n5940 0.40625
r8809 n5939 n5940 0.18181818181818182
r8810 n5825 n5941 0.035326086956521736
r8811 n5940 n5941 0.14204545454545456
r8812 n5826 n5942 0.081250000000000003
r8813 n5827 n5943 0.032500000000000001
r8814 n5942 n5943 0.19886363636363635
r8815 n5828 n5944 0.8125
r8816 n5943 n5944 0.14772727272727273
r8817 n5829 n5945 0.029017857142857144
r8818 n5944 n5945 0.16477272727272727
r8819 n5830 n5946 0.8125
r8820 n5945 n5946 0.16477272727272727
r8821 n5831 n5947 0.032500000000000001
r8822 n5946 n5947 0.14772727272727273
r8823 n5832 n5948 0.081250000000000003
r8824 n5947 n5948 0.19886363636363635
r8825 n5833 n5949 0.02462121212121212
r8826 n5834 n5950 0.40625
r8827 n5949 n5950 1.09375
r8828 n5835 n5951 0.027083333333333334
r8829 n5950 n5951 1
r8830 n5836 n5952 0.40625
r8831 n5951 n5952 1
r8832 n5837 n5953 0.02462121212121212
r8833 n5952 n5953 1.09375
r8834 n5838 n5954 0.081250000000000003
r8835 n5953 n5954 1.34375
r8836 n5839 n5955 0.019817073170731708
r8837 n5954 n5955 1.59375
r8838 n5840 n5956 0.019817073170731708
r8839 n5955 n5956 2.5625
r8840 n5841 n5957 0.019817073170731708
r8841 n5956 n5957 2.5625
r8842 n5842 n5958 0.02389705882352941
r8843 n5957 n5958 2.34375
r8844 n5843 n5959 0.029653284671532845
r8845 n5958 n5959 1.91875
r8846 n5844 n5960 0.029438405797101448
r8847 n5959 n5960 1.71875
r8848 n5845 n5961 0.02389705882352941
r8849 n5960 n5961 1.925
r8850 n5846 n5962 0.0625
r8851 n5961 n5962 1.46875
r8852 n5847 n5963 0.020312500000000001
r8853 n5962 n5963 1.65625
r8854 n5848 n5964 0.8125
r8855 n5963 n5964 1.28125
r8856 n5849 n5965 0.02462121212121212
r8857 n5964 n5965 1.0625
r8858 n5850 n5966 0.8125
r8859 n5965 n5966 1.0625
r8860 n5851 n5967 0.035326086956521736
r8861 n5966 n5967 0.75
r8862 n5852 n5968 0.203125
r8863 n5967 n5968 0.84375
r8864 n5853 n5969 0.13541666666666666
r8865 n5968 n5969 0.3125
r8866 n5854 n5970 0.16250000000000001
r8867 n5969 n5970 0.34375
r8868 n5855 n5971 0.8125
r8869 n5970 n5971 0.1875
r8870 n5856 n5972 0.0625
r8871 n5971 n5972 0.4375
r8872 n5857 n5973 0.081250000000000003
r8873 n5972 n5973 0.71875
r8874 n5858 n5974 0.16250000000000001
r8875 n5973 n5974 0.46875
r8876 n5859 n5975 0.16250000000000001
r8877 n5974 n5975 0.3125
r8878 n5860 n5976 0.8125
r8879 n5975 n5976 0.1875
r8880 n5861 n5977 0.27083333333333331
r8881 n5976 n5977 0.125
r8882 n5862 n5978 0.8125
r8883 n5977 n5978 0.125
r8884 n5863 n5979 0.090277777777777776
r8885 n5978 n5979 0.3125
r8886 n5864 n5980 0.081250000000000003
r8887 n5979 n5980 0.59375
r8888 n5865 n5981 0.16250000000000001
r8889 n5980 n5981 0.46875
r8890 n5866 n5982 0.16250000000000001
r8891 n5981 n5982 0.3125
r8892 n5867 n5983 0.8125
r8893 n5982 n5983 0.1875
r8894 n5868 n5984 0.40625
r8895 n5983 n5984 0.09375
r8896 n5869 n5985 0.8125
r8897 n5984 n5985 0.09375
r8898 n5870 n5986 0.8125
r8899 n5985 n5986 0.0625
r8900 n5871 n5987 0.8125
r8901 n5986 n5987 0.0625
r8902 n5872 n5988 0.203125
r8903 n5987 n5988 0.15625
r8904 n5873 n5989 0.16250000000000001
r8905 n5988 n5989 0.28125
r8906 n5874 n5990 0.8125
r8907 n5989 n5990 0.1875
r8908 n5875 n5991 0.081250000000000003
r8909 n5990 n5991 0.34375
r8910 n5876 n5992 0.27083333333333331
r8911 n5991 n5992 0.40625
r8912 n5877 n5993 0.13541666666666666
r8913 n5992 n5993 0.28125
r8914 n5878 n5994 0.40625
r8915 n5993 n5994 0.25
r8916 n5879 n5995 0.8125
r8917 n5994 n5995 0.09375
r8918 n5880 n5996 0.8125
r8919 n5995 n5996 0.0625
r8920 n5881 n5997 0.13541666666666666
r8921 n5996 n5997 0.21875
r8922 n5882 n5998 0.16250000000000001
r8923 n5997 n5998 0.34375
r8924 n5883 n5999 0.8125
r8925 n5998 n5999 0.1875
r8926 n5884 n6000 0.203125
r8927 n5999 n6000 0.15625
r8928 n5885 n6001 0.16250000000000001
r8929 n6000 n6001 0.28125
r8930 n5886 n6002 0.27083333333333331
r8931 n6001 n6002 0.25
r8932 n5887 n6003 0.11607142857142858
r8933 n6002 n6003 0.3125
r8934 n5888 n6004 0.13541666666666666
r8935 n6003 n6004 0.40625
r8936 n5889 n6005 0.081250000000000003
r8937 n6004 n6005 0.5
r8938 n5890 n6006 0.203125
r8939 n6005 n6006 0.4375
r8940 n5891 n6007 0.11607142857142858
r8941 n6006 n6007 0.34375
r8942 n5892 n6008 0.090277777777777776
r8943 n6007 n6008 0.5
r8944 n5893 n6009 0.203125
r8945 n6008 n6009 0.40625
r8946 n5894 n6010 0.1015625
r8947 n6009 n6010 0.375
r8948 n5895 n6011 0.16250000000000001
r8949 n6010 n6011 0.40625
r8950 n5896 n6012 0.13541666666666666
r8951 n6011 n6012 0.34375
r8952 n5897 n6013 0.40625
r8953 n6012 n6013 0.25
r8954 n5898 n6014 0.04779411764705882
r8955 n6013 n6014 0.59375
r8956 n5899 n6015 0.0625
r8957 n6014 n6015 0.9375
r8958 n5900 n6016 0.40625
r8959 n6015 n6016 0.46875
r8960 n5901 n6017 0.40625
r8961 n6016 n6017 0.125
r8962 n5902 n6018 0.203125
r8963 n6017 n6018 0.1875
r8964 n5903 n6019 0.16250000000000001
r8965 n6018 n6019 0.28125
r8966 n5904 n6020 0.1015625
r8967 n6019 n6020 0.40625
r8968 n5905 n6021 0.203125
r8969 n6020 n6021 0.375
r8970 n5906 n6022 0.0625
r8971 n6021 n6022 0.53125
r8972 n5907 n6023 0.11607142857142858
r8973 n6022 n6023 0.625
r8974 n5908 n6024 0.030092592592592591
r8975 n6023 n6024 1.0625
r8976 n5909 n6025 0.40625
r8977 n6024 n6025 0.90625
r8978 n5910 n6026 0.16250000000000001
r8979 n6025 n6026 0.21875
r8980 n5911 n6027 0.030092592592592591
r8981 n6026 n6027 1
r8982 n5912 n6028 0.40625
r8983 n6027 n6028 0.90625
r8984 n5913 n6029 0.025390625
r8985 n6028 n6029 1.0625
r8986 n5914 n6030 0.02389705882352941
r8987 n6029 n6030 2.0625
r8988 n5915 n6031 0.02389705882352941
r8989 n6030 n6031 2.125
r8990 n5916 n6032 0.02389705882352941
r8991 n6031 n6032 2.125
r8992 n5917 n6033 0.02389705882352941
r8993 n6032 n6033 2.125
r8994 n5918 n6034 0.02389705882352941
r8995 n6033 n6034 2.125
r8996 n5919 n6035 0.02389705882352941
r8997 n6034 n6035 2.125
r8998 n5920 n6036 0.02389705882352941
r8999 n6035 n6036 2.125
r9000 n5921 n6037 0.02389705882352941
r9001 n6036 n6037 2.125
r9002 n5922 n6038 0.02389705882352941
r9003 n6037 n6038 2.125
r9004 n5923 n6039 0.02389705882352941
r9005 n6038 n6039 2.125
r9006 n5924 n6040 0.02389705882352941
r9007 n6039 n6040 2.125
r9008 n5925 n6041 0.02389705882352941
r9009 n6040 n6041 2.125
r9010 n5926 n6042 0.02389705882352941
r9011 n6041 n6042 2.125
r9012 n5927 n6043 0.02389705882352941
r9013 n6042 n6043 2.125
r9014 n5928 n6044 0.02389705882352941
r9015 n6043 n6044 2.125
r9016 n5929 n6045 0.02389705882352941
r9017 n6044 n6045 2.125
r9018 n5930 n6046 0.02389705882352941
r9019 n6045 n6046 2.125
r9020 n5931 n6047 0.02389705882352941
r9021 n6046 n6047 2.125
r9022 n5932 n6048 0.02389705882352941
r9023 n6047 n6048 2.125
r9024 n5933 n6049 0.02389705882352941
r9025 n6048 n6049 2.125
r9026 n5934 n6050 0.02389705882352941
r9027 n6049 n6050 2.125
r9028 n5935 n6051 0.02389705882352941
r9029 n6050 n6051 2.125
r9030 n5936 n6052 0.073863636363636367
r9031 n6051 n6052 1.40625
r9032 n5937 n6053 0.035326086956521736
r9033 n6052 n6053 1.0625
r9034 n5938 n6054 0.40625
r9035 n6053 n6054 0.78125
r9036 n5939 n6055 0.027083333333333334
r9037 n6054 n6055 1
r9038 n5940 n6056 0.40625
r9039 n6055 n6056 1
r9040 n5941 n6057 0.035326086956521736
r9041 n6056 n6057 0.78125
r9042 n5942 n6058 0.081250000000000003
r9043 n5943 n6059 0.032500000000000001
r9044 n6058 n6059 1.09375
r9045 n5944 n6060 0.8125
r9046 n6059 n6060 0.8125
r9047 n5945 n6061 0.029017857142857144
r9048 n6060 n6061 0.90625
r9049 n5946 n6062 0.8125
r9050 n6061 n6062 0.90625
r9051 n5947 n6063 0.032500000000000001
r9052 n6062 n6063 0.8125
r9053 n5948 n6064 0.081250000000000003
r9054 n6063 n6064 1.09375
r9055 n5949 n6065 0.060606060606060608
r9056 n5950 n6066 1
r9057 n6065 n6066 0.072916666666666671
r9058 n5951 n6067 0.066666666666666666
r9059 n6066 n6067 0.066666666666666666
r9060 n5952 n6068 1
r9061 n6067 n6068 0.066666666666666666
r9062 n5953 n6069 0.060606060606060608
r9063 n6068 n6069 0.072916666666666671
r9064 n5954 n6070 0.20000000000000001
r9065 n6069 n6070 0.089583333333333334
r9066 n5955 n6071 0.04878048780487805
r9067 n6070 n6071 0.10625
r9068 n5956 n6072 0.04878048780487805
r9069 n6071 n6072 0.17083333333333334
r9070 n5957 n6073 0.04878048780487805
r9071 n6072 n6073 0.17083333333333334
r9072 n5958 n6074 0.058823529411764705
r9073 n6073 n6074 0.15625
r9074 n5959 n6075 0.072992700729927001
r9075 n6074 n6075 0.12791666666666668
r9076 n5960 n6076 0.072463768115942032
r9077 n6075 n6076 0.11458333333333333
r9078 n5961 n6077 0.058823529411764705
r9079 n6076 n6077 0.12833333333333333
r9080 n5962 n6078 0.15384615384615385
r9081 n6077 n6078 0.097916666666666666
r9082 n5963 n6079 0.050000000000000003
r9083 n6078 n6079 0.11041666666666666
r9084 n5964 n6080 2
r9085 n6079 n6080 0.085416666666666669
r9086 n5965 n6081 0.060606060606060608
r9087 n6080 n6081 0.070833333333333331
r9088 n5966 n6082 2
r9089 n6081 n6082 0.070833333333333331
r9090 n5967 n6083 0.086956521739130432
r9091 n6082 n6083 0.050000000000000003
r9092 n5968 n6084 0.5
r9093 n6083 n6084 0.056250000000000001
r9094 n5969 n6085 0.33333333333333331
r9095 n6084 n6085 0.020833333333333332
r9096 n5970 n6086 0.40000000000000002
r9097 n6085 n6086 0.022916666666666665
r9098 n5971 n6087 2
r9099 n6086 n6087 0.012500000000000001
r9100 n5972 n6088 0.15384615384615385
r9101 n6087 n6088 0.029166666666666667
r9102 n5973 n6089 0.20000000000000001
r9103 n6088 n6089 0.04791666666666667
r9104 n5974 n6090 0.40000000000000002
r9105 n6089 n6090 0.03125
r9106 n5975 n6091 0.40000000000000002
r9107 n6090 n6091 0.020833333333333332
r9108 n5976 n6092 2
r9109 n6091 n6092 0.012500000000000001
r9110 n5977 n6093 0.66666666666666663
r9111 n6092 n6093 0.0083333333333333332
r9112 n5978 n6094 2
r9113 n6093 n6094 0.0083333333333333332
r9114 n5979 n6095 0.22222222222222221
r9115 n6094 n6095 0.020833333333333332
r9116 n5980 n6096 0.20000000000000001
r9117 n6095 n6096 0.039583333333333331
r9118 n5981 n6097 0.40000000000000002
r9119 n6096 n6097 0.03125
r9120 n5982 n6098 0.40000000000000002
r9121 n6097 n6098 0.020833333333333332
r9122 n5983 n6099 2
r9123 n6098 n6099 0.012500000000000001
r9124 n5984 n6100 1
r9125 n6099 n6100 0.0062500000000000003
r9126 n5985 n6101 2
r9127 n6100 n6101 0.0062500000000000003
r9128 n5986 n6102 2
r9129 n6101 n6102 0.0041666666666666666
r9130 n5987 n6103 2
r9131 n6102 n6103 0.0041666666666666666
r9132 n5988 n6104 0.5
r9133 n6103 n6104 0.010416666666666666
r9134 n5989 n6105 0.40000000000000002
r9135 n6104 n6105 0.018749999999999999
r9136 n5990 n6106 2
r9137 n6105 n6106 0.012500000000000001
r9138 n5991 n6107 0.20000000000000001
r9139 n6106 n6107 0.022916666666666665
r9140 n5992 n6108 0.66666666666666663
r9141 n6107 n6108 0.027083333333333334
r9142 n5993 n6109 0.33333333333333331
r9143 n6108 n6109 0.018749999999999999
r9144 n5994 n6110 1
r9145 n6109 n6110 0.016666666666666666
r9146 n5995 n6111 2
r9147 n6110 n6111 0.0062500000000000003
r9148 n5996 n6112 2
r9149 n6111 n6112 0.0041666666666666666
r9150 n5997 n6113 0.33333333333333331
r9151 n6112 n6113 0.014583333333333334
r9152 n5998 n6114 0.40000000000000002
r9153 n6113 n6114 0.022916666666666665
r9154 n5999 n6115 2
r9155 n6114 n6115 0.012500000000000001
r9156 n6000 n6116 0.5
r9157 n6115 n6116 0.010416666666666666
r9158 n6001 n6117 0.40000000000000002
r9159 n6116 n6117 0.018749999999999999
r9160 n6002 n6118 0.66666666666666663
r9161 n6117 n6118 0.016666666666666666
r9162 n6003 n6119 0.2857142857142857
r9163 n6118 n6119 0.020833333333333332
r9164 n6004 n6120 0.33333333333333331
r9165 n6119 n6120 0.027083333333333334
r9166 n6005 n6121 0.20000000000000001
r9167 n6120 n6121 0.033333333333333333
r9168 n6006 n6122 0.5
r9169 n6121 n6122 0.029166666666666667
r9170 n6007 n6123 0.2857142857142857
r9171 n6122 n6123 0.022916666666666665
r9172 n6008 n6124 0.22222222222222221
r9173 n6123 n6124 0.033333333333333333
r9174 n6009 n6125 0.5
r9175 n6124 n6125 0.027083333333333334
r9176 n6010 n6126 0.25
r9177 n6125 n6126 0.025000000000000001
r9178 n6011 n6127 0.40000000000000002
r9179 n6126 n6127 0.027083333333333334
r9180 n6012 n6128 0.33333333333333331
r9181 n6127 n6128 0.022916666666666665
r9182 n6013 n6129 1
r9183 n6128 n6129 0.016666666666666666
r9184 n6014 n6130 0.11764705882352941
r9185 n6129 n6130 0.039583333333333331
r9186 n6015 n6131 0.15384615384615385
r9187 n6130 n6131 0.0625
r9188 n6016 n6132 1
r9189 n6131 n6132 0.03125
r9190 n6017 n6133 1
r9191 n6132 n6133 0.0083333333333333332
r9192 n6018 n6134 0.5
r9193 n6133 n6134 0.012500000000000001
r9194 n6019 n6135 0.40000000000000002
r9195 n6134 n6135 0.018749999999999999
r9196 n6020 n6136 0.25
r9197 n6135 n6136 0.027083333333333334
r9198 n6021 n6137 0.5
r9199 n6136 n6137 0.025000000000000001
r9200 n6022 n6138 0.15384615384615385
r9201 n6137 n6138 0.035416666666666666
r9202 n6023 n6139 0.2857142857142857
r9203 n6138 n6139 0.041666666666666664
r9204 n6024 n6140 0.07407407407407407
r9205 n6139 n6140 0.070833333333333331
r9206 n6025 n6141 1
r9207 n6140 n6141 0.060416666666666667
r9208 n6026 n6142 0.40000000000000002
r9209 n6141 n6142 0.014583333333333334
r9210 n6027 n6143 0.07407407407407407
r9211 n6142 n6143 0.066666666666666666
r9212 n6028 n6144 1
r9213 n6143 n6144 0.060416666666666667
r9214 n6029 n6145 0.0625
r9215 n6144 n6145 0.070833333333333331
r9216 n6030 n6146 0.058823529411764705
r9217 n6145 n6146 0.13750000000000001
r9218 n6031 n6147 0.058823529411764705
r9219 n6146 n6147 0.14166666666666666
r9220 n6032 n6148 0.058823529411764705
r9221 n6147 n6148 0.14166666666666666
r9222 n6033 n6149 0.058823529411764705
r9223 n6148 n6149 0.14166666666666666
r9224 n6034 n6150 0.058823529411764705
r9225 n6149 n6150 0.14166666666666666
r9226 n6035 n6151 0.058823529411764705
r9227 n6150 n6151 0.14166666666666666
r9228 n6036 n6152 0.058823529411764705
r9229 n6151 n6152 0.14166666666666666
r9230 n6037 n6153 0.058823529411764705
r9231 n6152 n6153 0.14166666666666666
r9232 n6038 n6154 0.058823529411764705
r9233 n6153 n6154 0.14166666666666666
r9234 n6039 n6155 0.058823529411764705
r9235 n6154 n6155 0.14166666666666666
r9236 n6040 n6156 0.058823529411764705
r9237 n6155 n6156 0.14166666666666666
r9238 n6041 n6157 0.058823529411764705
r9239 n6156 n6157 0.14166666666666666
r9240 n6042 n6158 0.058823529411764705
r9241 n6157 n6158 0.14166666666666666
r9242 n6043 n6159 0.058823529411764705
r9243 n6158 n6159 0.14166666666666666
r9244 n6044 n6160 0.058823529411764705
r9245 n6159 n6160 0.14166666666666666
r9246 n6045 n6161 0.058823529411764705
r9247 n6160 n6161 0.14166666666666666
r9248 n6046 n6162 0.058823529411764705
r9249 n6161 n6162 0.14166666666666666
r9250 n6047 n6163 0.058823529411764705
r9251 n6162 n6163 0.14166666666666666
r9252 n6048 n6164 0.058823529411764705
r9253 n6163 n6164 0.14166666666666666
r9254 n6049 n6165 0.058823529411764705
r9255 n6164 n6165 0.14166666666666666
r9256 n6050 n6166 0.058823529411764705
r9257 n6165 n6166 0.14166666666666666
r9258 n6051 n6167 0.058823529411764705
r9259 n6166 n6167 0.14166666666666666
r9260 n6052 n6168 0.18181818181818182
r9261 n6167 n6168 0.09375
r9262 n6053 n6169 0.086956521739130432
r9263 n6168 n6169 0.070833333333333331
r9264 n6054 n6170 1
r9265 n6169 n6170 0.052083333333333336
r9266 n6055 n6171 0.066666666666666666
r9267 n6170 n6171 0.066666666666666666
r9268 n6056 n6172 1
r9269 n6171 n6172 0.066666666666666666
r9270 n6057 n6173 0.086956521739130432
r9271 n6172 n6173 0.052083333333333336
r9272 n6058 n6174 0.20000000000000001
r9273 n6059 n6175 0.080000000000000002
r9274 n6174 n6175 0.072916666666666671
r9275 n6060 n6176 2
r9276 n6175 n6176 0.054166666666666669
r9277 n6061 n6177 0.071428571428571425
r9278 n6176 n6177 0.060416666666666667
r9279 n6062 n6178 2
r9280 n6177 n6178 0.060416666666666667
r9281 n6063 n6179 0.080000000000000002
r9282 n6178 n6179 0.054166666666666669
r9283 n6064 n6180 0.20000000000000001
r9284 n6179 n6180 0.072916666666666671
r9285 n6065 n6181 0.060606060606060608
r9286 n6066 n6182 1
r9287 n6181 n6182 1.09375
r9288 n6067 n6183 0.066666666666666666
r9289 n6182 n6183 1
r9290 n6068 n6184 1
r9291 n6183 n6184 1
r9292 n6069 n6185 0.060606060606060608
r9293 n6184 n6185 1.09375
r9294 n6070 n6186 0.20000000000000001
r9295 n6185 n6186 1.34375
r9296 n6071 n6187 0.04878048780487805
r9297 n6186 n6187 1.59375
r9298 n6072 n6188 0.04878048780487805
r9299 n6187 n6188 2.5625
r9300 n6073 n6189 0.04878048780487805
r9301 n6188 n6189 2.5625
r9302 n6074 n6190 0.058823529411764705
r9303 n6189 n6190 2.34375
r9304 n6075 n6191 0.072992700729927001
r9305 n6190 n6191 1.91875
r9306 n6076 n6192 0.072463768115942032
r9307 n6191 n6192 1.71875
r9308 n6077 n6193 0.058823529411764705
r9309 n6192 n6193 1.925
r9310 n6078 n6194 0.15384615384615385
r9311 n6193 n6194 1.46875
r9312 n6079 n6195 0.050000000000000003
r9313 n6194 n6195 1.65625
r9314 n6080 n6196 2
r9315 n6195 n6196 1.28125
r9316 n6081 n6197 0.060606060606060608
r9317 n6196 n6197 1.0625
r9318 n6082 n6198 2
r9319 n6197 n6198 1.0625
r9320 n6083 n6199 0.086956521739130432
r9321 n6198 n6199 0.75
r9322 n6084 n6200 0.5
r9323 n6199 n6200 0.84375
r9324 n6085 n6201 0.33333333333333331
r9325 n6200 n6201 0.3125
r9326 n6086 n6202 0.40000000000000002
r9327 n6201 n6202 0.34375
r9328 n6087 n6203 2
r9329 n6202 n6203 0.1875
r9330 n6088 n6204 0.15384615384615385
r9331 n6203 n6204 0.4375
r9332 n6089 n6205 0.20000000000000001
r9333 n6204 n6205 0.71875
r9334 n6090 n6206 0.40000000000000002
r9335 n6205 n6206 0.46875
r9336 n6091 n6207 0.40000000000000002
r9337 n6206 n6207 0.3125
r9338 n6092 n6208 2
r9339 n6207 n6208 0.1875
r9340 n6093 n6209 0.66666666666666663
r9341 n6208 n6209 0.125
r9342 n6094 n6210 2
r9343 n6209 n6210 0.125
r9344 n6095 n6211 0.22222222222222221
r9345 n6210 n6211 0.3125
r9346 n6096 n6212 0.20000000000000001
r9347 n6211 n6212 0.59375
r9348 n6097 n6213 0.40000000000000002
r9349 n6212 n6213 0.46875
r9350 n6098 n6214 0.40000000000000002
r9351 n6213 n6214 0.3125
r9352 n6099 n6215 2
r9353 n6214 n6215 0.1875
r9354 n6100 n6216 1
r9355 n6215 n6216 0.09375
r9356 n6101 n6217 2
r9357 n6216 n6217 0.09375
r9358 n6102 n6218 2
r9359 n6217 n6218 0.0625
r9360 n6103 n6219 2
r9361 n6218 n6219 0.0625
r9362 n6104 n6220 0.5
r9363 n6219 n6220 0.15625
r9364 n6105 n6221 0.40000000000000002
r9365 n6220 n6221 0.28125
r9366 n6106 n6222 2
r9367 n6221 n6222 0.1875
r9368 n6107 n6223 0.20000000000000001
r9369 n6222 n6223 0.34375
r9370 n6108 n6224 0.66666666666666663
r9371 n6223 n6224 0.40625
r9372 n6109 n6225 0.33333333333333331
r9373 n6224 n6225 0.28125
r9374 n6110 n6226 1
r9375 n6225 n6226 0.25
r9376 n6111 n6227 2
r9377 n6226 n6227 0.09375
r9378 n6112 n6228 2
r9379 n6227 n6228 0.0625
r9380 n6113 n6229 0.33333333333333331
r9381 n6228 n6229 0.21875
r9382 n6114 n6230 0.40000000000000002
r9383 n6229 n6230 0.34375
r9384 n6115 n6231 2
r9385 n6230 n6231 0.1875
r9386 n6116 n6232 0.5
r9387 n6231 n6232 0.15625
r9388 n6117 n6233 0.40000000000000002
r9389 n6232 n6233 0.28125
r9390 n6118 n6234 0.66666666666666663
r9391 n6233 n6234 0.25
r9392 n6119 n6235 0.2857142857142857
r9393 n6234 n6235 0.3125
r9394 n6120 n6236 0.33333333333333331
r9395 n6235 n6236 0.40625
r9396 n6121 n6237 0.20000000000000001
r9397 n6236 n6237 0.5
r9398 n6122 n6238 0.5
r9399 n6237 n6238 0.4375
r9400 n6123 n6239 0.2857142857142857
r9401 n6238 n6239 0.34375
r9402 n6124 n6240 0.22222222222222221
r9403 n6239 n6240 0.5
r9404 n6125 n6241 0.5
r9405 n6240 n6241 0.40625
r9406 n6126 n6242 0.25
r9407 n6241 n6242 0.375
r9408 n6127 n6243 0.40000000000000002
r9409 n6242 n6243 0.40625
r9410 n6128 n6244 0.33333333333333331
r9411 n6243 n6244 0.34375
r9412 n6129 n6245 1
r9413 n6244 n6245 0.25
r9414 n6130 n6246 0.11764705882352941
r9415 n6245 n6246 0.59375
r9416 n6131 n6247 0.15384615384615385
r9417 n6246 n6247 0.9375
r9418 n6132 n6248 1
r9419 n6247 n6248 0.46875
r9420 n6133 n6249 1
r9421 n6248 n6249 0.125
r9422 n6134 n6250 0.5
r9423 n6249 n6250 0.1875
r9424 n6135 n6251 0.40000000000000002
r9425 n6250 n6251 0.28125
r9426 n6136 n6252 0.25
r9427 n6251 n6252 0.40625
r9428 n6137 n6253 0.5
r9429 n6252 n6253 0.375
r9430 n6138 n6254 0.15384615384615385
r9431 n6253 n6254 0.53125
r9432 n6139 n6255 0.2857142857142857
r9433 n6254 n6255 0.625
r9434 n6140 n6256 0.07407407407407407
r9435 n6255 n6256 1.0625
r9436 n6141 n6257 1
r9437 n6256 n6257 0.90625
r9438 n6142 n6258 0.40000000000000002
r9439 n6257 n6258 0.21875
r9440 n6143 n6259 0.07407407407407407
r9441 n6258 n6259 1
r9442 n6144 n6260 1
r9443 n6259 n6260 0.90625
r9444 n6145 n6261 0.0625
r9445 n6260 n6261 1.0625
r9446 n6146 n6262 0.058823529411764705
r9447 n6261 n6262 2.0625
r9448 n6147 n6263 0.058823529411764705
r9449 n6262 n6263 2.125
r9450 n6148 n6264 0.058823529411764705
r9451 n6263 n6264 2.125
r9452 n6149 n6265 0.058823529411764705
r9453 n6264 n6265 2.125
r9454 n6150 n6266 0.058823529411764705
r9455 n6265 n6266 2.125
r9456 n6151 n6267 0.058823529411764705
r9457 n6266 n6267 2.125
r9458 n6152 n6268 0.058823529411764705
r9459 n6267 n6268 2.125
r9460 n6153 n6269 0.058823529411764705
r9461 n6268 n6269 2.125
r9462 n6154 n6270 0.058823529411764705
r9463 n6269 n6270 2.125
r9464 n6155 n6271 0.058823529411764705
r9465 n6270 n6271 2.125
r9466 n6156 n6272 0.058823529411764705
r9467 n6271 n6272 2.125
r9468 n6157 n6273 0.058823529411764705
r9469 n6272 n6273 2.125
r9470 n6158 n6274 0.058823529411764705
r9471 n6273 n6274 2.125
r9472 n6159 n6275 0.058823529411764705
r9473 n6274 n6275 2.125
r9474 n6160 n6276 0.058823529411764705
r9475 n6275 n6276 2.125
r9476 n6161 n6277 0.058823529411764705
r9477 n6276 n6277 2.125
r9478 n6162 n6278 0.058823529411764705
r9479 n6277 n6278 2.125
r9480 n6163 n6279 0.058823529411764705
r9481 n6278 n6279 2.125
r9482 n6164 n6280 0.058823529411764705
r9483 n6279 n6280 2.125
r9484 n6165 n6281 0.058823529411764705
r9485 n6280 n6281 2.125
r9486 n6166 n6282 0.058823529411764705
r9487 n6281 n6282 2.125
r9488 n6167 n6283 0.058823529411764705
r9489 n6282 n6283 2.125
r9490 n6168 n6284 0.18181818181818182
r9491 n6283 n6284 1.40625
r9492 n6169 n6285 0.086956521739130432
r9493 n6284 n6285 1.0625
r9494 n6170 n6286 1
r9495 n6285 n6286 0.78125
r9496 n6171 n6287 0.066666666666666666
r9497 n6286 n6287 1
r9498 n6172 n6288 1
r9499 n6287 n6288 1
r9500 n6173 n6289 0.086956521739130432
r9501 n6288 n6289 0.78125
r9502 n6174 n6290 0.20000000000000001
r9503 n6175 n6291 0.080000000000000002
r9504 n6290 n6291 1.09375
r9505 n6176 n6292 2
r9506 n6291 n6292 0.8125
r9507 n6177 n6293 0.071428571428571425
r9508 n6292 n6293 0.90625
r9509 n6178 n6294 2
r9510 n6293 n6294 0.90625
r9511 n6179 n6295 0.080000000000000002
r9512 n6294 n6295 0.8125
r9513 n6180 n6296 0.20000000000000001
r9514 n6295 n6296 1.09375
r9515 n6181 n6297 0.02462121212121212
r9516 n6182 n6298 0.40625
r9517 n6297 n6298 0.19886363636363635
r9518 n6183 n6299 0.027083333333333334
r9519 n6298 n6299 0.18181818181818182
r9520 n6184 n6300 0.40625
r9521 n6299 n6300 0.18181818181818182
r9522 n6185 n6301 0.02462121212121212
r9523 n6300 n6301 0.19886363636363635
r9524 n6186 n6302 0.081250000000000003
r9525 n6301 n6302 0.24431818181818182
r9526 n6187 n6303 0.019817073170731708
r9527 n6302 n6303 0.28977272727272729
r9528 n6188 n6304 0.019817073170731708
r9529 n6303 n6304 0.46590909090909088
r9530 n6189 n6305 0.019817073170731708
r9531 n6304 n6305 0.46590909090909088
r9532 n6190 n6306 0.02389705882352941
r9533 n6305 n6306 0.42613636363636365
r9534 n6191 n6307 0.029653284671532845
r9535 n6306 n6307 0.34886363636363638
r9536 n6192 n6308 0.029438405797101448
r9537 n6307 n6308 0.3125
r9538 n6193 n6309 0.02389705882352941
r9539 n6308 n6309 0.34999999999999998
r9540 n6194 n6310 0.0625
r9541 n6309 n6310 0.26704545454545453
r9542 n6195 n6311 0.020312500000000001
r9543 n6310 n6311 0.30113636363636365
r9544 n6196 n6312 0.8125
r9545 n6311 n6312 0.23295454545454544
r9546 n6197 n6313 0.02462121212121212
r9547 n6312 n6313 0.19318181818181818
r9548 n6198 n6314 0.8125
r9549 n6313 n6314 0.19318181818181818
r9550 n6199 n6315 0.035326086956521736
r9551 n6314 n6315 0.13636363636363635
r9552 n6200 n6316 0.203125
r9553 n6315 n6316 0.15340909090909091
r9554 n6201 n6317 0.13541666666666666
r9555 n6316 n6317 0.056818181818181816
r9556 n6202 n6318 0.16250000000000001
r9557 n6317 n6318 0.0625
r9558 n6203 n6319 0.8125
r9559 n6318 n6319 0.034090909090909088
r9560 n6204 n6320 0.0625
r9561 n6319 n6320 0.079545454545454544
r9562 n6205 n6321 0.081250000000000003
r9563 n6320 n6321 0.13068181818181818
r9564 n6206 n6322 0.16250000000000001
r9565 n6321 n6322 0.085227272727272721
r9566 n6207 n6323 0.16250000000000001
r9567 n6322 n6323 0.056818181818181816
r9568 n6208 n6324 0.8125
r9569 n6323 n6324 0.034090909090909088
r9570 n6209 n6325 0.27083333333333331
r9571 n6324 n6325 0.022727272727272728
r9572 n6210 n6326 0.8125
r9573 n6325 n6326 0.022727272727272728
r9574 n6211 n6327 0.090277777777777776
r9575 n6326 n6327 0.056818181818181816
r9576 n6212 n6328 0.081250000000000003
r9577 n6327 n6328 0.10795454545454546
r9578 n6213 n6329 0.16250000000000001
r9579 n6328 n6329 0.085227272727272721
r9580 n6214 n6330 0.16250000000000001
r9581 n6329 n6330 0.056818181818181816
r9582 n6215 n6331 0.8125
r9583 n6330 n6331 0.034090909090909088
r9584 n6216 n6332 0.40625
r9585 n6331 n6332 0.017045454545454544
r9586 n6217 n6333 0.8125
r9587 n6332 n6333 0.017045454545454544
r9588 n6218 n6334 0.8125
r9589 n6333 n6334 0.011363636363636364
r9590 n6219 n6335 0.8125
r9591 n6334 n6335 0.011363636363636364
r9592 n6220 n6336 0.203125
r9593 n6335 n6336 0.028409090909090908
r9594 n6221 n6337 0.16250000000000001
r9595 n6336 n6337 0.05113636363636364
r9596 n6222 n6338 0.8125
r9597 n6337 n6338 0.034090909090909088
r9598 n6223 n6339 0.081250000000000003
r9599 n6338 n6339 0.0625
r9600 n6224 n6340 0.27083333333333331
r9601 n6339 n6340 0.073863636363636367
r9602 n6225 n6341 0.13541666666666666
r9603 n6340 n6341 0.05113636363636364
r9604 n6226 n6342 0.40625
r9605 n6341 n6342 0.045454545454545456
r9606 n6227 n6343 0.8125
r9607 n6342 n6343 0.017045454545454544
r9608 n6228 n6344 0.8125
r9609 n6343 n6344 0.011363636363636364
r9610 n6229 n6345 0.13541666666666666
r9611 n6344 n6345 0.039772727272727272
r9612 n6230 n6346 0.16250000000000001
r9613 n6345 n6346 0.0625
r9614 n6231 n6347 0.8125
r9615 n6346 n6347 0.034090909090909088
r9616 n6232 n6348 0.203125
r9617 n6347 n6348 0.028409090909090908
r9618 n6233 n6349 0.16250000000000001
r9619 n6348 n6349 0.05113636363636364
r9620 n6234 n6350 0.27083333333333331
r9621 n6349 n6350 0.045454545454545456
r9622 n6235 n6351 0.11607142857142858
r9623 n6350 n6351 0.056818181818181816
r9624 n6236 n6352 0.13541666666666666
r9625 n6351 n6352 0.073863636363636367
r9626 n6237 n6353 0.081250000000000003
r9627 n6352 n6353 0.090909090909090912
r9628 n6238 n6354 0.203125
r9629 n6353 n6354 0.079545454545454544
r9630 n6239 n6355 0.11607142857142858
r9631 n6354 n6355 0.0625
r9632 n6240 n6356 0.090277777777777776
r9633 n6355 n6356 0.090909090909090912
r9634 n6241 n6357 0.203125
r9635 n6356 n6357 0.073863636363636367
r9636 n6242 n6358 0.1015625
r9637 n6357 n6358 0.068181818181818177
r9638 n6243 n6359 0.16250000000000001
r9639 n6358 n6359 0.073863636363636367
r9640 n6244 n6360 0.13541666666666666
r9641 n6359 n6360 0.0625
r9642 n6245 n6361 0.40625
r9643 n6360 n6361 0.045454545454545456
r9644 n6246 n6362 0.04779411764705882
r9645 n6361 n6362 0.10795454545454546
r9646 n6247 n6363 0.0625
r9647 n6362 n6363 0.17045454545454544
r9648 n6248 n6364 0.40625
r9649 n6363 n6364 0.085227272727272721
r9650 n6249 n6365 0.40625
r9651 n6364 n6365 0.022727272727272728
r9652 n6250 n6366 0.203125
r9653 n6365 n6366 0.034090909090909088
r9654 n6251 n6367 0.16250000000000001
r9655 n6366 n6367 0.05113636363636364
r9656 n6252 n6368 0.1015625
r9657 n6367 n6368 0.073863636363636367
r9658 n6253 n6369 0.203125
r9659 n6368 n6369 0.068181818181818177
r9660 n6254 n6370 0.0625
r9661 n6369 n6370 0.096590909090909088
r9662 n6255 n6371 0.11607142857142858
r9663 n6370 n6371 0.11363636363636363
r9664 n6256 n6372 0.030092592592592591
r9665 n6371 n6372 0.19318181818181818
r9666 n6257 n6373 0.40625
r9667 n6372 n6373 0.16477272727272727
r9668 n6258 n6374 0.16250000000000001
r9669 n6373 n6374 0.039772727272727272
r9670 n6259 n6375 0.030092592592592591
r9671 n6374 n6375 0.18181818181818182
r9672 n6260 n6376 0.40625
r9673 n6375 n6376 0.16477272727272727
r9674 n6261 n6377 0.025390625
r9675 n6376 n6377 0.19318181818181818
r9676 n6262 n6378 0.02389705882352941
r9677 n6377 n6378 0.375
r9678 n6263 n6379 0.02389705882352941
r9679 n6378 n6379 0.38636363636363635
r9680 n6264 n6380 0.02389705882352941
r9681 n6379 n6380 0.38636363636363635
r9682 n6265 n6381 0.02389705882352941
r9683 n6380 n6381 0.38636363636363635
r9684 n6266 n6382 0.02389705882352941
r9685 n6381 n6382 0.38636363636363635
r9686 n6267 n6383 0.02389705882352941
r9687 n6382 n6383 0.38636363636363635
r9688 n6268 n6384 0.02389705882352941
r9689 n6383 n6384 0.38636363636363635
r9690 n6269 n6385 0.02389705882352941
r9691 n6384 n6385 0.38636363636363635
r9692 n6270 n6386 0.02389705882352941
r9693 n6385 n6386 0.38636363636363635
r9694 n6271 n6387 0.02389705882352941
r9695 n6386 n6387 0.38636363636363635
r9696 n6272 n6388 0.02389705882352941
r9697 n6387 n6388 0.38636363636363635
r9698 n6273 n6389 0.02389705882352941
r9699 n6388 n6389 0.38636363636363635
r9700 n6274 n6390 0.02389705882352941
r9701 n6389 n6390 0.38636363636363635
r9702 n6275 n6391 0.02389705882352941
r9703 n6390 n6391 0.38636363636363635
r9704 n6276 n6392 0.02389705882352941
r9705 n6391 n6392 0.38636363636363635
r9706 n6277 n6393 0.02389705882352941
r9707 n6392 n6393 0.38636363636363635
r9708 n6278 n6394 0.02389705882352941
r9709 n6393 n6394 0.38636363636363635
r9710 n6279 n6395 0.02389705882352941
r9711 n6394 n6395 0.38636363636363635
r9712 n6280 n6396 0.02389705882352941
r9713 n6395 n6396 0.38636363636363635
r9714 n6281 n6397 0.02389705882352941
r9715 n6396 n6397 0.38636363636363635
r9716 n6282 n6398 0.02389705882352941
r9717 n6397 n6398 0.38636363636363635
r9718 n6283 n6399 0.02389705882352941
r9719 n6398 n6399 0.38636363636363635
r9720 n6284 n6400 0.073863636363636367
r9721 n6399 n6400 0.25568181818181818
r9722 n6285 n6401 0.035326086956521736
r9723 n6400 n6401 0.19318181818181818
r9724 n6286 n6402 0.40625
r9725 n6401 n6402 0.14204545454545456
r9726 n6287 n6403 0.027083333333333334
r9727 n6402 n6403 0.18181818181818182
r9728 n6288 n6404 0.40625
r9729 n6403 n6404 0.18181818181818182
r9730 n6289 n6405 0.035326086956521736
r9731 n6404 n6405 0.14204545454545456
r9732 n6290 n6406 0.081250000000000003
r9733 n6291 n6407 0.032500000000000001
r9734 n6406 n6407 0.19886363636363635
r9735 n6292 n6408 0.8125
r9736 n6407 n6408 0.14772727272727273
r9737 n6293 n6409 0.029017857142857144
r9738 n6408 n6409 0.16477272727272727
r9739 n6294 n6410 0.8125
r9740 n6409 n6410 0.16477272727272727
r9741 n6295 n6411 0.032500000000000001
r9742 n6410 n6411 0.14772727272727273
r9743 n6296 n6412 0.081250000000000003
r9744 n6411 n6412 0.19886363636363635
r9745 n6297 n6413 0.02462121212121212
r9746 n6298 n6414 0.40625
r9747 n6413 n6414 1.09375
r9748 n6299 n6415 0.027083333333333334
r9749 n6414 n6415 1
r9750 n6300 n6416 0.40625
r9751 n6415 n6416 1
r9752 n6301 n6417 0.02462121212121212
r9753 n6416 n6417 1.09375
r9754 n6401 n6418 0.035326086956521736
r9755 n6402 n6419 0.40625
r9756 n6418 n6419 0.78125
r9757 n6403 n6420 0.027083333333333334
r9758 n6419 n6420 1
r9759 n6404 n6421 0.40625
r9760 n6420 n6421 1
r9761 n6405 n6422 0.035326086956521736
r9762 n6421 n6422 0.78125
r9763 n6406 n6423 0.081250000000000003
r9764 n6407 n6424 0.032500000000000001
r9765 n6423 n6424 1.09375
r9766 n6408 n6425 0.8125
r9767 n6424 n6425 0.8125
r9768 n6409 n6426 0.029017857142857144
r9769 n6425 n6426 0.90625
r9770 n6410 n6427 0.8125
r9771 n6426 n6427 0.90625
r9772 n6411 n6428 0.032500000000000001
r9773 n6427 n6428 0.8125
r9774 n6412 n6429 0.081250000000000003
r9775 n6428 n6429 1.09375
r9776 n6413 n6430 0.067424242424242428
r9777 n6414 n6431 1.1125
r9778 n6430 n6431 0.065104166666666671
r9779 n6415 n6432 0.074166666666666672
r9780 n6431 n6432 0.059523809523809521
r9781 n6416 n6433 1.1125
r9782 n6432 n6433 0.059523809523809521
r9783 n6417 n6434 0.067424242424242428
r9784 n6433 n6434 0.065104166666666671
r9785 n6423 n6435 0.2225
r9786 n6424 n6436 0.088999999999999996
r9787 n6435 n6436 0.065104166666666671
r9788 n6425 n6437 2.2250000000000001
r9789 n6436 n6437 0.04836309523809524
r9790 n6426 n6438 0.07946428571428571
r9791 n6437 n6438 0.053943452380952384
r9792 n6427 n6439 2.2250000000000001
r9793 n6438 n6439 0.053943452380952384
r9794 n6428 n6440 0.088999999999999996
r9795 n6439 n6440 0.04836309523809524
r9796 n6429 n6441 0.2225
r9797 n6440 n6441 0.065104166666666671
r9798 n6430 n6442 0.12689393939393939
r9799 n6431 n6443 2.09375
r9800 n6442 n6443 0.0654940119760479
r9801 n6432 n6444 0.13958333333333334
r9802 n6443 n6444 0.059880239520958084
r9803 n6433 n6445 2.09375
r9804 n6444 n6445 0.059880239520958084
r9805 n6434 n6446 0.12689393939393939
r9806 n6445 n6446 0.0654940119760479
r9807 n6435 n6447 0.41875000000000001
r9808 n6436 n6448 0.16750000000000001
r9809 n6447 n6448 0.0654940119760479
r9810 n6437 n6449 4.1875
r9811 n6448 n6449 0.048652694610778445
r9812 n6438 n6450 0.14955357142857142
r9813 n6449 n6450 0.054266467065868261
r9814 n6439 n6451 4.1875
r9815 n6450 n6451 0.054266467065868261
r9816 n6440 n6452 0.16750000000000001
r9817 n6451 n6452 0.048652694610778445
r9818 n6441 n6453 0.41875000000000001
r9819 n6452 n6453 0.0654940119760479
r9820 n6442 n6454 0.084090909090909091
r9821 n6443 n6455 1.3875
r9822 n6454 n6455 0.19886363636363635
r9823 n6444 n6456 0.092499999999999999
r9824 n6455 n6456 0.18181818181818182
r9825 n6445 n6457 1.3875
r9826 n6456 n6457 0.18181818181818182
r9827 n6446 n6458 0.084090909090909091
r9828 n6457 n6458 0.19886363636363635
r9829 n6447 n6459 0.27750000000000002
r9830 n6448 n6460 0.111
r9831 n6459 n6460 0.19886363636363635
r9832 n6449 n6461 2.7749999999999999
r9833 n6460 n6461 0.14772727272727273
r9834 n6450 n6462 0.099107142857142852
r9835 n6461 n6462 0.16477272727272727
r9836 n6451 n6463 2.7749999999999999
r9837 n6462 n6463 0.16477272727272727
r9838 n6452 n6464 0.111
r9839 n6463 n6464 0.14772727272727273
r9840 n6453 n6465 0.27750000000000002
r9841 n6464 n6465 0.19886363636363635
r9842 n6454 n6466 0.039772727272727272
r9843 n6455 n6467 0.65625
r9844 n6466 n6467 0.21875
r9845 n6456 n6468 0.043749999999999997
r9846 n6467 n6468 0.20000000000000001
r9847 n6457 n6469 0.65625
r9848 n6468 n6469 0.20000000000000001
r9849 n6458 n6470 0.039772727272727272
r9850 n6469 n6470 0.21875
r9851 n6471 n6472 0.0625
r9852 n6472 n6473 0.037499999999999999
r9853 n6473 n6474 0.018749999999999999
r9854 n6474 n6475 0.018749999999999999
r9855 n6475 n6476 0.012500000000000001
r9856 n6476 n6477 0.012500000000000001
r9857 n6477 n6478 0.03125
r9858 n6478 n6479 0.056250000000000001
r9859 n6479 n6480 0.037499999999999999
r9860 n6480 n6481 0.068750000000000006
r9861 n6481 n6482 0.081250000000000003
r9862 n6482 n6483 0.056250000000000001
r9863 n6483 n6484 0.050000000000000003
r9864 n6484 n6485 0.018749999999999999
r9865 n6485 n6486 0.012500000000000001
r9866 n6486 n6487 0.043749999999999997
r9867 n6487 n6488 0.068750000000000006
r9868 n6488 n6489 0.037499999999999999
r9869 n6489 n6490 0.03125
r9870 n6490 n6491 0.056250000000000001
r9871 n6491 n6492 0.050000000000000003
r9872 n6492 n6493 0.0625
r9873 n6459 n6494 0.13125000000000001
r9874 n6460 n6495 0.052499999999999998
r9875 n6494 n6495 0.21875
r9876 n6461 n6496 1.3125
r9877 n6495 n6496 0.16250000000000001
r9878 n6462 n6497 0.046875
r9879 n6496 n6497 0.18124999999999999
r9880 n6463 n6498 1.3125
r9881 n6497 n6498 0.18124999999999999
r9882 n6464 n6499 0.052499999999999998
r9883 n6498 n6499 0.16250000000000001
r9884 n6465 n6500 0.13125000000000001
r9885 n6499 n6500 0.21875
r9886 n6466 n6501 0.022727272727272728
r9887 n6467 n6502 0.375
r9888 n6501 n6502 1.09375
r9889 n6468 n6503 0.025000000000000001
r9890 n6502 n6503 1
r9891 n6469 n6504 0.375
r9892 n6503 n6504 1
r9893 n6470 n6505 0.022727272727272728
r9894 n6504 n6505 1.09375
r9895 n6471 n6506 0.14999999999999999
r9896 n6472 n6507 0.14999999999999999
r9897 n6506 n6507 0.3125
r9898 n6473 n6508 0.75
r9899 n6507 n6508 0.1875
r9900 n6474 n6509 0.375
r9901 n6508 n6509 0.09375
r9902 n6475 n6510 0.75
r9903 n6509 n6510 0.09375
r9904 n6476 n6511 0.75
r9905 n6510 n6511 0.0625
r9906 n6477 n6512 0.75
r9907 n6511 n6512 0.0625
r9908 n6478 n6513 0.1875
r9909 n6512 n6513 0.15625
r9910 n6479 n6514 0.14999999999999999
r9911 n6513 n6514 0.28125
r9912 n6480 n6515 0.75
r9913 n6514 n6515 0.1875
r9914 n6481 n6516 0.074999999999999997
r9915 n6515 n6516 0.34375
r9916 n6482 n6517 0.25
r9917 n6516 n6517 0.40625
r9918 n6483 n6518 0.125
r9919 n6517 n6518 0.28125
r9920 n6484 n6519 0.375
r9921 n6518 n6519 0.25
r9922 n6485 n6520 0.75
r9923 n6519 n6520 0.09375
r9924 n6486 n6521 0.75
r9925 n6520 n6521 0.0625
r9926 n6487 n6522 0.125
r9927 n6521 n6522 0.21875
r9928 n6488 n6523 0.14999999999999999
r9929 n6522 n6523 0.34375
r9930 n6489 n6524 0.75
r9931 n6523 n6524 0.1875
r9932 n6490 n6525 0.1875
r9933 n6524 n6525 0.15625
r9934 n6491 n6526 0.14999999999999999
r9935 n6525 n6526 0.28125
r9936 n6492 n6527 0.25
r9937 n6526 n6527 0.25
r9938 n6493 n6528 0.10714285714285714
r9939 n6527 n6528 0.3125
r9940 n6529 n6530 0.78125
r9941 n6530 n6531 1.0625
r9942 n6531 n6532 0.9375
r9943 n6532 n6533 1.0625
r9944 n6533 n6534 0.78125
r9945 n6494 n6535 0.074999999999999997
r9946 n6495 n6536 0.029999999999999999
r9947 n6535 n6536 1.09375
r9948 n6496 n6537 0.75
r9949 n6536 n6537 0.8125
r9950 n6497 n6538 0.026785714285714284
r9951 n6537 n6538 0.90625
r9952 n6498 n6539 0.75
r9953 n6538 n6539 0.90625
r9954 n6499 n6540 0.029999999999999999
r9955 n6539 n6540 0.8125
r9956 n6500 n6541 0.074999999999999997
r9957 n6540 n6541 1.09375
r9958 n6501 n6542 0.00946969696969697
r9959 n6502 n6543 0.15625
r9960 n6542 n6543 0.72916666666666663
r9961 n6503 n6544 0.010416666666666666
r9962 n6543 n6544 0.66666666666666663
r9963 n6504 n6545 0.15625
r9964 n6544 n6545 0.66666666666666663
r9965 n6505 n6546 0.00946969696969697
r9966 n6545 n6546 0.72916666666666663
r9967 n6506 n6547 0.0625
r9968 n6507 n6548 0.0625
r9969 n6547 n6548 0.20833333333333334
r9970 n6508 n6549 0.3125
r9971 n6548 n6549 0.125
r9972 n6509 n6550 0.15625
r9973 n6549 n6550 0.0625
r9974 n6510 n6551 0.3125
r9975 n6550 n6551 0.0625
r9976 n6511 n6552 0.3125
r9977 n6551 n6552 0.041666666666666664
r9978 n6512 n6553 0.3125
r9979 n6552 n6553 0.041666666666666664
r9980 n6513 n6554 0.078125
r9981 n6553 n6554 0.10416666666666667
r9982 n6514 n6555 0.0625
r9983 n6554 n6555 0.1875
r9984 n6515 n6556 0.3125
r9985 n6555 n6556 0.125
r9986 n6516 n6557 0.03125
r9987 n6556 n6557 0.22916666666666666
r9988 n6517 n6558 0.10416666666666667
r9989 n6557 n6558 0.27083333333333331
r9990 n6518 n6559 0.052083333333333336
r9991 n6558 n6559 0.1875
r9992 n6519 n6560 0.15625
r9993 n6559 n6560 0.16666666666666666
r9994 n6520 n6561 0.3125
r9995 n6560 n6561 0.0625
r9996 n6521 n6562 0.3125
r9997 n6561 n6562 0.041666666666666664
r9998 n6522 n6563 0.052083333333333336
r9999 n6562 n6563 0.14583333333333334
r10000 n6523 n6564 0.0625
r10001 n6563 n6564 0.22916666666666666
r10002 n6524 n6565 0.3125
r10003 n6564 n6565 0.125
r10004 n6525 n6566 0.078125
r10005 n6565 n6566 0.10416666666666667
r10006 n6526 n6567 0.0625
r10007 n6566 n6567 0.1875
r10008 n6527 n6568 0.10416666666666667
r10009 n6567 n6568 0.16666666666666666
r10010 n6528 n6569 0.044642857142857144
r10011 n6568 n6569 0.20833333333333334
r10012 n6529 n6570 0.044642857142857144
r10013 n6530 n6571 0.017361111111111112
r10014 n6570 n6571 0.52083333333333337
r10015 n6531 n6572 0.01953125
r10016 n6571 n6572 0.70833333333333337
r10017 n6532 n6573 0.022321428571428572
r10018 n6572 n6573 0.625
r10019 n6533 n6574 0.015625
r10020 n6573 n6574 0.70833333333333337
r10021 n6534 n6575 0.0625
r10022 n6574 n6575 0.52083333333333337
r10023 n6575 n6576 0.70833333333333337
r10024 n6576 n6577 1.3125
r10025 n6577 n6578 1.4166666666666667
r10026 n6578 n6579 1.4166666666666667
r10027 n6579 n6580 1.5416666666666667
r10028 n6580 n6581 1.5416666666666667
r10029 n6581 n6582 1.4166666666666667
r10030 n6582 n6583 1.4166666666666667
r10031 n6583 n6584 1.0625
r10032 n6584 n6585 0.70833333333333337
r10033 n6585 n6586 1.2083333333333333
r10034 n6586 n6587 1.7083333333333333
r10035 n6587 n6588 1.7083333333333333
r10036 n6588 n6589 1.0625
r10037 n6535 n6590 0.03125
r10038 n6589 n6590 0.41666666666666669
r10039 n6536 n6591 0.012500000000000001
r10040 n6590 n6591 0.72916666666666663
r10041 n6537 n6592 0.3125
r10042 n6591 n6592 0.54166666666666663
r10043 n6538 n6593 0.011160714285714286
r10044 n6592 n6593 0.60416666666666663
r10045 n6539 n6594 0.3125
r10046 n6593 n6594 0.60416666666666663
r10047 n6540 n6595 0.012500000000000001
r10048 n6594 n6595 0.54166666666666663
r10049 n6541 n6596 0.03125
r10050 n6595 n6596 0.72916666666666663
r10051 n6542 n6597 0.015151515151515152
r10052 n6543 n6598 0.25
r10053 n6597 n6598 0.4375
r10054 n6544 n6599 0.016666666666666666
r10055 n6598 n6599 0.40000000000000002
r10056 n6545 n6600 0.25
r10057 n6599 n6600 0.40000000000000002
r10058 n6546 n6601 0.015151515151515152
r10059 n6600 n6601 0.4375
r10060 n6547 n6602 0.10000000000000001
r10061 n6548 n6603 0.10000000000000001
r10062 n6602 n6603 0.125
r10063 n6549 n6604 0.5
r10064 n6603 n6604 0.074999999999999997
r10065 n6550 n6605 0.25
r10066 n6604 n6605 0.037499999999999999
r10067 n6551 n6606 0.5
r10068 n6605 n6606 0.037499999999999999
r10069 n6552 n6607 0.5
r10070 n6606 n6607 0.025000000000000001
r10071 n6553 n6608 0.5
r10072 n6607 n6608 0.025000000000000001
r10073 n6554 n6609 0.125
r10074 n6608 n6609 0.0625
r10075 n6555 n6610 0.10000000000000001
r10076 n6609 n6610 0.1125
r10077 n6556 n6611 0.5
r10078 n6610 n6611 0.074999999999999997
r10079 n6557 n6612 0.050000000000000003
r10080 n6611 n6612 0.13750000000000001
r10081 n6558 n6613 0.16666666666666666
r10082 n6612 n6613 0.16250000000000001
r10083 n6559 n6614 0.083333333333333329
r10084 n6613 n6614 0.1125
r10085 n6560 n6615 0.25
r10086 n6614 n6615 0.10000000000000001
r10087 n6561 n6616 0.5
r10088 n6615 n6616 0.037499999999999999
r10089 n6562 n6617 0.5
r10090 n6616 n6617 0.025000000000000001
r10091 n6563 n6618 0.083333333333333329
r10092 n6617 n6618 0.087499999999999994
r10093 n6564 n6619 0.10000000000000001
r10094 n6618 n6619 0.13750000000000001
r10095 n6565 n6620 0.5
r10096 n6619 n6620 0.074999999999999997
r10097 n6566 n6621 0.125
r10098 n6620 n6621 0.0625
r10099 n6567 n6622 0.10000000000000001
r10100 n6621 n6622 0.1125
r10101 n6568 n6623 0.16666666666666666
r10102 n6622 n6623 0.10000000000000001
r10103 n6569 n6624 0.071428571428571425
r10104 n6623 n6624 0.125
r10105 n6570 n6625 0.071428571428571425
r10106 n6571 n6626 0.027777777777777776
r10107 n6625 n6626 0.3125
r10108 n6572 n6627 0.03125
r10109 n6626 n6627 0.42499999999999999
r10110 n6573 n6628 0.035714285714285712
r10111 n6627 n6628 0.375
r10112 n6574 n6629 0.025000000000000001
r10113 n6628 n6629 0.42499999999999999
r10114 n6575 n6630 0.10000000000000001
r10115 n6629 n6630 0.3125
r10116 n6576 n6631 0.017241379310344827
r10117 n6630 n6631 0.42499999999999999
r10118 n6577 n6632 0.014705882352941176
r10119 n6631 n6632 0.78749999999999998
r10120 n6578 n6633 0.014705882352941176
r10121 n6632 n6633 0.84999999999999998
r10122 n6579 n6634 0.014705882352941176
r10123 n6633 n6634 0.84999999999999998
r10124 n6580 n6635 0.012500000000000001
r10125 n6634 n6635 0.92500000000000004
r10126 n6581 n6636 0.014705882352941176
r10127 n6635 n6636 0.92500000000000004
r10128 n6582 n6637 0.014705882352941176
r10129 n6636 n6637 0.84999999999999998
r10130 n6583 n6638 0.014705882352941176
r10131 n6637 n6638 0.84999999999999998
r10132 n6584 n6639 0.029411764705882353
r10133 n6638 n6639 0.63749999999999996
r10134 n6585 n6640 0.029411764705882353
r10135 n6639 n6640 0.42499999999999999
r10136 n6586 n6641 0.012195121951219513
r10137 n6640 n6641 0.72499999999999998
r10138 n6587 n6642 0.012195121951219513
r10139 n6641 n6642 1.0249999999999999
r10140 n6588 n6643 0.012195121951219513
r10141 n6642 n6643 1.0249999999999999
r10142 n6589 n6644 0.050000000000000003
r10143 n6643 n6644 0.63749999999999996
r10144 n6590 n6645 0.050000000000000003
r10145 n6644 n6645 0.25
r10146 n6591 n6646 0.02
r10147 n6645 n6646 0.4375
r10148 n6592 n6647 0.5
r10149 n6646 n6647 0.32500000000000001
r10150 n6593 n6648 0.017857142857142856
r10151 n6647 n6648 0.36249999999999999
r10152 n6594 n6649 0.5
r10153 n6648 n6649 0.36249999999999999
r10154 n6595 n6650 0.02
r10155 n6649 n6650 0.32500000000000001
r10156 n6596 n6651 0.050000000000000003
r10157 n6650 n6651 0.4375
r10158 n6597 n6652 0.015151515151515152
r10159 n6598 n6653 0.25
r10160 n6652 n6653 0.72916666666666663
r10161 n6599 n6654 0.016666666666666666
r10162 n6653 n6654 0.66666666666666663
r10163 n6600 n6655 0.25
r10164 n6654 n6655 0.66666666666666663
r10165 n6601 n6656 0.015151515151515152
r10166 n6655 n6656 0.72916666666666663
r10167 n6602 n6657 0.10000000000000001
r10168 n6603 n6658 0.10000000000000001
r10169 n6657 n6658 0.20833333333333334
r10170 n6604 n6659 0.5
r10171 n6658 n6659 0.125
r10172 n6605 n6660 0.25
r10173 n6659 n6660 0.0625
r10174 n6606 n6661 0.5
r10175 n6660 n6661 0.0625
r10176 n6607 n6662 0.5
r10177 n6661 n6662 0.041666666666666664
r10178 n6608 n6663 0.5
r10179 n6662 n6663 0.041666666666666664
r10180 n6609 n6664 0.125
r10181 n6663 n6664 0.10416666666666667
r10182 n6610 n6665 0.10000000000000001
r10183 n6664 n6665 0.1875
r10184 n6611 n6666 0.5
r10185 n6665 n6666 0.125
r10186 n6612 n6667 0.050000000000000003
r10187 n6666 n6667 0.22916666666666666
r10188 n6613 n6668 0.16666666666666666
r10189 n6667 n6668 0.27083333333333331
r10190 n6614 n6669 0.083333333333333329
r10191 n6668 n6669 0.1875
r10192 n6615 n6670 0.25
r10193 n6669 n6670 0.16666666666666666
r10194 n6616 n6671 0.5
r10195 n6670 n6671 0.0625
r10196 n6617 n6672 0.5
r10197 n6671 n6672 0.041666666666666664
r10198 n6618 n6673 0.083333333333333329
r10199 n6672 n6673 0.14583333333333334
r10200 n6619 n6674 0.10000000000000001
r10201 n6673 n6674 0.22916666666666666
r10202 n6620 n6675 0.5
r10203 n6674 n6675 0.125
r10204 n6621 n6676 0.125
r10205 n6675 n6676 0.10416666666666667
r10206 n6622 n6677 0.10000000000000001
r10207 n6676 n6677 0.1875
r10208 n6623 n6678 0.16666666666666666
r10209 n6677 n6678 0.16666666666666666
r10210 n6624 n6679 0.071428571428571425
r10211 n6678 n6679 0.20833333333333334
r10212 n6625 n6680 0.071428571428571425
r10213 n6626 n6681 0.027777777777777776
r10214 n6680 n6681 0.52083333333333337
r10215 n6627 n6682 0.03125
r10216 n6681 n6682 0.70833333333333337
r10217 n6628 n6683 0.035714285714285712
r10218 n6682 n6683 0.625
r10219 n6629 n6684 0.025000000000000001
r10220 n6683 n6684 0.70833333333333337
r10221 n6630 n6685 0.10000000000000001
r10222 n6684 n6685 0.52083333333333337
r10223 n6631 n6686 0.017241379310344827
r10224 n6685 n6686 0.70833333333333337
r10225 n6632 n6687 0.014705882352941176
r10226 n6686 n6687 1.3125
r10227 n6633 n6688 0.014705882352941176
r10228 n6687 n6688 1.4166666666666667
r10229 n6634 n6689 0.014705882352941176
r10230 n6688 n6689 1.4166666666666667
r10231 n6635 n6690 0.012500000000000001
r10232 n6689 n6690 1.5416666666666667
r10233 n6636 n6691 0.014705882352941176
r10234 n6690 n6691 1.5416666666666667
r10235 n6637 n6692 0.014705882352941176
r10236 n6691 n6692 1.4166666666666667
r10237 n6638 n6693 0.014705882352941176
r10238 n6692 n6693 1.4166666666666667
r10239 n6639 n6694 0.029411764705882353
r10240 n6693 n6694 1.0625
r10241 n6640 n6695 0.029411764705882353
r10242 n6694 n6695 0.70833333333333337
r10243 n6641 n6696 0.012195121951219513
r10244 n6695 n6696 1.2083333333333333
r10245 n6642 n6697 0.012195121951219513
r10246 n6696 n6697 1.7083333333333333
r10247 n6643 n6698 0.012195121951219513
r10248 n6697 n6698 1.7083333333333333
r10249 n6644 n6699 0.050000000000000003
r10250 n6698 n6699 1.0625
r10251 n6645 n6700 0.050000000000000003
r10252 n6699 n6700 0.41666666666666669
r10253 n6646 n6701 0.02
r10254 n6700 n6701 0.72916666666666663
r10255 n6647 n6702 0.5
r10256 n6701 n6702 0.54166666666666663
r10257 n6648 n6703 0.017857142857142856
r10258 n6702 n6703 0.60416666666666663
r10259 n6649 n6704 0.5
r10260 n6703 n6704 0.60416666666666663
r10261 n6650 n6705 0.02
r10262 n6704 n6705 0.54166666666666663
r10263 n6651 n6706 0.050000000000000003
r10264 n6705 n6706 0.72916666666666663
r10265 n6652 n6707 0.00946969696969697
r10266 n6653 n6708 0.15625
r10267 n6707 n6708 1.09375
r10268 n6654 n6709 0.010416666666666666
r10269 n6708 n6709 1
r10270 n6655 n6710 0.15625
r10271 n6709 n6710 1
r10272 n6656 n6711 0.00946969696969697
r10273 n6710 n6711 1.09375
r10274 n6657 n6712 0.0625
r10275 n6658 n6713 0.0625
r10276 n6712 n6713 0.3125
r10277 n6659 n6714 0.3125
r10278 n6713 n6714 0.1875
r10279 n6660 n6715 0.15625
r10280 n6714 n6715 0.09375
r10281 n6661 n6716 0.3125
r10282 n6715 n6716 0.09375
r10283 n6662 n6717 0.3125
r10284 n6716 n6717 0.0625
r10285 n6663 n6718 0.3125
r10286 n6717 n6718 0.0625
r10287 n6664 n6719 0.078125
r10288 n6718 n6719 0.15625
r10289 n6665 n6720 0.0625
r10290 n6719 n6720 0.28125
r10291 n6666 n6721 0.3125
r10292 n6720 n6721 0.1875
r10293 n6667 n6722 0.03125
r10294 n6721 n6722 0.34375
r10295 n6668 n6723 0.10416666666666667
r10296 n6722 n6723 0.40625
r10297 n6669 n6724 0.052083333333333336
r10298 n6723 n6724 0.28125
r10299 n6670 n6725 0.15625
r10300 n6724 n6725 0.25
r10301 n6671 n6726 0.3125
r10302 n6725 n6726 0.09375
r10303 n6672 n6727 0.3125
r10304 n6726 n6727 0.0625
r10305 n6673 n6728 0.052083333333333336
r10306 n6727 n6728 0.21875
r10307 n6674 n6729 0.0625
r10308 n6728 n6729 0.34375
r10309 n6675 n6730 0.3125
r10310 n6729 n6730 0.1875
r10311 n6676 n6731 0.078125
r10312 n6730 n6731 0.15625
r10313 n6677 n6732 0.0625
r10314 n6731 n6732 0.28125
r10315 n6678 n6733 0.10416666666666667
r10316 n6732 n6733 0.25
r10317 n6679 n6734 0.044642857142857144
r10318 n6733 n6734 0.3125
r10319 n6680 n6735 0.044642857142857144
r10320 n6681 n6736 0.017361111111111112
r10321 n6735 n6736 0.78125
r10322 n6682 n6737 0.01953125
r10323 n6736 n6737 1.0625
r10324 n6683 n6738 0.022321428571428572
r10325 n6737 n6738 0.9375
r10326 n6684 n6739 0.015625
r10327 n6738 n6739 1.0625
r10328 n6685 n6740 0.0625
r10329 n6739 n6740 0.78125
r10330 n6686 n6741 0.010775862068965518
r10331 n6740 n6741 1.0625
r10332 n6687 n6742 0.0091911764705882356
r10333 n6741 n6742 1.96875
r10334 n6688 n6743 0.0091911764705882356
r10335 n6742 n6743 2.125
r10336 n6689 n6744 0.0091911764705882356
r10337 n6743 n6744 2.125
r10338 n6690 n6745 0.0078125
r10339 n6744 n6745 2.3125
r10340 n6691 n6746 0.0091911764705882356
r10341 n6745 n6746 2.3125
r10342 n6692 n6747 0.0091911764705882356
r10343 n6746 n6747 2.125
r10344 n6693 n6748 0.0091911764705882356
r10345 n6747 n6748 2.125
r10346 n6694 n6749 0.018382352941176471
r10347 n6748 n6749 1.59375
r10348 n6695 n6750 0.018382352941176471
r10349 n6749 n6750 1.0625
r10350 n6696 n6751 0.007621951219512195
r10351 n6750 n6751 1.8125
r10352 n6697 n6752 0.007621951219512195
r10353 n6751 n6752 2.5625
r10354 n6698 n6753 0.007621951219512195
r10355 n6752 n6753 2.5625
r10356 n6699 n6754 0.03125
r10357 n6753 n6754 1.59375
r10358 n6700 n6755 0.03125
r10359 n6754 n6755 0.625
r10360 n6701 n6756 0.012500000000000001
r10361 n6755 n6756 1.09375
r10362 n6702 n6757 0.3125
r10363 n6756 n6757 0.8125
r10364 n6703 n6758 0.011160714285714286
r10365 n6757 n6758 0.90625
r10366 n6704 n6759 0.3125
r10367 n6758 n6759 0.90625
r10368 n6705 n6760 0.012500000000000001
r10369 n6759 n6760 0.8125
r10370 n6706 n6761 0.03125
r10371 n6760 n6761 1.09375
r10372 n6707 n6762 0.060606060606060608
r10373 n6708 n6763 1
r10374 n6762 n6763 0.072916666666666671
r10375 n6709 n6764 0.066666666666666666
r10376 n6763 n6764 0.066666666666666666
r10377 n6710 n6765 1
r10378 n6764 n6765 0.066666666666666666
r10379 n6711 n6766 0.060606060606060608
r10380 n6765 n6766 0.072916666666666671
r10381 n6712 n6767 0.40000000000000002
r10382 n6713 n6768 0.40000000000000002
r10383 n6767 n6768 0.020833333333333332
r10384 n6714 n6769 2
r10385 n6768 n6769 0.012500000000000001
r10386 n6715 n6770 1
r10387 n6769 n6770 0.0062500000000000003
r10388 n6716 n6771 2
r10389 n6770 n6771 0.0062500000000000003
r10390 n6717 n6772 2
r10391 n6771 n6772 0.0041666666666666666
r10392 n6718 n6773 2
r10393 n6772 n6773 0.0041666666666666666
r10394 n6719 n6774 0.5
r10395 n6773 n6774 0.010416666666666666
r10396 n6720 n6775 0.40000000000000002
r10397 n6774 n6775 0.018749999999999999
r10398 n6721 n6776 2
r10399 n6775 n6776 0.012500000000000001
r10400 n6722 n6777 0.20000000000000001
r10401 n6776 n6777 0.022916666666666665
r10402 n6723 n6778 0.66666666666666663
r10403 n6777 n6778 0.027083333333333334
r10404 n6724 n6779 0.33333333333333331
r10405 n6778 n6779 0.018749999999999999
r10406 n6725 n6780 1
r10407 n6779 n6780 0.016666666666666666
r10408 n6726 n6781 2
r10409 n6780 n6781 0.0062500000000000003
r10410 n6727 n6782 2
r10411 n6781 n6782 0.0041666666666666666
r10412 n6728 n6783 0.33333333333333331
r10413 n6782 n6783 0.014583333333333334
r10414 n6729 n6784 0.40000000000000002
r10415 n6783 n6784 0.022916666666666665
r10416 n6730 n6785 2
r10417 n6784 n6785 0.012500000000000001
r10418 n6731 n6786 0.5
r10419 n6785 n6786 0.010416666666666666
r10420 n6732 n6787 0.40000000000000002
r10421 n6786 n6787 0.018749999999999999
r10422 n6733 n6788 0.66666666666666663
r10423 n6787 n6788 0.016666666666666666
r10424 n6734 n6789 0.2857142857142857
r10425 n6788 n6789 0.020833333333333332
r10426 n6735 n6790 0.2857142857142857
r10427 n6736 n6791 0.1111111111111111
r10428 n6790 n6791 0.052083333333333336
r10429 n6737 n6792 0.125
r10430 n6791 n6792 0.070833333333333331
r10431 n6738 n6793 0.14285714285714285
r10432 n6792 n6793 0.0625
r10433 n6739 n6794 0.10000000000000001
r10434 n6793 n6794 0.070833333333333331
r10435 n6740 n6795 0.40000000000000002
r10436 n6794 n6795 0.052083333333333336
r10437 n6741 n6796 0.068965517241379309
r10438 n6795 n6796 0.070833333333333331
r10439 n6742 n6797 0.058823529411764705
r10440 n6796 n6797 0.13125000000000001
r10441 n6743 n6798 0.058823529411764705
r10442 n6797 n6798 0.14166666666666666
r10443 n6744 n6799 0.058823529411764705
r10444 n6798 n6799 0.14166666666666666
r10445 n6745 n6800 0.050000000000000003
r10446 n6799 n6800 0.15416666666666667
r10447 n6746 n6801 0.058823529411764705
r10448 n6800 n6801 0.15416666666666667
r10449 n6747 n6802 0.058823529411764705
r10450 n6801 n6802 0.14166666666666666
r10451 n6748 n6803 0.058823529411764705
r10452 n6802 n6803 0.14166666666666666
r10453 n6749 n6804 0.11764705882352941
r10454 n6803 n6804 0.10625
r10455 n6750 n6805 0.11764705882352941
r10456 n6804 n6805 0.070833333333333331
r10457 n6751 n6806 0.04878048780487805
r10458 n6805 n6806 0.12083333333333333
r10459 n6752 n6807 0.04878048780487805
r10460 n6806 n6807 0.17083333333333334
r10461 n6753 n6808 0.04878048780487805
r10462 n6807 n6808 0.17083333333333334
r10463 n6754 n6809 0.20000000000000001
r10464 n6808 n6809 0.10625
r10465 n6755 n6810 0.20000000000000001
r10466 n6809 n6810 0.041666666666666664
r10467 n6756 n6811 0.080000000000000002
r10468 n6810 n6811 0.072916666666666671
r10469 n6757 n6812 2
r10470 n6811 n6812 0.054166666666666669
r10471 n6758 n6813 0.071428571428571425
r10472 n6812 n6813 0.060416666666666667
r10473 n6759 n6814 2
r10474 n6813 n6814 0.060416666666666667
r10475 n6760 n6815 0.080000000000000002
r10476 n6814 n6815 0.054166666666666669
r10477 n6761 n6816 0.20000000000000001
r10478 n6815 n6816 0.072916666666666671
r10479 n6762 n6817 0.060606060606060608
r10480 n6763 n6818 1
r10481 n6817 n6818 1.09375
r10482 n6764 n6819 0.066666666666666666
r10483 n6818 n6819 1
r10484 n6765 n6820 1
r10485 n6819 n6820 1
r10486 n6766 n6821 0.060606060606060608
r10487 n6820 n6821 1.09375
r10488 n6767 n6822 0.40000000000000002
r10489 n6768 n6823 0.40000000000000002
r10490 n6822 n6823 0.3125
r10491 n6769 n6824 2
r10492 n6823 n6824 0.1875
r10493 n6770 n6825 1
r10494 n6824 n6825 0.09375
r10495 n6771 n6826 2
r10496 n6825 n6826 0.09375
r10497 n6772 n6827 2
r10498 n6826 n6827 0.0625
r10499 n6773 n6828 2
r10500 n6827 n6828 0.0625
r10501 n6774 n6829 0.5
r10502 n6828 n6829 0.15625
r10503 n6775 n6830 0.40000000000000002
r10504 n6829 n6830 0.28125
r10505 n6776 n6831 2
r10506 n6830 n6831 0.1875
r10507 n6777 n6832 0.20000000000000001
r10508 n6831 n6832 0.34375
r10509 n6778 n6833 0.66666666666666663
r10510 n6832 n6833 0.40625
r10511 n6779 n6834 0.33333333333333331
r10512 n6833 n6834 0.28125
r10513 n6780 n6835 1
r10514 n6834 n6835 0.25
r10515 n6781 n6836 2
r10516 n6835 n6836 0.09375
r10517 n6782 n6837 2
r10518 n6836 n6837 0.0625
r10519 n6783 n6838 0.33333333333333331
r10520 n6837 n6838 0.21875
r10521 n6784 n6839 0.40000000000000002
r10522 n6838 n6839 0.34375
r10523 n6785 n6840 2
r10524 n6839 n6840 0.1875
r10525 n6786 n6841 0.5
r10526 n6840 n6841 0.15625
r10527 n6787 n6842 0.40000000000000002
r10528 n6841 n6842 0.28125
r10529 n6788 n6843 0.66666666666666663
r10530 n6842 n6843 0.25
r10531 n6789 n6844 0.2857142857142857
r10532 n6843 n6844 0.3125
r10533 n6790 n6845 0.2857142857142857
r10534 n6791 n6846 0.1111111111111111
r10535 n6845 n6846 0.78125
r10536 n6792 n6847 0.125
r10537 n6846 n6847 1.0625
r10538 n6793 n6848 0.14285714285714285
r10539 n6847 n6848 0.9375
r10540 n6794 n6849 0.10000000000000001
r10541 n6848 n6849 1.0625
r10542 n6795 n6850 0.40000000000000002
r10543 n6849 n6850 0.78125
r10544 n6796 n6851 0.068965517241379309
r10545 n6850 n6851 1.0625
r10546 n6797 n6852 0.058823529411764705
r10547 n6851 n6852 1.96875
r10548 n6798 n6853 0.058823529411764705
r10549 n6852 n6853 2.125
r10550 n6799 n6854 0.058823529411764705
r10551 n6853 n6854 2.125
r10552 n6800 n6855 0.050000000000000003
r10553 n6854 n6855 2.3125
r10554 n6801 n6856 0.058823529411764705
r10555 n6855 n6856 2.3125
r10556 n6802 n6857 0.058823529411764705
r10557 n6856 n6857 2.125
r10558 n6803 n6858 0.058823529411764705
r10559 n6857 n6858 2.125
r10560 n6804 n6859 0.11764705882352941
r10561 n6858 n6859 1.59375
r10562 n6805 n6860 0.11764705882352941
r10563 n6859 n6860 1.0625
r10564 n6806 n6861 0.04878048780487805
r10565 n6860 n6861 1.8125
r10566 n6807 n6862 0.04878048780487805
r10567 n6861 n6862 2.5625
r10568 n6808 n6863 0.04878048780487805
r10569 n6862 n6863 2.5625
r10570 n6809 n6864 0.20000000000000001
r10571 n6863 n6864 1.59375
r10572 n6810 n6865 0.20000000000000001
r10573 n6864 n6865 0.625
r10574 n6811 n6866 0.080000000000000002
r10575 n6865 n6866 1.09375
r10576 n6812 n6867 2
r10577 n6866 n6867 0.8125
r10578 n6813 n6868 0.071428571428571425
r10579 n6867 n6868 0.90625
r10580 n6814 n6869 2
r10581 n6868 n6869 0.90625
r10582 n6815 n6870 0.080000000000000002
r10583 n6869 n6870 0.8125
r10584 n6816 n6871 0.20000000000000001
r10585 n6870 n6871 1.09375
r10586 n6817 n6872 0.00946969696969697
r10587 n6818 n6873 0.15625
r10588 n6872 n6873 0.72916666666666663
r10589 n6819 n6874 0.010416666666666666
r10590 n6873 n6874 0.66666666666666663
r10591 n6820 n6875 0.15625
r10592 n6874 n6875 0.66666666666666663
r10593 n6821 n6876 0.00946969696969697
r10594 n6875 n6876 0.72916666666666663
r10595 n6822 n6877 0.0625
r10596 n6823 n6878 0.0625
r10597 n6877 n6878 0.20833333333333334
r10598 n6824 n6879 0.3125
r10599 n6878 n6879 0.125
r10600 n6825 n6880 0.15625
r10601 n6879 n6880 0.0625
r10602 n6826 n6881 0.3125
r10603 n6880 n6881 0.0625
r10604 n6827 n6882 0.3125
r10605 n6881 n6882 0.041666666666666664
r10606 n6828 n6883 0.3125
r10607 n6882 n6883 0.041666666666666664
r10608 n6829 n6884 0.078125
r10609 n6883 n6884 0.10416666666666667
r10610 n6830 n6885 0.0625
r10611 n6884 n6885 0.1875
r10612 n6831 n6886 0.3125
r10613 n6885 n6886 0.125
r10614 n6832 n6887 0.03125
r10615 n6886 n6887 0.22916666666666666
r10616 n6833 n6888 0.10416666666666667
r10617 n6887 n6888 0.27083333333333331
r10618 n6834 n6889 0.052083333333333336
r10619 n6888 n6889 0.1875
r10620 n6835 n6890 0.15625
r10621 n6889 n6890 0.16666666666666666
r10622 n6836 n6891 0.3125
r10623 n6890 n6891 0.0625
r10624 n6837 n6892 0.3125
r10625 n6891 n6892 0.041666666666666664
r10626 n6838 n6893 0.052083333333333336
r10627 n6892 n6893 0.14583333333333334
r10628 n6839 n6894 0.0625
r10629 n6893 n6894 0.22916666666666666
r10630 n6840 n6895 0.3125
r10631 n6894 n6895 0.125
r10632 n6841 n6896 0.078125
r10633 n6895 n6896 0.10416666666666667
r10634 n6842 n6897 0.0625
r10635 n6896 n6897 0.1875
r10636 n6843 n6898 0.10416666666666667
r10637 n6897 n6898 0.16666666666666666
r10638 n6844 n6899 0.044642857142857144
r10639 n6898 n6899 0.20833333333333334
r10640 n6845 n6900 0.044642857142857144
r10641 n6846 n6901 0.017361111111111112
r10642 n6900 n6901 0.52083333333333337
r10643 n6847 n6902 0.01953125
r10644 n6901 n6902 0.70833333333333337
r10645 n6848 n6903 0.022321428571428572
r10646 n6902 n6903 0.625
r10647 n6849 n6904 0.015625
r10648 n6903 n6904 0.70833333333333337
r10649 n6850 n6905 0.0625
r10650 n6904 n6905 0.52083333333333337
r10651 n6851 n6906 0.010775862068965518
r10652 n6905 n6906 0.70833333333333337
r10653 n6852 n6907 0.0091911764705882356
r10654 n6906 n6907 1.3125
r10655 n6853 n6908 0.0091911764705882356
r10656 n6907 n6908 1.4166666666666667
r10657 n6854 n6909 0.0091911764705882356
r10658 n6908 n6909 1.4166666666666667
r10659 n6855 n6910 0.0078125
r10660 n6909 n6910 1.5416666666666667
r10661 n6856 n6911 0.0091911764705882356
r10662 n6910 n6911 1.5416666666666667
r10663 n6857 n6912 0.0091911764705882356
r10664 n6911 n6912 1.4166666666666667
r10665 n6858 n6913 0.0091911764705882356
r10666 n6912 n6913 1.4166666666666667
r10667 n6859 n6914 0.018382352941176471
r10668 n6913 n6914 1.0625
r10669 n6860 n6915 0.018382352941176471
r10670 n6914 n6915 0.70833333333333337
r10671 n6861 n6916 0.007621951219512195
r10672 n6915 n6916 1.2083333333333333
r10673 n6862 n6917 0.007621951219512195
r10674 n6916 n6917 1.7083333333333333
r10675 n6863 n6918 0.007621951219512195
r10676 n6917 n6918 1.7083333333333333
r10677 n6864 n6919 0.03125
r10678 n6918 n6919 1.0625
r10679 n6865 n6920 0.03125
r10680 n6919 n6920 0.41666666666666669
r10681 n6866 n6921 0.012500000000000001
r10682 n6920 n6921 0.72916666666666663
r10683 n6867 n6922 0.3125
r10684 n6921 n6922 0.54166666666666663
r10685 n6868 n6923 0.011160714285714286
r10686 n6922 n6923 0.60416666666666663
r10687 n6869 n6924 0.3125
r10688 n6923 n6924 0.60416666666666663
r10689 n6870 n6925 0.012500000000000001
r10690 n6924 n6925 0.54166666666666663
r10691 n6871 n6926 0.03125
r10692 n6925 n6926 0.72916666666666663
r10693 n6872 n6927 0.015151515151515152
r10694 n6873 n6928 0.25
r10695 n6927 n6928 0.4375
r10696 n6874 n6929 0.016666666666666666
r10697 n6928 n6929 0.40000000000000002
r10698 n6875 n6930 0.25
r10699 n6929 n6930 0.40000000000000002
r10700 n6876 n6931 0.015151515151515152
r10701 n6930 n6931 0.4375
r10702 n6877 n6932 0.10000000000000001
r10703 n6878 n6933 0.10000000000000001
r10704 n6932 n6933 0.125
r10705 n6879 n6934 0.5
r10706 n6933 n6934 0.074999999999999997
r10707 n6880 n6935 0.25
r10708 n6934 n6935 0.037499999999999999
r10709 n6881 n6936 0.5
r10710 n6935 n6936 0.037499999999999999
r10711 n6882 n6937 0.5
r10712 n6936 n6937 0.025000000000000001
r10713 n6883 n6938 0.5
r10714 n6937 n6938 0.025000000000000001
r10715 n6884 n6939 0.125
r10716 n6938 n6939 0.0625
r10717 n6885 n6940 0.10000000000000001
r10718 n6939 n6940 0.1125
r10719 n6886 n6941 0.5
r10720 n6940 n6941 0.074999999999999997
r10721 n6887 n6942 0.050000000000000003
r10722 n6941 n6942 0.13750000000000001
r10723 n6888 n6943 0.16666666666666666
r10724 n6942 n6943 0.16250000000000001
r10725 n6889 n6944 0.083333333333333329
r10726 n6943 n6944 0.1125
r10727 n6890 n6945 0.25
r10728 n6944 n6945 0.10000000000000001
r10729 n6891 n6946 0.5
r10730 n6945 n6946 0.037499999999999999
r10731 n6892 n6947 0.5
r10732 n6946 n6947 0.025000000000000001
r10733 n6893 n6948 0.083333333333333329
r10734 n6947 n6948 0.087499999999999994
r10735 n6894 n6949 0.10000000000000001
r10736 n6948 n6949 0.13750000000000001
r10737 n6895 n6950 0.5
r10738 n6949 n6950 0.074999999999999997
r10739 n6896 n6951 0.125
r10740 n6950 n6951 0.0625
r10741 n6897 n6952 0.10000000000000001
r10742 n6951 n6952 0.1125
r10743 n6898 n6953 0.16666666666666666
r10744 n6952 n6953 0.10000000000000001
r10745 n6899 n6954 0.071428571428571425
r10746 n6953 n6954 0.125
r10747 n6900 n6955 0.071428571428571425
r10748 n6901 n6956 0.027777777777777776
r10749 n6955 n6956 0.3125
r10750 n6902 n6957 0.03125
r10751 n6956 n6957 0.42499999999999999
r10752 n6903 n6958 0.035714285714285712
r10753 n6957 n6958 0.375
r10754 n6904 n6959 0.025000000000000001
r10755 n6958 n6959 0.42499999999999999
r10756 n6905 n6960 0.10000000000000001
r10757 n6959 n6960 0.3125
r10758 n6906 n6961 0.017241379310344827
r10759 n6960 n6961 0.42499999999999999
r10760 n6907 n6962 0.014705882352941176
r10761 n6961 n6962 0.78749999999999998
r10762 n6908 n6963 0.014705882352941176
r10763 n6962 n6963 0.84999999999999998
r10764 n6909 n6964 0.014705882352941176
r10765 n6963 n6964 0.84999999999999998
r10766 n6910 n6965 0.012500000000000001
r10767 n6964 n6965 0.92500000000000004
r10768 n6911 n6966 0.014705882352941176
r10769 n6965 n6966 0.92500000000000004
r10770 n6912 n6967 0.014705882352941176
r10771 n6966 n6967 0.84999999999999998
r10772 n6913 n6968 0.014705882352941176
r10773 n6967 n6968 0.84999999999999998
r10774 n6914 n6969 0.029411764705882353
r10775 n6968 n6969 0.63749999999999996
r10776 n6915 n6970 0.029411764705882353
r10777 n6969 n6970 0.42499999999999999
r10778 n6916 n6971 0.012195121951219513
r10779 n6970 n6971 0.72499999999999998
r10780 n6917 n6972 0.012195121951219513
r10781 n6971 n6972 1.0249999999999999
r10782 n6918 n6973 0.012195121951219513
r10783 n6972 n6973 1.0249999999999999
r10784 n6919 n6974 0.050000000000000003
r10785 n6973 n6974 0.63749999999999996
r10786 n6920 n6975 0.050000000000000003
r10787 n6974 n6975 0.25
r10788 n6921 n6976 0.02
r10789 n6975 n6976 0.4375
r10790 n6922 n6977 0.5
r10791 n6976 n6977 0.32500000000000001
r10792 n6923 n6978 0.017857142857142856
r10793 n6977 n6978 0.36249999999999999
r10794 n6924 n6979 0.5
r10795 n6978 n6979 0.36249999999999999
r10796 n6925 n6980 0.02
r10797 n6979 n6980 0.32500000000000001
r10798 n6926 n6981 0.050000000000000003
r10799 n6980 n6981 0.4375
r10800 n6927 n6982 0.015151515151515152
r10801 n6928 n6983 0.25
r10802 n6982 n6983 0.72916666666666663
r10803 n6929 n6984 0.016666666666666666
r10804 n6983 n6984 0.66666666666666663
r10805 n6930 n6985 0.25
r10806 n6984 n6985 0.66666666666666663
r10807 n6931 n6986 0.015151515151515152
r10808 n6985 n6986 0.72916666666666663
r10809 n6932 n6987 0.10000000000000001
r10810 n6933 n6988 0.10000000000000001
r10811 n6987 n6988 0.20833333333333334
r10812 n6934 n6989 0.5
r10813 n6988 n6989 0.125
r10814 n6935 n6990 0.25
r10815 n6989 n6990 0.0625
r10816 n6936 n6991 0.5
r10817 n6990 n6991 0.0625
r10818 n6937 n6992 0.5
r10819 n6991 n6992 0.041666666666666664
r10820 n6938 n6993 0.5
r10821 n6992 n6993 0.041666666666666664
r10822 n6939 n6994 0.125
r10823 n6993 n6994 0.10416666666666667
r10824 n6940 n6995 0.10000000000000001
r10825 n6994 n6995 0.1875
r10826 n6941 n6996 0.5
r10827 n6995 n6996 0.125
r10828 n6942 n6997 0.050000000000000003
r10829 n6996 n6997 0.22916666666666666
r10830 n6943 n6998 0.16666666666666666
r10831 n6997 n6998 0.27083333333333331
r10832 n6944 n6999 0.083333333333333329
r10833 n6998 n6999 0.1875
r10834 n6945 n7000 0.25
r10835 n6999 n7000 0.16666666666666666
r10836 n6946 n7001 0.5
r10837 n7000 n7001 0.0625
r10838 n6947 n7002 0.5
r10839 n7001 n7002 0.041666666666666664
r10840 n6948 n7003 0.083333333333333329
r10841 n7002 n7003 0.14583333333333334
r10842 n6949 n7004 0.10000000000000001
r10843 n7003 n7004 0.22916666666666666
r10844 n6950 n7005 0.5
r10845 n7004 n7005 0.125
r10846 n6951 n7006 0.125
r10847 n7005 n7006 0.10416666666666667
r10848 n6952 n7007 0.10000000000000001
r10849 n7006 n7007 0.1875
r10850 n6953 n7008 0.16666666666666666
r10851 n7007 n7008 0.16666666666666666
r10852 n6954 n7009 0.071428571428571425
r10853 n7008 n7009 0.20833333333333334
r10854 n6955 n7010 0.071428571428571425
r10855 n6956 n7011 0.027777777777777776
r10856 n7010 n7011 0.52083333333333337
r10857 n6957 n7012 0.03125
r10858 n7011 n7012 0.70833333333333337
r10859 n6958 n7013 0.035714285714285712
r10860 n7012 n7013 0.625
r10861 n6959 n7014 0.025000000000000001
r10862 n7013 n7014 0.70833333333333337
r10863 n6960 n7015 0.10000000000000001
r10864 n7014 n7015 0.52083333333333337
r10865 n6961 n7016 0.017241379310344827
r10866 n7015 n7016 0.70833333333333337
r10867 n6962 n7017 0.014705882352941176
r10868 n7016 n7017 1.3125
r10869 n6963 n7018 0.014705882352941176
r10870 n7017 n7018 1.4166666666666667
r10871 n6964 n7019 0.014705882352941176
r10872 n7018 n7019 1.4166666666666667
r10873 n6965 n7020 0.012500000000000001
r10874 n7019 n7020 1.5416666666666667
r10875 n6966 n7021 0.014705882352941176
r10876 n7020 n7021 1.5416666666666667
r10877 n6967 n7022 0.014705882352941176
r10878 n7021 n7022 1.4166666666666667
r10879 n6968 n7023 0.014705882352941176
r10880 n7022 n7023 1.4166666666666667
r10881 n6969 n7024 0.029411764705882353
r10882 n7023 n7024 1.0625
r10883 n6970 n7025 0.029411764705882353
r10884 n7024 n7025 0.70833333333333337
r10885 n6971 n7026 0.012195121951219513
r10886 n7025 n7026 1.2083333333333333
r10887 n6972 n7027 0.012195121951219513
r10888 n7026 n7027 1.7083333333333333
r10889 n6973 n7028 0.012195121951219513
r10890 n7027 n7028 1.7083333333333333
r10891 n6974 n7029 0.050000000000000003
r10892 n7028 n7029 1.0625
r10893 n6975 n7030 0.050000000000000003
r10894 n7029 n7030 0.41666666666666669
r10895 n6976 n7031 0.02
r10896 n7030 n7031 0.72916666666666663
r10897 n6977 n7032 0.5
r10898 n7031 n7032 0.54166666666666663
r10899 n6978 n7033 0.017857142857142856
r10900 n7032 n7033 0.60416666666666663
r10901 n6979 n7034 0.5
r10902 n7033 n7034 0.60416666666666663
r10903 n6980 n7035 0.02
r10904 n7034 n7035 0.54166666666666663
r10905 n6981 n7036 0.050000000000000003
r10906 n7035 n7036 0.72916666666666663
r10907 n6982 n7037 0.00946969696969697
r10908 n6983 n7038 0.15625
r10909 n7037 n7038 1.09375
r10910 n6984 n7039 0.010416666666666666
r10911 n7038 n7039 1
r10912 n6985 n7040 0.15625
r10913 n7039 n7040 1
r10914 n6986 n7041 0.00946969696969697
r10915 n7040 n7041 1.09375
r10916 n6987 n7042 0.0625
r10917 n6988 n7043 0.0625
r10918 n7042 n7043 0.3125
r10919 n6989 n7044 0.3125
r10920 n7043 n7044 0.1875
r10921 n6990 n7045 0.15625
r10922 n7044 n7045 0.09375
r10923 n6991 n7046 0.3125
r10924 n7045 n7046 0.09375
r10925 n6992 n7047 0.3125
r10926 n7046 n7047 0.0625
r10927 n6993 n7048 0.3125
r10928 n7047 n7048 0.0625
r10929 n6994 n7049 0.078125
r10930 n7048 n7049 0.15625
r10931 n6995 n7050 0.0625
r10932 n7049 n7050 0.28125
r10933 n6996 n7051 0.3125
r10934 n7050 n7051 0.1875
r10935 n6997 n7052 0.03125
r10936 n7051 n7052 0.34375
r10937 n6998 n7053 0.10416666666666667
r10938 n7052 n7053 0.40625
r10939 n6999 n7054 0.052083333333333336
r10940 n7053 n7054 0.28125
r10941 n7000 n7055 0.15625
r10942 n7054 n7055 0.25
r10943 n7001 n7056 0.3125
r10944 n7055 n7056 0.09375
r10945 n7002 n7057 0.3125
r10946 n7056 n7057 0.0625
r10947 n7003 n7058 0.052083333333333336
r10948 n7057 n7058 0.21875
r10949 n7004 n7059 0.0625
r10950 n7058 n7059 0.34375
r10951 n7005 n7060 0.3125
r10952 n7059 n7060 0.1875
r10953 n7006 n7061 0.078125
r10954 n7060 n7061 0.15625
r10955 n7007 n7062 0.0625
r10956 n7061 n7062 0.28125
r10957 n7008 n7063 0.10416666666666667
r10958 n7062 n7063 0.25
r10959 n7009 n7064 0.044642857142857144
r10960 n7063 n7064 0.3125
r10961 n7010 n7065 0.044642857142857144
r10962 n7011 n7066 0.017361111111111112
r10963 n7065 n7066 0.78125
r10964 n7012 n7067 0.01953125
r10965 n7066 n7067 1.0625
r10966 n7013 n7068 0.022321428571428572
r10967 n7067 n7068 0.9375
r10968 n7014 n7069 0.015625
r10969 n7068 n7069 1.0625
r10970 n7015 n7070 0.0625
r10971 n7069 n7070 0.78125
r10972 n7030 n7071 0.03125
r10973 n7031 n7072 0.012500000000000001
r10974 n7071 n7072 1.09375
r10975 n7032 n7073 0.3125
r10976 n7072 n7073 0.8125
r10977 n7033 n7074 0.011160714285714286
r10978 n7073 n7074 0.90625
r10979 n7034 n7075 0.3125
r10980 n7074 n7075 0.90625
r10981 n7035 n7076 0.012500000000000001
r10982 n7075 n7076 0.8125
r10983 n7036 n7077 0.03125
r10984 n7076 n7077 1.09375
r10985 n7037 n7078 0.022727272727272728
r10986 n7038 n7079 0.375
r10987 n7078 n7079 0.21875
r10988 n7039 n7080 0.025000000000000001
r10989 n7079 n7080 0.20000000000000001
r10990 n7040 n7081 0.375
r10991 n7080 n7081 0.20000000000000001
r10992 n7041 n7082 0.022727272727272728
r10993 n7081 n7082 0.21875
r10994 n7042 n7083 0.14999999999999999
r10995 n7043 n7084 0.14999999999999999
r10996 n7083 n7084 0.0625
r10997 n7044 n7085 0.75
r10998 n7084 n7085 0.037499999999999999
r10999 n7045 n7086 0.375
r11000 n7085 n7086 0.018749999999999999
r11001 n7046 n7087 0.75
r11002 n7086 n7087 0.018749999999999999
r11003 n7047 n7088 0.75
r11004 n7087 n7088 0.012500000000000001
r11005 n7048 n7089 0.75
r11006 n7088 n7089 0.012500000000000001
r11007 n7049 n7090 0.1875
r11008 n7089 n7090 0.03125
r11009 n7050 n7091 0.14999999999999999
r11010 n7090 n7091 0.056250000000000001
r11011 n7051 n7092 0.75
r11012 n7091 n7092 0.037499999999999999
r11013 n7052 n7093 0.074999999999999997
r11014 n7092 n7093 0.068750000000000006
r11015 n7053 n7094 0.25
r11016 n7093 n7094 0.081250000000000003
r11017 n7054 n7095 0.125
r11018 n7094 n7095 0.056250000000000001
r11019 n7055 n7096 0.375
r11020 n7095 n7096 0.050000000000000003
r11021 n7056 n7097 0.75
r11022 n7096 n7097 0.018749999999999999
r11023 n7057 n7098 0.75
r11024 n7097 n7098 0.012500000000000001
r11025 n7058 n7099 0.125
r11026 n7098 n7099 0.043749999999999997
r11027 n7059 n7100 0.14999999999999999
r11028 n7099 n7100 0.068750000000000006
r11029 n7060 n7101 0.75
r11030 n7100 n7101 0.037499999999999999
r11031 n7061 n7102 0.1875
r11032 n7101 n7102 0.03125
r11033 n7062 n7103 0.14999999999999999
r11034 n7102 n7103 0.056250000000000001
r11035 n7063 n7104 0.25
r11036 n7103 n7104 0.050000000000000003
r11037 n7064 n7105 0.10714285714285714
r11038 n7104 n7105 0.0625
r11039 n7071 n7106 0.074999999999999997
r11040 n7072 n7107 0.029999999999999999
r11041 n7106 n7107 0.21875
r11042 n7073 n7108 0.75
r11043 n7107 n7108 0.16250000000000001
r11044 n7074 n7109 0.026785714285714284
r11045 n7108 n7109 0.18124999999999999
r11046 n7075 n7110 0.75
r11047 n7109 n7110 0.18124999999999999
r11048 n7076 n7111 0.029999999999999999
r11049 n7110 n7111 0.16250000000000001
r11050 n7077 n7112 0.074999999999999997
r11051 n7111 n7112 0.21875
r11052 n7078 n7113 0.039772727272727272
r11053 n7079 n7114 0.65625
r11054 n7113 n7114 0.19886363636363635
r11055 n7080 n7115 0.043749999999999997
r11056 n7114 n7115 0.18181818181818182
r11057 n7081 n7116 0.65625
r11058 n7115 n7116 0.18181818181818182
r11059 n7082 n7117 0.039772727272727272
r11060 n7116 n7117 0.19886363636363635
r11061 n7106 n7118 0.13125000000000001
r11062 n7107 n7119 0.052499999999999998
r11063 n7118 n7119 0.19886363636363635
r11064 n7108 n7120 1.3125
r11065 n7119 n7120 0.14772727272727273
r11066 n7109 n7121 0.046875
r11067 n7120 n7121 0.16477272727272727
r11068 n7110 n7122 1.3125
r11069 n7121 n7122 0.16477272727272727
r11070 n7111 n7123 0.052499999999999998
r11071 n7122 n7123 0.14772727272727273
r11072 n7112 n7124 0.13125000000000001
r11073 n7123 n7124 0.19886363636363635
r11074 n7113 n7125 0.096590909090909088
r11075 n7114 n7126 1.59375
r11076 n7125 n7126 0.0546875
r11077 n7115 n7127 0.10625
r11078 n7126 n7127 0.050000000000000003
r11079 n7116 n7128 1.59375
r11080 n7127 n7128 0.050000000000000003
r11081 n7117 n7129 0.096590909090909088
r11082 n7128 n7129 0.0546875
r11083 n7118 n7130 0.31874999999999998
r11084 n7119 n7131 0.1275
r11085 n7130 n7131 0.0546875
r11086 n7120 n7132 3.1875
r11087 n7131 n7132 0.040625000000000001
r11088 n7121 n7133 0.11383928571428571
r11089 n7132 n7133 0.045312499999999999
r11090 n7122 n7134 3.1875
r11091 n7133 n7134 0.045312499999999999
r11092 n7123 n7135 0.1275
r11093 n7134 n7135 0.040625000000000001
r11094 n7124 n7136 0.31874999999999998
r11095 n7135 n7136 0.0546875
r11096 n7125 n7137 0.15151515151515152
r11097 n7126 n7138 2.5
r11098 n7137 n7138 0.0546875
r11099 n7127 n7139 0.16666666666666666
r11100 n7138 n7139 0.050000000000000003
r11101 n7128 n7140 2.5
r11102 n7139 n7140 0.050000000000000003
r11103 n7129 n7141 0.15151515151515152
r11104 n7140 n7141 0.0546875
r11105 n7130 n7142 0.5
r11106 n7131 n7143 0.20000000000000001
r11107 n7142 n7143 0.0546875
r11108 n7132 n7144 5
r11109 n7143 n7144 0.040625000000000001
r11110 n7133 n7145 0.17857142857142858
r11111 n7144 n7145 0.045312499999999999
r11112 n7134 n7146 5
r11113 n7145 n7146 0.045312499999999999
r11114 n7135 n7147 0.20000000000000001
r11115 n7146 n7147 0.040625000000000001
r11116 n7136 n7148 0.5
r11117 n7147 n7148 0.0546875
r11118 n7137 n7149 0.14015151515151514
r11119 n7138 n7150 2.3125
r11120 n7149 n7150 0.064338235294117641
r11121 n7139 n7151 0.15416666666666667
r11122 n7150 n7151 0.058823529411764705
r11123 n7140 n7152 2.3125
r11124 n7151 n7152 0.058823529411764705
r11125 n7141 n7153 0.14015151515151514
r11126 n7152 n7153 0.064338235294117641
r11127 n7142 n7154 0.46250000000000002
r11128 n7143 n7155 0.185
r11129 n7154 n7155 0.064338235294117641
r11130 n7144 n7156 4.625
r11131 n7155 n7156 0.04779411764705882
r11132 n7145 n7157 0.16517857142857142
r11133 n7156 n7157 0.053308823529411763
r11134 n7146 n7158 4.625
r11135 n7157 n7158 0.053308823529411763
r11136 n7147 n7159 0.185
r11137 n7158 n7159 0.04779411764705882
r11138 n7148 n7160 0.46250000000000002
r11139 n7159 n7160 0.064338235294117641
r11140 n7149 n7161 0.14734848484848484
r11141 n7150 n7162 2.4312499999999999
r11142 n7161 n7162 0.049942922374429224
r11143 n7151 n7163 0.16208333333333333
r11144 n7162 n7163 0.045662100456621002
r11145 n7152 n7164 2.4312499999999999
r11146 n7163 n7164 0.045662100456621002
r11147 n7153 n7165 0.14734848484848484
r11148 n7164 n7165 0.049942922374429224
r11149 n7154 n7166 0.48625000000000002
r11150 n7155 n7167 0.19450000000000001
r11151 n7166 n7167 0.049942922374429224
r11152 n7156 n7168 4.8624999999999998
r11153 n7167 n7168 0.037100456621004564
r11154 n7157 n7169 0.17366071428571428
r11155 n7168 n7169 0.041381278538812787
r11156 n7158 n7170 4.8624999999999998
r11157 n7169 n7170 0.041381278538812787
r11158 n7159 n7171 0.19450000000000001
r11159 n7170 n7171 0.037100456621004564
r11160 n7160 n7172 0.48625000000000002
r11161 n7171 n7172 0.049942922374429224
r11162 n7161 n7173 0.16553030303030303
r11163 n7162 n7174 2.7312500000000002
r11164 n7173 n7174 0.050172018348623851
r11165 n7163 n7175 0.18208333333333335
r11166 n7174 n7175 0.045871559633027525
r11167 n7164 n7176 2.7312500000000002
r11168 n7175 n7176 0.045871559633027525
r11169 n7165 n7177 0.16553030303030303
r11170 n7176 n7177 0.050172018348623851
r11171 n7166 n7178 0.54625000000000001
r11172 n7167 n7179 0.2185
r11173 n7178 n7179 0.050172018348623851
r11174 n7168 n7180 5.4625000000000004
r11175 n7179 n7180 0.037270642201834861
r11176 n7169 n7181 0.19508928571428572
r11177 n7180 n7181 0.041571100917431193
r11178 n7170 n7182 5.4625000000000004
r11179 n7181 n7182 0.041571100917431193
r11180 n7171 n7183 0.2185
r11181 n7182 n7183 0.037270642201834861
r11182 n7172 n7184 0.54625000000000001
r11183 n7183 n7184 0.050172018348623851
r11184 n7173 n7185 0.16553030303030303
r11185 n7174 n7186 2.7312500000000002
r11186 n7185 n7186 0.049942922374429224
r11187 n7175 n7187 0.18208333333333335
r11188 n7186 n7187 0.045662100456621002
r11189 n7176 n7188 2.7312500000000002
r11190 n7187 n7188 0.045662100456621002
r11191 n7177 n7189 0.16553030303030303
r11192 n7188 n7189 0.049942922374429224
r11193 n7178 n7190 0.54625000000000001
r11194 n7179 n7191 0.2185
r11195 n7190 n7191 0.049942922374429224
r11196 n7180 n7192 5.4625000000000004
r11197 n7191 n7192 0.037100456621004564
r11198 n7181 n7193 0.19508928571428572
r11199 n7192 n7193 0.041381278538812787
r11200 n7182 n7194 5.4625000000000004
r11201 n7193 n7194 0.041381278538812787
r11202 n7183 n7195 0.2185
r11203 n7194 n7195 0.037100456621004564
r11204 n7184 n7196 0.54625000000000001
r11205 n7195 n7196 0.049942922374429224
r11206 n7185 n7197 0.16590909090909092
r11207 n7186 n7198 2.7374999999999998
r11208 n7197 n7198 0.049942922374429224
r11209 n7187 n7199 0.1825
r11210 n7198 n7199 0.045662100456621002
r11211 n7188 n7200 2.7374999999999998
r11212 n7199 n7200 0.045662100456621002
r11213 n7189 n7201 0.16590909090909092
r11214 n7200 n7201 0.049942922374429224
r11215 n7190 n7202 0.54749999999999999
r11216 n7191 n7203 0.219
r11217 n7202 n7203 0.049942922374429224
r11218 n7192 n7204 5.4749999999999996
r11219 n7203 n7204 0.037100456621004564
r11220 n7193 n7205 0.19553571428571428
r11221 n7204 n7205 0.041381278538812787
r11222 n7194 n7206 5.4749999999999996
r11223 n7205 n7206 0.041381278538812787
r11224 n7195 n7207 0.219
r11225 n7206 n7207 0.037100456621004564
r11226 n7196 n7208 0.54749999999999999
r11227 n7207 n7208 0.049942922374429224
r11228 n7197 n7209 0.15227272727272728
r11229 n7198 n7210 2.5125000000000002
r11230 n7209 n7210 0.059767759562841527
r11231 n7199 n7211 0.16750000000000001
r11232 n7210 n7211 0.054644808743169397
r11233 n7200 n7212 2.5125000000000002
r11234 n7211 n7212 0.054644808743169397
r11235 n7201 n7213 0.15227272727272728
r11236 n7212 n7213 0.059767759562841527
r11237 n7202 n7214 0.50249999999999995
r11238 n7203 n7215 0.20100000000000001
r11239 n7214 n7215 0.059767759562841527
r11240 n7204 n7216 5.0250000000000004
r11241 n7215 n7216 0.044398907103825137
r11242 n7205 n7217 0.17946428571428572
r11243 n7216 n7217 0.049521857923497267
r11244 n7206 n7218 5.0250000000000004
r11245 n7217 n7218 0.049521857923497267
r11246 n7207 n7219 0.20100000000000001
r11247 n7218 n7219 0.044398907103825137
r11248 n7208 n7220 0.50249999999999995
r11249 n7219 n7220 0.059767759562841527
r11250 n7209 n7221 0.13901515151515151
r11251 n7210 n7222 2.2937500000000002
r11252 n7221 n7222 0.059442934782608696
r11253 n7211 n7223 0.15291666666666667
r11254 n7222 n7223 0.05434782608695652
r11255 n7212 n7224 2.2937500000000002
r11256 n7223 n7224 0.05434782608695652
r11257 n7213 n7225 0.13901515151515151
r11258 n7224 n7225 0.059442934782608696
r11259 n7214 n7226 0.45874999999999999
r11260 n7215 n7227 0.1835
r11261 n7226 n7227 0.059442934782608696
r11262 n7216 n7228 4.5875000000000004
r11263 n7227 n7228 0.044157608695652176
r11264 n7217 n7229 0.16383928571428572
r11265 n7228 n7229 0.049252717391304345
r11266 n7218 n7230 4.5875000000000004
r11267 n7229 n7230 0.049252717391304345
r11268 n7219 n7231 0.1835
r11269 n7230 n7231 0.044157608695652176
r11270 n7220 n7232 0.45874999999999999
r11271 n7231 n7232 0.059442934782608696
r11272 n7221 n7233 0.13901515151515151
r11273 n7222 n7234 2.2937500000000002
r11274 n7233 n7234 0.059767759562841527
r11275 n7223 n7235 0.15291666666666667
r11276 n7234 n7235 0.054644808743169397
r11277 n7224 n7236 2.2937500000000002
r11278 n7235 n7236 0.054644808743169397
r11279 n7225 n7237 0.13901515151515151
r11280 n7236 n7237 0.059767759562841527
r11281 n7226 n7238 0.45874999999999999
r11282 n7227 n7239 0.1835
r11283 n7238 n7239 0.059767759562841527
r11284 n7228 n7240 4.5875000000000004
r11285 n7239 n7240 0.044398907103825137
r11286 n7229 n7241 0.16383928571428572
r11287 n7240 n7241 0.049521857923497267
r11288 n7230 n7242 4.5875000000000004
r11289 n7241 n7242 0.049521857923497267
r11290 n7231 n7243 0.1835
r11291 n7242 n7243 0.044398907103825137
r11292 n7232 n7244 0.45874999999999999
r11293 n7243 n7244 0.059767759562841527
r11294 n7245 n7246 0.17624999999999999
r11295 n7246 n7247 0.11750000000000001
r11296 n7247 n7248 0.070499999999999993
r11297 n7248 n7249 0.047
r11298 n7249 n7250 0.047
r11299 n7250 n7251 0.11750000000000001
r11300 n7251 n7252 0.22325
r11301 n7252 n7253 0.17624999999999999
r11302 n7253 n7254 0.11750000000000001
r11303 n7254 n7255 0.070499999999999993
r11304 n7255 n7256 0.035249999999999997
r11305 n7256 n7257 0.035249999999999997
r11306 n7257 n7258 0.0235
r11307 n7258 n7259 0.0235
r11308 n7259 n7260 0.058750000000000004
r11309 n7260 n7261 0.10575000000000001
r11310 n7261 n7262 0.070499999999999993
r11311 n7262 n7263 0.12925
r11312 n7245 n7264 0.0093999999999999986
r11313 n7246 n7265 0.018799999999999997
r11314 n7264 n7265 0.17624999999999999
r11315 n7247 n7266 0.018799999999999997
r11316 n7265 n7266 0.11750000000000001
r11317 n7248 n7267 0.094
r11318 n7266 n7267 0.070499999999999993
r11319 n7249 n7268 0.031333333333333331
r11320 n7267 n7268 0.047
r11321 n7250 n7269 0.094
r11322 n7268 n7269 0.047
r11323 n7251 n7270 0.010444444444444444
r11324 n7269 n7270 0.11750000000000001
r11325 n7252 n7271 0.0093999999999999986
r11326 n7270 n7271 0.22325
r11327 n7253 n7272 0.018799999999999997
r11328 n7271 n7272 0.17624999999999999
r11329 n7254 n7273 0.018799999999999997
r11330 n7272 n7273 0.11750000000000001
r11331 n7255 n7274 0.094
r11332 n7273 n7274 0.070499999999999993
r11333 n7256 n7275 0.047
r11334 n7274 n7275 0.035249999999999997
r11335 n7257 n7276 0.094
r11336 n7275 n7276 0.035249999999999997
r11337 n7258 n7277 0.094
r11338 n7276 n7277 0.0235
r11339 n7259 n7278 0.094
r11340 n7277 n7278 0.0235
r11341 n7260 n7279 0.0235
r11342 n7278 n7279 0.058750000000000004
r11343 n7261 n7280 0.018799999999999997
r11344 n7279 n7280 0.10575000000000001
r11345 n7262 n7281 0.094
r11346 n7280 n7281 0.070499999999999993
r11347 n7263 n7282 0.0093999999999999986
r11348 n7281 n7282 0.12925
r11349 n7264 n7283 0.0093999999999999986
r11350 n7265 n7284 0.018799999999999997
r11351 n7283 n7284 0.17624999999999999
r11352 n7266 n7285 0.018799999999999997
r11353 n7284 n7285 0.11750000000000001
r11354 n7267 n7286 0.094
r11355 n7285 n7286 0.070499999999999993
r11356 n7268 n7287 0.031333333333333331
r11357 n7286 n7287 0.047
r11358 n7269 n7288 0.094
r11359 n7287 n7288 0.047
r11360 n7270 n7289 0.010444444444444444
r11361 n7288 n7289 0.11750000000000001
r11362 n7271 n7290 0.0093999999999999986
r11363 n7289 n7290 0.22325
r11364 n7272 n7291 0.018799999999999997
r11365 n7290 n7291 0.17624999999999999
r11366 n7273 n7292 0.018799999999999997
r11367 n7291 n7292 0.11750000000000001
r11368 n7274 n7293 0.094
r11369 n7292 n7293 0.070499999999999993
r11370 n7275 n7294 0.047
r11371 n7293 n7294 0.035249999999999997
r11372 n7276 n7295 0.094
r11373 n7294 n7295 0.035249999999999997
r11374 n7277 n7296 0.094
r11375 n7295 n7296 0.0235
r11376 n7278 n7297 0.094
r11377 n7296 n7297 0.0235
r11378 n7279 n7298 0.0235
r11379 n7297 n7298 0.058750000000000004
r11380 n7280 n7299 0.018799999999999997
r11381 n7298 n7299 0.10575000000000001
r11382 n7281 n7300 0.094
r11383 n7299 n7300 0.070499999999999993
r11384 n7282 n7301 0.0093999999999999986
r11385 n7300 n7301 0.12925
r11386 n7283 n7302 0.0141
r11387 n7284 n7303 0.028199999999999999
r11388 n7302 n7303 0.088124999999999995
r11389 n7285 n7304 0.028199999999999999
r11390 n7303 n7304 0.058750000000000004
r11391 n7286 n7305 0.14099999999999999
r11392 n7304 n7305 0.035249999999999997
r11393 n7287 n7306 0.047
r11394 n7305 n7306 0.0235
r11395 n7288 n7307 0.14099999999999999
r11396 n7306 n7307 0.0235
r11397 n7289 n7308 0.015666666666666666
r11398 n7307 n7308 0.058750000000000004
r11399 n7290 n7309 0.0141
r11400 n7308 n7309 0.111625
r11401 n7291 n7310 0.028199999999999999
r11402 n7309 n7310 0.088124999999999995
r11403 n7292 n7311 0.028199999999999999
r11404 n7310 n7311 0.058750000000000004
r11405 n7293 n7312 0.14099999999999999
r11406 n7311 n7312 0.035249999999999997
r11407 n7294 n7313 0.070499999999999993
r11408 n7312 n7313 0.017624999999999998
r11409 n7295 n7314 0.14099999999999999
r11410 n7313 n7314 0.017624999999999998
r11411 n7296 n7315 0.14099999999999999
r11412 n7314 n7315 0.01175
r11413 n7297 n7316 0.14099999999999999
r11414 n7315 n7316 0.01175
r11415 n7298 n7317 0.035249999999999997
r11416 n7316 n7317 0.029375000000000002
r11417 n7299 n7318 0.028199999999999999
r11418 n7317 n7318 0.052875000000000005
r11419 n7300 n7319 0.14099999999999999
r11420 n7318 n7319 0.035249999999999997
r11421 n7301 n7320 0.0141
r11422 n7319 n7320 0.064625000000000002
r11423 n7302 n7321 0.025849999999999998
r11424 n7303 n7322 0.051699999999999996
r11425 n7321 n7322 0.050357142857142857
r11426 n7304 n7323 0.051699999999999996
r11427 n7322 n7323 0.033571428571428572
r11428 n7305 n7324 0.25850000000000001
r11429 n7323 n7324 0.020142857142857143
r11430 n7306 n7325 0.086166666666666669
r11431 n7324 n7325 0.013428571428571429
r11432 n7307 n7326 0.25850000000000001
r11433 n7325 n7326 0.013428571428571429
r11434 n7308 n7327 0.028722222222222222
r11435 n7326 n7327 0.033571428571428572
r11436 n7309 n7328 0.025849999999999998
r11437 n7327 n7328 0.063785714285714279
r11438 n7310 n7329 0.051699999999999996
r11439 n7328 n7329 0.050357142857142857
r11440 n7311 n7330 0.051699999999999996
r11441 n7329 n7330 0.033571428571428572
r11442 n7312 n7331 0.25850000000000001
r11443 n7330 n7331 0.020142857142857143
r11444 n7313 n7332 0.12925
r11445 n7331 n7332 0.010071428571428571
r11446 n7314 n7333 0.25850000000000001
r11447 n7332 n7333 0.010071428571428571
r11448 n7315 n7334 0.25850000000000001
r11449 n7333 n7334 0.0067142857142857143
r11450 n7316 n7335 0.25850000000000001
r11451 n7334 n7335 0.0067142857142857143
r11452 n7317 n7336 0.064625000000000002
r11453 n7335 n7336 0.016785714285714286
r11454 n7318 n7337 0.051699999999999996
r11455 n7336 n7337 0.030214285714285718
r11456 n7319 n7338 0.25850000000000001
r11457 n7337 n7338 0.020142857142857143
r11458 n7320 n7339 0.025849999999999998
r11459 n7338 n7339 0.036928571428571429
r11460 n7321 n7340 0.0235
r11461 n7322 n7341 0.047
r11462 n7340 n7341 0.11749999999999999
r11463 n7323 n7342 0.047
r11464 n7341 n7342 0.078333333333333338
r11465 n7324 n7343 0.23500000000000001
r11466 n7342 n7343 0.047
r11467 n7325 n7344 0.078333333333333338
r11468 n7343 n7344 0.031333333333333331
r11469 n7326 n7345 0.23500000000000001
r11470 n7344 n7345 0.031333333333333331
r11471 n7327 n7346 0.026111111111111113
r11472 n7345 n7346 0.078333333333333338
r11473 n7328 n7347 0.0235
r11474 n7346 n7347 0.14883333333333332
r11475 n7329 n7348 0.047
r11476 n7347 n7348 0.11749999999999999
r11477 n7330 n7349 0.047
r11478 n7348 n7349 0.078333333333333338
r11479 n7331 n7350 0.23500000000000001
r11480 n7349 n7350 0.047
r11481 n7332 n7351 0.11750000000000001
r11482 n7350 n7351 0.0235
r11483 n7333 n7352 0.23500000000000001
r11484 n7351 n7352 0.0235
r11485 n7334 n7353 0.23500000000000001
r11486 n7352 n7353 0.015666666666666666
r11487 n7335 n7354 0.23500000000000001
r11488 n7353 n7354 0.015666666666666666
r11489 n7336 n7355 0.058750000000000004
r11490 n7354 n7355 0.039166666666666669
r11491 n7337 n7356 0.047
r11492 n7355 n7356 0.070500000000000007
r11493 n7338 n7357 0.23500000000000001
r11494 n7356 n7357 0.047
r11495 n7339 n7358 0.0235
r11496 n7357 n7358 0.086166666666666669
r11497 n7340 n7359 0.0141
r11498 n7341 n7360 0.028199999999999999
r11499 n7359 n7360 0.11749999999999999
r11500 n7342 n7361 0.028199999999999999
r11501 n7360 n7361 0.078333333333333338
r11502 n7343 n7362 0.14099999999999999
r11503 n7361 n7362 0.047
r11504 n7344 n7363 0.047
r11505 n7362 n7363 0.031333333333333331
r11506 n7345 n7364 0.14099999999999999
r11507 n7363 n7364 0.031333333333333331
r11508 n7346 n7365 0.015666666666666666
r11509 n7364 n7365 0.078333333333333338
r11510 n7347 n7366 0.0141
r11511 n7365 n7366 0.14883333333333332
r11512 n7348 n7367 0.028199999999999999
r11513 n7366 n7367 0.11749999999999999
r11514 n7349 n7368 0.028199999999999999
r11515 n7367 n7368 0.078333333333333338
r11516 n7350 n7369 0.14099999999999999
r11517 n7368 n7369 0.047
r11518 n7351 n7370 0.070499999999999993
r11519 n7369 n7370 0.0235
r11520 n7352 n7371 0.14099999999999999
r11521 n7370 n7371 0.0235
r11522 n7353 n7372 0.14099999999999999
r11523 n7371 n7372 0.015666666666666666
r11524 n7354 n7373 0.14099999999999999
r11525 n7372 n7373 0.015666666666666666
r11526 n7355 n7374 0.035249999999999997
r11527 n7373 n7374 0.039166666666666669
r11528 n7356 n7375 0.028199999999999999
r11529 n7374 n7375 0.070500000000000007
r11530 n7357 n7376 0.14099999999999999
r11531 n7375 n7376 0.047
r11532 n7358 n7377 0.0141
r11533 n7376 n7377 0.086166666666666669
r11534 n7359 n7378 0.01175
r11535 n7360 n7379 0.0235
r11536 n7378 n7379 0.17624999999999999
r11537 n7361 n7380 0.0235
r11538 n7379 n7380 0.11750000000000001
r11539 n7362 n7381 0.11750000000000001
r11540 n7380 n7381 0.070499999999999993
r11541 n7363 n7382 0.039166666666666669
r11542 n7381 n7382 0.047
r11543 n7364 n7383 0.11750000000000001
r11544 n7382 n7383 0.047
r11545 n7365 n7384 0.013055555555555556
r11546 n7383 n7384 0.11750000000000001
r11547 n7366 n7385 0.01175
r11548 n7384 n7385 0.22325
r11549 n7367 n7386 0.0235
r11550 n7385 n7386 0.17624999999999999
r11551 n7368 n7387 0.0235
r11552 n7386 n7387 0.11750000000000001
r11553 n7369 n7388 0.11750000000000001
r11554 n7387 n7388 0.070499999999999993
r11555 n7370 n7389 0.058750000000000004
r11556 n7388 n7389 0.035249999999999997
r11557 n7371 n7390 0.11750000000000001
r11558 n7389 n7390 0.035249999999999997
r11559 n7372 n7391 0.11750000000000001
r11560 n7390 n7391 0.0235
r11561 n7373 n7392 0.11750000000000001
r11562 n7391 n7392 0.0235
r11563 n7374 n7393 0.029375000000000002
r11564 n7392 n7393 0.058750000000000004
r11565 n7375 n7394 0.0235
r11566 n7393 n7394 0.10575000000000001
r11567 n7376 n7395 0.11750000000000001
r11568 n7394 n7395 0.070499999999999993
r11569 n7377 n7396 0.01175
r11570 n7395 n7396 0.12925
r11571 n7378 n7397 0.039949999999999999
r11572 n7379 n7398 0.079899999999999999
r11573 n7397 n7398 0.0235
r11574 n7380 n7399 0.079899999999999999
r11575 n7398 n7399 0.015666666666666666
r11576 n7381 n7400 0.39950000000000002
r11577 n7399 n7400 0.0093999999999999986
r11578 n7382 n7401 0.13316666666666668
r11579 n7400 n7401 0.006266666666666666
r11580 n7383 n7402 0.39950000000000002
r11581 n7401 n7402 0.006266666666666666
r11582 n7384 n7403 0.044388888888888887
r11583 n7402 n7403 0.015666666666666666
r11584 n7385 n7404 0.039949999999999999
r11585 n7403 n7404 0.029766666666666667
r11586 n7386 n7405 0.079899999999999999
r11587 n7404 n7405 0.0235
r11588 n7387 n7406 0.079899999999999999
r11589 n7405 n7406 0.015666666666666666
r11590 n7388 n7407 0.39950000000000002
r11591 n7406 n7407 0.0093999999999999986
r11592 n7389 n7408 0.19975000000000001
r11593 n7407 n7408 0.0046999999999999993
r11594 n7390 n7409 0.39950000000000002
r11595 n7408 n7409 0.0046999999999999993
r11596 n7391 n7410 0.39950000000000002
r11597 n7409 n7410 0.003133333333333333
r11598 n7392 n7411 0.39950000000000002
r11599 n7410 n7411 0.003133333333333333
r11600 n7393 n7412 0.099875000000000005
r11601 n7411 n7412 0.0078333333333333328
r11602 n7394 n7413 0.079899999999999999
r11603 n7412 n7413 0.014100000000000001
r11604 n7395 n7414 0.39950000000000002
r11605 n7413 n7414 0.0093999999999999986
r11606 n7396 n7415 0.039949999999999999
r11607 n7414 n7415 0.017233333333333333
r11608 n7397 n7416 0.070499999999999993
r11609 n7398 n7417 0.14099999999999999
r11610 n7416 n7417 0.0235
r11611 n7399 n7418 0.14099999999999999
r11612 n7417 n7418 0.015666666666666666
r11613 n7400 n7419 0.70499999999999996
r11614 n7418 n7419 0.0093999999999999986
r11615 n7401 n7420 0.23499999999999999
r11616 n7419 n7420 0.006266666666666666
r11617 n7402 n7421 0.70499999999999996
r11618 n7420 n7421 0.006266666666666666
r11619 n7403 n7422 0.078333333333333338
r11620 n7421 n7422 0.015666666666666666
r11621 n7404 n7423 0.070499999999999993
r11622 n7422 n7423 0.029766666666666667
r11623 n7405 n7424 0.14099999999999999
r11624 n7423 n7424 0.0235
r11625 n7406 n7425 0.14099999999999999
r11626 n7424 n7425 0.015666666666666666
r11627 n7407 n7426 0.70499999999999996
r11628 n7425 n7426 0.0093999999999999986
r11629 n7408 n7427 0.35249999999999998
r11630 n7426 n7427 0.0046999999999999993
r11631 n7409 n7428 0.70499999999999996
r11632 n7427 n7428 0.0046999999999999993
r11633 n7410 n7429 0.70499999999999996
r11634 n7428 n7429 0.003133333333333333
r11635 n7411 n7430 0.70499999999999996
r11636 n7429 n7430 0.003133333333333333
r11637 n7412 n7431 0.17624999999999999
r11638 n7430 n7431 0.0078333333333333328
r11639 n7413 n7432 0.14099999999999999
r11640 n7431 n7432 0.014100000000000001
r11641 n7414 n7433 0.70499999999999996
r11642 n7432 n7433 0.0093999999999999986
r11643 n7415 n7434 0.070499999999999993
r11644 n7433 n7434 0.017233333333333333
r11645 n7416 n7435 0.039949999999999999
r11646 n7417 n7436 0.079899999999999999
r11647 n7435 n7436 0.17624999999999999
r11648 n7418 n7437 0.079899999999999999
r11649 n7436 n7437 0.11750000000000001
r11650 n7419 n7438 0.39950000000000002
r11651 n7437 n7438 0.070499999999999993
r11652 n7420 n7439 0.13316666666666668
r11653 n7438 n7439 0.047
r11654 n7421 n7440 0.39950000000000002
r11655 n7439 n7440 0.047
r11656 n7422 n7441 0.044388888888888887
r11657 n7440 n7441 0.11750000000000001
r11658 n7423 n7442 0.039949999999999999
r11659 n7441 n7442 0.22325
r11660 n7424 n7443 0.079899999999999999
r11661 n7442 n7443 0.17624999999999999
r11662 n7425 n7444 0.079899999999999999
r11663 n7443 n7444 0.11750000000000001
r11664 n7426 n7445 0.39950000000000002
r11665 n7444 n7445 0.070499999999999993
r11666 n7427 n7446 0.19975000000000001
r11667 n7445 n7446 0.035249999999999997
r11668 n7428 n7447 0.39950000000000002
r11669 n7446 n7447 0.035249999999999997
r11670 n7429 n7448 0.39950000000000002
r11671 n7447 n7448 0.0235
r11672 n7430 n7449 0.39950000000000002
r11673 n7448 n7449 0.0235
r11674 n7431 n7450 0.099875000000000005
r11675 n7449 n7450 0.058750000000000004
r11676 n7432 n7451 0.079899999999999999
r11677 n7450 n7451 0.10575000000000001
r11678 n7433 n7452 0.39950000000000002
r11679 n7451 n7452 0.070499999999999993
r11680 n7434 n7453 0.039949999999999999
r11681 n7452 n7453 0.12925
r11682 n7435 n7454 0.01175
r11683 n7436 n7455 0.0235
r11684 n7454 n7455 0.11749999999999999
r11685 n7437 n7456 0.0235
r11686 n7455 n7456 0.078333333333333338
r11687 n7438 n7457 0.11750000000000001
r11688 n7456 n7457 0.047
r11689 n7439 n7458 0.039166666666666669
r11690 n7457 n7458 0.031333333333333331
r11691 n7440 n7459 0.11750000000000001
r11692 n7458 n7459 0.031333333333333331
r11693 n7441 n7460 0.013055555555555556
r11694 n7459 n7460 0.078333333333333338
r11695 n7442 n7461 0.01175
r11696 n7460 n7461 0.14883333333333332
r11697 n7443 n7462 0.0235
r11698 n7461 n7462 0.11749999999999999
r11699 n7444 n7463 0.0235
r11700 n7462 n7463 0.078333333333333338
r11701 n7445 n7464 0.11750000000000001
r11702 n7463 n7464 0.047
r11703 n7446 n7465 0.058750000000000004
r11704 n7464 n7465 0.0235
r11705 n7447 n7466 0.11750000000000001
r11706 n7465 n7466 0.0235
r11707 n7448 n7467 0.11750000000000001
r11708 n7466 n7467 0.015666666666666666
r11709 n7449 n7468 0.11750000000000001
r11710 n7467 n7468 0.015666666666666666
r11711 n7450 n7469 0.029375000000000002
r11712 n7468 n7469 0.039166666666666669
r11713 n7451 n7470 0.0235
r11714 n7469 n7470 0.070500000000000007
r11715 n7452 n7471 0.11750000000000001
r11716 n7470 n7471 0.047
r11717 n7453 n7472 0.01175
r11718 n7471 n7472 0.086166666666666669
r11719 n7454 n7473 0.0141
r11720 n7455 n7474 0.028199999999999999
r11721 n7473 n7474 0.11749999999999999
r11722 n7456 n7475 0.028199999999999999
r11723 n7474 n7475 0.078333333333333338
r11724 n7457 n7476 0.14099999999999999
r11725 n7475 n7476 0.047
r11726 n7458 n7477 0.047
r11727 n7476 n7477 0.031333333333333331
r11728 n7459 n7478 0.14099999999999999
r11729 n7477 n7478 0.031333333333333331
r11730 n7460 n7479 0.015666666666666666
r11731 n7478 n7479 0.078333333333333338
r11732 n7461 n7480 0.0141
r11733 n7479 n7480 0.14883333333333332
r11734 n7462 n7481 0.028199999999999999
r11735 n7480 n7481 0.11749999999999999
r11736 n7463 n7482 0.028199999999999999
r11737 n7481 n7482 0.078333333333333338
r11738 n7464 n7483 0.14099999999999999
r11739 n7482 n7483 0.047
r11740 n7465 n7484 0.070499999999999993
r11741 n7483 n7484 0.0235
r11742 n7466 n7485 0.14099999999999999
r11743 n7484 n7485 0.0235
r11744 n7467 n7486 0.14099999999999999
r11745 n7485 n7486 0.015666666666666666
r11746 n7468 n7487 0.14099999999999999
r11747 n7486 n7487 0.015666666666666666
r11748 n7469 n7488 0.035249999999999997
r11749 n7487 n7488 0.039166666666666669
r11750 n7470 n7489 0.028199999999999999
r11751 n7488 n7489 0.070500000000000007
r11752 n7471 n7490 0.14099999999999999
r11753 n7489 n7490 0.047
r11754 n7472 n7491 0.0141
r11755 n7490 n7491 0.086166666666666669
r11756 n7473 n7492 0.0235
r11757 n7474 n7493 0.047
r11758 n7492 n7493 0.050357142857142857
r11759 n7475 n7494 0.047
r11760 n7493 n7494 0.033571428571428572
r11761 n7476 n7495 0.23500000000000001
r11762 n7494 n7495 0.020142857142857143
r11763 n7477 n7496 0.078333333333333338
r11764 n7495 n7496 0.013428571428571429
r11765 n7478 n7497 0.23500000000000001
r11766 n7496 n7497 0.013428571428571429
r11767 n7479 n7498 0.026111111111111113
r11768 n7497 n7498 0.033571428571428572
r11769 n7480 n7499 0.0235
r11770 n7498 n7499 0.063785714285714279
r11771 n7481 n7500 0.047
r11772 n7499 n7500 0.050357142857142857
r11773 n7482 n7501 0.047
r11774 n7500 n7501 0.033571428571428572
r11775 n7483 n7502 0.23500000000000001
r11776 n7501 n7502 0.020142857142857143
r11777 n7484 n7503 0.11750000000000001
r11778 n7502 n7503 0.010071428571428571
r11779 n7485 n7504 0.23500000000000001
r11780 n7503 n7504 0.010071428571428571
r11781 n7486 n7505 0.23500000000000001
r11782 n7504 n7505 0.0067142857142857143
r11783 n7487 n7506 0.23500000000000001
r11784 n7505 n7506 0.0067142857142857143
r11785 n7488 n7507 0.058750000000000004
r11786 n7506 n7507 0.016785714285714286
r11787 n7489 n7508 0.047
r11788 n7507 n7508 0.030214285714285718
r11789 n7490 n7509 0.23500000000000001
r11790 n7508 n7509 0.020142857142857143
r11791 n7491 n7510 0.0235
r11792 n7509 n7510 0.036928571428571429
r11793 n7492 n7511 0.035249999999999997
r11794 n7493 n7512 0.070499999999999993
r11795 n7511 n7512 0.044062499999999998
r11796 n7494 n7513 0.070499999999999993
r11797 n7512 n7513 0.029375000000000002
r11798 n7495 n7514 0.35249999999999998
r11799 n7513 n7514 0.017624999999999998
r11800 n7496 n7515 0.11749999999999999
r11801 n7514 n7515 0.01175
r11802 n7497 n7516 0.35249999999999998
r11803 n7515 n7516 0.01175
r11804 n7498 n7517 0.039166666666666669
r11805 n7516 n7517 0.029375000000000002
r11806 n7499 n7518 0.035249999999999997
r11807 n7517 n7518 0.055812500000000001
r11808 n7500 n7519 0.070499999999999993
r11809 n7518 n7519 0.044062499999999998
r11810 n7501 n7520 0.070499999999999993
r11811 n7519 n7520 0.029375000000000002
r11812 n7502 n7521 0.35249999999999998
r11813 n7520 n7521 0.017624999999999998
r11814 n7503 n7522 0.17624999999999999
r11815 n7521 n7522 0.0088124999999999992
r11816 n7504 n7523 0.35249999999999998
r11817 n7522 n7523 0.0088124999999999992
r11818 n7505 n7524 0.35249999999999998
r11819 n7523 n7524 0.005875
r11820 n7506 n7525 0.35249999999999998
r11821 n7524 n7525 0.005875
r11822 n7507 n7526 0.088124999999999995
r11823 n7525 n7526 0.014687500000000001
r11824 n7508 n7527 0.070499999999999993
r11825 n7526 n7527 0.026437500000000003
r11826 n7509 n7528 0.35249999999999998
r11827 n7527 n7528 0.017624999999999998
r11828 n7510 n7529 0.035249999999999997
r11829 n7528 n7529 0.032312500000000001
r11830 n7511 n7530 0.0235
r11831 n7512 n7531 0.047
r11832 n7530 n7531 0.17624999999999999
r11833 n7513 n7532 0.047
r11834 n7531 n7532 0.11750000000000001
r11835 n7514 n7533 0.23500000000000001
r11836 n7532 n7533 0.070499999999999993
r11837 n7515 n7534 0.078333333333333338
r11838 n7533 n7534 0.047
r11839 n7516 n7535 0.23500000000000001
r11840 n7534 n7535 0.047
r11841 n7517 n7536 0.026111111111111113
r11842 n7535 n7536 0.11750000000000001
r11843 n7518 n7537 0.0235
r11844 n7536 n7537 0.22325
r11845 n7519 n7538 0.047
r11846 n7537 n7538 0.17624999999999999
r11847 n7520 n7539 0.047
r11848 n7538 n7539 0.11750000000000001
r11849 n7521 n7540 0.23500000000000001
r11850 n7539 n7540 0.070499999999999993
r11851 n7522 n7541 0.11750000000000001
r11852 n7540 n7541 0.035249999999999997
r11853 n7523 n7542 0.23500000000000001
r11854 n7541 n7542 0.035249999999999997
r11855 n7524 n7543 0.23500000000000001
r11856 n7542 n7543 0.0235
r11857 n7525 n7544 0.23500000000000001
r11858 n7543 n7544 0.0235
r11859 n7526 n7545 0.058750000000000004
r11860 n7544 n7545 0.058750000000000004
r11861 n7527 n7546 0.047
r11862 n7545 n7546 0.10575000000000001
r11863 n7528 n7547 0.23500000000000001
r11864 n7546 n7547 0.070499999999999993
r11865 n7529 n7548 0.0235
r11866 n7547 n7548 0.12925
r11867 n7531 n7549 0.1598
r11868 n7532 n7550 0.1598
r11869 n7549 n7550 0.0073437500000000005
r11870 n7533 n7551 0.79900000000000004
r11871 n7550 n7551 0.0044062499999999996
r11872 n7534 n7552 0.26633333333333337
r11873 n7551 n7552 0.0029375
r11874 n7535 n7553 0.79900000000000004
r11875 n7552 n7553 0.0029375
r11876 n7536 n7554 0.088777777777777775
r11877 n7553 n7554 0.0073437500000000005
r11878 n7537 n7555 0.079899999999999999
r11879 n7554 n7555 0.013953125
r11880 n7538 n7556 0.1598
r11881 n7555 n7556 0.011015624999999999
r11882 n7539 n7557 0.1598
r11883 n7556 n7557 0.0073437500000000005
r11884 n7540 n7558 0.79900000000000004
r11885 n7557 n7558 0.0044062499999999996
r11886 n7541 n7559 0.39950000000000002
r11887 n7558 n7559 0.0022031249999999998
r11888 n7542 n7560 0.79900000000000004
r11889 n7559 n7560 0.0022031249999999998
r11890 n7543 n7561 0.79900000000000004
r11891 n7560 n7561 0.00146875
r11892 n7544 n7562 0.79900000000000004
r11893 n7561 n7562 0.00146875
r11894 n7545 n7563 0.19975000000000001
r11895 n7562 n7563 0.0036718750000000002
r11896 n7546 n7564 0.1598
r11897 n7563 n7564 0.0066093750000000007
r11898 n7547 n7565 0.79900000000000004
r11899 n7564 n7565 0.0044062499999999996
r11900 n7549 n7566 0.37130000000000002
r11901 n7550 n7567 0.37130000000000002
r11902 n7566 n7567 0.0050000000000000001
r11903 n7551 n7568 1.8565
r11904 n7567 n7568 0.0029999999999999996
r11905 n7552 n7569 0.61883333333333335
r11906 n7568 n7569 0.002
r11907 n7553 n7570 1.8565
r11908 n7569 n7570 0.002
r11909 n7554 n7571 0.20627777777777778
r11910 n7570 n7571 0.0050000000000000001
r11911 n7555 n7572 0.18565000000000001
r11912 n7571 n7572 0.0094999999999999998
r11913 n7556 n7573 0.37130000000000002
r11914 n7572 n7573 0.0074999999999999997
r11915 n7557 n7574 0.37130000000000002
r11916 n7573 n7574 0.0050000000000000001
r11917 n7558 n7575 1.8565
r11918 n7574 n7575 0.0029999999999999996
r11919 n7559 n7576 0.92825000000000002
r11920 n7575 n7576 0.0014999999999999998
r11921 n7560 n7577 1.8565
r11922 n7576 n7577 0.0014999999999999998
r11923 n7561 n7578 1.8565
r11924 n7577 n7578 0.001
r11925 n7562 n7579 1.8565
r11926 n7578 n7579 0.001
r11927 n7563 n7580 0.46412500000000001
r11928 n7579 n7580 0.0025000000000000001
r11929 n7564 n7581 0.37130000000000002
r11930 n7580 n7581 0.0045000000000000005
r11931 n7565 n7582 1.8565
r11932 n7581 n7582 0.0029999999999999996
r11933 n7566 n7583 0.38069999999999998
r11934 n7567 n7584 0.38069999999999998
r11935 n7583 n7584 0.0069117647058823534
r11936 n7568 n7585 1.9035
r11937 n7584 n7585 0.0041470588235294117
r11938 n7569 n7586 0.63449999999999995
r11939 n7585 n7586 0.0027647058823529408
r11940 n7570 n7587 1.9035
r11941 n7586 n7587 0.0027647058823529408
r11942 n7571 n7588 0.21149999999999999
r11943 n7587 n7588 0.0069117647058823534
r11944 n7572 n7589 0.19034999999999999
r11945 n7588 n7589 0.01313235294117647
r11946 n7573 n7590 0.38069999999999998
r11947 n7589 n7590 0.010367647058823528
r11948 n7574 n7591 0.38069999999999998
r11949 n7590 n7591 0.0069117647058823534
r11950 n7575 n7592 1.9035
r11951 n7591 n7592 0.0041470588235294117
r11952 n7576 n7593 0.95174999999999998
r11953 n7592 n7593 0.0020735294117647058
r11954 n7577 n7594 1.9035
r11955 n7593 n7594 0.0020735294117647058
r11956 n7578 n7595 1.9035
r11957 n7594 n7595 0.0013823529411764704
r11958 n7579 n7596 1.9035
r11959 n7595 n7596 0.0013823529411764704
r11960 n7580 n7597 0.47587499999999999
r11961 n7596 n7597 0.0034558823529411767
r11962 n7581 n7598 0.38069999999999998
r11963 n7597 n7598 0.0062205882352941184
r11964 n7582 n7599 1.9035
r11965 n7598 n7599 0.0041470588235294117
r11966 n7583 n7600 0.38822000000000001
r11967 n7584 n7601 0.38822000000000001
r11968 n7600 n7601 0.0048353909465020575
r11969 n7585 n7602 1.9411
r11970 n7601 n7602 0.0029012345679012342
r11971 n7586 n7603 0.64703333333333335
r11972 n7602 n7603 0.001934156378600823
r11973 n7587 n7604 1.9411
r11974 n7603 n7604 0.001934156378600823
r11975 n7588 n7605 0.2156777777777778
r11976 n7604 n7605 0.0048353909465020575
r11977 n7589 n7606 0.19411
r11978 n7605 n7606 0.009187242798353909
r11979 n7590 n7607 0.38822000000000001
r11980 n7606 n7607 0.0072530864197530862
r11981 n7591 n7608 0.38822000000000001
r11982 n7607 n7608 0.0048353909465020575
r11983 n7592 n7609 1.9411
r11984 n7608 n7609 0.0029012345679012342
r11985 n7593 n7610 0.97055000000000002
r11986 n7609 n7610 0.0014506172839506171
r11987 n7594 n7611 1.9411
r11988 n7610 n7611 0.0014506172839506171
r11989 n7595 n7612 1.9411
r11990 n7611 n7612 0.00096707818930041151
r11991 n7596 n7613 1.9411
r11992 n7612 n7613 0.00096707818930041151
r11993 n7597 n7614 0.48527500000000001
r11994 n7613 n7614 0.0024176954732510287
r11995 n7598 n7615 0.38822000000000001
r11996 n7614 n7615 0.0043518518518518524
r11997 n7599 n7616 1.9411
r11998 n7615 n7616 0.0029012345679012342
r11999 n7600 n7617 0.45777999999999996
r12000 n7601 n7618 0.45777999999999996
r12001 n7617 n7618 0.0048155737704918032
r12002 n7602 n7619 2.2888999999999999
r12003 n7618 n7619 0.0028893442622950818
r12004 n7603 n7620 0.76296666666666668
r12005 n7619 n7620 0.0019262295081967213
r12006 n7604 n7621 2.2888999999999999
r12007 n7620 n7621 0.0019262295081967213
r12008 n7605 n7622 0.25432222222222223
r12009 n7621 n7622 0.0048155737704918032
r12010 n7606 n7623 0.22888999999999998
r12011 n7622 n7623 0.0091495901639344259
r12012 n7607 n7624 0.45777999999999996
r12013 n7623 n7624 0.0072233606557377044
r12014 n7608 n7625 0.45777999999999996
r12015 n7624 n7625 0.0048155737704918032
r12016 n7609 n7626 2.2888999999999999
r12017 n7625 n7626 0.0028893442622950818
r12018 n7610 n7627 1.14445
r12019 n7626 n7627 0.0014446721311475409
r12020 n7611 n7628 2.2888999999999999
r12021 n7627 n7628 0.0014446721311475409
r12022 n7612 n7629 2.2888999999999999
r12023 n7628 n7629 0.00096311475409836063
r12024 n7613 n7630 2.2888999999999999
r12025 n7629 n7630 0.00096311475409836063
r12026 n7614 n7631 0.57222499999999998
r12027 n7630 n7631 0.0024077868852459016
r12028 n7615 n7632 0.45777999999999996
r12029 n7631 n7632 0.0043340163934426235
r12030 n7616 n7633 2.2888999999999999
r12031 n7632 n7633 0.0028893442622950818
r12032 n7617 n7634 0.45777999999999996
r12033 n7618 n7635 0.45777999999999996
r12034 n7634 n7635 0.0048353909465020575
r12035 n7619 n7636 2.2888999999999999
r12036 n7635 n7636 0.0029012345679012342
r12037 n7620 n7637 0.76296666666666668
r12038 n7636 n7637 0.001934156378600823
r12039 n7621 n7638 2.2888999999999999
r12040 n7637 n7638 0.001934156378600823
r12041 n7622 n7639 0.25432222222222223
r12042 n7638 n7639 0.0048353909465020575
r12043 n7623 n7640 0.22888999999999998
r12044 n7639 n7640 0.009187242798353909
r12045 n7624 n7641 0.45777999999999996
r12046 n7640 n7641 0.0072530864197530862
r12047 n7625 n7642 0.45777999999999996
r12048 n7641 n7642 0.0048353909465020575
r12049 n7626 n7643 2.2888999999999999
r12050 n7642 n7643 0.0029012345679012342
r12051 n7627 n7644 1.14445
r12052 n7643 n7644 0.0014506172839506171
r12053 n7628 n7645 2.2888999999999999
r12054 n7644 n7645 0.0014506172839506171
r12055 n7629 n7646 2.2888999999999999
r12056 n7645 n7646 0.00096707818930041151
r12057 n7630 n7647 2.2888999999999999
r12058 n7646 n7647 0.00096707818930041151
r12059 n7631 n7648 0.57222499999999998
r12060 n7647 n7648 0.0024176954732510287
r12061 n7632 n7649 0.45777999999999996
r12062 n7648 n7649 0.0043518518518518524
r12063 n7633 n7650 2.2888999999999999
r12064 n7649 n7650 0.0029012345679012342
r12065 n7634 n7651 0.45683999999999997
r12066 n7635 n7652 0.45683999999999997
r12067 n7651 n7652 0.0048353909465020575
r12068 n7636 n7653 2.2841999999999998
r12069 n7652 n7653 0.0029012345679012342
r12070 n7637 n7654 0.76139999999999997
r12071 n7653 n7654 0.001934156378600823
r12072 n7638 n7655 2.2841999999999998
r12073 n7654 n7655 0.001934156378600823
r12074 n7639 n7656 0.25379999999999997
r12075 n7655 n7656 0.0048353909465020575
r12076 n7640 n7657 0.22841999999999998
r12077 n7656 n7657 0.009187242798353909
r12078 n7641 n7658 0.45683999999999997
r12079 n7657 n7658 0.0072530864197530862
r12080 n7642 n7659 0.45683999999999997
r12081 n7658 n7659 0.0048353909465020575
r12082 n7643 n7660 2.2841999999999998
r12083 n7659 n7660 0.0029012345679012342
r12084 n7644 n7661 1.1420999999999999
r12085 n7660 n7661 0.0014506172839506171
r12086 n7645 n7662 2.2841999999999998
r12087 n7661 n7662 0.0014506172839506171
r12088 n7646 n7663 2.2841999999999998
r12089 n7662 n7663 0.00096707818930041151
r12090 n7647 n7664 2.2841999999999998
r12091 n7663 n7664 0.00096707818930041151
r12092 n7648 n7665 0.57104999999999995
r12093 n7664 n7665 0.0024176954732510287
r12094 n7649 n7666 0.45683999999999997
r12095 n7665 n7666 0.0043518518518518524
r12096 n7650 n7667 2.2841999999999998
r12097 n7666 n7667 0.0029012345679012342
r12098 n7651 n7668 0.45777999999999996
r12099 n7652 n7669 0.45777999999999996
r12100 n7668 n7669 0.0048155737704918032
r12101 n7653 n7670 2.2888999999999999
r12102 n7669 n7670 0.0028893442622950818
r12103 n7654 n7671 0.76296666666666668
r12104 n7670 n7671 0.0019262295081967213
r12105 n7655 n7672 2.2888999999999999
r12106 n7671 n7672 0.0019262295081967213
r12107 n7656 n7673 0.25432222222222223
r12108 n7672 n7673 0.0048155737704918032
r12109 n7657 n7674 0.22888999999999998
r12110 n7673 n7674 0.0091495901639344259
r12111 n7658 n7675 0.45777999999999996
r12112 n7674 n7675 0.0072233606557377044
r12113 n7659 n7676 0.45777999999999996
r12114 n7675 n7676 0.0048155737704918032
r12115 n7660 n7677 2.2888999999999999
r12116 n7676 n7677 0.0028893442622950818
r12117 n7661 n7678 1.14445
r12118 n7677 n7678 0.0014446721311475409
r12119 n7662 n7679 2.2888999999999999
r12120 n7678 n7679 0.0014446721311475409
r12121 n7663 n7680 2.2888999999999999
r12122 n7679 n7680 0.00096311475409836063
r12123 n7664 n7681 2.2888999999999999
r12124 n7680 n7681 0.00096311475409836063
r12125 n7665 n7682 0.57222499999999998
r12126 n7681 n7682 0.0024077868852459016
r12127 n7666 n7683 0.45777999999999996
r12128 n7682 n7683 0.0043340163934426235
r12129 n7667 n7684 2.2888999999999999
r12130 n7683 n7684 0.0028893442622950818
r12131 n7668 n7685 0.45777999999999996
r12132 n7669 n7686 0.45777999999999996
r12133 n7685 n7686 0.0048353909465020575
r12134 n7670 n7687 2.2888999999999999
r12135 n7686 n7687 0.0029012345679012342
r12136 n7671 n7688 0.76296666666666668
r12137 n7687 n7688 0.001934156378600823
r12138 n7672 n7689 2.2888999999999999
r12139 n7688 n7689 0.001934156378600823
r12140 n7673 n7690 0.25432222222222223
r12141 n7689 n7690 0.0048353909465020575
r12142 n7674 n7691 0.22888999999999998
r12143 n7690 n7691 0.009187242798353909
r12144 n7675 n7692 0.45777999999999996
r12145 n7691 n7692 0.0072530864197530862
r12146 n7676 n7693 0.45777999999999996
r12147 n7692 n7693 0.0048353909465020575
r12148 n7677 n7694 2.2888999999999999
r12149 n7693 n7694 0.0029012345679012342
r12150 n7678 n7695 1.14445
r12151 n7694 n7695 0.0014506172839506171
r12152 n7679 n7696 2.2888999999999999
r12153 n7695 n7696 0.0014506172839506171
r12154 n7680 n7697 2.2888999999999999
r12155 n7696 n7697 0.00096707818930041151
r12156 n7681 n7698 2.2888999999999999
r12157 n7697 n7698 0.00096707818930041151
r12158 n7682 n7699 0.57222499999999998
r12159 n7698 n7699 0.0024176954732510287
r12160 n7683 n7700 0.45777999999999996
r12161 n7699 n7700 0.0043518518518518524
r12162 n7684 n7701 2.2888999999999999
r12163 n7700 n7701 0.0029012345679012342
r12164 n7685 n7702 0.23782
r12165 n7686 n7703 0.23782
r12166 n7702 n7703 0.11750000000000001
r12167 n7687 n7704 1.1891
r12168 n7703 n7704 0.070499999999999993
r12169 n7688 n7705 0.39636666666666664
r12170 n7704 n7705 0.047
r12171 n7689 n7706 1.1891
r12172 n7705 n7706 0.047
r12173 n7690 n7707 0.13212222222222222
r12174 n7706 n7707 0.11750000000000001
r12175 n7691 n7708 0.11891
r12176 n7707 n7708 0.22325
r12177 n7692 n7709 0.23782
r12178 n7708 n7709 0.17624999999999999
r12179 n7693 n7710 0.23782
r12180 n7709 n7710 0.11750000000000001
r12181 n7694 n7711 1.1891
r12182 n7710 n7711 0.070499999999999993
r12183 n7695 n7712 0.59455000000000002
r12184 n7711 n7712 0.035249999999999997
r12185 n7696 n7713 1.1891
r12186 n7712 n7713 0.035249999999999997
r12187 n7697 n7714 1.1891
r12188 n7713 n7714 0.0235
r12189 n7698 n7715 1.1891
r12190 n7714 n7715 0.0235
r12191 n7699 n7716 0.29727500000000001
r12192 n7715 n7716 0.058750000000000004
r12193 n7700 n7717 0.23782
r12194 n7716 n7717 0.10575000000000001
r12195 n7701 n7718 1.1891
r12196 n7717 n7718 0.070499999999999993
r12197 n7702 n7719 0.061100000000000002
r12198 n7703 n7720 0.061100000000000002
r12199 n7719 n7720 0.021363636363636366
r12200 n7704 n7721 0.30549999999999999
r12201 n7720 n7721 0.012818181818181817
r12202 n7705 n7722 0.10183333333333335
r12203 n7721 n7722 0.0085454545454545453
r12204 n7706 n7723 0.30549999999999999
r12205 n7722 n7723 0.0085454545454545453
r12206 n7707 n7724 0.033944444444444444
r12207 n7723 n7724 0.021363636363636366
r12208 n7708 n7725 0.030550000000000001
r12209 n7724 n7725 0.040590909090909087
r12210 n7709 n7726 0.061100000000000002
r12211 n7725 n7726 0.032045454545454544
r12212 n7710 n7727 0.061100000000000002
r12213 n7726 n7727 0.021363636363636366
r12214 n7711 n7728 0.30549999999999999
r12215 n7727 n7728 0.012818181818181817
r12216 n7712 n7729 0.15275
r12217 n7728 n7729 0.0064090909090909086
r12218 n7713 n7730 0.30549999999999999
r12219 n7729 n7730 0.0064090909090909086
r12220 n7714 n7731 0.30549999999999999
r12221 n7730 n7731 0.0042727272727272727
r12222 n7715 n7732 0.30549999999999999
r12223 n7731 n7732 0.0042727272727272727
r12224 n7716 n7733 0.076374999999999998
r12225 n7732 n7733 0.010681818181818183
r12226 n7717 n7734 0.061100000000000002
r12227 n7733 n7734 0.019227272727272728
r12228 n7718 n7735 0.30549999999999999
r12229 n7734 n7735 0.012818181818181817
r12230 n7719 n7736 0.061100000000000002
r12231 n7720 n7737 0.061100000000000002
r12232 n7736 n7737 0.11750000000000001
r12233 n7721 n7738 0.30549999999999999
r12234 n7737 n7738 0.070499999999999993
r12235 n7722 n7739 0.10183333333333335
r12236 n7738 n7739 0.047
r12237 n7723 n7740 0.30549999999999999
r12238 n7739 n7740 0.047
r12239 n7724 n7741 0.033944444444444444
r12240 n7740 n7741 0.11750000000000001
r12241 n7725 n7742 0.030550000000000001
r12242 n7741 n7742 0.22325
r12243 n7726 n7743 0.061100000000000002
r12244 n7742 n7743 0.17624999999999999
r12245 n7727 n7744 0.061100000000000002
r12246 n7743 n7744 0.11750000000000001
r12247 n7728 n7745 0.30549999999999999
r12248 n7744 n7745 0.070499999999999993
r12249 n7729 n7746 0.15275
r12250 n7745 n7746 0.035249999999999997
r12251 n7730 n7747 0.30549999999999999
r12252 n7746 n7747 0.035249999999999997
r12253 n7731 n7748 0.30549999999999999
r12254 n7747 n7748 0.0235
r12255 n7732 n7749 0.30549999999999999
r12256 n7748 n7749 0.0235
r12257 n7733 n7750 0.076374999999999998
r12258 n7749 n7750 0.058750000000000004
r12259 n7734 n7751 0.061100000000000002
r12260 n7750 n7751 0.10575000000000001
r12261 n7735 n7752 0.30549999999999999
r12262 n7751 n7752 0.070499999999999993
r12263 n7736 n7753 0.15039999999999998
r12264 n7737 n7754 0.15039999999999998
r12265 n7753 n7754 0.0078333333333333328
r12266 n7738 n7755 0.752
r12267 n7754 n7755 0.0046999999999999993
r12268 n7739 n7756 0.25066666666666665
r12269 n7755 n7756 0.003133333333333333
r12270 n7740 n7757 0.752
r12271 n7756 n7757 0.003133333333333333
r12272 n7741 n7758 0.08355555555555555
r12273 n7757 n7758 0.0078333333333333328
r12274 n7742 n7759 0.075199999999999989
r12275 n7758 n7759 0.014883333333333333
r12276 n7743 n7760 0.15039999999999998
r12277 n7759 n7760 0.01175
r12278 n7744 n7761 0.15039999999999998
r12279 n7760 n7761 0.0078333333333333328
r12280 n7745 n7762 0.752
r12281 n7761 n7762 0.0046999999999999993
r12282 n7746 n7763 0.376
r12283 n7762 n7763 0.0023499999999999997
r12284 n7747 n7764 0.752
r12285 n7763 n7764 0.0023499999999999997
r12286 n7748 n7765 0.752
r12287 n7764 n7765 0.0015666666666666665
r12288 n7749 n7766 0.752
r12289 n7765 n7766 0.0015666666666666665
r12290 n7750 n7767 0.188
r12291 n7766 n7767 0.0039166666666666664
r12292 n7751 n7768 0.15039999999999998
r12293 n7767 n7768 0.0070500000000000007
r12294 n7752 n7769 0.752
r12295 n7768 n7769 0.0046999999999999993
r12296 n7753 n7770 0.15039999999999998
r12297 n7754 n7771 0.15039999999999998
r12298 n7770 n7771 0.11750000000000001
r12299 n7755 n7772 0.752
r12300 n7771 n7772 0.070499999999999993
r12301 n7756 n7773 0.25066666666666665
r12302 n7772 n7773 0.047
r12303 n7757 n7774 0.752
r12304 n7773 n7774 0.047
r12305 n7758 n7775 0.08355555555555555
r12306 n7774 n7775 0.11750000000000001
r12307 n7759 n7776 0.075199999999999989
r12308 n7775 n7776 0.22325
r12309 n7760 n7777 0.15039999999999998
r12310 n7776 n7777 0.17624999999999999
r12311 n7761 n7778 0.15039999999999998
r12312 n7777 n7778 0.11750000000000001
r12313 n7762 n7779 0.752
r12314 n7778 n7779 0.070499999999999993
r12315 n7763 n7780 0.376
r12316 n7779 n7780 0.035249999999999997
r12317 n7764 n7781 0.752
r12318 n7780 n7781 0.035249999999999997
r12319 n7765 n7782 0.752
r12320 n7781 n7782 0.0235
r12321 n7766 n7783 0.752
r12322 n7782 n7783 0.0235
r12323 n7767 n7784 0.188
r12324 n7783 n7784 0.058750000000000004
r12325 n7768 n7785 0.15039999999999998
r12326 n7784 n7785 0.10575000000000001
r12327 n7769 n7786 0.752
r12328 n7785 n7786 0.070499999999999993
r12329 n7770 n7787 0.061100000000000002
r12330 n7771 n7788 0.061100000000000002
r12331 n7787 n7788 0.021363636363636366
r12332 n7772 n7789 0.30549999999999999
r12333 n7788 n7789 0.012818181818181817
r12334 n7773 n7790 0.10183333333333335
r12335 n7789 n7790 0.0085454545454545453
r12336 n7774 n7791 0.30549999999999999
r12337 n7790 n7791 0.0085454545454545453
r12338 n7775 n7792 0.033944444444444444
r12339 n7791 n7792 0.021363636363636366
r12340 n7776 n7793 0.030550000000000001
r12341 n7792 n7793 0.040590909090909087
r12342 n7777 n7794 0.061100000000000002
r12343 n7793 n7794 0.032045454545454544
r12344 n7778 n7795 0.061100000000000002
r12345 n7794 n7795 0.021363636363636366
r12346 n7779 n7796 0.30549999999999999
r12347 n7795 n7796 0.012818181818181817
r12348 n7780 n7797 0.15275
r12349 n7796 n7797 0.0064090909090909086
r12350 n7781 n7798 0.30549999999999999
r12351 n7797 n7798 0.0064090909090909086
r12352 n7782 n7799 0.30549999999999999
r12353 n7798 n7799 0.0042727272727272727
r12354 n7783 n7800 0.30549999999999999
r12355 n7799 n7800 0.0042727272727272727
r12356 n7784 n7801 0.076374999999999998
r12357 n7800 n7801 0.010681818181818183
r12358 n7785 n7802 0.061100000000000002
r12359 n7801 n7802 0.019227272727272728
r12360 n7786 n7803 0.30549999999999999
r12361 n7802 n7803 0.012818181818181817
r12362 n7787 n7804 0.061100000000000002
r12363 n7788 n7805 0.061100000000000002
r12364 n7804 n7805 0.11750000000000001
r12365 n7789 n7806 0.30549999999999999
r12366 n7805 n7806 0.070499999999999993
r12367 n7790 n7807 0.10183333333333335
r12368 n7806 n7807 0.047
r12369 n7791 n7808 0.30549999999999999
r12370 n7807 n7808 0.047
r12371 n7792 n7809 0.033944444444444444
r12372 n7808 n7809 0.11750000000000001
r12373 n7793 n7810 0.030550000000000001
r12374 n7809 n7810 0.22325
r12375 n7794 n7811 0.061100000000000002
r12376 n7810 n7811 0.17624999999999999
r12377 n7795 n7812 0.061100000000000002
r12378 n7811 n7812 0.11750000000000001
r12379 n7796 n7813 0.30549999999999999
r12380 n7812 n7813 0.070499999999999993
r12381 n7797 n7814 0.15275
r12382 n7813 n7814 0.035249999999999997
r12383 n7798 n7815 0.30549999999999999
r12384 n7814 n7815 0.035249999999999997
r12385 n7799 n7816 0.30549999999999999
r12386 n7815 n7816 0.0235
r12387 n7800 n7817 0.30549999999999999
r12388 n7816 n7817 0.0235
r12389 n7801 n7818 0.076374999999999998
r12390 n7817 n7818 0.058750000000000004
r12391 n7802 n7819 0.061100000000000002
r12392 n7818 n7819 0.10575000000000001
r12393 n7803 n7820 0.30549999999999999
r12394 n7819 n7820 0.070499999999999993
r12395 n7804 n7821 0.16732
r12396 n7805 n7822 0.16732
r12397 n7821 n7822 0.0069940476190476194
r12398 n7806 n7823 0.83660000000000001
r12399 n7822 n7823 0.0041964285714285714
r12400 n7807 n7824 0.27886666666666665
r12401 n7823 n7824 0.0027976190476190475
r12402 n7808 n7825 0.83660000000000001
r12403 n7824 n7825 0.0027976190476190475
r12404 n7809 n7826 0.092955555555555555
r12405 n7825 n7826 0.0069940476190476194
r12406 n7810 n7827 0.083659999999999998
r12407 n7826 n7827 0.013288690476190477
r12408 n7811 n7828 0.16732
r12409 n7827 n7828 0.010491071428571428
r12410 n7812 n7829 0.16732
r12411 n7828 n7829 0.0069940476190476194
r12412 n7813 n7830 0.83660000000000001
r12413 n7829 n7830 0.0041964285714285714
r12414 n7814 n7831 0.41830000000000001
r12415 n7830 n7831 0.0020982142857142857
r12416 n7815 n7832 0.83660000000000001
r12417 n7831 n7832 0.0020982142857142857
r12418 n7816 n7833 0.83660000000000001
r12419 n7832 n7833 0.0013988095238095237
r12420 n7817 n7834 0.83660000000000001
r12421 n7833 n7834 0.0013988095238095237
r12422 n7818 n7835 0.20915
r12423 n7834 n7835 0.0034970238095238097
r12424 n7819 n7836 0.16732
r12425 n7835 n7836 0.006294642857142858
r12426 n7820 n7837 0.83660000000000001
r12427 n7836 n7837 0.0041964285714285714
r12428 n7821 n7838 0.31489999999999996
r12429 n7822 n7839 0.31489999999999996
r12430 n7838 n7839 0.0070359281437125751
r12431 n7823 n7840 1.5745
r12432 n7839 n7840 0.0042215568862275449
r12433 n7824 n7841 0.52483333333333326
r12434 n7840 n7841 0.0028143712574850298
r12435 n7825 n7842 1.5745
r12436 n7841 n7842 0.0028143712574850298
r12437 n7826 n7843 0.17494444444444443
r12438 n7842 n7843 0.0070359281437125751
r12439 n7827 n7844 0.15744999999999998
r12440 n7843 n7844 0.013368263473053891
r12441 n7828 n7845 0.31489999999999996
r12442 n7844 n7845 0.010553892215568862
r12443 n7829 n7846 0.31489999999999996
r12444 n7845 n7846 0.0070359281437125751
r12445 n7830 n7847 1.5745
r12446 n7846 n7847 0.0042215568862275449
r12447 n7831 n7848 0.78725000000000001
r12448 n7847 n7848 0.0021107784431137725
r12449 n7832 n7849 1.5745
r12450 n7848 n7849 0.0021107784431137725
r12451 n7833 n7850 1.5745
r12452 n7849 n7850 0.0014071856287425149
r12453 n7834 n7851 1.5745
r12454 n7850 n7851 0.0014071856287425149
r12455 n7835 n7852 0.393625
r12456 n7851 n7852 0.0035179640718562876
r12457 n7836 n7853 0.31489999999999996
r12458 n7852 n7853 0.0063323353293413178
r12459 n7837 n7854 1.5745
r12460 n7853 n7854 0.0042215568862275449
r12461 n7838 n7855 0.20867999999999998
r12462 n7839 n7856 0.20867999999999998
r12463 n7855 n7856 0.021363636363636366
r12464 n7840 n7857 1.0433999999999999
r12465 n7856 n7857 0.012818181818181817
r12466 n7841 n7858 0.3478
r12467 n7857 n7858 0.0085454545454545453
r12468 n7842 n7859 1.0433999999999999
r12469 n7858 n7859 0.0085454545454545453
r12470 n7843 n7860 0.11593333333333332
r12471 n7859 n7860 0.021363636363636366
r12472 n7844 n7861 0.10433999999999999
r12473 n7860 n7861 0.040590909090909087
r12474 n7845 n7862 0.20867999999999998
r12475 n7861 n7862 0.032045454545454544
r12476 n7846 n7863 0.20867999999999998
r12477 n7862 n7863 0.021363636363636366
r12478 n7847 n7864 1.0433999999999999
r12479 n7863 n7864 0.012818181818181817
r12480 n7848 n7865 0.52169999999999994
r12481 n7864 n7865 0.0064090909090909086
r12482 n7849 n7866 1.0433999999999999
r12483 n7865 n7866 0.0064090909090909086
r12484 n7850 n7867 1.0433999999999999
r12485 n7866 n7867 0.0042727272727272727
r12486 n7851 n7868 1.0433999999999999
r12487 n7867 n7868 0.0042727272727272727
r12488 n7852 n7869 0.26084999999999997
r12489 n7868 n7869 0.010681818181818183
r12490 n7853 n7870 0.20867999999999998
r12491 n7869 n7870 0.019227272727272728
r12492 n7854 n7871 1.0433999999999999
r12493 n7870 n7871 0.012818181818181817
r12494 n7855 n7872 0.098699999999999996
r12495 n7856 n7873 0.098699999999999996
r12496 n7872 n7873 0.0235
r12497 n7857 n7874 0.49349999999999994
r12498 n7873 n7874 0.0141
r12499 n7858 n7875 0.16449999999999998
r12500 n7874 n7875 0.0093999999999999986
r12501 n7859 n7876 0.49349999999999994
r12502 n7875 n7876 0.0093999999999999986
r12503 n7860 n7877 0.054833333333333331
r12504 n7876 n7877 0.0235
r12505 n7861 n7878 0.049349999999999998
r12506 n7877 n7878 0.044649999999999995
r12507 n7862 n7879 0.098699999999999996
r12508 n7878 n7879 0.035249999999999997
r12509 n7863 n7880 0.098699999999999996
r12510 n7879 n7880 0.0235
r12511 n7864 n7881 0.49349999999999994
r12512 n7880 n7881 0.0141
r12513 n7865 n7882 0.24674999999999997
r12514 n7881 n7882 0.0070499999999999998
r12515 n7866 n7883 0.49349999999999994
r12516 n7882 n7883 0.0070499999999999998
r12517 n7867 n7884 0.49349999999999994
r12518 n7883 n7884 0.0046999999999999993
r12519 n7868 n7885 0.49349999999999994
r12520 n7884 n7885 0.0046999999999999993
r12521 n7869 n7886 0.12337499999999998
r12522 n7885 n7886 0.01175
r12523 n7870 n7887 0.098699999999999996
r12524 n7886 n7887 0.021150000000000002
r12525 n7871 n7888 0.49349999999999994
r12526 n7887 n7888 0.0141
r12527 n7888 n7889 0.025849999999999998
r12528 n7889 n7890 0.030550000000000001
r12529 n7890 n7891 0.021150000000000002
r12530 n7891 n7892 0.018799999999999997
r12531 n7892 n7893 0.0070499999999999998
r12532 n7893 n7894 0.0046999999999999993
r12533 n7894 n7895 0.016449999999999999
r12534 n7895 n7896 0.025849999999999998
r12535 n7896 n7897 0.0141
r12536 n7897 n7898 0.01175
r12537 n7898 n7899 0.021150000000000002
r12538 n7899 n7900 0.018799999999999997
r12539 n7900 n7901 0.0235
r12540 n7872 n7902 0.056399999999999999
r12541 n7873 n7903 0.056399999999999999
r12542 n7902 n7903 0.11750000000000001
r12543 n7874 n7904 0.28199999999999997
r12544 n7903 n7904 0.070499999999999993
r12545 n7875 n7905 0.094
r12546 n7904 n7905 0.047
r12547 n7876 n7906 0.28199999999999997
r12548 n7905 n7906 0.047
r12549 n7877 n7907 0.031333333333333331
r12550 n7906 n7907 0.11750000000000001
r12551 n7878 n7908 0.028199999999999999
r12552 n7907 n7908 0.22325
r12553 n7879 n7909 0.056399999999999999
r12554 n7908 n7909 0.17624999999999999
r12555 n7880 n7910 0.056399999999999999
r12556 n7909 n7910 0.11750000000000001
r12557 n7881 n7911 0.28199999999999997
r12558 n7910 n7911 0.070499999999999993
r12559 n7882 n7912 0.14099999999999999
r12560 n7911 n7912 0.035249999999999997
r12561 n7883 n7913 0.28199999999999997
r12562 n7912 n7913 0.035249999999999997
r12563 n7884 n7914 0.28199999999999997
r12564 n7913 n7914 0.0235
r12565 n7885 n7915 0.28199999999999997
r12566 n7914 n7915 0.0235
r12567 n7886 n7916 0.070499999999999993
r12568 n7915 n7916 0.058750000000000004
r12569 n7887 n7917 0.056399999999999999
r12570 n7916 n7917 0.10575000000000001
r12571 n7888 n7918 0.28199999999999997
r12572 n7917 n7918 0.070499999999999993
r12573 n7889 n7919 0.028199999999999999
r12574 n7918 n7919 0.12925
r12575 n7890 n7920 0.094
r12576 n7919 n7920 0.15275
r12577 n7891 n7921 0.047
r12578 n7920 n7921 0.10575000000000001
r12579 n7892 n7922 0.14099999999999999
r12580 n7921 n7922 0.094
r12581 n7893 n7923 0.28199999999999997
r12582 n7922 n7923 0.035249999999999997
r12583 n7894 n7924 0.28199999999999997
r12584 n7923 n7924 0.0235
r12585 n7895 n7925 0.047
r12586 n7924 n7925 0.082250000000000004
r12587 n7896 n7926 0.056399999999999999
r12588 n7925 n7926 0.12925
r12589 n7897 n7927 0.28199999999999997
r12590 n7926 n7927 0.070499999999999993
r12591 n7898 n7928 0.070499999999999993
r12592 n7927 n7928 0.058750000000000004
r12593 n7899 n7929 0.056399999999999999
r12594 n7928 n7929 0.10575000000000001
r12595 n7900 n7930 0.094
r12596 n7929 n7930 0.094
r12597 n7901 n7931 0.040285714285714286
r12598 n7930 n7931 0.11750000000000001
r12599 n7902 n7932 0.0235
r12600 n7903 n7933 0.0235
r12601 n7932 n7933 0.078333333333333338
r12602 n7904 n7934 0.11750000000000001
r12603 n7933 n7934 0.047
r12604 n7905 n7935 0.039166666666666669
r12605 n7934 n7935 0.031333333333333331
r12606 n7906 n7936 0.11750000000000001
r12607 n7935 n7936 0.031333333333333331
r12608 n7907 n7937 0.013055555555555556
r12609 n7936 n7937 0.078333333333333338
r12610 n7908 n7938 0.01175
r12611 n7937 n7938 0.14883333333333332
r12612 n7909 n7939 0.0235
r12613 n7938 n7939 0.11749999999999999
r12614 n7910 n7940 0.0235
r12615 n7939 n7940 0.078333333333333338
r12616 n7911 n7941 0.11750000000000001
r12617 n7940 n7941 0.047
r12618 n7912 n7942 0.058750000000000004
r12619 n7941 n7942 0.0235
r12620 n7913 n7943 0.11750000000000001
r12621 n7942 n7943 0.0235
r12622 n7914 n7944 0.11750000000000001
r12623 n7943 n7944 0.015666666666666666
r12624 n7915 n7945 0.11750000000000001
r12625 n7944 n7945 0.015666666666666666
r12626 n7916 n7946 0.029375000000000002
r12627 n7945 n7946 0.039166666666666669
r12628 n7917 n7947 0.0235
r12629 n7946 n7947 0.070500000000000007
r12630 n7918 n7948 0.11750000000000001
r12631 n7947 n7948 0.047
r12632 n7919 n7949 0.01175
r12633 n7948 n7949 0.086166666666666669
r12634 n7920 n7950 0.039166666666666669
r12635 n7949 n7950 0.10183333333333335
r12636 n7921 n7951 0.019583333333333335
r12637 n7950 n7951 0.070500000000000007
r12638 n7922 n7952 0.058750000000000004
r12639 n7951 n7952 0.062666666666666662
r12640 n7923 n7953 0.11750000000000001
r12641 n7952 n7953 0.0235
r12642 n7924 n7954 0.11750000000000001
r12643 n7953 n7954 0.015666666666666666
r12644 n7925 n7955 0.019583333333333335
r12645 n7954 n7955 0.054833333333333331
r12646 n7926 n7956 0.0235
r12647 n7955 n7956 0.086166666666666669
r12648 n7927 n7957 0.11750000000000001
r12649 n7956 n7957 0.047
r12650 n7928 n7958 0.029375000000000002
r12651 n7957 n7958 0.039166666666666669
r12652 n7929 n7959 0.0235
r12653 n7958 n7959 0.070500000000000007
r12654 n7930 n7960 0.039166666666666669
r12655 n7959 n7960 0.062666666666666662
r12656 n7931 n7961 0.016785714285714286
r12657 n7960 n7961 0.078333333333333338
r12658 n7932 n7962 0.037599999999999995
r12659 n7933 n7963 0.037599999999999995
r12660 n7962 n7963 0.047
r12661 n7934 n7964 0.188
r12662 n7963 n7964 0.028199999999999999
r12663 n7935 n7965 0.062666666666666662
r12664 n7964 n7965 0.018799999999999997
r12665 n7936 n7966 0.188
r12666 n7965 n7966 0.018799999999999997
r12667 n7937 n7967 0.020888888888888887
r12668 n7966 n7967 0.047
r12669 n7938 n7968 0.018799999999999997
r12670 n7967 n7968 0.08929999999999999
r12671 n7939 n7969 0.037599999999999995
r12672 n7968 n7969 0.070499999999999993
r12673 n7940 n7970 0.037599999999999995
r12674 n7969 n7970 0.047
r12675 n7941 n7971 0.188
r12676 n7970 n7971 0.028199999999999999
r12677 n7942 n7972 0.094
r12678 n7971 n7972 0.0141
r12679 n7943 n7973 0.188
r12680 n7972 n7973 0.0141
r12681 n7944 n7974 0.188
r12682 n7973 n7974 0.0093999999999999986
r12683 n7945 n7975 0.188
r12684 n7974 n7975 0.0093999999999999986
r12685 n7946 n7976 0.047
r12686 n7975 n7976 0.0235
r12687 n7947 n7977 0.037599999999999995
r12688 n7976 n7977 0.042300000000000004
r12689 n7948 n7978 0.188
r12690 n7977 n7978 0.028199999999999999
r12691 n7949 n7979 0.018799999999999997
r12692 n7978 n7979 0.051699999999999996
r12693 n7950 n7980 0.062666666666666662
r12694 n7979 n7980 0.061100000000000002
r12695 n7951 n7981 0.031333333333333331
r12696 n7980 n7981 0.042300000000000004
r12697 n7952 n7982 0.094
r12698 n7981 n7982 0.037599999999999995
r12699 n7953 n7983 0.188
r12700 n7982 n7983 0.0141
r12701 n7954 n7984 0.188
r12702 n7983 n7984 0.0093999999999999986
r12703 n7955 n7985 0.031333333333333331
r12704 n7984 n7985 0.032899999999999999
r12705 n7956 n7986 0.037599999999999995
r12706 n7985 n7986 0.051699999999999996
r12707 n7957 n7987 0.188
r12708 n7986 n7987 0.028199999999999999
r12709 n7958 n7988 0.047
r12710 n7987 n7988 0.0235
r12711 n7959 n7989 0.037599999999999995
r12712 n7988 n7989 0.042300000000000004
r12713 n7960 n7990 0.062666666666666662
r12714 n7989 n7990 0.037599999999999995
r12715 n7961 n7991 0.026857142857142857
r12716 n7990 n7991 0.047
r12717 n7962 n7992 0.037599999999999995
r12718 n7963 n7993 0.037599999999999995
r12719 n7992 n7993 0.078333333333333338
r12720 n7964 n7994 0.188
r12721 n7993 n7994 0.047
r12722 n7965 n7995 0.062666666666666662
r12723 n7994 n7995 0.031333333333333331
r12724 n7966 n7996 0.188
r12725 n7995 n7996 0.031333333333333331
r12726 n7967 n7997 0.020888888888888887
r12727 n7996 n7997 0.078333333333333338
r12728 n7968 n7998 0.018799999999999997
r12729 n7997 n7998 0.14883333333333332
r12730 n7969 n7999 0.037599999999999995
r12731 n7998 n7999 0.11749999999999999
r12732 n7970 n8000 0.037599999999999995
r12733 n7999 n8000 0.078333333333333338
r12734 n7971 n8001 0.188
r12735 n8000 n8001 0.047
r12736 n7972 n8002 0.094
r12737 n8001 n8002 0.0235
r12738 n7973 n8003 0.188
r12739 n8002 n8003 0.0235
r12740 n7974 n8004 0.188
r12741 n8003 n8004 0.015666666666666666
r12742 n7975 n8005 0.188
r12743 n8004 n8005 0.015666666666666666
r12744 n7976 n8006 0.047
r12745 n8005 n8006 0.039166666666666669
r12746 n7977 n8007 0.037599999999999995
r12747 n8006 n8007 0.070500000000000007
r12748 n7978 n8008 0.188
r12749 n8007 n8008 0.047
r12750 n7979 n8009 0.018799999999999997
r12751 n8008 n8009 0.086166666666666669
r12752 n7980 n8010 0.062666666666666662
r12753 n8009 n8010 0.10183333333333335
r12754 n7981 n8011 0.031333333333333331
r12755 n8010 n8011 0.070500000000000007
r12756 n7982 n8012 0.094
r12757 n8011 n8012 0.062666666666666662
r12758 n7983 n8013 0.188
r12759 n8012 n8013 0.0235
r12760 n7984 n8014 0.188
r12761 n8013 n8014 0.015666666666666666
r12762 n7985 n8015 0.031333333333333331
r12763 n8014 n8015 0.054833333333333331
r12764 n7986 n8016 0.037599999999999995
r12765 n8015 n8016 0.086166666666666669
r12766 n7987 n8017 0.188
r12767 n8016 n8017 0.047
r12768 n7988 n8018 0.047
r12769 n8017 n8018 0.039166666666666669
r12770 n7989 n8019 0.037599999999999995
r12771 n8018 n8019 0.070500000000000007
r12772 n7990 n8020 0.062666666666666662
r12773 n8019 n8020 0.062666666666666662
r12774 n7991 n8021 0.026857142857142857
r12775 n8020 n8021 0.078333333333333338
r12776 n7992 n8022 0.0235
r12777 n7993 n8023 0.0235
r12778 n8022 n8023 0.11750000000000001
r12779 n7994 n8024 0.11750000000000001
r12780 n8023 n8024 0.070499999999999993
r12781 n7995 n8025 0.039166666666666669
r12782 n8024 n8025 0.047
r12783 n7996 n8026 0.11750000000000001
r12784 n8025 n8026 0.047
r12785 n7997 n8027 0.013055555555555556
r12786 n8026 n8027 0.11750000000000001
r12787 n7998 n8028 0.01175
r12788 n8027 n8028 0.22325
r12789 n7999 n8029 0.0235
r12790 n8028 n8029 0.17624999999999999
r12791 n8000 n8030 0.0235
r12792 n8029 n8030 0.11750000000000001
r12793 n8001 n8031 0.11750000000000001
r12794 n8030 n8031 0.070499999999999993
r12795 n8002 n8032 0.058750000000000004
r12796 n8031 n8032 0.035249999999999997
r12797 n8003 n8033 0.11750000000000001
r12798 n8032 n8033 0.035249999999999997
r12799 n8004 n8034 0.11750000000000001
r12800 n8033 n8034 0.0235
r12801 n8005 n8035 0.11750000000000001
r12802 n8034 n8035 0.0235
r12803 n8006 n8036 0.029375000000000002
r12804 n8035 n8036 0.058750000000000004
r12805 n8007 n8037 0.0235
r12806 n8036 n8037 0.10575000000000001
r12807 n8008 n8038 0.11750000000000001
r12808 n8037 n8038 0.070499999999999993
r12809 n8009 n8039 0.01175
r12810 n8038 n8039 0.12925
r12811 n8010 n8040 0.039166666666666669
r12812 n8039 n8040 0.15275
r12813 n8011 n8041 0.019583333333333335
r12814 n8040 n8041 0.10575000000000001
r12815 n8012 n8042 0.058750000000000004
r12816 n8041 n8042 0.094
r12817 n8013 n8043 0.11750000000000001
r12818 n8042 n8043 0.035249999999999997
r12819 n8014 n8044 0.11750000000000001
r12820 n8043 n8044 0.0235
r12821 n8015 n8045 0.019583333333333335
r12822 n8044 n8045 0.082250000000000004
r12823 n8016 n8046 0.0235
r12824 n8045 n8046 0.12925
r12825 n8017 n8047 0.11750000000000001
r12826 n8046 n8047 0.070499999999999993
r12827 n8018 n8048 0.029375000000000002
r12828 n8047 n8048 0.058750000000000004
r12829 n8019 n8049 0.0235
r12830 n8048 n8049 0.10575000000000001
r12831 n8020 n8050 0.039166666666666669
r12832 n8049 n8050 0.094
r12833 n8021 n8051 0.016785714285714286
r12834 n8050 n8051 0.11750000000000001
r12835 n8022 n8052 0.15039999999999998
r12836 n8023 n8053 0.15039999999999998
r12837 n8052 n8053 0.0078333333333333328
r12838 n8024 n8054 0.752
r12839 n8053 n8054 0.0046999999999999993
r12840 n8025 n8055 0.25066666666666665
r12841 n8054 n8055 0.003133333333333333
r12842 n8026 n8056 0.752
r12843 n8055 n8056 0.003133333333333333
r12844 n8027 n8057 0.08355555555555555
r12845 n8056 n8057 0.0078333333333333328
r12846 n8028 n8058 0.075199999999999989
r12847 n8057 n8058 0.014883333333333333
r12848 n8029 n8059 0.15039999999999998
r12849 n8058 n8059 0.01175
r12850 n8030 n8060 0.15039999999999998
r12851 n8059 n8060 0.0078333333333333328
r12852 n8031 n8061 0.752
r12853 n8060 n8061 0.0046999999999999993
r12854 n8032 n8062 0.376
r12855 n8061 n8062 0.0023499999999999997
r12856 n8033 n8063 0.752
r12857 n8062 n8063 0.0023499999999999997
r12858 n8034 n8064 0.752
r12859 n8063 n8064 0.0015666666666666665
r12860 n8035 n8065 0.752
r12861 n8064 n8065 0.0015666666666666665
r12862 n8036 n8066 0.188
r12863 n8065 n8066 0.0039166666666666664
r12864 n8037 n8067 0.15039999999999998
r12865 n8066 n8067 0.0070500000000000007
r12866 n8038 n8068 0.752
r12867 n8067 n8068 0.0046999999999999993
r12868 n8039 n8069 0.075199999999999989
r12869 n8068 n8069 0.0086166666666666666
r12870 n8040 n8070 0.25066666666666665
r12871 n8069 n8070 0.010183333333333334
r12872 n8041 n8071 0.12533333333333332
r12873 n8070 n8071 0.0070500000000000007
r12874 n8042 n8072 0.376
r12875 n8071 n8072 0.006266666666666666
r12876 n8043 n8073 0.752
r12877 n8072 n8073 0.0023499999999999997
r12878 n8044 n8074 0.752
r12879 n8073 n8074 0.0015666666666666665
r12880 n8045 n8075 0.12533333333333332
r12881 n8074 n8075 0.0054833333333333331
r12882 n8046 n8076 0.15039999999999998
r12883 n8075 n8076 0.0086166666666666666
r12884 n8047 n8077 0.752
r12885 n8076 n8077 0.0046999999999999993
r12886 n8048 n8078 0.188
r12887 n8077 n8078 0.0039166666666666664
r12888 n8049 n8079 0.15039999999999998
r12889 n8078 n8079 0.0070500000000000007
r12890 n8050 n8080 0.25066666666666665
r12891 n8079 n8080 0.006266666666666666
r12892 n8051 n8081 0.10742857142857143
r12893 n8080 n8081 0.0078333333333333328
r12894 n8052 n8082 0.15039999999999998
r12895 n8053 n8083 0.15039999999999998
r12896 n8082 n8083 0.11750000000000001
r12897 n8054 n8084 0.752
r12898 n8083 n8084 0.070499999999999993
r12899 n8055 n8085 0.25066666666666665
r12900 n8084 n8085 0.047
r12901 n8056 n8086 0.752
r12902 n8085 n8086 0.047
r12903 n8057 n8087 0.08355555555555555
r12904 n8086 n8087 0.11750000000000001
r12905 n8058 n8088 0.075199999999999989
r12906 n8087 n8088 0.22325
r12907 n8059 n8089 0.15039999999999998
r12908 n8088 n8089 0.17624999999999999
r12909 n8060 n8090 0.15039999999999998
r12910 n8089 n8090 0.11750000000000001
r12911 n8061 n8091 0.752
r12912 n8090 n8091 0.070499999999999993
r12913 n8062 n8092 0.376
r12914 n8091 n8092 0.035249999999999997
r12915 n8063 n8093 0.752
r12916 n8092 n8093 0.035249999999999997
r12917 n8064 n8094 0.752
r12918 n8093 n8094 0.0235
r12919 n8065 n8095 0.752
r12920 n8094 n8095 0.0235
r12921 n8066 n8096 0.188
r12922 n8095 n8096 0.058750000000000004
r12923 n8067 n8097 0.15039999999999998
r12924 n8096 n8097 0.10575000000000001
r12925 n8068 n8098 0.752
r12926 n8097 n8098 0.070499999999999993
r12927 n8069 n8099 0.075199999999999989
r12928 n8098 n8099 0.12925
r12929 n8070 n8100 0.25066666666666665
r12930 n8099 n8100 0.15275
r12931 n8071 n8101 0.12533333333333332
r12932 n8100 n8101 0.10575000000000001
r12933 n8072 n8102 0.376
r12934 n8101 n8102 0.094
r12935 n8073 n8103 0.752
r12936 n8102 n8103 0.035249999999999997
r12937 n8074 n8104 0.752
r12938 n8103 n8104 0.0235
r12939 n8075 n8105 0.12533333333333332
r12940 n8104 n8105 0.082250000000000004
r12941 n8076 n8106 0.15039999999999998
r12942 n8105 n8106 0.12925
r12943 n8077 n8107 0.752
r12944 n8106 n8107 0.070499999999999993
r12945 n8078 n8108 0.188
r12946 n8107 n8108 0.058750000000000004
r12947 n8079 n8109 0.15039999999999998
r12948 n8108 n8109 0.10575000000000001
r12949 n8080 n8110 0.25066666666666665
r12950 n8109 n8110 0.094
r12951 n8081 n8111 0.10742857142857143
r12952 n8110 n8111 0.11750000000000001
r12953 n8082 n8112 0.0235
r12954 n8083 n8113 0.0235
r12955 n8112 n8113 0.078333333333333338
r12956 n8084 n8114 0.11750000000000001
r12957 n8113 n8114 0.047
r12958 n8085 n8115 0.039166666666666669
r12959 n8114 n8115 0.031333333333333331
r12960 n8086 n8116 0.11750000000000001
r12961 n8115 n8116 0.031333333333333331
r12962 n8087 n8117 0.013055555555555556
r12963 n8116 n8117 0.078333333333333338
r12964 n8088 n8118 0.01175
r12965 n8117 n8118 0.14883333333333332
r12966 n8089 n8119 0.0235
r12967 n8118 n8119 0.11749999999999999
r12968 n8090 n8120 0.0235
r12969 n8119 n8120 0.078333333333333338
r12970 n8091 n8121 0.11750000000000001
r12971 n8120 n8121 0.047
r12972 n8092 n8122 0.058750000000000004
r12973 n8121 n8122 0.0235
r12974 n8093 n8123 0.11750000000000001
r12975 n8122 n8123 0.0235
r12976 n8094 n8124 0.11750000000000001
r12977 n8123 n8124 0.015666666666666666
r12978 n8095 n8125 0.11750000000000001
r12979 n8124 n8125 0.015666666666666666
r12980 n8096 n8126 0.029375000000000002
r12981 n8125 n8126 0.039166666666666669
r12982 n8097 n8127 0.0235
r12983 n8126 n8127 0.070500000000000007
r12984 n8098 n8128 0.11750000000000001
r12985 n8127 n8128 0.047
r12986 n8099 n8129 0.01175
r12987 n8128 n8129 0.086166666666666669
r12988 n8100 n8130 0.039166666666666669
r12989 n8129 n8130 0.10183333333333335
r12990 n8101 n8131 0.019583333333333335
r12991 n8130 n8131 0.070500000000000007
r12992 n8102 n8132 0.058750000000000004
r12993 n8131 n8132 0.062666666666666662
r12994 n8103 n8133 0.11750000000000001
r12995 n8132 n8133 0.0235
r12996 n8104 n8134 0.11750000000000001
r12997 n8133 n8134 0.015666666666666666
r12998 n8105 n8135 0.019583333333333335
r12999 n8134 n8135 0.054833333333333331
r13000 n8106 n8136 0.0235
r13001 n8135 n8136 0.086166666666666669
r13002 n8107 n8137 0.11750000000000001
r13003 n8136 n8137 0.047
r13004 n8108 n8138 0.029375000000000002
r13005 n8137 n8138 0.039166666666666669
r13006 n8109 n8139 0.0235
r13007 n8138 n8139 0.070500000000000007
r13008 n8110 n8140 0.039166666666666669
r13009 n8139 n8140 0.062666666666666662
r13010 n8111 n8141 0.016785714285714286
r13011 n8140 n8141 0.078333333333333338
r13012 n8112 n8142 0.037599999999999995
r13013 n8113 n8143 0.037599999999999995
r13014 n8142 n8143 0.047
r13015 n8114 n8144 0.188
r13016 n8143 n8144 0.028199999999999999
r13017 n8115 n8145 0.062666666666666662
r13018 n8144 n8145 0.018799999999999997
r13019 n8116 n8146 0.188
r13020 n8145 n8146 0.018799999999999997
r13021 n8117 n8147 0.020888888888888887
r13022 n8146 n8147 0.047
r13023 n8118 n8148 0.018799999999999997
r13024 n8147 n8148 0.08929999999999999
r13025 n8119 n8149 0.037599999999999995
r13026 n8148 n8149 0.070499999999999993
r13027 n8120 n8150 0.037599999999999995
r13028 n8149 n8150 0.047
r13029 n8121 n8151 0.188
r13030 n8150 n8151 0.028199999999999999
r13031 n8122 n8152 0.094
r13032 n8151 n8152 0.0141
r13033 n8123 n8153 0.188
r13034 n8152 n8153 0.0141
r13035 n8124 n8154 0.188
r13036 n8153 n8154 0.0093999999999999986
r13037 n8125 n8155 0.188
r13038 n8154 n8155 0.0093999999999999986
r13039 n8126 n8156 0.047
r13040 n8155 n8156 0.0235
r13041 n8127 n8157 0.037599999999999995
r13042 n8156 n8157 0.042300000000000004
r13043 n8128 n8158 0.188
r13044 n8157 n8158 0.028199999999999999
r13045 n8129 n8159 0.018799999999999997
r13046 n8158 n8159 0.051699999999999996
r13047 n8130 n8160 0.062666666666666662
r13048 n8159 n8160 0.061100000000000002
r13049 n8131 n8161 0.031333333333333331
r13050 n8160 n8161 0.042300000000000004
r13051 n8132 n8162 0.094
r13052 n8161 n8162 0.037599999999999995
r13053 n8133 n8163 0.188
r13054 n8162 n8163 0.0141
r13055 n8134 n8164 0.188
r13056 n8163 n8164 0.0093999999999999986
r13057 n8135 n8165 0.031333333333333331
r13058 n8164 n8165 0.032899999999999999
r13059 n8136 n8166 0.037599999999999995
r13060 n8165 n8166 0.051699999999999996
r13061 n8137 n8167 0.188
r13062 n8166 n8167 0.028199999999999999
r13063 n8138 n8168 0.047
r13064 n8167 n8168 0.0235
r13065 n8139 n8169 0.037599999999999995
r13066 n8168 n8169 0.042300000000000004
r13067 n8140 n8170 0.062666666666666662
r13068 n8169 n8170 0.037599999999999995
r13069 n8141 n8171 0.026857142857142857
r13070 n8170 n8171 0.047
r13071 n8142 n8172 0.037599999999999995
r13072 n8143 n8173 0.037599999999999995
r13073 n8172 n8173 0.078333333333333338
r13074 n8144 n8174 0.188
r13075 n8173 n8174 0.047
r13076 n8145 n8175 0.062666666666666662
r13077 n8174 n8175 0.031333333333333331
r13078 n8146 n8176 0.188
r13079 n8175 n8176 0.031333333333333331
r13080 n8147 n8177 0.020888888888888887
r13081 n8176 n8177 0.078333333333333338
r13082 n8148 n8178 0.018799999999999997
r13083 n8177 n8178 0.14883333333333332
r13084 n8149 n8179 0.037599999999999995
r13085 n8178 n8179 0.11749999999999999
r13086 n8150 n8180 0.037599999999999995
r13087 n8179 n8180 0.078333333333333338
r13088 n8151 n8181 0.188
r13089 n8180 n8181 0.047
r13090 n8152 n8182 0.094
r13091 n8181 n8182 0.0235
r13092 n8153 n8183 0.188
r13093 n8182 n8183 0.0235
r13094 n8154 n8184 0.188
r13095 n8183 n8184 0.015666666666666666
r13096 n8155 n8185 0.188
r13097 n8184 n8185 0.015666666666666666
r13098 n8156 n8186 0.047
r13099 n8185 n8186 0.039166666666666669
r13100 n8157 n8187 0.037599999999999995
r13101 n8186 n8187 0.070500000000000007
r13102 n8158 n8188 0.188
r13103 n8187 n8188 0.047
r13104 n8159 n8189 0.018799999999999997
r13105 n8188 n8189 0.086166666666666669
r13106 n8160 n8190 0.062666666666666662
r13107 n8189 n8190 0.10183333333333335
r13108 n8161 n8191 0.031333333333333331
r13109 n8190 n8191 0.070500000000000007
r13110 n8162 n8192 0.094
r13111 n8191 n8192 0.062666666666666662
r13112 n8163 n8193 0.188
r13113 n8192 n8193 0.0235
r13114 n8164 n8194 0.188
r13115 n8193 n8194 0.015666666666666666
r13116 n8165 n8195 0.031333333333333331
r13117 n8194 n8195 0.054833333333333331
r13118 n8166 n8196 0.037599999999999995
r13119 n8195 n8196 0.086166666666666669
r13120 n8167 n8197 0.188
r13121 n8196 n8197 0.047
r13122 n8168 n8198 0.047
r13123 n8197 n8198 0.039166666666666669
r13124 n8169 n8199 0.037599999999999995
r13125 n8198 n8199 0.070500000000000007
r13126 n8170 n8200 0.062666666666666662
r13127 n8199 n8200 0.062666666666666662
r13128 n8171 n8201 0.026857142857142857
r13129 n8200 n8201 0.078333333333333338
r13130 n8172 n8202 0.0235
r13131 n8173 n8203 0.0235
r13132 n8202 n8203 0.11750000000000001
r13133 n8174 n8204 0.11750000000000001
r13134 n8203 n8204 0.070499999999999993
r13135 n8175 n8205 0.039166666666666669
r13136 n8204 n8205 0.047
r13137 n8176 n8206 0.11750000000000001
r13138 n8205 n8206 0.047
r13139 n8177 n8207 0.013055555555555556
r13140 n8206 n8207 0.11750000000000001
r13141 n8178 n8208 0.01175
r13142 n8207 n8208 0.22325
r13143 n8179 n8209 0.0235
r13144 n8208 n8209 0.17624999999999999
r13145 n8180 n8210 0.0235
r13146 n8209 n8210 0.11750000000000001
r13147 n8181 n8211 0.11750000000000001
r13148 n8210 n8211 0.070499999999999993
r13149 n8182 n8212 0.058750000000000004
r13150 n8211 n8212 0.035249999999999997
r13151 n8183 n8213 0.11750000000000001
r13152 n8212 n8213 0.035249999999999997
r13153 n8184 n8214 0.11750000000000001
r13154 n8213 n8214 0.0235
r13155 n8185 n8215 0.11750000000000001
r13156 n8214 n8215 0.0235
r13157 n8186 n8216 0.029375000000000002
r13158 n8215 n8216 0.058750000000000004
r13159 n8187 n8217 0.0235
r13160 n8216 n8217 0.10575000000000001
r13161 n8188 n8218 0.11750000000000001
r13162 n8217 n8218 0.070499999999999993
r13163 n8189 n8219 0.01175
r13164 n8218 n8219 0.12925
r13165 n8190 n8220 0.039166666666666669
r13166 n8219 n8220 0.15275
r13167 n8191 n8221 0.019583333333333335
r13168 n8220 n8221 0.10575000000000001
r13169 n8192 n8222 0.058750000000000004
r13170 n8221 n8222 0.094
r13171 n8193 n8223 0.11750000000000001
r13172 n8222 n8223 0.035249999999999997
r13173 n8194 n8224 0.11750000000000001
r13174 n8223 n8224 0.0235
r13175 n8195 n8225 0.019583333333333335
r13176 n8224 n8225 0.082250000000000004
r13177 n8196 n8226 0.0235
r13178 n8225 n8226 0.12925
r13179 n8197 n8227 0.11750000000000001
r13180 n8226 n8227 0.070499999999999993
r13181 n8198 n8228 0.029375000000000002
r13182 n8227 n8228 0.058750000000000004
r13183 n8199 n8229 0.0235
r13184 n8228 n8229 0.10575000000000001
r13185 n8200 n8230 0.039166666666666669
r13186 n8229 n8230 0.094
r13187 n8201 n8231 0.016785714285714286
r13188 n8230 n8231 0.11750000000000001
r13189 n8209 n8232 0.056399999999999999
r13190 n8210 n8233 0.056399999999999999
r13191 n8232 n8233 0.0235
r13192 n8211 n8234 0.28199999999999997
r13193 n8233 n8234 0.0141
r13194 n8212 n8235 0.14099999999999999
r13195 n8234 n8235 0.0070499999999999998
r13196 n8213 n8236 0.28199999999999997
r13197 n8235 n8236 0.0070499999999999998
r13198 n8214 n8237 0.28199999999999997
r13199 n8236 n8237 0.0046999999999999993
r13200 n8215 n8238 0.28199999999999997
r13201 n8237 n8238 0.0046999999999999993
r13202 n8216 n8239 0.070499999999999993
r13203 n8238 n8239 0.01175
r13204 n8217 n8240 0.056399999999999999
r13205 n8239 n8240 0.021150000000000002
r13206 n8218 n8241 0.28199999999999997
r13207 n8240 n8241 0.0141
r13208 n8219 n8242 0.028199999999999999
r13209 n8241 n8242 0.025849999999999998
r13210 n8220 n8243 0.094
r13211 n8242 n8243 0.030550000000000001
r13212 n8221 n8244 0.047
r13213 n8243 n8244 0.021150000000000002
r13214 n8222 n8245 0.14099999999999999
r13215 n8244 n8245 0.018799999999999997
r13216 n8223 n8246 0.28199999999999997
r13217 n8245 n8246 0.0070499999999999998
r13218 n8224 n8247 0.28199999999999997
r13219 n8246 n8247 0.0046999999999999993
r13220 n8225 n8248 0.047
r13221 n8247 n8248 0.016449999999999999
r13222 n8226 n8249 0.056399999999999999
r13223 n8248 n8249 0.025849999999999998
r13224 n8227 n8250 0.28199999999999997
r13225 n8249 n8250 0.0141
r13226 n8228 n8251 0.070499999999999993
r13227 n8250 n8251 0.01175
r13228 n8229 n8252 0.056399999999999999
r13229 n8251 n8252 0.021150000000000002
r13230 n8230 n8253 0.094
r13231 n8252 n8253 0.018799999999999997
r13232 n8231 n8254 0.040285714285714286
r13233 n8253 n8254 0.0235
r13234 n8234 n8255 0.49349999999999994
r13235 n8235 n8256 0.24674999999999997
r13236 n8255 n8256 0.0064090909090909086
r13237 n8236 n8257 0.49349999999999994
r13238 n8256 n8257 0.0064090909090909086
r13239 n8237 n8258 0.49349999999999994
r13240 n8257 n8258 0.0042727272727272727
r13241 n8238 n8259 0.49349999999999994
r13242 n8258 n8259 0.0042727272727272727
r13243 n8239 n8260 0.12337499999999998
r13244 n8259 n8260 0.010681818181818183
r13245 n8240 n8261 0.098699999999999996
r13246 n8260 n8261 0.019227272727272728
r13247 n8241 n8262 0.49349999999999994
r13248 n8261 n8262 0.012818181818181817
r13249 n8242 n8263 0.049349999999999998
r13250 n8262 n8263 0.0235
r13251 n8243 n8264 0.16449999999999998
r13252 n8263 n8264 0.027772727272727275
r13253 n8244 n8265 0.08224999999999999
r13254 n8264 n8265 0.019227272727272728
r13255 n8245 n8266 0.24674999999999997
r13256 n8265 n8266 0.017090909090909091
r13257 n8246 n8267 0.49349999999999994
r13258 n8266 n8267 0.0064090909090909086
r13259 n8247 n8268 0.49349999999999994
r13260 n8267 n8268 0.0042727272727272727
r13261 n8248 n8269 0.08224999999999999
r13262 n8268 n8269 0.014954545454545455
r13263 n8249 n8270 0.098699999999999996
r13264 n8269 n8270 0.0235
r13265 n8250 n8271 0.49349999999999994
r13266 n8270 n8271 0.012818181818181817
r13267 n8251 n8272 0.12337499999999998
r13268 n8271 n8272 0.010681818181818183
r13269 n8252 n8273 0.098699999999999996
r13270 n8272 n8273 0.019227272727272728
r13271 n8255 n8274 1.1984999999999999
r13272 n8256 n8275 0.59924999999999995
r13273 n8274 n8275 0.0017625
r13274 n8257 n8276 1.1984999999999999
r13275 n8275 n8276 0.0017625
r13276 n8258 n8277 1.1984999999999999
r13277 n8276 n8277 0.0011749999999999998
r13278 n8259 n8278 1.1984999999999999
r13279 n8277 n8278 0.0011749999999999998
r13280 n8260 n8279 0.29962499999999997
r13281 n8278 n8279 0.0029375
r13282 n8261 n8280 0.2397
r13283 n8279 n8280 0.0052875000000000005
r13284 n8262 n8281 1.1984999999999999
r13285 n8280 n8281 0.0035249999999999999
r13286 n8263 n8282 0.11985
r13287 n8281 n8282 0.0064624999999999995
r13288 n8264 n8283 0.39949999999999997
r13289 n8282 n8283 0.0076375000000000002
r13290 n8265 n8284 0.19974999999999998
r13291 n8283 n8284 0.0052875000000000005
r13292 n8266 n8285 0.59924999999999995
r13293 n8284 n8285 0.0046999999999999993
r13294 n8267 n8286 1.1984999999999999
r13295 n8285 n8286 0.0017625
r13296 n8268 n8287 1.1984999999999999
r13297 n8286 n8287 0.0011749999999999998
r13298 n8269 n8288 0.19974999999999998
r13299 n8287 n8288 0.0041124999999999998
r13300 n8270 n8289 0.2397
r13301 n8288 n8289 0.0064624999999999995
r13302 n8271 n8290 1.1984999999999999
r13303 n8289 n8290 0.0035249999999999999
r13304 n8272 n8291 0.29962499999999997
r13305 n8290 n8291 0.0029375
r13306 n8273 n8292 0.2397
r13307 n8291 n8292 0.0052875000000000005
r13308 n8274 n8293 1.8800000000000001
r13309 n8275 n8294 0.94000000000000006
r13310 n8293 n8294 0.0017625
r13311 n8276 n8295 1.8800000000000001
r13312 n8294 n8295 0.0017625
r13313 n8277 n8296 1.8800000000000001
r13314 n8295 n8296 0.0011749999999999998
r13315 n8278 n8297 1.8800000000000001
r13316 n8296 n8297 0.0011749999999999998
r13317 n8279 n8298 0.47000000000000003
r13318 n8297 n8298 0.0029375
r13319 n8280 n8299 0.376
r13320 n8298 n8299 0.0052875000000000005
r13321 n8281 n8300 1.8800000000000001
r13322 n8299 n8300 0.0035249999999999999
r13323 n8282 n8301 0.188
r13324 n8300 n8301 0.0064624999999999995
r13325 n8283 n8302 0.62666666666666671
r13326 n8301 n8302 0.0076375000000000002
r13327 n8284 n8303 0.31333333333333335
r13328 n8302 n8303 0.0052875000000000005
r13329 n8285 n8304 0.94000000000000006
r13330 n8303 n8304 0.0046999999999999993
r13331 n8286 n8305 1.8800000000000001
r13332 n8304 n8305 0.0017625
r13333 n8287 n8306 1.8800000000000001
r13334 n8305 n8306 0.0011749999999999998
r13335 n8288 n8307 0.31333333333333335
r13336 n8306 n8307 0.0041124999999999998
r13337 n8289 n8308 0.376
r13338 n8307 n8308 0.0064624999999999995
r13339 n8290 n8309 1.8800000000000001
r13340 n8308 n8309 0.0035249999999999999
r13341 n8291 n8310 0.47000000000000003
r13342 n8309 n8310 0.0029375
r13343 n8292 n8311 0.376
r13344 n8310 n8311 0.0052875000000000005
r13345 n8293 n8312 1.7390000000000001
r13346 n8294 n8313 0.86950000000000005
r13347 n8312 n8313 0.0020735294117647058
r13348 n8295 n8314 1.7390000000000001
r13349 n8313 n8314 0.0020735294117647058
r13350 n8296 n8315 1.7390000000000001
r13351 n8314 n8315 0.0013823529411764704
r13352 n8297 n8316 1.7390000000000001
r13353 n8315 n8316 0.0013823529411764704
r13354 n8298 n8317 0.43475000000000003
r13355 n8316 n8317 0.0034558823529411767
r13356 n8299 n8318 0.3478
r13357 n8317 n8318 0.0062205882352941184
r13358 n8300 n8319 1.7390000000000001
r13359 n8318 n8319 0.0041470588235294117
r13360 n8301 n8320 0.1739
r13361 n8319 n8320 0.0076029411764705884
r13362 n8302 n8321 0.57966666666666666
r13363 n8320 n8321 0.0089852941176470601
r13364 n8303 n8322 0.28983333333333333
r13365 n8321 n8322 0.0062205882352941184
r13366 n8304 n8323 0.86950000000000005
r13367 n8322 n8323 0.0055294117647058817
r13368 n8305 n8324 1.7390000000000001
r13369 n8323 n8324 0.0020735294117647058
r13370 n8306 n8325 1.7390000000000001
r13371 n8324 n8325 0.0013823529411764704
r13372 n8307 n8326 0.28983333333333333
r13373 n8325 n8326 0.0048382352941176475
r13374 n8308 n8327 0.3478
r13375 n8326 n8327 0.0076029411764705884
r13376 n8309 n8328 1.7390000000000001
r13377 n8327 n8328 0.0041470588235294117
r13378 n8310 n8329 0.43475000000000003
r13379 n8328 n8329 0.0034558823529411767
r13380 n8311 n8330 0.3478
r13381 n8329 n8330 0.0062205882352941184
r13382 n8312 n8331 1.8283
r13383 n8313 n8332 0.91415000000000002
r13384 n8331 n8332 0.0016095890410958904
r13385 n8314 n8333 1.8283
r13386 n8332 n8333 0.0016095890410958904
r13387 n8315 n8334 1.8283
r13388 n8333 n8334 0.0010730593607305935
r13389 n8316 n8335 1.8283
r13390 n8334 n8335 0.0010730593607305935
r13391 n8317 n8336 0.45707500000000001
r13392 n8335 n8336 0.0026826484018264841
r13393 n8318 n8337 0.36566000000000004
r13394 n8336 n8337 0.004828767123287672
r13395 n8319 n8338 1.8283
r13396 n8337 n8338 0.0032191780821917808
r13397 n8320 n8339 0.18283000000000002
r13398 n8338 n8339 0.0059018264840182645
r13399 n8321 n8340 0.60943333333333338
r13400 n8339 n8340 0.0069748858447488587
r13401 n8322 n8341 0.30471666666666669
r13402 n8340 n8341 0.004828767123287672
r13403 n8323 n8342 0.91415000000000002
r13404 n8341 n8342 0.0042922374429223741
r13405 n8324 n8343 1.8283
r13406 n8342 n8343 0.0016095890410958904
r13407 n8325 n8344 1.8283
r13408 n8343 n8344 0.0010730593607305935
r13409 n8326 n8345 0.30471666666666669
r13410 n8344 n8345 0.0037557077625570779
r13411 n8327 n8346 0.36566000000000004
r13412 n8345 n8346 0.0059018264840182645
r13413 n8328 n8347 1.8283
r13414 n8346 n8347 0.0032191780821917808
r13415 n8329 n8348 0.45707500000000001
r13416 n8347 n8348 0.0026826484018264841
r13417 n8330 n8349 0.36566000000000004
r13418 n8348 n8349 0.004828767123287672
r13419 n8331 n8350 2.0539000000000001
r13420 n8332 n8351 1.02695
r13421 n8350 n8351 0.0016169724770642201
r13422 n8333 n8352 2.0539000000000001
r13423 n8351 n8352 0.0016169724770642201
r13424 n8334 n8353 2.0539000000000001
r13425 n8352 n8353 0.0010779816513761468
r13426 n8335 n8354 2.0539000000000001
r13427 n8353 n8354 0.0010779816513761468
r13428 n8336 n8355 0.51347500000000001
r13429 n8354 n8355 0.0026949541284403671
r13430 n8337 n8356 0.41078000000000003
r13431 n8355 n8356 0.0048509174311926612
r13432 n8338 n8357 2.0539000000000001
r13433 n8356 n8357 0.0032339449541284402
r13434 n8339 n8358 0.20539000000000002
r13435 n8357 n8358 0.0059288990825688073
r13436 n8340 n8359 0.68463333333333343
r13437 n8358 n8359 0.0070068807339449543
r13438 n8341 n8360 0.34231666666666671
r13439 n8359 n8360 0.0048509174311926612
r13440 n8342 n8361 1.02695
r13441 n8360 n8361 0.0043119266055045872
r13442 n8343 n8362 2.0539000000000001
r13443 n8361 n8362 0.0016169724770642201
r13444 n8344 n8363 2.0539000000000001
r13445 n8362 n8363 0.0010779816513761468
r13446 n8345 n8364 0.34231666666666671
r13447 n8363 n8364 0.0037729357798165137
r13448 n8346 n8365 0.41078000000000003
r13449 n8364 n8365 0.0059288990825688073
r13450 n8347 n8366 2.0539000000000001
r13451 n8365 n8366 0.0032339449541284402
r13452 n8348 n8367 0.51347500000000001
r13453 n8366 n8367 0.0026949541284403671
r13454 n8349 n8368 0.41078000000000003
r13455 n8367 n8368 0.0048509174311926612
r13456 n8350 n8369 2.0539000000000001
r13457 n8351 n8370 1.02695
r13458 n8369 n8370 0.0016095890410958904
r13459 n8352 n8371 2.0539000000000001
r13460 n8370 n8371 0.0016095890410958904
r13461 n8353 n8372 2.0539000000000001
r13462 n8371 n8372 0.0010730593607305935
r13463 n8354 n8373 2.0539000000000001
r13464 n8372 n8373 0.0010730593607305935
r13465 n8355 n8374 0.51347500000000001
r13466 n8373 n8374 0.0026826484018264841
r13467 n8356 n8375 0.41078000000000003
r13468 n8374 n8375 0.004828767123287672
r13469 n8357 n8376 2.0539000000000001
r13470 n8375 n8376 0.0032191780821917808
r13471 n8358 n8377 0.20539000000000002
r13472 n8376 n8377 0.0059018264840182645
r13473 n8359 n8378 0.68463333333333343
r13474 n8377 n8378 0.0069748858447488587
r13475 n8360 n8379 0.34231666666666671
r13476 n8378 n8379 0.004828767123287672
r13477 n8361 n8380 1.02695
r13478 n8379 n8380 0.0042922374429223741
r13479 n8362 n8381 2.0539000000000001
r13480 n8380 n8381 0.0016095890410958904
r13481 n8363 n8382 2.0539000000000001
r13482 n8381 n8382 0.0010730593607305935
r13483 n8364 n8383 0.34231666666666671
r13484 n8382 n8383 0.0037557077625570779
r13485 n8365 n8384 0.41078000000000003
r13486 n8383 n8384 0.0059018264840182645
r13487 n8366 n8385 2.0539000000000001
r13488 n8384 n8385 0.0032191780821917808
r13489 n8367 n8386 0.51347500000000001
r13490 n8385 n8386 0.0026826484018264841
r13491 n8368 n8387 0.41078000000000003
r13492 n8386 n8387 0.004828767123287672
r13493 n8369 n8388 2.0585999999999998
r13494 n8370 n8389 1.0292999999999999
r13495 n8388 n8389 0.0016095890410958904
r13496 n8371 n8390 2.0585999999999998
r13497 n8389 n8390 0.0016095890410958904
r13498 n8372 n8391 2.0585999999999998
r13499 n8390 n8391 0.0010730593607305935
r13500 n8373 n8392 2.0585999999999998
r13501 n8391 n8392 0.0010730593607305935
r13502 n8374 n8393 0.51464999999999994
r13503 n8392 n8393 0.0026826484018264841
r13504 n8375 n8394 0.41171999999999997
r13505 n8393 n8394 0.004828767123287672
r13506 n8376 n8395 2.0585999999999998
r13507 n8394 n8395 0.0032191780821917808
r13508 n8377 n8396 0.20585999999999999
r13509 n8395 n8396 0.0059018264840182645
r13510 n8378 n8397 0.68619999999999992
r13511 n8396 n8397 0.0069748858447488587
r13512 n8379 n8398 0.34309999999999996
r13513 n8397 n8398 0.004828767123287672
r13514 n8380 n8399 1.0292999999999999
r13515 n8398 n8399 0.0042922374429223741
r13516 n8381 n8400 2.0585999999999998
r13517 n8399 n8400 0.0016095890410958904
r13518 n8382 n8401 2.0585999999999998
r13519 n8400 n8401 0.0010730593607305935
r13520 n8383 n8402 0.34309999999999996
r13521 n8401 n8402 0.0037557077625570779
r13522 n8384 n8403 0.41171999999999997
r13523 n8402 n8403 0.0059018264840182645
r13524 n8385 n8404 2.0585999999999998
r13525 n8403 n8404 0.0032191780821917808
r13526 n8386 n8405 0.51464999999999994
r13527 n8404 n8405 0.0026826484018264841
r13528 n8387 n8406 0.41171999999999997
r13529 n8405 n8406 0.004828767123287672
r13530 n8388 out 1.8893999999999997
r13531 n8389 out 0.94469999999999987
r13532 n8390 out 1.8893999999999997
r13533 n8391 out 1.8893999999999997
r13534 n8392 out 1.8893999999999997
r13535 n8393 out 0.47234999999999994
r13536 n8394 out 0.37787999999999999
r13537 n8395 out 1.8893999999999997
r13538 n8396 out 0.18894
r13539 n8397 out 0.62979999999999992
r13540 n8398 out 0.31489999999999996
r13541 n8399 out 0.94469999999999987
r13542 n8400 out 1.8893999999999997
r13543 n8401 out 1.8893999999999997
r13544 n8402 out 0.31489999999999996
r13545 n8403 out 0.37787999999999999
r13546 n8404 out 1.8893999999999997
r13547 n8405 out 0.47234999999999994
r13548 n8406 out 0.37787999999999999
r13549 n9 0 158.10000000000002
r13550 n10 0 10.540000000000001
r13551 n11 0 158.10000000000002
r13552 n193 n1873 2687.7000000000003
r13553 n194 n1874 179.18000000000004
r13554 n195 n1875 2687.7000000000003
r13555 n200 n1885 179.18000000000004
r13556 n201 n1886 11.945333333333334
r13557 n202 n1887 179.18000000000004
r13558 n207 n1897 2687.7000000000003
r13559 n208 n1898 179.18000000000004
r13560 n209 n1899 2687.7000000000003
r13561 n467 n2152 413.49230769230769
r13562 n468 n2153 537.53999999999996
r13563 n469 n2154 1075.0799999999999
r13564 n470 n2155 1075.0799999999999
r13565 n471 n2156 5375.4000000000005
r13566 n504 n2183 51.686538461538461
r13567 n505 n2184 67.192499999999995
r13568 n506 n2185 134.38499999999999
r13569 n507 n2186 134.38499999999999
r13570 n508 n2187 671.92500000000007
r13571 n541 n2214 59.070329670329677
r13572 n542 n2215 76.791428571428582
r13573 n543 n2216 153.58285714285716
r13574 n544 n2217 153.58285714285716
r13575 n545 n2218 767.91428571428582
r13576 n578 n2245 413.49230769230769
r13577 n579 n2246 537.53999999999996
r13578 n580 n2247 1075.0799999999999
r13579 n581 n2248 1075.0799999999999
r13580 n582 n2249 5375.4000000000005
r13581 n735 n2654 413.49230769230769
r13582 n736 n2655 537.53999999999996
r13583 n737 n2656 1075.0799999999999
r13584 n738 n2657 1075.0799999999999
r13585 n739 n2658 5375.4000000000005
r13586 n772 n2685 55.132307692307698
r13587 n773 n2686 71.672000000000011
r13588 n774 n2687 143.34400000000002
r13589 n775 n2688 143.34400000000002
r13590 n776 n2689 716.72000000000014
r13591 n809 n2716 55.132307692307698
r13592 n810 n2717 71.672000000000011
r13593 n811 n2718 143.34400000000002
r13594 n812 n2719 143.34400000000002
r13595 n813 n2720 716.72000000000014
r13596 n846 n2747 413.49230769230769
r13597 n847 n2748 537.53999999999996
r13598 n848 n2749 1075.0799999999999
r13599 n849 n2750 1075.0799999999999
r13600 n850 n2751 5375.4000000000005
r13601 n250 n1975 5375.4000000000005
r13602 n251 n1976 5375.4000000000005
r13603 n252 n1977 5375.4000000000005
r13604 n253 n1978 1343.8500000000001
r13605 n254 n1979 1075.0799999999999
r13606 n255 n1980 5375.4000000000005
r13607 n256 n1981 537.53999999999996
r13608 n257 n1982 1791.8000000000002
r13609 n258 n1983 895.90000000000009
r13610 n259 n1984 2687.7000000000003
r13611 n318 n1997 358.36000000000007
r13612 n319 n1998 358.36000000000007
r13613 n320 n1999 358.36000000000007
r13614 n321 n2000 89.590000000000018
r13615 n322 n2001 71.672000000000011
r13616 n323 n2002 358.36000000000007
r13617 n324 n2003 35.836000000000006
r13618 n325 n2004 119.45333333333335
r13619 n326 n2005 59.726666666666674
r13620 n327 n2006 179.18000000000004
r13621 n386 n2019 5375.4000000000005
r13622 n387 n2020 5375.4000000000005
r13623 n388 n2021 5375.4000000000005
r13624 n389 n2022 1343.8500000000001
r13625 n390 n2023 1075.0799999999999
r13626 n391 n2024 5375.4000000000005
r13627 n392 n2025 537.53999999999996
r13628 n393 n2026 1791.8000000000002
r13629 n394 n2027 895.90000000000009
r13630 n395 n2028 2687.7000000000003
r13631 n482 n2167 5375.4000000000005
r13632 n483 n2168 1343.8500000000001
r13633 n484 n2169 1075.0799999999999
r13634 n485 n2170 5375.4000000000005
r13635 n486 n2171 537.53999999999996
r13636 n487 n2172 1791.8000000000002
r13637 n488 n2173 895.90000000000009
r13638 n489 n2174 2687.7000000000003
r13639 n490 n2175 5375.4000000000005
r13640 n491 n2176 5375.4000000000005
r13641 n519 n2198 671.92500000000007
r13642 n520 n2199 167.98125000000002
r13643 n521 n2200 134.38499999999999
r13644 n522 n2201 671.92500000000007
r13645 n523 n2202 67.192499999999995
r13646 n524 n2203 223.97500000000002
r13647 n525 n2204 111.98750000000001
r13648 n526 n2205 335.96250000000003
r13649 n527 n2206 671.92500000000007
r13650 n528 n2207 671.92500000000007
r13651 n556 n2229 767.91428571428582
r13652 n557 n2230 191.97857142857146
r13653 n558 n2231 153.58285714285716
r13654 n559 n2232 767.91428571428582
r13655 n560 n2233 76.791428571428582
r13656 n561 n2234 255.97142857142859
r13657 n562 n2235 127.98571428571429
r13658 n563 n2236 383.95714285714291
r13659 n564 n2237 767.91428571428582
r13660 n565 n2238 767.91428571428582
r13661 n593 n2260 5375.4000000000005
r13662 n594 n2261 1343.8500000000001
r13663 n595 n2262 1075.0799999999999
r13664 n596 n2263 5375.4000000000005
r13665 n597 n2264 537.53999999999996
r13666 n598 n2265 1791.8000000000002
r13667 n599 n2266 895.90000000000009
r13668 n600 n2267 2687.7000000000003
r13669 n601 n2268 5375.4000000000005
r13670 n602 n2269 5375.4000000000005
r13671 n750 n2669 5375.4000000000005
r13672 n751 n2670 1343.8500000000001
r13673 n752 n2671 1075.0799999999999
r13674 n753 n2672 5375.4000000000005
r13675 n754 n2673 537.53999999999996
r13676 n755 n2674 1791.8000000000002
r13677 n756 n2675 895.90000000000009
r13678 n757 n2676 2687.7000000000003
r13679 n758 n2677 5375.4000000000005
r13680 n759 n2678 5375.4000000000005
r13681 n787 n2700 716.72000000000014
r13682 n788 n2701 179.18000000000004
r13683 n789 n2702 143.34400000000002
r13684 n790 n2703 716.72000000000014
r13685 n791 n2704 71.672000000000011
r13686 n792 n2705 238.90666666666669
r13687 n793 n2706 119.45333333333335
r13688 n794 n2707 358.36000000000007
r13689 n795 n2708 716.72000000000014
r13690 n796 n2709 716.72000000000014
r13691 n824 n2731 716.72000000000014
r13692 n825 n2732 179.18000000000004
r13693 n826 n2733 143.34400000000002
r13694 n827 n2734 716.72000000000014
r13695 n828 n2735 71.672000000000011
r13696 n829 n2736 238.90666666666669
r13697 n830 n2737 119.45333333333335
r13698 n831 n2738 358.36000000000007
r13699 n832 n2739 716.72000000000014
r13700 n833 n2740 716.72000000000014
r13701 n861 n2762 5375.4000000000005
r13702 n862 n2763 1343.8500000000001
r13703 n863 n2764 1075.0799999999999
r13704 n864 n2765 5375.4000000000005
r13705 n865 n2766 537.53999999999996
r13706 n866 n2767 1791.8000000000002
r13707 n867 n2768 895.90000000000009
r13708 n868 n2769 2687.7000000000003
r13709 n869 n2770 5375.4000000000005
r13710 n870 n2771 5375.4000000000005
r13711 n663 n2469 2687.7000000000003
r13712 n664 n2470 316.20000000000005
r13713 n665 n2471 413.49230769230769
r13714 n666 n2472 2687.7000000000003
r13715 n671 n2482 191.97857142857146
r13716 n672 n2483 22.585714285714289
r13717 n673 n2484 29.535164835164839
r13718 n674 n2485 191.97857142857146
r13719 n679 n2495 2687.7000000000003
r13720 n680 n2496 316.20000000000005
r13721 n681 n2497 413.49230769230769
r13722 n682 n2498 2687.7000000000003
r13723 n687 n2508 2687.7000000000003
r13724 n688 n2509 316.20000000000005
r13725 n689 n2510 413.49230769230769
r13726 n690 n2511 2687.7000000000003
r13727 n1070 n2867 2687.7000000000003
r13728 n1071 n2868 179.18000000000004
r13729 n1072 n2869 2687.7000000000003
r13730 n1217 n2872 179.18000000000004
r13731 n1218 n2873 11.945333333333334
r13732 n1219 n2874 179.18000000000004
r13733 n1364 n2877 2687.7000000000003
r13734 n1365 n2878 179.18000000000004
r13735 n1366 n2879 2687.7000000000003
r13736 n1886 n3679 4.5
r13737 n2190 n4616 28.125
r13738 n2191 n4617 25.3125
r13739 n2192 n4618 50.625
r13740 n2193 n4619 50.625
r13741 n2194 n4620 253.125
r13742 n2221 n4675 32.142857142857139
r13743 n2222 n4676 28.928571428571427
r13744 n2223 n4677 57.857142857142854
r13745 n2224 n4678 57.857142857142854
r13746 n2225 n4679 289.28571428571428
r13747 n2692 n5471 30
r13748 n2693 n5472 27
r13749 n2694 n5473 54
r13750 n2695 n5474 54
r13751 n2696 n5475 270
r13752 n2723 n5502 30
r13753 n2724 n5503 27
r13754 n2725 n5504 54
r13755 n2726 n5505 54
r13756 n2727 n5506 270
r13757 n1999 n4094 135
r13758 n2000 n4095 33.75
r13759 n2001 n4096 27
r13760 n2002 n4097 135
r13761 n2003 n4098 13.5
r13762 n2004 n4099 45
r13763 n2005 n4100 22.5
r13764 t_r1_a n6776 135
r13765 t_r1_a n6777 13.5
r13766 t_r1_a n6778 45
r13767 t_r1_a n6779 22.5
r13768 t_r1_a n6780 67.5
r13769 t_r1_a n6781 135
r13770 t_r1_a n6782 135
r13771 t_r1_a n6783 22.5
r13772 n2483 n5132 8.5084033613445378
r13773 n2484 n5133 11.126373626373626
r13774 n2496 n5176 119.11764705882352
r13775 n2497 n5177 155.76923076923077
r13776 n2873 n6171 4.5
r13777 t_r1_b n6792 8.4375
r13778 t_r1_b n6793 9.6428571428571423
r13779 n1891 n3704 135
r13780 n1892 n3705 4.8214285714285712
r13781 n1893 n3706 135
r13782 n5406 n7362 1818.6666666666667
r13783 n5407 n7363 606.22222222222229
r13784 n5408 n7364 1818.6666666666667
r13785 n5409 n7365 202.07407407407408
r13786 n5410 n7366 181.86666666666667
r13787 n5411 n7367 363.73333333333335
r13788 n5412 n7368 363.73333333333335
r13789 n5413 n7369 1818.6666666666667
r13790 n5414 n7370 909.33333333333337
r13791 n5415 n7371 1818.6666666666667
r13792 n5416 n7372 1818.6666666666667
r13793 n5417 n7373 1818.6666666666667
r13794 n5437 n7381 2728
r13795 n5438 n7382 909.33333333333337
r13796 n5439 n7383 2728
r13797 n5440 n7384 303.11111111111114
r13798 n5441 n7385 272.80000000000001
r13799 n5442 n7386 545.60000000000002
r13800 n5443 n7387 545.60000000000002
r13801 n5444 n7388 2728
r13802 n5445 n7389 1364
r13803 n5446 n7390 2728
r13804 n5447 n7391 2728
r13805 n5448 n7392 2728
r13806 n5468 n7400 363.73333333333335
r13807 n5469 n7401 121.24444444444444
r13808 n5470 n7402 363.73333333333335
r13809 n5471 n7403 40.414814814814811
r13810 n5472 n7404 36.373333333333335
r13811 n5473 n7405 72.74666666666667
r13812 n5474 n7406 72.74666666666667
r13813 n5475 n7407 363.73333333333335
r13814 n5476 n7408 181.86666666666667
r13815 n5477 n7409 363.73333333333335
r13816 n5478 n7410 363.73333333333335
r13817 n5479 n7411 363.73333333333335
r13818 n5499 n7419 363.73333333333335
r13819 n5500 n7420 121.24444444444444
r13820 n5501 n7421 363.73333333333335
r13821 n5502 n7422 40.414814814814811
r13822 n5503 n7423 36.373333333333335
r13823 n5504 n7424 72.74666666666667
r13824 n5505 n7425 72.74666666666667
r13825 n5506 n7426 363.73333333333335
r13826 n5507 n7427 181.86666666666667
r13827 n5508 n7428 363.73333333333335
r13828 n5509 n7429 363.73333333333335
r13829 n5510 n7430 363.73333333333335
r13830 n5530 n7438 2728
r13831 n5531 n7439 909.33333333333337
r13832 n5532 n7440 2728
r13833 n5533 n7441 303.11111111111114
r13834 n5534 n7442 272.80000000000001
r13835 n5535 n7443 545.60000000000002
r13836 n5536 n7444 545.60000000000002
r13837 n5537 n7445 2728
r13838 n5538 n7446 1364
r13839 n5539 n7447 2728
r13840 n5540 n7448 2728
r13841 n5541 n7449 2728
r13842 n5561 n7457 1818.6666666666667
r13843 n5562 n7458 606.22222222222229
r13844 n5563 n7459 1818.6666666666667
r13845 n5564 n7460 202.07407407407408
r13846 n5565 n7461 181.86666666666667
r13847 n5566 n7462 363.73333333333335
r13848 n5567 n7463 363.73333333333335
r13849 n5568 n7464 1818.6666666666667
r13850 n5569 n7465 909.33333333333337
r13851 n5570 n7466 1818.6666666666667
r13852 n5571 n7467 1818.6666666666667
r13853 n5572 n7468 1818.6666666666667
r13854 n6665 n8007 363.73333333333335
r13855 n6666 n8008 1818.6666666666667
r13856 n6667 n8009 181.86666666666667
r13857 n6668 n8010 606.22222222222229
r13858 n6669 n8011 303.11111111111114
r13859 n6670 n8012 909.33333333333337
r13860 n6671 n8013 1818.6666666666667
r13861 n6672 n8014 1818.6666666666667
r13862 n6673 n8015 303.11111111111114
r13863 n6674 n8016 363.73333333333335
r13864 n6720 n8037 545.60000000000002
r13865 n6721 n8038 2728
r13866 n6722 n8039 272.80000000000001
r13867 n6723 n8040 909.33333333333337
r13868 n6724 n8041 454.66666666666669
r13869 n6725 n8042 1364
r13870 n6726 n8043 2728
r13871 n6727 n8044 2728
r13872 n6728 n8045 454.66666666666669
r13873 n6729 n8046 545.60000000000002
r13874 n6775 n8067 36.373333333333335
r13875 n6776 n8068 181.86666666666667
r13876 n6777 n8069 18.186666666666667
r13877 n6778 n8070 60.62222222222222
r13878 n6779 n8071 30.31111111111111
r13879 n6780 n8072 90.933333333333337
r13880 n6781 n8073 181.86666666666667
r13881 n6782 n8074 181.86666666666667
r13882 n6783 n8075 30.31111111111111
r13883 n6784 n8076 36.373333333333335
r13884 n6830 n8097 545.60000000000002
r13885 n6831 n8098 2728
r13886 n6832 n8099 272.80000000000001
r13887 n6833 n8100 909.33333333333337
r13888 n6834 n8101 454.66666666666669
r13889 n6835 n8102 1364
r13890 n6836 n8103 2728
r13891 n6837 n8104 2728
r13892 n6838 n8105 454.66666666666669
r13893 n6839 n8106 545.60000000000002
r13894 n6885 n8127 363.73333333333335
r13895 n6886 n8128 1818.6666666666667
r13896 n6887 n8129 181.86666666666667
r13897 n6888 n8130 606.22222222222229
r13898 n6889 n8131 303.11111111111114
r13899 n6890 n8132 909.33333333333337
r13900 n6891 n8133 1818.6666666666667
r13901 n6892 n8134 1818.6666666666667
r13902 n6893 n8135 303.11111111111114
r13903 n6894 n8136 363.73333333333335
r13904 n442 t_m1_b 585
r13905 n536 t_m1_b 1420.7142857142858
r13906 n573 t_m1_b 9945
r13907 n610 t_m1_b 4972.5
r13908 n614 t_m1_b 9945
r13909 n622 t_m1_b 19890
r13910 n630 t_m1_b 4972.5
r13911 n638 t_m1_b 9945
r13912 n646 t_m1_b 3978
r13913 n702 t_m1_b 4972.5
r13914 n710 t_m1_b 2841.4285714285716
r13915 n718 t_m1_b 6630
r13916 n726 t_m1_b 6630
r13917 n730 t_m1_b 9945
r13918 n767 t_m1_b 1326
r13919 n894 t_m1_b 9945
r13920 n898 t_m1_b 621.5625
r13921 n230 t_m1_b 10246.363636363636
r13922 n231 t_m1_b 338130
r13923 n298 t_m1_b 683.09090909090912
r13924 n299 t_m1_b 22542
r13925 n366 t_m1_b 10246.363636363636
r13926 n367 t_m1_b 338130
r13927 n910 t_m1_b 602.72727272727275
r13928 n911 t_m1_b 19890
r13929 n236 t_m1_b 338130
r13930 n237 t_m1_b 26010
r13931 n238 t_m1_b 33813
r13932 n239 t_m1_b 67626
r13933 n240 t_m1_b 67626
r13934 n304 t_m1_b 22542
r13935 n305 t_m1_b 1734
r13936 n306 t_m1_b 2254.2000000000003
r13937 n307 t_m1_b 4508.4000000000005
r13938 n308 t_m1_b 4508.4000000000005
r13939 n372 t_m1_b 338130
r13940 n373 t_m1_b 26010
r13941 n374 t_m1_b 33813
r13942 n375 t_m1_b 67626
r13943 n376 t_m1_b 67626
r13944 n916 t_m1_b 19890
r13945 n917 t_m1_b 1530
r13946 n918 t_m1_b 1989
r13947 n919 t_m1_b 3978
r13948 n920 t_m1_b 3978
r13949 n467 t_m1_s 8225.3846153846152
r13950 n468 t_m1_s 10693
r13951 n469 t_m1_s 21386
r13952 n470 t_m1_s 21386
r13953 n471 t_m1_s 106930
r13954 n504 t_m1_s 1028.1730769230769
r13955 n505 t_m1_s 1336.625
r13956 n506 t_m1_s 2673.25
r13957 n507 t_m1_s 2673.25
r13958 n508 t_m1_s 13366.25
r13959 n541 t_m1_s 1175.0549450549452
r13960 n542 t_m1_s 1527.5714285714287
r13961 n543 t_m1_s 3055.1428571428573
r13962 n544 t_m1_s 3055.1428571428573
r13963 n545 t_m1_s 15275.714285714286
r13964 n578 t_m1_s 8225.3846153846152
r13965 n579 t_m1_s 10693
r13966 n580 t_m1_s 21386
r13967 n581 t_m1_s 21386
r13968 n582 t_m1_s 106930
r13969 n735 t_m1_d 8225.3846153846152
r13970 n736 t_m1_d 10693
r13971 n737 t_m1_d 21386
r13972 n738 t_m1_d 21386
r13973 n739 t_m1_d 106930
r13974 n772 t_m1_d 1096.7179487179487
r13975 n773 t_m1_d 1425.7333333333333
r13976 n774 t_m1_d 2851.4666666666667
r13977 n775 t_m1_d 2851.4666666666667
r13978 n776 t_m1_d 14257.333333333334
r13979 n809 t_m1_d 1096.7179487179487
r13980 n810 t_m1_d 1425.7333333333333
r13981 n811 t_m1_d 2851.4666666666667
r13982 n812 t_m1_d 2851.4666666666667
r13983 n813 t_m1_d 14257.333333333334
r13984 n846 t_m1_d 8225.3846153846152
r13985 n847 t_m1_d 10693
r13986 n848 t_m1_d 21386
r13987 n849 t_m1_d 21386
r13988 n850 t_m1_d 106930
r13989 n251 t_m1_b 338130
r13990 n252 t_m1_b 338130
r13991 n253 t_m1_b 84532.5
r13992 n254 t_m1_b 67626
r13993 n255 t_m1_b 338130
r13994 n256 t_m1_b 33813
r13995 n257 t_m1_b 112710
r13996 n258 t_m1_b 56355
r13997 n259 t_m1_b 169065
r13998 n260 t_m1_b 338130
r13999 n319 t_m1_b 22542
r14000 n320 t_m1_b 22542
r14001 n321 t_m1_b 5635.5
r14002 n322 t_m1_b 4508.4000000000005
r14003 n323 t_m1_b 22542
r14004 n324 t_m1_b 2254.2000000000003
r14005 n325 t_m1_b 7514
r14006 n326 t_m1_b 3757
r14007 n327 t_m1_b 11271
r14008 n328 t_m1_b 22542
r14009 n387 t_m1_b 338130
r14010 n388 t_m1_b 338130
r14011 n389 t_m1_b 84532.5
r14012 n390 t_m1_b 67626
r14013 n391 t_m1_b 338130
r14014 n392 t_m1_b 33813
r14015 n393 t_m1_b 112710
r14016 n394 t_m1_b 56355
r14017 n395 t_m1_b 169065
r14018 n396 t_m1_b 338130
r14019 n931 t_m1_b 19890
r14020 n932 t_m1_b 19890
r14021 n933 t_m1_b 4972.5
r14022 n934 t_m1_b 3978
r14023 n935 t_m1_b 19890
r14024 n936 t_m1_b 1989
r14025 n937 t_m1_b 6630
r14026 n938 t_m1_b 3315
r14027 n939 t_m1_b 9945
r14028 n940 t_m1_b 19890
r14029 n482 t_m1_s 106930
r14030 n483 t_m1_s 26732.5
r14031 n484 t_m1_s 21386
r14032 n485 t_m1_s 106930
r14033 n486 t_m1_s 10693
r14034 n487 t_m1_s 35643.333333333336
r14035 n488 t_m1_s 17821.666666666668
r14036 n489 t_m1_s 53465
r14037 n490 t_m1_s 106930
r14038 n491 t_m1_s 106930
r14039 n519 t_m1_s 13366.25
r14040 n520 t_m1_s 3341.5625
r14041 n521 t_m1_s 2673.25
r14042 n522 t_m1_s 13366.25
r14043 n523 t_m1_s 1336.625
r14044 n524 t_m1_s 4455.416666666667
r14045 n525 t_m1_s 2227.7083333333335
r14046 n526 t_m1_s 6683.125
r14047 n527 t_m1_s 13366.25
r14048 n528 t_m1_s 13366.25
r14049 n556 t_m1_s 15275.714285714286
r14050 n557 t_m1_s 3818.9285714285716
r14051 n558 t_m1_s 3055.1428571428573
r14052 n559 t_m1_s 15275.714285714286
r14053 n560 t_m1_s 1527.5714285714287
r14054 n561 t_m1_s 5091.9047619047615
r14055 n562 t_m1_s 2545.9523809523807
r14056 n563 t_m1_s 7637.8571428571431
r14057 n564 t_m1_s 15275.714285714286
r14058 n565 t_m1_s 15275.714285714286
r14059 n593 t_m1_s 106930
r14060 n594 t_m1_s 26732.5
r14061 n595 t_m1_s 21386
r14062 n596 t_m1_s 106930
r14063 n597 t_m1_s 10693
r14064 n598 t_m1_s 35643.333333333336
r14065 n599 t_m1_s 17821.666666666668
r14066 n600 t_m1_s 53465
r14067 n601 t_m1_s 106930
r14068 n602 t_m1_s 106930
r14069 n750 t_m1_d 106930
r14070 n751 t_m1_d 26732.5
r14071 n752 t_m1_d 21386
r14072 n753 t_m1_d 106930
r14073 n754 t_m1_d 10693
r14074 n755 t_m1_d 35643.333333333336
r14075 n756 t_m1_d 17821.666666666668
r14076 n757 t_m1_d 53465
r14077 n758 t_m1_d 106930
r14078 n759 t_m1_d 106930
r14079 n787 t_m1_d 14257.333333333334
r14080 n788 t_m1_d 3564.3333333333335
r14081 n789 t_m1_d 2851.4666666666667
r14082 n790 t_m1_d 14257.333333333334
r14083 n791 t_m1_d 1425.7333333333333
r14084 n792 t_m1_d 4752.4444444444443
r14085 n793 t_m1_d 2376.2222222222222
r14086 n794 t_m1_d 7128.666666666667
r14087 n795 t_m1_d 14257.333333333334
r14088 n796 t_m1_d 14257.333333333334
r14089 n824 t_m1_d 14257.333333333334
r14090 n825 t_m1_d 3564.3333333333335
r14091 n826 t_m1_d 2851.4666666666667
r14092 n827 t_m1_d 14257.333333333334
r14093 n828 t_m1_d 1425.7333333333333
r14094 n829 t_m1_d 4752.4444444444443
r14095 n830 t_m1_d 2376.2222222222222
r14096 n831 t_m1_d 7128.666666666667
r14097 n832 t_m1_d 14257.333333333334
r14098 n833 t_m1_d 14257.333333333334
r14099 n861 t_m1_d 106930
r14100 n862 t_m1_d 26732.5
r14101 n863 t_m1_d 21386
r14102 n864 t_m1_d 106930
r14103 n865 t_m1_d 10693
r14104 n866 t_m1_d 35643.333333333336
r14105 n867 t_m1_d 17821.666666666668
r14106 n868 t_m1_d 53465
r14107 n869 t_m1_d 106930
r14108 n870 t_m1_d 106930
r14109 n270 t_m1_b 33813
r14110 n271 t_m1_b 84532.5
r14111 n272 t_m1_b 48304.285714285717
r14112 n273 t_m1_b 37570
r14113 n274 t_m1_b 84532.5
r14114 n338 t_m1_b 2254.2000000000003
r14115 n339 t_m1_b 5635.5
r14116 n340 t_m1_b 3220.2857142857142
r14117 n341 t_m1_b 2504.6666666666665
r14118 n342 t_m1_b 5635.5
r14119 n406 t_m1_b 33813
r14120 n407 t_m1_b 84532.5
r14121 n408 t_m1_b 48304.285714285717
r14122 n409 t_m1_b 37570
r14123 n410 t_m1_b 84532.5
r14124 n950 t_m1_b 1989
r14125 n951 t_m1_b 4972.5
r14126 n952 t_m1_b 2841.4285714285716
r14127 n953 t_m1_b 2210
r14128 n954 t_m1_b 4972.5
r14129 n663 t_m1_g 43928
r14130 n664 t_m1_g 5168
r14131 n665 t_m1_g 6758.1538461538457
r14132 n666 t_m1_g 43928
r14133 n671 t_m1_g 3137.7142857142858
r14134 n672 t_m1_g 369.14285714285717
r14135 n673 t_m1_g 482.72527472527474
r14136 n674 t_m1_g 3137.7142857142858
r14137 n679 t_m1_g 43928
r14138 n680 t_m1_g 5168
r14139 n681 t_m1_g 6758.1538461538457
r14140 n682 t_m1_g 43928
r14141 n687 t_m1_g 43928
r14142 n688 t_m1_g 5168
r14143 n689 t_m1_g 6758.1538461538457
r14144 n690 t_m1_g 43928
r14145 n280 t_m1_b 26010
r14146 n281 t_m1_b 169065
r14147 n282 t_m1_b 169065
r14148 n283 t_m1_b 84532.5
r14149 n284 t_m1_b 67626
r14150 n285 t_m1_b 42266.25
r14151 n348 t_m1_b 1734
r14152 n349 t_m1_b 11271
r14153 n350 t_m1_b 11271
r14154 n351 t_m1_b 5635.5
r14155 n352 t_m1_b 4508.4000000000005
r14156 n353 t_m1_b 2817.75
r14157 n416 t_m1_b 26010
r14158 n417 t_m1_b 169065
r14159 n418 t_m1_b 169065
r14160 n419 t_m1_b 84532.5
r14161 n420 t_m1_b 67626
r14162 n421 t_m1_b 42266.25
r14163 n960 t_m1_b 1530
r14164 n961 t_m1_b 9945
r14165 n962 t_m1_b 9945
r14166 n963 t_m1_b 4972.5
r14167 n964 t_m1_b 3978
r14168 n965 t_m1_b 2486.25
r14169 n443 t_m1_b 3978
r14170 n444 t_m1_b 736.66666666666674
r14171 n445 t_m1_b 9945
r14172 n570 t_m1_b 9660.8571428571431
r14173 n571 t_m1_b 1789.047619047619
r14174 n572 t_m1_b 24152.142857142859
r14175 n607 t_m1_b 67626
r14176 n608 t_m1_b 12523.333333333334
r14177 n609 t_m1_b 169065
r14178 n611 t_m1_b 33813
r14179 n612 t_m1_b 6261.666666666667
r14180 n613 t_m1_b 84532.5
r14181 n619 t_m1_b 67626
r14182 n620 t_m1_b 12523.333333333334
r14183 n621 t_m1_b 169065
r14184 n627 t_m1_b 135252
r14185 n628 t_m1_b 25046.666666666668
r14186 n629 t_m1_b 338130
r14187 n635 t_m1_b 33813
r14188 n636 t_m1_b 6261.666666666667
r14189 n637 t_m1_b 84532.5
r14190 n643 t_m1_b 67626
r14191 n644 t_m1_b 12523.333333333334
r14192 n645 t_m1_b 169065
r14193 n651 t_m1_b 27050.400000000001
r14194 n652 t_m1_b 5009.333333333333
r14195 n653 t_m1_b 67626
r14196 n707 t_m1_b 33813
r14197 n708 t_m1_b 6261.666666666667
r14198 n709 t_m1_b 84532.5
r14199 n715 t_m1_b 19321.714285714286
r14200 n716 t_m1_b 3578.0952380952381
r14201 n717 t_m1_b 48304.285714285717
r14202 n723 t_m1_b 45084
r14203 n724 t_m1_b 8348.8888888888887
r14204 n725 t_m1_b 112710
r14205 n727 t_m1_b 45084
r14206 n728 t_m1_b 8348.8888888888887
r14207 n729 t_m1_b 112710
r14208 n764 t_m1_b 67626
r14209 n765 t_m1_b 12523.333333333334
r14210 n766 t_m1_b 169065
r14211 n801 t_m1_b 9016.8000000000011
r14212 n802 t_m1_b 1669.7777777777778
r14213 n803 t_m1_b 22542
r14214 n895 t_m1_b 67626
r14215 n896 t_m1_b 12523.333333333334
r14216 n897 t_m1_b 169065
r14217 n899 t_m1_b 4226.625
r14218 n900 t_m1_b 782.70833333333337
r14219 n901 t_m1_b 10566.5625
r14220 n1427 t_r1_w 1808.181818181818
r14221 n1430 t_r1_w 1989
r14222 n1433 t_r1_w 9945
r14223 n1436 t_r1_w 6630
r14224 n1439 t_r1_w 3978
r14225 n1442 t_r1_w 6630
r14226 n1454 t_r1_w 6630
r14227 n1457 t_r1_w 3978
r14228 n1460 t_r1_w 6630
r14229 n1463 t_r1_w 9945
r14230 n1466 t_r1_w 1989
r14231 n1469 t_r1_w 1808.181818181818
r14232 n980 t_r1_w 338130
r14233 n981 t_r1_w 10246.363636363636
r14234 n1127 t_r1_w 22542
r14235 n1128 t_r1_w 683.09090909090912
r14236 n1274 t_r1_w 338130
r14237 n1275 t_r1_w 10246.363636363636
r14238 n1484 t_r1_w 19890
r14239 n1485 t_r1_w 602.72727272727275
r14240 n986 t_r1_w 67626
r14241 n987 t_r1_w 338130
r14242 n988 t_r1_w 26010
r14243 n989 t_r1_w 33813
r14244 n990 t_r1_w 67626
r14245 n1133 t_r1_w 4508.4000000000005
r14246 n1134 t_r1_w 22542
r14247 n1135 t_r1_w 1734
r14248 n1136 t_r1_w 2254.2000000000003
r14249 n1137 t_r1_w 4508.4000000000005
r14250 n1280 t_r1_w 67626
r14251 n1281 t_r1_w 338130
r14252 n1282 t_r1_w 26010
r14253 n1283 t_r1_w 33813
r14254 n1284 t_r1_w 67626
r14255 n1490 t_r1_w 3978
r14256 n1491 t_r1_w 19890
r14257 n1492 t_r1_w 1530
r14258 n1493 t_r1_w 1989
r14259 n1494 t_r1_w 3978
r14260 n998 t_r1_w 67626
r14261 n999 t_r1_w 338130
r14262 n1000 t_r1_w 169065
r14263 n1001 t_r1_w 338130
r14264 n1002 t_r1_w 338130
r14265 n1003 t_r1_w 338130
r14266 n1004 t_r1_w 84532.5
r14267 n1005 t_r1_w 67626
r14268 n1006 t_r1_w 338130
r14269 n1007 t_r1_w 33813
r14270 n1008 t_r1_w 112710
r14271 n1145 t_r1_w 4508.4000000000005
r14272 n1146 t_r1_w 22542
r14273 n1147 t_r1_w 11271
r14274 n1148 t_r1_w 22542
r14275 n1149 t_r1_w 22542
r14276 n1150 t_r1_w 22542
r14277 n1151 t_r1_w 5635.5
r14278 n1152 t_r1_w 4508.4000000000005
r14279 n1153 t_r1_w 22542
r14280 n1154 t_r1_w 2254.2000000000003
r14281 n1155 t_r1_w 7514
r14282 n1292 t_r1_w 67626
r14283 n1293 t_r1_w 338130
r14284 n1294 t_r1_w 169065
r14285 n1295 t_r1_w 338130
r14286 n1296 t_r1_w 338130
r14287 n1297 t_r1_w 338130
r14288 n1298 t_r1_w 84532.5
r14289 n1299 t_r1_w 67626
r14290 n1300 t_r1_w 338130
r14291 n1301 t_r1_w 33813
r14292 n1302 t_r1_w 112710
r14293 n1502 t_r1_w 3978
r14294 n1503 t_r1_w 19890
r14295 n1504 t_r1_w 9945
r14296 n1505 t_r1_w 19890
r14297 n1506 t_r1_w 19890
r14298 n1507 t_r1_w 19890
r14299 n1508 t_r1_w 4972.5
r14300 n1509 t_r1_w 3978
r14301 n1510 t_r1_w 19890
r14302 n1511 t_r1_w 1989
r14303 n1512 t_r1_w 6630
r14304 n1019 t_r1_w 48304.285714285717
r14305 n1020 t_r1_w 56355
r14306 n1021 t_r1_w 33813
r14307 n1022 t_r1_w 84532.5
r14308 n1023 t_r1_w 48304.285714285717
r14309 n1166 t_r1_w 3220.2857142857142
r14310 n1167 t_r1_w 3757
r14311 n1168 t_r1_w 2254.2000000000003
r14312 n1169 t_r1_w 5635.5
r14313 n1170 t_r1_w 3220.2857142857142
r14314 n1313 t_r1_w 48304.285714285717
r14315 n1314 t_r1_w 56355
r14316 n1315 t_r1_w 33813
r14317 n1316 t_r1_w 84532.5
r14318 n1317 t_r1_w 48304.285714285717
r14319 n1523 t_r1_w 2841.4285714285716
r14320 n1524 t_r1_w 3315
r14321 n1525 t_r1_w 1989
r14322 n1526 t_r1_w 4972.5
r14323 n1527 t_r1_w 2841.4285714285716
r14324 n1030 t_r1_w 19890
r14325 n1031 t_r1_w 26010
r14326 n1032 t_r1_w 169065
r14327 n1033 t_r1_w 169065
r14328 n1177 t_r1_w 1326
r14329 n1178 t_r1_w 1734
r14330 n1179 t_r1_w 11271
r14331 n1180 t_r1_w 11271
r14332 n1324 t_r1_w 19890
r14333 n1325 t_r1_w 26010
r14334 n1326 t_r1_w 169065
r14335 n1327 t_r1_w 169065
r14336 n1534 t_r1_w 1170
r14337 n1535 t_r1_w 1530
r14338 n1536 t_r1_w 9945
r14339 n1537 t_r1_w 9945
r14340 n1039 t_r1_w 48304.285714285717
r14341 n1040 t_r1_w 12523.333333333334
r14342 n1186 t_r1_w 3220.2857142857142
r14343 n1187 t_r1_w 834.88888888888891
r14344 n1333 t_r1_w 48304.285714285717
r14345 n1334 t_r1_w 12523.333333333334
r14346 n1543 t_r1_w 2841.4285714285716
r14347 n1544 t_r1_w 736.66666666666674
r14348 n1044 t_r1_w 169065
r14349 n1045 t_r1_w 10566.5625
r14350 n1191 t_r1_w 11271
r14351 n1192 t_r1_w 704.4375
r14352 n1338 t_r1_w 169065
r14353 n1339 t_r1_w 10566.5625
r14354 n1548 t_r1_w 9945
r14355 n1549 t_r1_w 621.5625
r14356 n1047 t_r1_w 9945
r14357 n1194 t_r1_w 663
r14358 n1341 t_r1_w 9945
r14359 n1551 t_r1_w 585
r14360 n1049 t_r1_w 9945
r14361 n1196 t_r1_w 663
r14362 n1343 t_r1_w 9945
r14363 n1553 t_r1_w 585
r14364 n1051 t_r1_w 9945
r14365 n1198 t_r1_w 663
r14366 n1345 t_r1_w 9945
r14367 n1555 t_r1_w 585
r14368 n1053 t_r1_w 9945
r14369 n1200 t_r1_w 663
r14370 n1347 t_r1_w 9945
r14371 n1557 t_r1_w 585
r14372 n1055 t_r1_w 9945
r14373 n1202 t_r1_w 663
r14374 n1349 t_r1_w 9945
r14375 n1559 t_r1_w 585
r14376 n1057 t_r1_w 9945
r14377 n1204 t_r1_w 663
r14378 n1351 t_r1_w 9945
r14379 n1561 t_r1_w 585
r14380 n1059 t_r1_w 9945
r14381 n1206 t_r1_w 663
r14382 n1353 t_r1_w 9945
r14383 n1563 t_r1_w 585
r14384 n1061 t_r1_w 9945
r14385 n1208 t_r1_w 663
r14386 n1355 t_r1_w 9945
r14387 n1565 t_r1_w 585
r14388 n1063 t_r1_w 9945
r14389 n1210 t_r1_w 663
r14390 n1357 t_r1_w 9945
r14391 n1567 t_r1_w 585
r14392 n1065 t_r1_w 9945
r14393 n1212 t_r1_w 663
r14394 n1359 t_r1_w 9945
r14395 n1569 t_r1_w 585
r14396 n1067 t_r1_w 9945
r14397 n1214 t_r1_w 663
r14398 n1361 t_r1_w 9945
r14399 n1571 t_r1_w 585
r14400 n1070 t_r1_w 169065
r14401 n1071 t_r1_w 11271
r14402 n1072 t_r1_w 169065
r14403 n1217 t_r1_w 11271
r14404 n1218 t_r1_w 751.39999999999998
r14405 n1219 t_r1_w 11271
r14406 n1364 t_r1_w 169065
r14407 n1365 t_r1_w 11271
r14408 n1366 t_r1_w 169065
r14409 n1574 t_r1_w 9945
r14410 n1575 t_r1_w 663
r14411 n1576 t_r1_w 9945
r14412 n1075 t_r1_w 9945
r14413 n1222 t_r1_w 663
r14414 n1369 t_r1_w 9945
r14415 n1579 t_r1_w 585
r14416 n1077 t_r1_w 9945
r14417 n1224 t_r1_w 663
r14418 n1371 t_r1_w 9945
r14419 n1581 t_r1_w 585
r14420 n1079 t_r1_w 9945
r14421 n1226 t_r1_w 663
r14422 n1373 t_r1_w 9945
r14423 n1583 t_r1_w 585
r14424 n1081 t_r1_w 9945
r14425 n1228 t_r1_w 663
r14426 n1375 t_r1_w 9945
r14427 n1585 t_r1_w 585
r14428 n1083 t_r1_w 9945
r14429 n1230 t_r1_w 663
r14430 n1377 t_r1_w 9945
r14431 n1587 t_r1_w 585
r14432 n1085 t_r1_w 9945
r14433 n1232 t_r1_w 663
r14434 n1379 t_r1_w 9945
r14435 n1589 t_r1_w 585
r14436 n1087 t_r1_w 9945
r14437 n1234 t_r1_w 663
r14438 n1381 t_r1_w 9945
r14439 n1591 t_r1_w 585
r14440 n1089 t_r1_w 9945
r14441 n1236 t_r1_w 663
r14442 n1383 t_r1_w 9945
r14443 n1593 t_r1_w 585
r14444 n1091 t_r1_w 9945
r14445 n1238 t_r1_w 663
r14446 n1385 t_r1_w 9945
r14447 n1595 t_r1_w 585
r14448 n1093 t_r1_w 9945
r14449 n1240 t_r1_w 663
r14450 n1387 t_r1_w 9945
r14451 n1597 t_r1_w 585
r14452 n1095 t_r1_w 9945
r14453 n1242 t_r1_w 663
r14454 n1389 t_r1_w 9945
r14455 n1599 t_r1_w 585
r14456 n1097 t_r1_w 9945
r14457 n1244 t_r1_w 663
r14458 n1391 t_r1_w 9945
r14459 n1601 t_r1_w 585
r14460 n1100 t_r1_w 9945
r14461 n1247 t_r1_w 663
r14462 n1394 t_r1_w 9945
r14463 n1604 t_r1_w 585
r14464 n1102 t_r1_w 9945
r14465 n1249 t_r1_w 663
r14466 n1396 t_r1_w 9945
r14467 n1606 t_r1_w 585
r14468 n1104 t_r1_w 12523.333333333334
r14469 n1105 t_r1_w 48304.285714285717
r14470 n1251 t_r1_w 834.88888888888891
r14471 n1252 t_r1_w 3220.2857142857142
r14472 n1398 t_r1_w 12523.333333333334
r14473 n1399 t_r1_w 48304.285714285717
r14474 n1608 t_r1_w 736.66666666666674
r14475 n1609 t_r1_w 2841.4285714285716
r14476 n1108 t_r1_w 24152.142857142859
r14477 n1109 t_r1_w 16906.5
r14478 n1255 t_r1_w 1610.1428571428571
r14479 n1256 t_r1_w 1127.1000000000001
r14480 n1402 t_r1_w 24152.142857142859
r14481 n1403 t_r1_w 16906.5
r14482 n1612 t_r1_w 1420.7142857142858
r14483 n1613 t_r1_w 994.5
r14484 n1112 t_r1_w 9945
r14485 n1259 t_r1_w 663
r14486 n1406 t_r1_w 9945
r14487 n1616 t_r1_w 585
r14488 n1114 t_r1_w 9945
r14489 n1261 t_r1_w 663
r14490 n1408 t_r1_w 9945
r14491 n1618 t_r1_w 585
r14492 n1428 t_r1_w 3616.363636363636
r14493 n1429 t_r1_w 3616.363636363636
r14494 n1431 t_r1_w 3978
r14495 n1432 t_r1_w 3978
r14496 n1434 t_r1_w 19890
r14497 n1435 t_r1_w 19890
r14498 n1437 t_r1_w 13260
r14499 n1438 t_r1_w 13260
r14500 n1440 t_r1_w 7956
r14501 n1441 t_r1_w 7956
r14502 n1443 t_r1_w 13260
r14503 n1444 t_r1_w 13260
r14504 n1455 t_r1_w 13260
r14505 n1456 t_r1_w 13260
r14506 n1458 t_r1_w 7956
r14507 n1459 t_r1_w 7956
r14508 n1461 t_r1_w 13260
r14509 n1462 t_r1_w 13260
r14510 n1464 t_r1_w 19890
r14511 n1465 t_r1_w 19890
r14512 n1467 t_r1_w 3978
r14513 n1468 t_r1_w 3978
r14514 n1470 t_r1_w 3616.363636363636
r14515 n1471 t_r1_w 3616.363636363636
.save all
.control
set filetype=ascii
op
write op.raw all
quit
.endc
.end
