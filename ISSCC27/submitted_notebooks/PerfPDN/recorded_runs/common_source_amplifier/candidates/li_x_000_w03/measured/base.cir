.lib /home/gokalp/.local/share/perfpdn/pdks/sky130A/libs.tech/ngspice/sky130.lib.spice tt
.option scale=1e-6 reltol=1e-8 abstol=1e-14
.temp 27
.option klu reltol=1e-8 abstol=1e-14 vntol=1e-10
vin in 0 DC 0 AC 1 0
vdd vdd 0 DC 0 AC 0 0
C1 out 0 9.9999999999999998e-13
v_r1_a t_r1_a r1_a 0
v_r1_b t_r1_b r1_b -1.2
v_r1_w t_r1_w r1_w -0
XR1 r1_a r1_b r1_w sky130_fd_pr__res_high_po_0p35 L=8.67 mult=1 m=1
v_m1_d t_m1_d m1_d 0
v_m1_g t_m1_g m1_g -0.95472500000000005
v_m1_s t_m1_s m1_s -0
v_m1_b t_m1_b m1_b -0
XM1 m1_d m1_g m1_s m1_b sky130_fd_pr__nfet_01v8_lvt L=0.235 W=0.865 nf=1 ad='int(( 1 + 1 ) / 2 ) * 0.865 / 1 * 0.29' as='int(( 1 + 2 ) / 2 ) * 0.865 / 1 * 0.29' pd='2 * int(( 1 + 1 ) / 2 ) * ( 0.865 / 1 + 0.29 )' ps='2 * int(( 1 + 2 ) / 2 ) * ( 0.865 / 1 + 0.29 )' nrd='0.29 / 0.865 ' nrs='0.29 / 0.865 ' sa=0 sb=0 sd=0 mult=1 m=1
r0 n0 n1 6.4000000000000004
r1 n1 n2 5.2093023255813957
r2 n2 n3 4.7627906976744185
r3 n3 n4 4.7627906976744185
r4 n4 n5 5.2093023255813957
r5 n5 n6 6.4000000000000004
r6 n0 n7 49.280000000000001
r7 n1 n8 14.933333333333334
r8 n7 n8 8.0941176470588232
r9 n2 n9 246.40000000000001
r10 n8 n9 6.5882352941176467
r11 n3 n10 16.426666666666666
r12 n9 n10 6.0235294117647058
r13 n4 n11 246.40000000000001
r14 n10 n11 6.0235294117647058
r15 n5 n12 14.933333333333334
r16 n11 n12 6.5882352941176467
r17 n6 n13 49.280000000000001
r18 n12 n13 8.0941176470588232
r19 n7 n14 49.280000000000001
r20 n8 n15 14.933333333333334
r21 n14 n15 6.4000000000000004
r22 n9 n16 246.40000000000001
r23 n15 n16 5.2093023255813957
r24 n10 n17 16.426666666666666
r25 n16 n17 4.7627906976744185
r26 n11 n18 246.40000000000001
r27 n17 n18 4.7627906976744185
r28 n12 n19 14.933333333333334
r29 n18 n19 5.2093023255813957
r30 n13 n20 49.280000000000001
r31 n19 n20 6.4000000000000004
r32 n16 n21 297.60000000000002
r33 n17 n22 19.84
r34 n21 n22 4.0960000000000001
r35 n18 n23 297.60000000000002
r36 n22 n23 4.0960000000000001
r37 n21 n24 320
r38 n22 n25 21.333333333333332
r39 n24 n25 4.0960000000000001
r40 n23 n26 320
r41 n25 n26 4.0960000000000001
r42 n27 n28 1.935483870967742
r43 n28 n29 5.5483870967741939
r44 n24 n30 318.72000000000003
r45 n29 n30 4.5161290322580649
r46 n25 n31 21.248000000000001
r47 n30 n31 4.129032258064516
r48 n26 n32 318.72000000000003
r49 n31 n32 4.129032258064516
r50 n32 n33 4.5161290322580649
r51 n33 n34 5.5483870967741939
r52 n34 n35 1.935483870967742
r53 n27 n36 126.976
r54 n28 n37 63.488
r55 n36 n37 1.935483870967742
r56 n29 n38 19.238787878787878
r57 n37 n38 5.5483870967741939
r58 n30 n39 317.44
r59 n38 n39 4.5161290322580649
r60 n31 n40 21.162666666666667
r61 n39 n40 4.129032258064516
r62 n32 n41 317.44
r63 n40 n41 4.129032258064516
r64 n33 n42 19.238787878787878
r65 n41 n42 4.5161290322580649
r66 n34 n43 63.488
r67 n42 n43 5.5483870967741939
r68 n35 n44 126.976
r69 n43 n44 1.935483870967742
r70 n36 n45 126.976
r71 n37 n46 63.488
r72 n45 n46 1.935483870967742
r73 n38 n47 19.238787878787878
r74 n46 n47 5.5483870967741939
r75 n39 n48 317.44
r76 n47 n48 4.5161290322580649
r77 n40 n49 21.162666666666667
r78 n48 n49 4.129032258064516
r79 n41 n50 317.44
r80 n49 n50 4.129032258064516
r81 n42 n51 19.238787878787878
r82 n50 n51 4.5161290322580649
r83 n43 n52 63.488
r84 n51 n52 5.5483870967741939
r85 n44 n53 126.976
r86 n52 n53 1.935483870967742
r87 n45 n54 126.976
r88 n46 n55 63.488
r89 n54 n55 1.935483870967742
r90 n47 n56 19.238787878787878
r91 n55 n56 5.5483870967741939
r92 n48 n57 317.44
r93 n56 n57 4.5161290322580649
r94 n49 n58 21.162666666666667
r95 n57 n58 4.129032258064516
r96 n50 n59 317.44
r97 n58 n59 4.129032258064516
r98 n51 n60 19.238787878787878
r99 n59 n60 4.5161290322580649
r100 n52 n61 63.488
r101 n60 n61 5.5483870967741939
r102 n53 n62 126.976
r103 n61 n62 1.935483870967742
r104 n54 n63 126.976
r105 n55 n64 63.488
r106 n63 n64 1.935483870967742
r107 n56 n65 19.238787878787878
r108 n64 n65 5.5483870967741939
r109 n57 n66 317.44
r110 n65 n66 4.5161290322580649
r111 n58 n67 21.162666666666667
r112 n66 n67 4.129032258064516
r113 n59 n68 317.44
r114 n67 n68 4.129032258064516
r115 n60 n69 19.238787878787878
r116 n68 n69 4.5161290322580649
r117 n61 n70 63.488
r118 n69 n70 5.5483870967741939
r119 n62 n71 126.976
r120 n70 n71 1.935483870967742
r121 n63 n72 126.976
r122 n64 n73 63.488
r123 n72 n73 1.935483870967742
r124 n65 n74 19.238787878787878
r125 n73 n74 5.5483870967741939
r126 n66 n75 317.44
r127 n74 n75 4.5161290322580649
r128 n67 n76 21.162666666666667
r129 n75 n76 4.129032258064516
r130 n68 n77 317.44
r131 n76 n77 4.129032258064516
r132 n69 n78 19.238787878787878
r133 n77 n78 4.5161290322580649
r134 n70 n79 63.488
r135 n78 n79 5.5483870967741939
r136 n71 n80 126.976
r137 n79 n80 1.935483870967742
r138 n72 n81 126.72
r139 n73 n82 63.359999999999999
r140 n81 n82 1.9433198380566801
r141 n74 n83 19.199999999999999
r142 n82 n83 5.57085020242915
r143 n75 n84 316.80000000000001
r144 n83 n84 4.5344129554655872
r145 n76 n85 21.120000000000001
r146 n84 n85 4.1457489878542511
r147 n77 n86 316.80000000000001
r148 n85 n86 4.1457489878542511
r149 n78 n87 19.199999999999999
r150 n86 n87 4.5344129554655872
r151 n79 n88 63.359999999999999
r152 n87 n88 5.57085020242915
r153 n80 n89 126.72
r154 n88 n89 1.9433198380566801
r155 n81 n90 126.72
r156 n82 n91 63.359999999999999
r157 n90 n91 1.935483870967742
r158 n83 n92 19.199999999999999
r159 n91 n92 5.5483870967741939
r160 n84 n93 316.80000000000001
r161 n92 n93 4.5161290322580649
r162 n85 n94 21.120000000000001
r163 n93 n94 4.129032258064516
r164 n86 n95 316.80000000000001
r165 n94 n95 4.129032258064516
r166 n87 n96 19.199999999999999
r167 n95 n96 4.5161290322580649
r168 n88 n97 63.359999999999999
r169 n96 n97 5.5483870967741939
r170 n89 n98 126.72
r171 n97 n98 1.935483870967742
r172 n90 n99 126.976
r173 n91 n100 63.488
r174 n99 n100 1.935483870967742
r175 n92 n101 19.238787878787878
r176 n100 n101 5.5483870967741939
r177 n93 n102 317.44
r178 n101 n102 4.5161290322580649
r179 n94 n103 21.162666666666667
r180 n102 n103 4.129032258064516
r181 n95 n104 317.44
r182 n103 n104 4.129032258064516
r183 n96 n105 19.238787878787878
r184 n104 n105 4.5161290322580649
r185 n97 n106 63.488
r186 n105 n106 5.5483870967741939
r187 n98 n107 126.976
r188 n106 n107 1.935483870967742
r189 n99 n108 126.976
r190 n100 n109 63.488
r191 n108 n109 1.935483870967742
r192 n101 n110 19.238787878787878
r193 n109 n110 5.5483870967741939
r194 n102 n111 317.44
r195 n110 n111 4.5161290322580649
r196 n103 n112 21.162666666666667
r197 n111 n112 4.129032258064516
r198 n104 n113 317.44
r199 n112 n113 4.129032258064516
r200 n105 n114 19.238787878787878
r201 n113 n114 4.5161290322580649
r202 n106 n115 63.488
r203 n114 n115 5.5483870967741939
r204 n107 n116 126.976
r205 n115 n116 1.935483870967742
r206 n108 n117 126.976
r207 n109 n118 63.488
r208 n117 n118 1.935483870967742
r209 n110 n119 19.238787878787878
r210 n118 n119 5.5483870967741939
r211 n111 n120 317.44
r212 n119 n120 4.5161290322580649
r213 n112 n121 21.162666666666667
r214 n120 n121 4.129032258064516
r215 n113 n122 317.44
r216 n121 n122 4.129032258064516
r217 n114 n123 19.238787878787878
r218 n122 n123 4.5161290322580649
r219 n115 n124 63.488
r220 n123 n124 5.5483870967741939
r221 n116 n125 126.976
r222 n124 n125 1.935483870967742
r223 n117 n126 126.976
r224 n118 n127 63.488
r225 n126 n127 1.935483870967742
r226 n119 n128 19.238787878787878
r227 n127 n128 5.5483870967741939
r228 n120 n129 317.44
r229 n128 n129 4.5161290322580649
r230 n121 n130 21.162666666666667
r231 n129 n130 4.129032258064516
r232 n122 n131 317.44
r233 n130 n131 4.129032258064516
r234 n123 n132 19.238787878787878
r235 n131 n132 4.5161290322580649
r236 n124 n133 63.488
r237 n132 n133 5.5483870967741939
r238 n125 n134 126.976
r239 n133 n134 1.935483870967742
r240 n126 n135 126.976
r241 n127 n136 63.488
r242 n135 n136 1.935483870967742
r243 n128 n137 19.238787878787878
r244 n136 n137 5.5483870967741939
r245 n129 n138 317.44
r246 n137 n138 4.5161290322580649
r247 n130 n139 21.162666666666667
r248 n138 n139 4.129032258064516
r249 n131 n140 317.44
r250 n139 n140 4.129032258064516
r251 n132 n141 19.238787878787878
r252 n140 n141 4.5161290322580649
r253 n133 n142 63.488
r254 n141 n142 5.5483870967741939
r255 n134 n143 126.976
r256 n142 n143 1.935483870967742
r257 n135 n144 126.976
r258 n136 n145 63.488
r259 n144 n145 1.935483870967742
r260 n137 n146 19.238787878787878
r261 n145 n146 5.5483870967741939
r262 n138 n147 317.44
r263 n146 n147 4.5161290322580649
r264 n139 n148 21.162666666666667
r265 n147 n148 4.129032258064516
r266 n140 n149 317.44
r267 n148 n149 4.129032258064516
r268 n141 n150 19.238787878787878
r269 n149 n150 4.5161290322580649
r270 n142 n151 63.488
r271 n150 n151 5.5483870967741939
r272 n143 n152 126.976
r273 n151 n152 1.935483870967742
r274 n144 n153 126.976
r275 n145 n154 63.488
r276 n153 n154 1.935483870967742
r277 n146 n155 19.238787878787878
r278 n154 n155 5.5483870967741939
r279 n147 n156 317.44
r280 n155 n156 4.5161290322580649
r281 n148 n157 21.162666666666667
r282 n156 n157 4.129032258064516
r283 n149 n158 317.44
r284 n157 n158 4.129032258064516
r285 n150 n159 19.238787878787878
r286 n158 n159 4.5161290322580649
r287 n151 n160 63.488
r288 n159 n160 5.5483870967741939
r289 n152 n161 126.976
r290 n160 n161 1.935483870967742
r291 n153 n162 126.976
r292 n154 n163 63.488
r293 n162 n163 1.935483870967742
r294 n155 n164 19.238787878787878
r295 n163 n164 5.5483870967741939
r296 n156 n165 317.44
r297 n164 n165 4.5161290322580649
r298 n157 n166 21.162666666666667
r299 n165 n166 4.129032258064516
r300 n158 n167 317.44
r301 n166 n167 4.129032258064516
r302 n159 n168 19.238787878787878
r303 n167 n168 4.5161290322580649
r304 n160 n169 63.488
r305 n168 n169 5.5483870967741939
r306 n161 n170 126.976
r307 n169 n170 1.935483870967742
r308 n162 n171 126.976
r309 n163 n172 63.488
r310 n171 n172 1.935483870967742
r311 n164 n173 19.238787878787878
r312 n172 n173 5.5483870967741939
r313 n165 n174 317.44
r314 n173 n174 4.5161290322580649
r315 n166 n175 21.162666666666667
r316 n174 n175 4.129032258064516
r317 n167 n176 317.44
r318 n175 n176 4.129032258064516
r319 n168 n177 19.238787878787878
r320 n176 n177 4.5161290322580649
r321 n169 n178 63.488
r322 n177 n178 5.5483870967741939
r323 n170 n179 126.976
r324 n178 n179 1.935483870967742
r325 n171 n180 126.72
r326 n172 n181 63.359999999999999
r327 n180 n181 1.9433198380566801
r328 n173 n182 19.199999999999999
r329 n181 n182 5.57085020242915
r330 n174 n183 316.80000000000001
r331 n182 n183 4.5344129554655872
r332 n175 n184 21.120000000000001
r333 n183 n184 4.1457489878542511
r334 n176 n185 316.80000000000001
r335 n184 n185 4.1457489878542511
r336 n177 n186 19.199999999999999
r337 n185 n186 4.5344129554655872
r338 n178 n187 63.359999999999999
r339 n186 n187 5.57085020242915
r340 n179 n188 126.72
r341 n187 n188 1.9433198380566801
r342 n180 n189 126.72
r343 n181 n190 63.359999999999999
r344 n189 n190 1.935483870967742
r345 n182 n191 19.199999999999999
r346 n190 n191 5.5483870967741939
r347 n183 n192 316.80000000000001
r348 n191 n192 4.5161290322580649
r349 n184 n193 21.120000000000001
r350 n192 n193 4.129032258064516
r351 n185 n194 316.80000000000001
r352 n193 n194 4.129032258064516
r353 n186 n195 19.199999999999999
r354 n194 n195 4.5161290322580649
r355 n187 n196 63.359999999999999
r356 n195 n196 5.5483870967741939
r357 n188 n197 126.72
r358 n196 n197 1.935483870967742
r359 n189 n198 126.976
r360 n190 n199 63.488
r361 n198 n199 1.935483870967742
r362 n191 n200 19.238787878787878
r363 n199 n200 5.5483870967741939
r364 n192 n201 317.44
r365 n200 n201 4.5161290322580649
r366 n193 n202 21.162666666666667
r367 n201 n202 4.129032258064516
r368 n194 n203 317.44
r369 n202 n203 4.129032258064516
r370 n195 n204 19.238787878787878
r371 n203 n204 4.5161290322580649
r372 n196 n205 63.488
r373 n204 n205 5.5483870967741939
r374 n197 n206 126.976
r375 n205 n206 1.935483870967742
r376 n198 n207 126.976
r377 n199 n208 63.488
r378 n207 n208 1.935483870967742
r379 n200 n209 19.238787878787878
r380 n208 n209 5.5483870967741939
r381 n201 n210 317.44
r382 n209 n210 4.5161290322580649
r383 n202 n211 21.162666666666667
r384 n210 n211 4.129032258064516
r385 n203 n212 317.44
r386 n211 n212 4.129032258064516
r387 n204 n213 19.238787878787878
r388 n212 n213 4.5161290322580649
r389 n205 n214 63.488
r390 n213 n214 5.5483870967741939
r391 n206 n215 126.976
r392 n214 n215 1.935483870967742
r393 n207 n216 126.976
r394 n208 n217 63.488
r395 n216 n217 1.935483870967742
r396 n209 n218 19.238787878787878
r397 n217 n218 5.5483870967741939
r398 n210 n219 317.44
r399 n218 n219 4.5161290322580649
r400 n211 n220 21.162666666666667
r401 n219 n220 4.129032258064516
r402 n212 n221 317.44
r403 n220 n221 4.129032258064516
r404 n213 n222 19.238787878787878
r405 n221 n222 4.5161290322580649
r406 n214 n223 63.488
r407 n222 n223 5.5483870967741939
r408 n215 n224 126.976
r409 n223 n224 1.935483870967742
r410 n216 n225 126.976
r411 n217 n226 63.488
r412 n225 n226 1.935483870967742
r413 n218 n227 19.238787878787878
r414 n226 n227 5.5483870967741939
r415 n219 n228 317.44
r416 n227 n228 4.5161290322580649
r417 n220 n229 21.162666666666667
r418 n228 n229 4.129032258064516
r419 n221 n230 317.44
r420 n229 n230 4.129032258064516
r421 n222 n231 19.238787878787878
r422 n230 n231 4.5161290322580649
r423 n223 n232 63.488
r424 n231 n232 5.5483870967741939
r425 n224 n233 126.976
r426 n232 n233 1.935483870967742
r427 n225 n234 126.976
r428 n226 n235 63.488
r429 n234 n235 1.935483870967742
r430 n227 n236 19.238787878787878
r431 n235 n236 5.5483870967741939
r432 n228 n237 317.44
r433 n236 n237 4.5161290322580649
r434 n229 n238 21.162666666666667
r435 n237 n238 4.129032258064516
r436 n230 n239 317.44
r437 n238 n239 4.129032258064516
r438 n231 n240 19.238787878787878
r439 n239 n240 4.5161290322580649
r440 n232 n241 63.488
r441 n240 n241 5.5483870967741939
r442 n233 n242 126.976
r443 n241 n242 1.935483870967742
r444 n234 n243 126.976
r445 n235 n244 63.488
r446 n243 n244 1.935483870967742
r447 n236 n245 19.238787878787878
r448 n244 n245 5.5483870967741939
r449 n237 n246 317.44
r450 n245 n246 4.5161290322580649
r451 n238 n247 21.162666666666667
r452 n246 n247 4.129032258064516
r453 n239 n248 317.44
r454 n247 n248 4.129032258064516
r455 n240 n249 19.238787878787878
r456 n248 n249 4.5161290322580649
r457 n241 n250 63.488
r458 n249 n250 5.5483870967741939
r459 n242 n251 126.976
r460 n250 n251 1.935483870967742
r461 n243 n252 126.976
r462 n244 n253 63.488
r463 n252 n253 1.935483870967742
r464 n245 n254 19.238787878787878
r465 n253 n254 5.5483870967741939
r466 n246 n255 317.44
r467 n254 n255 4.5161290322580649
r468 n247 n256 21.162666666666667
r469 n255 n256 4.129032258064516
r470 n248 n257 317.44
r471 n256 n257 4.129032258064516
r472 n249 n258 19.238787878787878
r473 n257 n258 4.5161290322580649
r474 n250 n259 63.488
r475 n258 n259 5.5483870967741939
r476 n251 n260 126.976
r477 n259 n260 1.935483870967742
r478 n252 n261 126.976
r479 n253 n262 63.488
r480 n261 n262 1.935483870967742
r481 n254 n263 19.238787878787878
r482 n262 n263 5.5483870967741939
r483 n255 n264 317.44
r484 n263 n264 4.5161290322580649
r485 n256 n265 21.162666666666667
r486 n264 n265 4.129032258064516
r487 n257 n266 317.44
r488 n265 n266 4.129032258064516
r489 n258 n267 19.238787878787878
r490 n266 n267 4.5161290322580649
r491 n259 n268 63.488
r492 n267 n268 5.5483870967741939
r493 n260 n269 126.976
r494 n268 n269 1.935483870967742
r495 n261 n270 126.976
r496 n262 n271 63.488
r497 n270 n271 1.935483870967742
r498 n263 n272 19.238787878787878
r499 n271 n272 5.5483870967741939
r500 n264 n273 317.44
r501 n272 n273 4.5161290322580649
r502 n265 n274 21.162666666666667
r503 n273 n274 4.129032258064516
r504 n266 n275 317.44
r505 n274 n275 4.129032258064516
r506 n267 n276 19.238787878787878
r507 n275 n276 4.5161290322580649
r508 n268 n277 63.488
r509 n276 n277 5.5483870967741939
r510 n269 n278 126.976
r511 n277 n278 1.935483870967742
r512 n270 n279 126.976
r513 n271 n280 63.488
r514 n279 n280 1.935483870967742
r515 n272 n281 19.238787878787878
r516 n280 n281 5.5483870967741939
r517 n273 n282 317.44
r518 n281 n282 4.5161290322580649
r519 n274 n283 21.162666666666667
r520 n282 n283 4.129032258064516
r521 n275 n284 317.44
r522 n283 n284 4.129032258064516
r523 n276 n285 19.238787878787878
r524 n284 n285 4.5161290322580649
r525 n277 n286 63.488
r526 n285 n286 5.5483870967741939
r527 n278 n287 126.976
r528 n286 n287 1.935483870967742
r529 n279 n288 126.976
r530 n280 n289 63.488
r531 n288 n289 1.935483870967742
r532 n281 n290 19.238787878787878
r533 n289 n290 5.5483870967741939
r534 n282 n291 317.44
r535 n290 n291 4.5161290322580649
r536 n283 n292 21.162666666666667
r537 n291 n292 4.129032258064516
r538 n284 n293 317.44
r539 n292 n293 4.129032258064516
r540 n285 n294 19.238787878787878
r541 n293 n294 4.5161290322580649
r542 n286 n295 63.488
r543 n294 n295 5.5483870967741939
r544 n287 n296 126.976
r545 n295 n296 1.935483870967742
r546 n288 n297 126.72
r547 n289 n298 63.359999999999999
r548 n297 n298 1.9433198380566801
r549 n290 n299 19.199999999999999
r550 n298 n299 5.57085020242915
r551 n291 n300 316.80000000000001
r552 n299 n300 4.5344129554655872
r553 n292 n301 21.120000000000001
r554 n300 n301 4.1457489878542511
r555 n293 n302 316.80000000000001
r556 n301 n302 4.1457489878542511
r557 n294 n303 19.199999999999999
r558 n302 n303 4.5344129554655872
r559 n295 n304 63.359999999999999
r560 n303 n304 5.57085020242915
r561 n296 n305 126.72
r562 n304 n305 1.9433198380566801
r563 n297 n306 126.72
r564 n298 n307 63.359999999999999
r565 n306 n307 1.935483870967742
r566 n299 n308 19.199999999999999
r567 n307 n308 5.5483870967741939
r568 n300 n309 316.80000000000001
r569 n308 n309 4.5161290322580649
r570 n301 n310 21.120000000000001
r571 n309 n310 4.129032258064516
r572 n302 n311 316.80000000000001
r573 n310 n311 4.129032258064516
r574 n303 n312 19.199999999999999
r575 n311 n312 4.5161290322580649
r576 n304 n313 63.359999999999999
r577 n312 n313 5.5483870967741939
r578 n305 n314 126.72
r579 n313 n314 1.935483870967742
r580 n306 n315 126.976
r581 n307 n316 63.488
r582 n315 n316 1.935483870967742
r583 n308 n317 19.238787878787878
r584 n316 n317 5.5483870967741939
r585 n309 n318 317.44
r586 n317 n318 4.5161290322580649
r587 n310 n319 21.162666666666667
r588 n318 n319 4.129032258064516
r589 n311 n320 317.44
r590 n319 n320 4.129032258064516
r591 n312 n321 19.238787878787878
r592 n320 n321 4.5161290322580649
r593 n313 n322 63.488
r594 n321 n322 5.5483870967741939
r595 n314 n323 126.976
r596 n322 n323 1.935483870967742
r597 n315 n324 126.976
r598 n316 n325 63.488
r599 n324 n325 1.935483870967742
r600 n317 n326 19.238787878787878
r601 n325 n326 5.5483870967741939
r602 n318 n327 317.44
r603 n326 n327 4.5161290322580649
r604 n319 n328 21.162666666666667
r605 n327 n328 4.129032258064516
r606 n320 n329 317.44
r607 n328 n329 4.129032258064516
r608 n321 n330 19.238787878787878
r609 n329 n330 4.5161290322580649
r610 n322 n331 63.488
r611 n330 n331 5.5483870967741939
r612 n323 n332 126.976
r613 n331 n332 1.935483870967742
r614 n324 n333 126.976
r615 n325 n334 63.488
r616 n333 n334 1.935483870967742
r617 n326 n335 19.238787878787878
r618 n334 n335 5.5483870967741939
r619 n327 n336 317.44
r620 n335 n336 4.5161290322580649
r621 n328 n337 21.162666666666667
r622 n336 n337 4.129032258064516
r623 n329 n338 317.44
r624 n337 n338 4.129032258064516
r625 n330 n339 19.238787878787878
r626 n338 n339 4.5161290322580649
r627 n331 n340 63.488
r628 n339 n340 5.5483870967741939
r629 n332 n341 126.976
r630 n340 n341 1.935483870967742
r631 n333 n342 126.976
r632 n334 n343 63.488
r633 n342 n343 1.935483870967742
r634 n335 n344 19.238787878787878
r635 n343 n344 5.5483870967741939
r636 n336 n345 317.44
r637 n344 n345 4.5161290322580649
r638 n337 n346 21.162666666666667
r639 n345 n346 4.129032258064516
r640 n338 n347 317.44
r641 n346 n347 4.129032258064516
r642 n339 n348 19.238787878787878
r643 n347 n348 4.5161290322580649
r644 n340 n349 63.488
r645 n348 n349 5.5483870967741939
r646 n341 n350 126.976
r647 n349 n350 1.935483870967742
r648 n342 n351 126.976
r649 n343 n352 63.488
r650 n351 n352 1.935483870967742
r651 n344 n353 19.238787878787878
r652 n352 n353 5.5483870967741939
r653 n345 n354 317.44
r654 n353 n354 4.5161290322580649
r655 n346 n355 21.162666666666667
r656 n354 n355 4.129032258064516
r657 n347 n356 317.44
r658 n355 n356 4.129032258064516
r659 n348 n357 19.238787878787878
r660 n356 n357 4.5161290322580649
r661 n349 n358 63.488
r662 n357 n358 5.5483870967741939
r663 n350 n359 126.976
r664 n358 n359 1.935483870967742
r665 n351 n360 126.976
r666 n352 n361 63.488
r667 n360 n361 1.935483870967742
r668 n353 n362 19.238787878787878
r669 n361 n362 5.5483870967741939
r670 n354 n363 317.44
r671 n362 n363 4.5161290322580649
r672 n355 n364 21.162666666666667
r673 n363 n364 4.129032258064516
r674 n356 n365 317.44
r675 n364 n365 4.129032258064516
r676 n357 n366 19.238787878787878
r677 n365 n366 4.5161290322580649
r678 n358 n367 63.488
r679 n366 n367 5.5483870967741939
r680 n359 n368 126.976
r681 n367 n368 1.935483870967742
r682 n360 n369 126.976
r683 n361 n370 63.488
r684 n369 n370 1.935483870967742
r685 n362 n371 19.238787878787878
r686 n370 n371 5.5483870967741939
r687 n363 n372 317.44
r688 n371 n372 4.5161290322580649
r689 n364 n373 21.162666666666667
r690 n372 n373 4.129032258064516
r691 n365 n374 317.44
r692 n373 n374 4.129032258064516
r693 n366 n375 19.238787878787878
r694 n374 n375 4.5161290322580649
r695 n367 n376 63.488
r696 n375 n376 5.5483870967741939
r697 n368 n377 126.976
r698 n376 n377 1.935483870967742
r699 n369 n378 126.976
r700 n370 n379 63.488
r701 n378 n379 1.935483870967742
r702 n371 n380 19.238787878787878
r703 n379 n380 5.5483870967741939
r704 n372 n381 317.44
r705 n380 n381 4.5161290322580649
r706 n373 n382 21.162666666666667
r707 n381 n382 4.129032258064516
r708 n374 n383 317.44
r709 n382 n383 4.129032258064516
r710 n375 n384 19.238787878787878
r711 n383 n384 4.5161290322580649
r712 n376 n385 63.488
r713 n384 n385 5.5483870967741939
r714 n377 n386 126.976
r715 n385 n386 1.935483870967742
r716 n378 n387 126.976
r717 n379 n388 63.488
r718 n387 n388 1.935483870967742
r719 n380 n389 19.238787878787878
r720 n388 n389 5.5483870967741939
r721 n381 n390 317.44
r722 n389 n390 4.5161290322580649
r723 n382 n391 21.162666666666667
r724 n390 n391 4.129032258064516
r725 n383 n392 317.44
r726 n391 n392 4.129032258064516
r727 n384 n393 19.238787878787878
r728 n392 n393 4.5161290322580649
r729 n385 n394 63.488
r730 n393 n394 5.5483870967741939
r731 n386 n395 126.976
r732 n394 n395 1.935483870967742
r733 n387 n396 126.72
r734 n388 n397 63.359999999999999
r735 n396 n397 1.9433198380566801
r736 n389 n398 19.199999999999999
r737 n397 n398 5.57085020242915
r738 n390 n399 316.80000000000001
r739 n398 n399 4.5344129554655872
r740 n391 n400 21.120000000000001
r741 n399 n400 4.1457489878542511
r742 n392 n401 316.80000000000001
r743 n400 n401 4.1457489878542511
r744 n393 n402 19.199999999999999
r745 n401 n402 4.5344129554655872
r746 n394 n403 63.359999999999999
r747 n402 n403 5.57085020242915
r748 n395 n404 126.72
r749 n403 n404 1.9433198380566801
r750 n396 n405 126.72
r751 n397 n406 63.359999999999999
r752 n405 n406 1.935483870967742
r753 n398 n407 19.199999999999999
r754 n406 n407 5.5483870967741939
r755 n399 n408 316.80000000000001
r756 n407 n408 4.5161290322580649
r757 n400 n409 21.120000000000001
r758 n408 n409 4.129032258064516
r759 n401 n410 316.80000000000001
r760 n409 n410 4.129032258064516
r761 n402 n411 19.199999999999999
r762 n410 n411 4.5161290322580649
r763 n403 n412 63.359999999999999
r764 n411 n412 5.5483870967741939
r765 n404 n413 126.72
r766 n412 n413 1.935483870967742
r767 n405 n414 126.976
r768 n406 n415 63.488
r769 n414 n415 1.935483870967742
r770 n407 n416 19.238787878787878
r771 n415 n416 5.5483870967741939
r772 n408 n417 317.44
r773 n416 n417 4.5161290322580649
r774 n409 n418 21.162666666666667
r775 n417 n418 4.129032258064516
r776 n410 n419 317.44
r777 n418 n419 4.129032258064516
r778 n411 n420 19.238787878787878
r779 n419 n420 4.5161290322580649
r780 n412 n421 63.488
r781 n420 n421 5.5483870967741939
r782 n413 n422 126.976
r783 n421 n422 1.935483870967742
r784 n414 n423 126.976
r785 n415 n424 63.488
r786 n423 n424 1.935483870967742
r787 n416 n425 19.238787878787878
r788 n424 n425 5.5483870967741939
r789 n417 n426 317.44
r790 n425 n426 4.5161290322580649
r791 n418 n427 21.162666666666667
r792 n426 n427 4.129032258064516
r793 n419 n428 317.44
r794 n427 n428 4.129032258064516
r795 n420 n429 19.238787878787878
r796 n428 n429 4.5161290322580649
r797 n421 n430 63.488
r798 n429 n430 5.5483870967741939
r799 n422 n431 126.976
r800 n430 n431 1.935483870967742
r801 n423 n432 126.976
r802 n424 n433 63.488
r803 n432 n433 1.935483870967742
r804 n425 n434 19.238787878787878
r805 n433 n434 5.5483870967741939
r806 n426 n435 317.44
r807 n434 n435 4.5161290322580649
r808 n427 n436 21.162666666666667
r809 n435 n436 4.129032258064516
r810 n428 n437 317.44
r811 n436 n437 4.129032258064516
r812 n429 n438 19.238787878787878
r813 n437 n438 4.5161290322580649
r814 n430 n439 63.488
r815 n438 n439 5.5483870967741939
r816 n431 n440 126.976
r817 n439 n440 1.935483870967742
r818 n432 n441 126.976
r819 n433 n442 63.488
r820 n441 n442 1.935483870967742
r821 n434 n443 19.238787878787878
r822 n442 n443 5.5483870967741939
r823 n435 n444 317.44
r824 n443 n444 4.5161290322580649
r825 n436 n445 21.162666666666667
r826 n444 n445 4.129032258064516
r827 n437 n446 317.44
r828 n445 n446 4.129032258064516
r829 n438 n447 19.238787878787878
r830 n446 n447 4.5161290322580649
r831 n439 n448 63.488
r832 n447 n448 5.5483870967741939
r833 n440 n449 126.976
r834 n448 n449 1.935483870967742
r835 n441 n450 126.976
r836 n442 n451 63.488
r837 n450 n451 1.935483870967742
r838 n443 n452 19.238787878787878
r839 n451 n452 5.5483870967741939
r840 n444 n453 317.44
r841 n452 n453 4.5161290322580649
r842 n445 n454 21.162666666666667
r843 n453 n454 4.129032258064516
r844 n446 n455 317.44
r845 n454 n455 4.129032258064516
r846 n447 n456 19.238787878787878
r847 n455 n456 4.5161290322580649
r848 n448 n457 63.488
r849 n456 n457 5.5483870967741939
r850 n449 n458 126.976
r851 n457 n458 1.935483870967742
r852 n453 n459 318.72000000000003
r853 n454 n460 21.248000000000001
r854 n459 n460 4.0960000000000001
r855 n455 n461 318.72000000000003
r856 n460 n461 4.0960000000000001
r857 n459 n462 320
r858 n460 n463 21.333333333333332
r859 n462 n463 4.0960000000000001
r860 n461 n464 320
r861 n463 n464 4.0960000000000001
r862 n465 n466 13.76
r863 n462 n467 224
r864 n466 n467 11.199999999999999
r865 n463 n468 14.933333333333334
r866 n467 n468 10.24
r867 n464 n469 224
r868 n468 n469 10.24
r869 n469 n470 11.199999999999999
r870 n470 n471 13.76
r871 n465 n472 27.52
r872 n466 n473 8.3393939393939398
r873 n472 n473 11.965217391304348
r874 n467 n474 137.59999999999999
r875 n473 n474 9.7391304347826093
r876 n468 n475 9.1733333333333338
r877 n474 n475 8.9043478260869566
r878 n469 n476 137.59999999999999
r879 n475 n476 8.9043478260869566
r880 n470 n477 8.3393939393939398
r881 n476 n477 9.7391304347826093
r882 n471 n478 27.52
r883 n477 n478 11.965217391304348
r884 n472 n479 16
r885 n473 n480 4.8484848484848486
r886 n479 n480 137.59999999999999
r887 n474 n481 80
r888 n480 n481 112
r889 n475 n482 5.333333333333333
r890 n481 n482 102.40000000000001
r891 n476 n483 80
r892 n482 n483 102.40000000000001
r893 n477 n484 4.8484848484848486
r894 n483 n484 112
r895 n478 n485 16
r896 n484 n485 137.59999999999999
r897 n479 n486 20.48
r898 n480 n487 6.2060606060606061
r899 n486 n487 9.1733333333333338
r900 n481 n488 102.40000000000001
r901 n487 n488 7.4666666666666668
r902 n482 n489 6.8266666666666671
r903 n488 n489 6.8266666666666671
r904 n483 n490 102.40000000000001
r905 n489 n490 6.8266666666666671
r906 n484 n491 6.2060606060606061
r907 n490 n491 7.4666666666666668
r908 n485 n492 20.48
r909 n491 n492 9.1733333333333338
r910 n486 n493 20.48
r911 n487 n494 6.2060606060606061
r912 n493 n494 137.59999999999999
r913 n488 n495 102.40000000000001
r914 n494 n495 112
r915 n489 n496 6.8266666666666671
r916 n495 n496 102.40000000000001
r917 n490 n497 102.40000000000001
r918 n496 n497 102.40000000000001
r919 n491 n498 6.2060606060606061
r920 n497 n498 112
r921 n492 n499 20.48
r922 n498 n499 137.59999999999999
r923 n493 n500 16
r924 n494 n501 4.8484848484848486
r925 n500 n501 11.965217391304348
r926 n495 n502 80
r927 n501 n502 9.7391304347826093
r928 n496 n503 5.333333333333333
r929 n502 n503 8.9043478260869566
r930 n497 n504 80
r931 n503 n504 8.9043478260869566
r932 n498 n505 4.8484848484848486
r933 n504 n505 9.7391304347826093
r934 n499 n506 16
r935 n505 n506 11.965217391304348
r936 n500 n507 27.52
r937 n501 n508 8.3393939393939398
r938 n507 n508 13.76
r939 n502 n509 137.59999999999999
r940 n508 n509 11.199999999999999
r941 n503 n510 9.1733333333333338
r942 n509 n510 10.24
r943 n504 n511 137.59999999999999
r944 n510 n511 10.24
r945 n505 n512 8.3393939393939398
r946 n511 n512 11.199999999999999
r947 n506 n513 27.52
r948 n512 n513 13.76
r949 n514 n515 150.40000000000001
r950 n515 n516 169.59999999999999
r951 n516 n517 131.19999999999999
r952 n517 n518 108.8
r953 n518 n519 108.8
r954 n519 n520 76.799999999999997
r955 n520 n521 86.400000000000006
r956 n521 n522 32
r957 n522 n523 35.200000000000003
r958 n523 n524 19.199999999999999
r959 n524 n525 44.799999999999997
r960 n525 n526 73.599999999999994
r961 n526 n527 48
r962 n527 n528 32
r963 n528 n529 19.199999999999999
r964 n529 n530 12.800000000000001
r965 n530 n531 12.800000000000001
r966 n531 n532 32
r967 n532 n533 60.799999999999997
r968 n533 n534 48
r969 n534 n535 32
r970 n535 n536 19.199999999999999
r971 n536 n537 9.5999999999999996
r972 n537 n538 9.5999999999999996
r973 n538 n539 6.4000000000000004
r974 n539 n540 6.4000000000000004
r975 n540 n541 16
r976 n541 n542 28.800000000000001
r977 n542 n543 19.199999999999999
r978 n543 n544 35.200000000000003
r979 n544 n545 41.600000000000001
r980 n545 n546 28.800000000000001
r981 n546 n547 25.600000000000001
r982 n547 n548 9.5999999999999996
r983 n548 n549 6.4000000000000004
r984 n549 n550 22.399999999999999
r985 n550 n551 35.200000000000003
r986 n551 n552 19.199999999999999
r987 n552 n553 16
r988 n553 n554 28.800000000000001
r989 n554 n555 25.600000000000001
r990 n555 n556 32
r991 n556 n557 41.600000000000001
r992 n557 n558 51.200000000000003
r993 n558 n559 44.799999999999997
r994 n559 n560 35.200000000000003
r995 n560 n561 51.200000000000003
r996 n561 n562 41.600000000000001
r997 n562 n563 38.399999999999999
r998 n563 n564 41.600000000000001
r999 n564 n565 35.200000000000003
r1000 n565 n566 25.600000000000001
r1001 n566 n567 60.799999999999997
r1002 n567 n568 96
r1003 n568 n569 48
r1004 n569 n570 12.800000000000001
r1005 n570 n571 19.199999999999999
r1006 n571 n572 28.800000000000001
r1007 n572 n573 41.600000000000001
r1008 n573 n574 38.399999999999999
r1009 n574 n575 54.399999999999999
r1010 n575 n576 64
r1011 n576 n577 108.8
r1012 n577 n578 92.799999999999997
r1013 n578 n579 22.399999999999999
r1014 n579 n580 102.40000000000001
r1015 n580 n581 92.799999999999997
r1016 n514 n582 6.0235294117647058
r1017 n515 n583 15.753846153846155
r1018 n582 n583 10.026666666666667
r1019 n516 n584 5.1200000000000001
r1020 n583 n584 11.306666666666667
r1021 n517 n585 204.80000000000001
r1022 n584 n585 8.7466666666666661
r1023 n518 n586 6.2060606060606061
r1024 n585 n586 7.253333333333333
r1025 n519 n587 204.80000000000001
r1026 n586 n587 7.253333333333333
r1027 n520 n588 8.9043478260869566
r1028 n587 n588 5.1200000000000001
r1029 n521 n589 51.200000000000003
r1030 n588 n589 5.7599999999999998
r1031 n522 n590 34.133333333333333
r1032 n589 n590 2.1333333333333333
r1033 n523 n591 40.960000000000001
r1034 n590 n591 2.3466666666666667
r1035 n524 n592 204.80000000000001
r1036 n591 n592 1.28
r1037 n525 n593 15.753846153846155
r1038 n592 n593 2.9866666666666668
r1039 n526 n594 20.48
r1040 n593 n594 4.9066666666666663
r1041 n527 n595 40.960000000000001
r1042 n594 n595 3.2000000000000002
r1043 n528 n596 40.960000000000001
r1044 n595 n596 2.1333333333333333
r1045 n529 n597 204.80000000000001
r1046 n596 n597 1.28
r1047 n530 n598 68.266666666666666
r1048 n597 n598 0.85333333333333339
r1049 n531 n599 204.80000000000001
r1050 n598 n599 0.85333333333333339
r1051 n532 n600 22.755555555555556
r1052 n599 n600 2.1333333333333333
r1053 n533 n601 20.48
r1054 n600 n601 4.0533333333333337
r1055 n534 n602 40.960000000000001
r1056 n601 n602 3.2000000000000002
r1057 n535 n603 40.960000000000001
r1058 n602 n603 2.1333333333333333
r1059 n536 n604 204.80000000000001
r1060 n603 n604 1.28
r1061 n537 n605 102.40000000000001
r1062 n604 n605 0.64000000000000001
r1063 n538 n606 204.80000000000001
r1064 n605 n606 0.64000000000000001
r1065 n539 n607 204.80000000000001
r1066 n606 n607 0.42666666666666669
r1067 n540 n608 204.80000000000001
r1068 n607 n608 0.42666666666666669
r1069 n541 n609 51.200000000000003
r1070 n608 n609 1.0666666666666667
r1071 n542 n610 40.960000000000001
r1072 n609 n610 1.9199999999999999
r1073 n543 n611 204.80000000000001
r1074 n610 n611 1.28
r1075 n544 n612 20.48
r1076 n611 n612 2.3466666666666667
r1077 n545 n613 68.266666666666666
r1078 n612 n613 2.7733333333333334
r1079 n546 n614 34.133333333333333
r1080 n613 n614 1.9199999999999999
r1081 n547 n615 102.40000000000001
r1082 n614 n615 1.7066666666666668
r1083 n548 n616 204.80000000000001
r1084 n615 n616 0.64000000000000001
r1085 n549 n617 204.80000000000001
r1086 n616 n617 0.42666666666666669
r1087 n550 n618 34.133333333333333
r1088 n617 n618 1.4933333333333334
r1089 n551 n619 40.960000000000001
r1090 n618 n619 2.3466666666666667
r1091 n552 n620 204.80000000000001
r1092 n619 n620 1.28
r1093 n553 n621 51.200000000000003
r1094 n620 n621 1.0666666666666667
r1095 n554 n622 40.960000000000001
r1096 n621 n622 1.9199999999999999
r1097 n555 n623 68.266666666666666
r1098 n622 n623 1.7066666666666668
r1099 n556 n624 29.257142857142856
r1100 n623 n624 2.1333333333333333
r1101 n557 n625 34.133333333333333
r1102 n624 n625 2.7733333333333334
r1103 n558 n626 20.48
r1104 n625 n626 3.4133333333333336
r1105 n559 n627 51.200000000000003
r1106 n626 n627 2.9866666666666668
r1107 n560 n628 29.257142857142856
r1108 n627 n628 2.3466666666666667
r1109 n561 n629 22.755555555555556
r1110 n628 n629 3.4133333333333336
r1111 n562 n630 51.200000000000003
r1112 n629 n630 2.7733333333333334
r1113 n563 n631 25.600000000000001
r1114 n630 n631 2.5600000000000001
r1115 n564 n632 40.960000000000001
r1116 n631 n632 2.7733333333333334
r1117 n565 n633 34.133333333333333
r1118 n632 n633 2.3466666666666667
r1119 n566 n634 102.40000000000001
r1120 n633 n634 1.7066666666666668
r1121 n567 n635 12.047058823529412
r1122 n634 n635 4.0533333333333337
r1123 n568 n636 15.753846153846155
r1124 n635 n636 6.4000000000000004
r1125 n569 n637 102.40000000000001
r1126 n636 n637 3.2000000000000002
r1127 n570 n638 102.40000000000001
r1128 n637 n638 0.85333333333333339
r1129 n571 n639 51.200000000000003
r1130 n638 n639 1.28
r1131 n572 n640 40.960000000000001
r1132 n639 n640 1.9199999999999999
r1133 n573 n641 25.600000000000001
r1134 n640 n641 2.7733333333333334
r1135 n574 n642 51.200000000000003
r1136 n641 n642 2.5600000000000001
r1137 n575 n643 15.753846153846155
r1138 n642 n643 3.6266666666666665
r1139 n576 n644 29.257142857142856
r1140 n643 n644 4.2666666666666666
r1141 n577 n645 7.5851851851851855
r1142 n644 n645 7.253333333333333
r1143 n578 n646 102.40000000000001
r1144 n645 n646 6.1866666666666665
r1145 n579 n647 40.960000000000001
r1146 n646 n647 1.4933333333333334
r1147 n580 n648 7.5851851851851855
r1148 n647 n648 6.8266666666666671
r1149 n581 n649 102.40000000000001
r1150 n648 n649 6.1866666666666665
r1151 n582 n650 6.0235294117647058
r1152 n583 n651 15.753846153846155
r1153 n650 n651 150.40000000000001
r1154 n584 n652 5.1200000000000001
r1155 n651 n652 169.59999999999999
r1156 n585 n653 204.80000000000001
r1157 n652 n653 131.19999999999999
r1158 n586 n654 6.2060606060606061
r1159 n653 n654 108.8
r1160 n587 n655 204.80000000000001
r1161 n654 n655 108.8
r1162 n588 n656 8.9043478260869566
r1163 n655 n656 76.799999999999997
r1164 n589 n657 51.200000000000003
r1165 n656 n657 86.400000000000006
r1166 n590 n658 34.133333333333333
r1167 n657 n658 32
r1168 n591 n659 40.960000000000001
r1169 n658 n659 35.200000000000003
r1170 n592 n660 204.80000000000001
r1171 n659 n660 19.199999999999999
r1172 n593 n661 15.753846153846155
r1173 n660 n661 44.799999999999997
r1174 n594 n662 20.48
r1175 n661 n662 73.599999999999994
r1176 n595 n663 40.960000000000001
r1177 n662 n663 48
r1178 n596 n664 40.960000000000001
r1179 n663 n664 32
r1180 n597 n665 204.80000000000001
r1181 n664 n665 19.199999999999999
r1182 n598 n666 68.266666666666666
r1183 n665 n666 12.800000000000001
r1184 n599 n667 204.80000000000001
r1185 n666 n667 12.800000000000001
r1186 n600 n668 22.755555555555556
r1187 n667 n668 32
r1188 n601 n669 20.48
r1189 n668 n669 60.799999999999997
r1190 n602 n670 40.960000000000001
r1191 n669 n670 48
r1192 n603 n671 40.960000000000001
r1193 n670 n671 32
r1194 n604 n672 204.80000000000001
r1195 n671 n672 19.199999999999999
r1196 n605 n673 102.40000000000001
r1197 n672 n673 9.5999999999999996
r1198 n606 n674 204.80000000000001
r1199 n673 n674 9.5999999999999996
r1200 n607 n675 204.80000000000001
r1201 n674 n675 6.4000000000000004
r1202 n608 n676 204.80000000000001
r1203 n675 n676 6.4000000000000004
r1204 n609 n677 51.200000000000003
r1205 n676 n677 16
r1206 n610 n678 40.960000000000001
r1207 n677 n678 28.800000000000001
r1208 n611 n679 204.80000000000001
r1209 n678 n679 19.199999999999999
r1210 n612 n680 20.48
r1211 n679 n680 35.200000000000003
r1212 n613 n681 68.266666666666666
r1213 n680 n681 41.600000000000001
r1214 n614 n682 34.133333333333333
r1215 n681 n682 28.800000000000001
r1216 n615 n683 102.40000000000001
r1217 n682 n683 25.600000000000001
r1218 n616 n684 204.80000000000001
r1219 n683 n684 9.5999999999999996
r1220 n617 n685 204.80000000000001
r1221 n684 n685 6.4000000000000004
r1222 n618 n686 34.133333333333333
r1223 n685 n686 22.399999999999999
r1224 n619 n687 40.960000000000001
r1225 n686 n687 35.200000000000003
r1226 n620 n688 204.80000000000001
r1227 n687 n688 19.199999999999999
r1228 n621 n689 51.200000000000003
r1229 n688 n689 16
r1230 n622 n690 40.960000000000001
r1231 n689 n690 28.800000000000001
r1232 n623 n691 68.266666666666666
r1233 n690 n691 25.600000000000001
r1234 n624 n692 29.257142857142856
r1235 n691 n692 32
r1236 n625 n693 34.133333333333333
r1237 n692 n693 41.600000000000001
r1238 n626 n694 20.48
r1239 n693 n694 51.200000000000003
r1240 n627 n695 51.200000000000003
r1241 n694 n695 44.799999999999997
r1242 n628 n696 29.257142857142856
r1243 n695 n696 35.200000000000003
r1244 n629 n697 22.755555555555556
r1245 n696 n697 51.200000000000003
r1246 n630 n698 51.200000000000003
r1247 n697 n698 41.600000000000001
r1248 n631 n699 25.600000000000001
r1249 n698 n699 38.399999999999999
r1250 n632 n700 40.960000000000001
r1251 n699 n700 41.600000000000001
r1252 n633 n701 34.133333333333333
r1253 n700 n701 35.200000000000003
r1254 n634 n702 102.40000000000001
r1255 n701 n702 25.600000000000001
r1256 n635 n703 12.047058823529412
r1257 n702 n703 60.799999999999997
r1258 n636 n704 15.753846153846155
r1259 n703 n704 96
r1260 n637 n705 102.40000000000001
r1261 n704 n705 48
r1262 n638 n706 102.40000000000001
r1263 n705 n706 12.800000000000001
r1264 n639 n707 51.200000000000003
r1265 n706 n707 19.199999999999999
r1266 n640 n708 40.960000000000001
r1267 n707 n708 28.800000000000001
r1268 n641 n709 25.600000000000001
r1269 n708 n709 41.600000000000001
r1270 n642 n710 51.200000000000003
r1271 n709 n710 38.399999999999999
r1272 n643 n711 15.753846153846155
r1273 n710 n711 54.399999999999999
r1274 n644 n712 29.257142857142856
r1275 n711 n712 64
r1276 n645 n713 7.5851851851851855
r1277 n712 n713 108.8
r1278 n646 n714 102.40000000000001
r1279 n713 n714 92.799999999999997
r1280 n647 n715 40.960000000000001
r1281 n714 n715 22.399999999999999
r1282 n648 n716 7.5851851851851855
r1283 n715 n716 102.40000000000001
r1284 n649 n717 102.40000000000001
r1285 n716 n717 92.799999999999997
r1286 n650 n718 2.447058823529412
r1287 n715 n719 16.640000000000001
r1288 n716 n720 3.0814814814814815
r1289 n719 n720 18.618181818181817
r1290 n717 n721 41.600000000000001
r1291 n720 n721 16.872727272727271
r1292 n718 n722 2.447058823529412
r1293 n719 n723 16.640000000000001
r1294 n720 n724 3.0814814814814815
r1295 n723 n724 102.40000000000001
r1296 n721 n725 41.600000000000001
r1297 n724 n725 92.799999999999997
r1298 n722 n726 6.9647058823529413
r1299 n723 n727 47.359999999999999
r1300 n724 n728 8.7703703703703706
r1301 n727 n728 5.8514285714285714
r1302 n725 n729 118.40000000000001
r1303 n728 n729 5.3028571428571425
r1304 n726 n730 12.988235294117647
r1305 n727 n731 88.319999999999993
r1306 n728 n732 16.355555555555554
r1307 n731 n732 6.0235294117647058
r1308 n729 n733 220.80000000000001
r1309 n732 n733 5.4588235294117649
r1310 n730 n734 7.7176470588235295
r1311 n731 n735 52.479999999999997
r1312 n732 n736 9.7185185185185183
r1313 n735 n736 29.257142857142856
r1314 n733 n737 131.19999999999999
r1315 n736 n737 26.514285714285716
r1316 n734 n738 1.6941176470588235
r1317 n735 n739 11.52
r1318 n736 n740 2.1333333333333333
r1319 n739 n740 102.40000000000001
r1320 n737 n741 28.800000000000001
r1321 n740 n741 92.799999999999997
r1322 n738 n742 1.3176470588235294
r1323 n739 n743 8.9600000000000009
r1324 n740 n744 1.6592592592592592
r1325 n743 n744 40.960000000000001
r1326 n741 n745 22.399999999999999
r1327 n744 n745 37.119999999999997
r1328 n742 n746 2.0705882352941178
r1329 n743 n747 14.08
r1330 n744 n748 2.6074074074074076
r1331 n747 n748 34.133333333333333
r1332 n745 n749 35.200000000000003
r1333 n748 n749 30.933333333333334
r1334 n746 n750 1.5058823529411764
r1335 n751 n752 32
r1336 n752 n753 35.200000000000003
r1337 n753 n754 19.199999999999999
r1338 n754 n755 44.799999999999997
r1339 n755 n756 73.599999999999994
r1340 n756 n757 48
r1341 n757 n758 32
r1342 n758 n759 19.199999999999999
r1343 n759 n760 12.800000000000001
r1344 n760 n761 12.800000000000001
r1345 n761 n762 32
r1346 n762 n763 60.799999999999997
r1347 n763 n764 48
r1348 n764 n765 32
r1349 n765 n766 19.199999999999999
r1350 n766 n767 9.5999999999999996
r1351 n767 n768 9.5999999999999996
r1352 n768 n769 6.4000000000000004
r1353 n769 n770 6.4000000000000004
r1354 n770 n771 16
r1355 n771 n772 28.800000000000001
r1356 n772 n773 19.199999999999999
r1357 n773 n774 35.200000000000003
r1358 n774 n775 41.600000000000001
r1359 n775 n776 28.800000000000001
r1360 n776 n777 25.600000000000001
r1361 n777 n778 9.5999999999999996
r1362 n778 n779 6.4000000000000004
r1363 n779 n780 22.399999999999999
r1364 n780 n781 35.200000000000003
r1365 n781 n782 19.199999999999999
r1366 n782 n783 16
r1367 n747 n784 10.24
r1368 n748 n785 1.8962962962962964
r1369 n784 n785 102.40000000000001
r1370 n749 n786 25.600000000000001
r1371 n785 n786 92.799999999999997
r1372 n750 n787 3.388235294117647
r1373 n751 n788 28.800000000000001
r1374 n752 n789 19.199999999999999
r1375 n788 n789 4
r1376 n753 n790 23.039999999999999
r1377 n789 n790 4.4000000000000004
r1378 n754 n791 115.2
r1379 n790 n791 2.3999999999999999
r1380 n755 n792 8.861538461538462
r1381 n791 n792 5.5999999999999996
r1382 n756 n793 11.52
r1383 n792 n793 9.1999999999999993
r1384 n757 n794 23.039999999999999
r1385 n793 n794 6
r1386 n758 n795 23.039999999999999
r1387 n794 n795 4
r1388 n759 n796 115.2
r1389 n795 n796 2.3999999999999999
r1390 n760 n797 38.399999999999999
r1391 n796 n797 1.6000000000000001
r1392 n761 n798 115.2
r1393 n797 n798 1.6000000000000001
r1394 n762 n799 12.800000000000001
r1395 n798 n799 4
r1396 n763 n800 11.52
r1397 n799 n800 7.5999999999999996
r1398 n764 n801 23.039999999999999
r1399 n800 n801 6
r1400 n765 n802 23.039999999999999
r1401 n801 n802 4
r1402 n766 n803 115.2
r1403 n802 n803 2.3999999999999999
r1404 n767 n804 57.600000000000001
r1405 n803 n804 1.2
r1406 n768 n805 115.2
r1407 n804 n805 1.2
r1408 n769 n806 115.2
r1409 n805 n806 0.80000000000000004
r1410 n770 n807 115.2
r1411 n806 n807 0.80000000000000004
r1412 n771 n808 28.800000000000001
r1413 n807 n808 2
r1414 n772 n809 23.039999999999999
r1415 n808 n809 3.6000000000000001
r1416 n773 n810 115.2
r1417 n809 n810 2.3999999999999999
r1418 n774 n811 11.52
r1419 n810 n811 4.4000000000000004
r1420 n775 n812 38.399999999999999
r1421 n811 n812 5.2000000000000002
r1422 n776 n813 19.199999999999999
r1423 n812 n813 3.6000000000000001
r1424 n777 n814 57.600000000000001
r1425 n813 n814 3.2000000000000002
r1426 n778 n815 115.2
r1427 n814 n815 1.2
r1428 n779 n816 115.2
r1429 n815 n816 0.80000000000000004
r1430 n780 n817 19.199999999999999
r1431 n816 n817 2.7999999999999998
r1432 n781 n818 23.039999999999999
r1433 n817 n818 4.4000000000000004
r1434 n782 n819 115.2
r1435 n818 n819 2.3999999999999999
r1436 n783 n820 28.800000000000001
r1437 n819 n820 2
r1438 n784 n821 23.039999999999999
r1439 n785 n822 4.2666666666666666
r1440 n821 n822 12.800000000000001
r1441 n786 n823 57.600000000000001
r1442 n822 n823 11.6
r1443 n787 n824 5.6470588235294121
r1444 n788 n825 48
r1445 n789 n826 32
r1446 n825 n826 4.5714285714285712
r1447 n790 n827 38.399999999999999
r1448 n826 n827 5.0285714285714285
r1449 n791 n828 192
r1450 n827 n828 2.7428571428571429
r1451 n792 n829 14.76923076923077
r1452 n828 n829 6.4000000000000004
r1453 n793 n830 19.199999999999999
r1454 n829 n830 10.514285714285714
r1455 n794 n831 38.399999999999999
r1456 n830 n831 6.8571428571428568
r1457 n795 n832 38.399999999999999
r1458 n831 n832 4.5714285714285712
r1459 n796 n833 192
r1460 n832 n833 2.7428571428571429
r1461 n797 n834 64
r1462 n833 n834 1.8285714285714285
r1463 n798 n835 192
r1464 n834 n835 1.8285714285714285
r1465 n799 n836 21.333333333333332
r1466 n835 n836 4.5714285714285712
r1467 n800 n837 19.199999999999999
r1468 n836 n837 8.6857142857142851
r1469 n801 n838 38.399999999999999
r1470 n837 n838 6.8571428571428568
r1471 n802 n839 38.399999999999999
r1472 n838 n839 4.5714285714285712
r1473 n803 n840 192
r1474 n839 n840 2.7428571428571429
r1475 n804 n841 96
r1476 n840 n841 1.3714285714285714
r1477 n805 n842 192
r1478 n841 n842 1.3714285714285714
r1479 n806 n843 192
r1480 n842 n843 0.91428571428571426
r1481 n807 n844 192
r1482 n843 n844 0.91428571428571426
r1483 n808 n845 48
r1484 n844 n845 2.2857142857142856
r1485 n809 n846 38.399999999999999
r1486 n845 n846 4.1142857142857139
r1487 n810 n847 192
r1488 n846 n847 2.7428571428571429
r1489 n811 n848 19.199999999999999
r1490 n847 n848 5.0285714285714285
r1491 n812 n849 64
r1492 n848 n849 5.9428571428571431
r1493 n813 n850 32
r1494 n849 n850 4.1142857142857139
r1495 n814 n851 96
r1496 n850 n851 3.657142857142857
r1497 n815 n852 192
r1498 n851 n852 1.3714285714285714
r1499 n816 n853 192
r1500 n852 n853 0.91428571428571426
r1501 n817 n854 32
r1502 n853 n854 3.2000000000000002
r1503 n818 n855 38.399999999999999
r1504 n854 n855 5.0285714285714285
r1505 n819 n856 192
r1506 n855 n856 2.7428571428571429
r1507 n820 n857 48
r1508 n856 n857 2.2857142857142856
r1509 n821 n858 38.399999999999999
r1510 n822 n859 7.1111111111111107
r1511 n858 n859 14.628571428571428
r1512 n823 n860 96
r1513 n859 n860 13.257142857142858
r1514 n824 n861 3.0117647058823529
r1515 n825 n862 25.600000000000001
r1516 n826 n863 17.066666666666666
r1517 n862 n863 32
r1518 n827 n864 20.48
r1519 n863 n864 35.200000000000003
r1520 n828 n865 102.40000000000001
r1521 n864 n865 19.199999999999999
r1522 n829 n866 7.8769230769230774
r1523 n865 n866 44.799999999999997
r1524 n830 n867 10.24
r1525 n866 n867 73.599999999999994
r1526 n831 n868 20.48
r1527 n867 n868 48
r1528 n832 n869 20.48
r1529 n868 n869 32
r1530 n833 n870 102.40000000000001
r1531 n869 n870 19.199999999999999
r1532 n834 n871 34.133333333333333
r1533 n870 n871 12.800000000000001
r1534 n835 n872 102.40000000000001
r1535 n871 n872 12.800000000000001
r1536 n836 n873 11.377777777777778
r1537 n872 n873 32
r1538 n837 n874 10.24
r1539 n873 n874 60.799999999999997
r1540 n838 n875 20.48
r1541 n874 n875 48
r1542 n839 n876 20.48
r1543 n875 n876 32
r1544 n840 n877 102.40000000000001
r1545 n876 n877 19.199999999999999
r1546 n841 n878 51.200000000000003
r1547 n877 n878 9.5999999999999996
r1548 n842 n879 102.40000000000001
r1549 n878 n879 9.5999999999999996
r1550 n843 n880 102.40000000000001
r1551 n879 n880 6.4000000000000004
r1552 n844 n881 102.40000000000001
r1553 n880 n881 6.4000000000000004
r1554 n845 n882 25.600000000000001
r1555 n881 n882 16
r1556 n846 n883 20.48
r1557 n882 n883 28.800000000000001
r1558 n847 n884 102.40000000000001
r1559 n883 n884 19.199999999999999
r1560 n848 n885 10.24
r1561 n884 n885 35.200000000000003
r1562 n849 n886 34.133333333333333
r1563 n885 n886 41.600000000000001
r1564 n850 n887 17.066666666666666
r1565 n886 n887 28.800000000000001
r1566 n851 n888 51.200000000000003
r1567 n887 n888 25.600000000000001
r1568 n852 n889 102.40000000000001
r1569 n888 n889 9.5999999999999996
r1570 n853 n890 102.40000000000001
r1571 n889 n890 6.4000000000000004
r1572 n854 n891 17.066666666666666
r1573 n890 n891 22.399999999999999
r1574 n855 n892 20.48
r1575 n891 n892 35.200000000000003
r1576 n856 n893 102.40000000000001
r1577 n892 n893 19.199999999999999
r1578 n857 n894 25.600000000000001
r1579 n893 n894 16
r1580 n858 n895 20.48
r1581 n859 n896 3.7925925925925927
r1582 n895 n896 102.40000000000001
r1583 n860 n897 51.200000000000003
r1584 n896 n897 92.799999999999997
r1585 n861 n898 1.1294117647058823
r1586 n895 n899 7.6799999999999997
r1587 n896 n900 1.4222222222222223
r1588 n899 n900 51.200000000000003
r1589 n897 n901 19.199999999999999
r1590 n900 n901 46.399999999999999
r1591 n898 n902 1.1294117647058823
r1592 n903 n904 60.799999999999997
r1593 n904 n905 96
r1594 n905 n906 48
r1595 n899 n907 7.6799999999999997
r1596 n900 n908 1.4222222222222223
r1597 n907 n908 102.40000000000001
r1598 n901 n909 19.199999999999999
r1599 n908 n909 92.799999999999997
r1600 n902 n910 0.56470588235294117
r1601 n903 n911 9.5999999999999996
r1602 n904 n912 1.1294117647058823
r1603 n911 n912 121.59999999999999
r1604 n905 n913 1.476923076923077
r1605 n912 n913 192
r1606 n906 n914 9.5999999999999996
r1607 n913 n914 96
r1608 n907 n915 3.8399999999999999
r1609 n908 n916 0.71111111111111114
r1610 n915 n916 204.80000000000001
r1611 n909 n917 9.5999999999999996
r1612 n916 n917 185.59999999999999
r1613 n910 n918 0.94117647058823528
r1614 n911 n919 16
r1615 n912 n920 1.8823529411764706
r1616 n919 n920 30.399999999999999
r1617 n913 n921 2.4615384615384617
r1618 n920 n921 48
r1619 n914 n922 16
r1620 n921 n922 24
r1621 n915 n923 6.4000000000000004
r1622 n916 n924 1.1851851851851851
r1623 n923 n924 51.200000000000003
r1624 n917 n925 16
r1625 n924 n925 46.399999999999999
r1626 n918 n926 1.1294117647058823
r1627 n919 n927 19.199999999999999
r1628 n920 n928 2.2588235294117647
r1629 n927 n928 60.799999999999997
r1630 n921 n929 2.953846153846154
r1631 n928 n929 96
r1632 n922 n930 19.199999999999999
r1633 n929 n930 48
r1634 n923 n931 7.6799999999999997
r1635 n924 n932 1.4222222222222223
r1636 n931 n932 102.40000000000001
r1637 n925 n933 19.199999999999999
r1638 n932 n933 92.799999999999997
r1639 n926 n934 1.3176470588235294
r1640 n927 n935 22.399999999999999
r1641 n928 n936 2.6352941176470588
r1642 n935 n936 24.32
r1643 n929 n937 3.4461538461538463
r1644 n936 n937 38.399999999999999
r1645 n930 n938 22.399999999999999
r1646 n937 n938 19.199999999999999
r1647 n931 n939 8.9600000000000009
r1648 n932 n940 1.6592592592592592
r1649 n939 n940 40.960000000000001
r1650 n933 n941 22.399999999999999
r1651 n940 n941 37.119999999999997
r1652 n934 n942 1.3176470588235294
r1653 n935 n943 22.399999999999999
r1654 n936 n944 2.6352941176470588
r1655 n943 n944 60.799999999999997
r1656 n937 n945 3.4461538461538463
r1657 n944 n945 96
r1658 n938 n946 22.399999999999999
r1659 n945 n946 48
r1660 n939 n947 8.9600000000000009
r1661 n940 n948 1.6592592592592592
r1662 n947 n948 102.40000000000001
r1663 n941 n949 22.399999999999999
r1664 n948 n949 92.799999999999997
r1665 n942 n950 0.75294117647058822
r1666 n943 n951 12.800000000000001
r1667 n944 n952 1.5058823529411764
r1668 n951 n952 60.799999999999997
r1669 n945 n953 1.9692307692307693
r1670 n952 n953 96
r1671 n946 n954 12.800000000000001
r1672 n953 n954 48
r1673 n947 n955 5.1200000000000001
r1674 n948 n956 0.94814814814814818
r1675 n955 n956 102.40000000000001
r1676 n949 n957 12.800000000000001
r1677 n956 n957 92.799999999999997
r1678 n950 n958 5.6470588235294121
r1679 n951 n959 96
r1680 n952 n960 11.294117647058824
r1681 n959 n960 4.3428571428571425
r1682 n953 n961 14.76923076923077
r1683 n960 n961 6.8571428571428568
r1684 n954 n962 96
r1685 n961 n962 3.4285714285714284
r1686 n955 n963 38.399999999999999
r1687 n956 n964 7.1111111111111107
r1688 n963 n964 7.3142857142857141
r1689 n957 n965 96
r1690 n964 n965 6.628571428571429
r1691 n958 n966 5.6470588235294121
r1692 n959 n967 96
r1693 n960 n968 11.294117647058824
r1694 n967 n968 60.799999999999997
r1695 n961 n969 14.76923076923077
r1696 n968 n969 96
r1697 n962 n970 96
r1698 n969 n970 48
r1699 n963 n971 38.399999999999999
r1700 n964 n972 7.1111111111111107
r1701 n971 n972 102.40000000000001
r1702 n965 n973 96
r1703 n972 n973 92.799999999999997
r1704 n966 n974 0.75294117647058822
r1705 n967 n975 12.800000000000001
r1706 n968 n976 1.5058823529411764
r1707 n975 n976 60.799999999999997
r1708 n969 n977 1.9692307692307693
r1709 n976 n977 96
r1710 n970 n978 12.800000000000001
r1711 n977 n978 48
r1712 n971 n979 5.1200000000000001
r1713 n972 n980 0.94814814814814818
r1714 n979 n980 102.40000000000001
r1715 n973 n981 12.800000000000001
r1716 n980 n981 92.799999999999997
r1717 n974 n982 0.75294117647058822
r1718 n975 n983 12.800000000000001
r1719 n976 n984 1.5058823529411764
r1720 n983 n984 60.799999999999997
r1721 n977 n985 1.9692307692307693
r1722 n984 n985 96
r1723 n978 n986 12.800000000000001
r1724 n985 n986 48
r1725 n979 n987 5.1200000000000001
r1726 n980 n988 0.94814814814814818
r1727 n987 n988 102.40000000000001
r1728 n981 n989 12.800000000000001
r1729 n988 n989 92.799999999999997
r1730 n982 n990 1.1294117647058823
r1731 n983 n991 19.199999999999999
r1732 n984 n992 2.2588235294117647
r1733 n991 n992 30.399999999999999
r1734 n985 n993 2.953846153846154
r1735 n992 n993 48
r1736 n986 n994 19.199999999999999
r1737 n993 n994 24
r1738 n987 n995 7.6799999999999997
r1739 n988 n996 1.4222222222222223
r1740 n995 n996 51.200000000000003
r1741 n989 n997 19.199999999999999
r1742 n996 n997 46.399999999999999
r1743 n990 n998 2.0705882352941178
r1744 n991 n999 35.200000000000003
r1745 n992 n1000 4.1411764705882357
r1746 n999 n1000 17.37142857142857
r1747 n993 n1001 5.4153846153846157
r1748 n1000 n1001 27.428571428571427
r1749 n994 n1002 35.200000000000003
r1750 n1001 n1002 13.714285714285714
r1751 n995 n1003 14.08
r1752 n996 n1004 2.6074074074074076
r1753 n1003 n1004 29.257142857142856
r1754 n997 n1005 35.200000000000003
r1755 n1004 n1005 26.514285714285716
r1756 n998 n1006 1.8823529411764706
r1757 n999 n1007 32
r1758 n1000 n1008 3.7647058823529411
r1759 n1007 n1008 40.533333333333331
r1760 n1001 n1009 4.9230769230769234
r1761 n1008 n1009 64
r1762 n1002 n1010 32
r1763 n1009 n1010 32
r1764 n1003 n1011 12.800000000000001
r1765 n1004 n1012 2.3703703703703702
r1766 n1011 n1012 68.266666666666666
r1767 n1005 n1013 32
r1768 n1012 n1013 61.866666666666667
r1769 n1006 n1014 1.1294117647058823
r1770 n1011 n1015 7.6799999999999997
r1771 n1012 n1016 1.4222222222222223
r1772 n1015 n1016 68.266666666666666
r1773 n1013 n1017 19.199999999999999
r1774 n1016 n1017 61.866666666666667
r1775 n1014 n1018 0.94117647058823528
r1776 n1019 n1020 32
r1777 n1020 n1021 35.200000000000003
r1778 n1021 n1022 19.199999999999999
r1779 n1022 n1023 44.799999999999997
r1780 n1023 n1024 73.599999999999994
r1781 n1024 n1025 48
r1782 n1025 n1026 32
r1783 n1026 n1027 19.199999999999999
r1784 n1027 n1028 12.800000000000001
r1785 n1028 n1029 12.800000000000001
r1786 n1029 n1030 32
r1787 n1030 n1031 60.799999999999997
r1788 n1031 n1032 48
r1789 n1032 n1033 32
r1790 n1033 n1034 19.199999999999999
r1791 n1034 n1035 9.5999999999999996
r1792 n1035 n1036 9.5999999999999996
r1793 n1036 n1037 6.4000000000000004
r1794 n1037 n1038 6.4000000000000004
r1795 n1038 n1039 16
r1796 n1039 n1040 28.800000000000001
r1797 n1040 n1041 19.199999999999999
r1798 n1041 n1042 35.200000000000003
r1799 n1042 n1043 41.600000000000001
r1800 n1043 n1044 28.800000000000001
r1801 n1044 n1045 25.600000000000001
r1802 n1045 n1046 9.5999999999999996
r1803 n1046 n1047 6.4000000000000004
r1804 n1047 n1048 22.399999999999999
r1805 n1048 n1049 35.200000000000003
r1806 n1049 n1050 19.199999999999999
r1807 n1050 n1051 16
r1808 n1015 n1052 6.4000000000000004
r1809 n1016 n1053 1.1851851851851851
r1810 n1052 n1053 102.40000000000001
r1811 n1017 n1054 16
r1812 n1053 n1054 92.799999999999997
r1813 n1018 n1055 3.2000000000000002
r1814 n1019 n1056 27.199999999999999
r1815 n1020 n1057 18.133333333333333
r1816 n1056 n1057 4.2666666666666666
r1817 n1021 n1058 21.760000000000002
r1818 n1057 n1058 4.6933333333333334
r1819 n1022 n1059 108.8
r1820 n1058 n1059 2.5600000000000001
r1821 n1023 n1060 8.3692307692307697
r1822 n1059 n1060 5.9733333333333336
r1823 n1024 n1061 10.880000000000001
r1824 n1060 n1061 9.8133333333333326
r1825 n1025 n1062 21.760000000000002
r1826 n1061 n1062 6.4000000000000004
r1827 n1026 n1063 21.760000000000002
r1828 n1062 n1063 4.2666666666666666
r1829 n1027 n1064 108.8
r1830 n1063 n1064 2.5600000000000001
r1831 n1028 n1065 36.266666666666666
r1832 n1064 n1065 1.7066666666666668
r1833 n1029 n1066 108.8
r1834 n1065 n1066 1.7066666666666668
r1835 n1030 n1067 12.088888888888889
r1836 n1066 n1067 4.2666666666666666
r1837 n1031 n1068 10.880000000000001
r1838 n1067 n1068 8.1066666666666674
r1839 n1032 n1069 21.760000000000002
r1840 n1068 n1069 6.4000000000000004
r1841 n1033 n1070 21.760000000000002
r1842 n1069 n1070 4.2666666666666666
r1843 n1034 n1071 108.8
r1844 n1070 n1071 2.5600000000000001
r1845 n1035 n1072 54.399999999999999
r1846 n1071 n1072 1.28
r1847 n1036 n1073 108.8
r1848 n1072 n1073 1.28
r1849 n1037 n1074 108.8
r1850 n1073 n1074 0.85333333333333339
r1851 n1038 n1075 108.8
r1852 n1074 n1075 0.85333333333333339
r1853 n1039 n1076 27.199999999999999
r1854 n1075 n1076 2.1333333333333333
r1855 n1040 n1077 21.760000000000002
r1856 n1076 n1077 3.8399999999999999
r1857 n1041 n1078 108.8
r1858 n1077 n1078 2.5600000000000001
r1859 n1042 n1079 10.880000000000001
r1860 n1078 n1079 4.6933333333333334
r1861 n1043 n1080 36.266666666666666
r1862 n1079 n1080 5.5466666666666669
r1863 n1044 n1081 18.133333333333333
r1864 n1080 n1081 3.8399999999999999
r1865 n1045 n1082 54.399999999999999
r1866 n1081 n1082 3.4133333333333336
r1867 n1046 n1083 108.8
r1868 n1082 n1083 1.28
r1869 n1047 n1084 108.8
r1870 n1083 n1084 0.85333333333333339
r1871 n1048 n1085 18.133333333333333
r1872 n1084 n1085 2.9866666666666668
r1873 n1049 n1086 21.760000000000002
r1874 n1085 n1086 4.6933333333333334
r1875 n1050 n1087 108.8
r1876 n1086 n1087 2.5600000000000001
r1877 n1051 n1088 27.199999999999999
r1878 n1087 n1088 2.1333333333333333
r1879 n1052 n1089 21.760000000000002
r1880 n1053 n1090 4.0296296296296292
r1881 n1089 n1090 13.653333333333334
r1882 n1054 n1091 54.399999999999999
r1883 n1090 n1091 12.373333333333333
r1884 n1055 n1092 5.6470588235294121
r1885 n1056 n1093 48
r1886 n1057 n1094 32
r1887 n1093 n1094 4.2666666666666666
r1888 n1058 n1095 38.399999999999999
r1889 n1094 n1095 4.6933333333333334
r1890 n1059 n1096 192
r1891 n1095 n1096 2.5600000000000001
r1892 n1060 n1097 14.76923076923077
r1893 n1096 n1097 5.9733333333333336
r1894 n1061 n1098 19.199999999999999
r1895 n1097 n1098 9.8133333333333326
r1896 n1062 n1099 38.399999999999999
r1897 n1098 n1099 6.4000000000000004
r1898 n1063 n1100 38.399999999999999
r1899 n1099 n1100 4.2666666666666666
r1900 n1064 n1101 192
r1901 n1100 n1101 2.5600000000000001
r1902 n1065 n1102 64
r1903 n1101 n1102 1.7066666666666668
r1904 n1066 n1103 192
r1905 n1102 n1103 1.7066666666666668
r1906 n1067 n1104 21.333333333333332
r1907 n1103 n1104 4.2666666666666666
r1908 n1068 n1105 19.199999999999999
r1909 n1104 n1105 8.1066666666666674
r1910 n1069 n1106 38.399999999999999
r1911 n1105 n1106 6.4000000000000004
r1912 n1070 n1107 38.399999999999999
r1913 n1106 n1107 4.2666666666666666
r1914 n1071 n1108 192
r1915 n1107 n1108 2.5600000000000001
r1916 n1072 n1109 96
r1917 n1108 n1109 1.28
r1918 n1073 n1110 192
r1919 n1109 n1110 1.28
r1920 n1074 n1111 192
r1921 n1110 n1111 0.85333333333333339
r1922 n1075 n1112 192
r1923 n1111 n1112 0.85333333333333339
r1924 n1076 n1113 48
r1925 n1112 n1113 2.1333333333333333
r1926 n1077 n1114 38.399999999999999
r1927 n1113 n1114 3.8399999999999999
r1928 n1078 n1115 192
r1929 n1114 n1115 2.5600000000000001
r1930 n1079 n1116 19.199999999999999
r1931 n1115 n1116 4.6933333333333334
r1932 n1080 n1117 64
r1933 n1116 n1117 5.5466666666666669
r1934 n1081 n1118 32
r1935 n1117 n1118 3.8399999999999999
r1936 n1082 n1119 96
r1937 n1118 n1119 3.4133333333333336
r1938 n1083 n1120 192
r1939 n1119 n1120 1.28
r1940 n1084 n1121 192
r1941 n1120 n1121 0.85333333333333339
r1942 n1085 n1122 32
r1943 n1121 n1122 2.9866666666666668
r1944 n1086 n1123 38.399999999999999
r1945 n1122 n1123 4.6933333333333334
r1946 n1087 n1124 192
r1947 n1123 n1124 2.5600000000000001
r1948 n1088 n1125 48
r1949 n1124 n1125 2.1333333333333333
r1950 n1089 n1126 38.399999999999999
r1951 n1090 n1127 7.1111111111111107
r1952 n1126 n1127 13.653333333333334
r1953 n1091 n1128 96
r1954 n1127 n1128 12.373333333333333
r1955 n1092 n1129 3.2000000000000002
r1956 n1093 n1130 27.199999999999999
r1957 n1094 n1131 18.133333333333333
r1958 n1130 n1131 32
r1959 n1095 n1132 21.760000000000002
r1960 n1131 n1132 35.200000000000003
r1961 n1096 n1133 108.8
r1962 n1132 n1133 19.199999999999999
r1963 n1097 n1134 8.3692307692307697
r1964 n1133 n1134 44.799999999999997
r1965 n1098 n1135 10.880000000000001
r1966 n1134 n1135 73.599999999999994
r1967 n1099 n1136 21.760000000000002
r1968 n1135 n1136 48
r1969 n1100 n1137 21.760000000000002
r1970 n1136 n1137 32
r1971 n1101 n1138 108.8
r1972 n1137 n1138 19.199999999999999
r1973 n1102 n1139 36.266666666666666
r1974 n1138 n1139 12.800000000000001
r1975 n1103 n1140 108.8
r1976 n1139 n1140 12.800000000000001
r1977 n1104 n1141 12.088888888888889
r1978 n1140 n1141 32
r1979 n1105 n1142 10.880000000000001
r1980 n1141 n1142 60.799999999999997
r1981 n1106 n1143 21.760000000000002
r1982 n1142 n1143 48
r1983 n1107 n1144 21.760000000000002
r1984 n1143 n1144 32
r1985 n1108 n1145 108.8
r1986 n1144 n1145 19.199999999999999
r1987 n1109 n1146 54.399999999999999
r1988 n1145 n1146 9.5999999999999996
r1989 n1110 n1147 108.8
r1990 n1146 n1147 9.5999999999999996
r1991 n1111 n1148 108.8
r1992 n1147 n1148 6.4000000000000004
r1993 n1112 n1149 108.8
r1994 n1148 n1149 6.4000000000000004
r1995 n1113 n1150 27.199999999999999
r1996 n1149 n1150 16
r1997 n1114 n1151 21.760000000000002
r1998 n1150 n1151 28.800000000000001
r1999 n1115 n1152 108.8
r2000 n1151 n1152 19.199999999999999
r2001 n1116 n1153 10.880000000000001
r2002 n1152 n1153 35.200000000000003
r2003 n1117 n1154 36.266666666666666
r2004 n1153 n1154 41.600000000000001
r2005 n1118 n1155 18.133333333333333
r2006 n1154 n1155 28.800000000000001
r2007 n1119 n1156 54.399999999999999
r2008 n1155 n1156 25.600000000000001
r2009 n1120 n1157 108.8
r2010 n1156 n1157 9.5999999999999996
r2011 n1121 n1158 108.8
r2012 n1157 n1158 6.4000000000000004
r2013 n1122 n1159 18.133333333333333
r2014 n1158 n1159 22.399999999999999
r2015 n1123 n1160 21.760000000000002
r2016 n1159 n1160 35.200000000000003
r2017 n1124 n1161 108.8
r2018 n1160 n1161 19.199999999999999
r2019 n1125 n1162 27.199999999999999
r2020 n1161 n1162 16
r2021 n1126 n1163 21.760000000000002
r2022 n1127 n1164 4.0296296296296292
r2023 n1163 n1164 102.40000000000001
r2024 n1128 n1165 54.399999999999999
r2025 n1164 n1165 92.799999999999997
r2026 n1129 n1166 0.94117647058823528
r2027 n1163 n1167 6.4000000000000004
r2028 n1164 n1168 1.1851851851851851
r2029 n1167 n1168 68.266666666666666
r2030 n1165 n1169 16
r2031 n1168 n1169 61.866666666666667
r2032 n1166 n1170 1.1294117647058823
r2033 n1167 n1171 7.6799999999999997
r2034 n1168 n1172 1.4222222222222223
r2035 n1171 n1172 68.266666666666666
r2036 n1169 n1173 19.199999999999999
r2037 n1172 n1173 61.866666666666667
r2038 n1170 n1174 1.8823529411764706
r2039 n1171 n1175 12.800000000000001
r2040 n1172 n1176 2.3703703703703702
r2041 n1175 n1176 29.257142857142856
r2042 n1173 n1177 32
r2043 n1176 n1177 26.514285714285716
r2044 n1174 n1178 2.8235294117647061
r2045 n1175 n1179 19.199999999999999
r2046 n1176 n1180 3.5555555555555554
r2047 n1179 n1180 25.600000000000001
r2048 n1177 n1181 48
r2049 n1180 n1181 23.199999999999999
r2050 n1178 n1182 1.8823529411764706
r2051 n1179 n1183 12.800000000000001
r2052 n1180 n1184 2.3703703703703702
r2053 n1183 n1184 102.40000000000001
r2054 n1181 n1185 32
r2055 n1184 n1185 92.799999999999997
r2056 n1182 n1186 6.4000000000000004
r2057 n1183 n1187 43.520000000000003
r2058 n1184 n1188 8.0592592592592585
r2059 n1187 n1188 6.4000000000000004
r2060 n1185 n1189 108.8
r2061 n1188 n1189 5.7999999999999998
r2062 n1186 n1190 14.870588235294118
r2063 n1187 n1191 101.12
r2064 n1188 n1192 18.725925925925925
r2065 n1191 n1192 4.3574468085106384
r2066 n1189 n1193 252.80000000000001
r2067 n1192 n1193 3.9489361702127659
r2068 n1190 n1194 15.247058823529411
r2069 n1194 n1195 8.8470588235294123
r2070 n1195 n1196 9.9764705882352942
r2071 n1196 n1197 7.7176470588235295
r2072 n1197 n1198 6.4000000000000004
r2073 n1198 n1199 6.4000000000000004
r2074 n1199 n1200 4.5176470588235293
r2075 n1200 n1201 5.0823529411764703
r2076 n1201 n1202 1.8823529411764706
r2077 n1202 n1203 2.0705882352941178
r2078 n1203 n1204 1.1294117647058823
r2079 n1204 n1205 2.6352941176470588
r2080 n1205 n1206 4.3294117647058821
r2081 n1206 n1207 2.8235294117647061
r2082 n1207 n1208 1.8823529411764706
r2083 n1208 n1209 1.1294117647058823
r2084 n1209 n1210 0.75294117647058822
r2085 n1210 n1211 0.75294117647058822
r2086 n1211 n1212 1.8823529411764706
r2087 n1212 n1213 3.5764705882352943
r2088 n1213 n1214 2.8235294117647061
r2089 n1214 n1215 1.8823529411764706
r2090 n1215 n1216 1.1294117647058823
r2091 n1216 n1217 0.56470588235294117
r2092 n1217 n1218 0.56470588235294117
r2093 n1218 n1219 0.37647058823529411
r2094 n1219 n1220 0.37647058823529411
r2095 n1220 n1221 0.94117647058823528
r2096 n1221 n1222 1.6941176470588235
r2097 n1222 n1223 1.1294117647058823
r2098 n1223 n1224 2.0705882352941178
r2099 n1224 n1225 2.447058823529412
r2100 n1225 n1226 1.6941176470588235
r2101 n1226 n1227 1.5058823529411764
r2102 n1227 n1228 0.56470588235294117
r2103 n1228 n1229 0.37647058823529411
r2104 n1229 n1230 1.3176470588235294
r2105 n1230 n1231 2.0705882352941178
r2106 n1231 n1232 1.1294117647058823
r2107 n1232 n1233 0.94117647058823528
r2108 n1233 n1234 1.6941176470588235
r2109 n1234 n1235 1.5058823529411764
r2110 n1235 n1236 1.8823529411764706
r2111 n1236 n1237 2.447058823529412
r2112 n1237 n1238 3.0117647058823529
r2113 n1238 n1239 2.6352941176470588
r2114 n1239 n1240 2.0705882352941178
r2115 n1240 n1241 3.0117647058823529
r2116 n1241 n1242 2.447058823529412
r2117 n1242 n1243 2.2588235294117647
r2118 n1243 n1244 2.447058823529412
r2119 n1244 n1245 2.0705882352941178
r2120 n1245 n1246 1.5058823529411764
r2121 n1246 n1247 3.5764705882352943
r2122 n1247 n1248 5.6470588235294121
r2123 n1248 n1249 2.8235294117647061
r2124 n1249 n1250 0.75294117647058822
r2125 n1250 n1251 1.1294117647058823
r2126 n1251 n1252 1.6941176470588235
r2127 n1252 n1253 2.447058823529412
r2128 n1253 n1254 2.2588235294117647
r2129 n1254 n1255 3.2000000000000002
r2130 n1255 n1256 3.7647058823529411
r2131 n1256 n1257 6.4000000000000004
r2132 n1257 n1258 5.4588235294117649
r2133 n1191 n1259 103.68000000000001
r2134 n1258 n1259 1.3176470588235294
r2135 n1192 n1260 19.199999999999999
r2136 n1259 n1260 6.0235294117647058
r2137 n1193 n1261 259.19999999999999
r2138 n1260 n1261 5.4588235294117649
r2139 n1262 n1263 196.48000000000002
r2140 n1263 n1264 176
r2141 n1264 n1265 197.12
r2142 n1265 n1266 150.40000000000001
r2143 n1266 n1267 169.59999999999999
r2144 n1267 n1268 131.19999999999999
r2145 n1268 n1269 108.8
r2146 n1269 n1270 108.8
r2147 n1270 n1271 76.799999999999997
r2148 n1271 n1272 86.400000000000006
r2149 n1272 n1273 32
r2150 n1273 n1274 35.200000000000003
r2151 n1274 n1275 19.199999999999999
r2152 n1275 n1276 44.799999999999997
r2153 n1276 n1277 73.599999999999994
r2154 n1277 n1278 48
r2155 n1278 n1279 32
r2156 n1279 n1280 19.199999999999999
r2157 n1280 n1281 12.800000000000001
r2158 n1281 n1282 12.800000000000001
r2159 n1282 n1283 32
r2160 n1283 n1284 60.799999999999997
r2161 n1284 n1285 48
r2162 n1285 n1286 32
r2163 n1286 n1287 19.199999999999999
r2164 n1287 n1288 9.5999999999999996
r2165 n1288 n1289 9.5999999999999996
r2166 n1289 n1290 6.4000000000000004
r2167 n1290 n1291 6.4000000000000004
r2168 n1291 n1292 16
r2169 n1292 n1293 28.800000000000001
r2170 n1293 n1294 19.199999999999999
r2171 n1294 n1295 35.200000000000003
r2172 n1295 n1296 41.600000000000001
r2173 n1296 n1297 28.800000000000001
r2174 n1297 n1298 25.600000000000001
r2175 n1298 n1299 9.5999999999999996
r2176 n1299 n1300 6.4000000000000004
r2177 n1300 n1301 22.399999999999999
r2178 n1301 n1302 35.200000000000003
r2179 n1302 n1303 19.199999999999999
r2180 n1303 n1304 16
r2181 n1304 n1305 28.800000000000001
r2182 n1305 n1306 25.600000000000001
r2183 n1306 n1307 32
r2184 n1307 n1308 41.600000000000001
r2185 n1308 n1309 51.200000000000003
r2186 n1309 n1310 44.799999999999997
r2187 n1310 n1311 35.200000000000003
r2188 n1311 n1312 51.200000000000003
r2189 n1312 n1313 41.600000000000001
r2190 n1313 n1314 38.399999999999999
r2191 n1314 n1315 41.600000000000001
r2192 n1315 n1316 35.200000000000003
r2193 n1316 n1317 25.600000000000001
r2194 n1317 n1318 60.799999999999997
r2195 n1318 n1319 96
r2196 n1319 n1320 48
r2197 n1320 n1321 12.800000000000001
r2198 n1321 n1322 19.199999999999999
r2199 n1322 n1323 28.800000000000001
r2200 n1323 n1324 41.600000000000001
r2201 n1324 n1325 38.399999999999999
r2202 n1325 n1326 54.399999999999999
r2203 n1326 n1327 64
r2204 n1327 n1328 108.8
r2205 n1328 n1329 92.799999999999997
r2206 n1329 n1330 22.399999999999999
r2207 n1330 n1331 102.40000000000001
r2208 n1331 n1332 92.799999999999997
r2209 n1332 n1333 108.8
r2210 n1333 n1334 211.19999999999999
r2211 n1334 n1335 217.59999999999999
r2212 n1335 n1336 217.59999999999999
r2213 n1336 n1337 217.59999999999999
r2214 n1337 n1338 217.59999999999999
r2215 n1338 n1339 217.59999999999999
r2216 n1339 n1340 217.59999999999999
r2217 n1340 n1341 217.59999999999999
r2218 n1341 n1342 217.59999999999999
r2219 n1342 n1343 217.59999999999999
r2220 n1343 n1344 217.59999999999999
r2221 n1344 n1345 217.59999999999999
r2222 n1345 n1346 217.59999999999999
r2223 n1346 n1347 217.59999999999999
r2224 n1347 n1348 217.59999999999999
r2225 n1348 n1349 217.59999999999999
r2226 n1349 n1350 217.59999999999999
r2227 n1350 n1351 217.59999999999999
r2228 n1351 n1352 217.59999999999999
r2229 n1352 n1353 217.59999999999999
r2230 n1353 n1354 217.59999999999999
r2231 n1354 n1355 217.59999999999999
r2232 n1355 n1356 144
r2233 n1356 n1357 108.8
r2234 n1357 n1358 80
r2235 n1358 n1359 102.40000000000001
r2236 n1359 n1360 102.40000000000001
r2237 n1360 n1361 80
r2238 n1361 n1362 108.8
r2239 n1362 n1363 144
r2240 n1363 n1364 217.59999999999999
r2241 n1364 n1365 217.59999999999999
r2242 n1365 n1366 217.59999999999999
r2243 n1366 n1367 217.59999999999999
r2244 n1367 n1368 217.59999999999999
r2245 n1368 n1369 217.59999999999999
r2246 n1369 n1370 217.59999999999999
r2247 n1370 n1371 217.59999999999999
r2248 n1371 n1372 217.59999999999999
r2249 n1372 n1373 217.59999999999999
r2250 n1373 n1374 217.59999999999999
r2251 n1374 n1375 217.59999999999999
r2252 n1375 n1376 217.59999999999999
r2253 n1376 n1377 217.59999999999999
r2254 n1377 n1378 217.59999999999999
r2255 n1378 n1379 217.59999999999999
r2256 n1379 n1380 217.59999999999999
r2257 n1380 n1381 217.59999999999999
r2258 n1381 n1382 217.59999999999999
r2259 n1382 n1383 217.59999999999999
r2260 n1383 n1384 217.59999999999999
r2261 n1384 n1385 217.59999999999999
r2262 n1385 n1386 195.19999999999999
r2263 n1386 n1387 108.8
r2264 n1387 n1388 131.19999999999999
r2265 n1388 n1389 217.59999999999999
r2266 n1389 n1390 217.59999999999999
r2267 n1390 n1391 217.59999999999999
r2268 n1391 n1392 195.19999999999999
r2269 n1392 n1393 108.8
r2270 n1393 n1394 80
r2271 n1394 n1395 108.8
r2272 n1395 n1396 96
r2273 n1396 n1397 108.8
r2274 n1397 n1398 80
r2275 n1398 n1399 108.8
r2276 n1399 n1400 201.59999999999999
r2277 n1400 n1401 217.59999999999999
r2278 n1401 n1402 217.59999999999999
r2279 n1402 n1403 236.80000000000001
r2280 n1403 n1404 236.80000000000001
r2281 n1404 n1405 217.59999999999999
r2282 n1405 n1406 217.59999999999999
r2283 n1406 n1407 163.19999999999999
r2284 n1407 n1408 108.8
r2285 n1262 n1409 6.0235294117647058
r2286 n1263 n1410 7.4744525547445253
r2287 n1409 n1410 13.098666666666668
r2288 n1264 n1411 7.4202898550724639
r2289 n1410 n1411 11.733333333333333
r2290 n1265 n1412 6.0235294117647058
r2291 n1411 n1412 13.141333333333334
r2292 n1266 n1413 15.753846153846155
r2293 n1412 n1413 10.026666666666667
r2294 n1267 n1414 5.1200000000000001
r2295 n1413 n1414 11.306666666666667
r2296 n1268 n1415 204.80000000000001
r2297 n1414 n1415 8.7466666666666661
r2298 n1269 n1416 6.2060606060606061
r2299 n1415 n1416 7.253333333333333
r2300 n1270 n1417 204.80000000000001
r2301 n1416 n1417 7.253333333333333
r2302 n1271 n1418 8.9043478260869566
r2303 n1417 n1418 5.1200000000000001
r2304 n1272 n1419 51.200000000000003
r2305 n1418 n1419 5.7599999999999998
r2306 n1273 n1420 34.133333333333333
r2307 n1419 n1420 2.1333333333333333
r2308 n1274 n1421 40.960000000000001
r2309 n1420 n1421 2.3466666666666667
r2310 n1275 n1422 204.80000000000001
r2311 n1421 n1422 1.28
r2312 n1276 n1423 15.753846153846155
r2313 n1422 n1423 2.9866666666666668
r2314 n1277 n1424 20.48
r2315 n1423 n1424 4.9066666666666663
r2316 n1278 n1425 40.960000000000001
r2317 n1424 n1425 3.2000000000000002
r2318 n1279 n1426 40.960000000000001
r2319 n1425 n1426 2.1333333333333333
r2320 n1280 n1427 204.80000000000001
r2321 n1426 n1427 1.28
r2322 n1281 n1428 68.266666666666666
r2323 n1427 n1428 0.85333333333333339
r2324 n1282 n1429 204.80000000000001
r2325 n1428 n1429 0.85333333333333339
r2326 n1283 n1430 22.755555555555556
r2327 n1429 n1430 2.1333333333333333
r2328 n1284 n1431 20.48
r2329 n1430 n1431 4.0533333333333337
r2330 n1285 n1432 40.960000000000001
r2331 n1431 n1432 3.2000000000000002
r2332 n1286 n1433 40.960000000000001
r2333 n1432 n1433 2.1333333333333333
r2334 n1287 n1434 204.80000000000001
r2335 n1433 n1434 1.28
r2336 n1288 n1435 102.40000000000001
r2337 n1434 n1435 0.64000000000000001
r2338 n1289 n1436 204.80000000000001
r2339 n1435 n1436 0.64000000000000001
r2340 n1290 n1437 204.80000000000001
r2341 n1436 n1437 0.42666666666666669
r2342 n1291 n1438 204.80000000000001
r2343 n1437 n1438 0.42666666666666669
r2344 n1292 n1439 51.200000000000003
r2345 n1438 n1439 1.0666666666666667
r2346 n1293 n1440 40.960000000000001
r2347 n1439 n1440 1.9199999999999999
r2348 n1294 n1441 204.80000000000001
r2349 n1440 n1441 1.28
r2350 n1295 n1442 20.48
r2351 n1441 n1442 2.3466666666666667
r2352 n1296 n1443 68.266666666666666
r2353 n1442 n1443 2.7733333333333334
r2354 n1297 n1444 34.133333333333333
r2355 n1443 n1444 1.9199999999999999
r2356 n1298 n1445 102.40000000000001
r2357 n1444 n1445 1.7066666666666668
r2358 n1299 n1446 204.80000000000001
r2359 n1445 n1446 0.64000000000000001
r2360 n1300 n1447 204.80000000000001
r2361 n1446 n1447 0.42666666666666669
r2362 n1301 n1448 34.133333333333333
r2363 n1447 n1448 1.4933333333333334
r2364 n1302 n1449 40.960000000000001
r2365 n1448 n1449 2.3466666666666667
r2366 n1303 n1450 204.80000000000001
r2367 n1449 n1450 1.28
r2368 n1304 n1451 51.200000000000003
r2369 n1450 n1451 1.0666666666666667
r2370 n1305 n1452 40.960000000000001
r2371 n1451 n1452 1.9199999999999999
r2372 n1306 n1453 68.266666666666666
r2373 n1452 n1453 1.7066666666666668
r2374 n1307 n1454 29.257142857142856
r2375 n1453 n1454 2.1333333333333333
r2376 n1308 n1455 34.133333333333333
r2377 n1454 n1455 2.7733333333333334
r2378 n1309 n1456 20.48
r2379 n1455 n1456 3.4133333333333336
r2380 n1310 n1457 51.200000000000003
r2381 n1456 n1457 2.9866666666666668
r2382 n1311 n1458 29.257142857142856
r2383 n1457 n1458 2.3466666666666667
r2384 n1312 n1459 22.755555555555556
r2385 n1458 n1459 3.4133333333333336
r2386 n1313 n1460 51.200000000000003
r2387 n1459 n1460 2.7733333333333334
r2388 n1314 n1461 25.600000000000001
r2389 n1460 n1461 2.5600000000000001
r2390 n1315 n1462 40.960000000000001
r2391 n1461 n1462 2.7733333333333334
r2392 n1316 n1463 34.133333333333333
r2393 n1462 n1463 2.3466666666666667
r2394 n1317 n1464 102.40000000000001
r2395 n1463 n1464 1.7066666666666668
r2396 n1318 n1465 12.047058823529412
r2397 n1464 n1465 4.0533333333333337
r2398 n1319 n1466 15.753846153846155
r2399 n1465 n1466 6.4000000000000004
r2400 n1320 n1467 102.40000000000001
r2401 n1466 n1467 3.2000000000000002
r2402 n1321 n1468 102.40000000000001
r2403 n1467 n1468 0.85333333333333339
r2404 n1322 n1469 51.200000000000003
r2405 n1468 n1469 1.28
r2406 n1323 n1470 40.960000000000001
r2407 n1469 n1470 1.9199999999999999
r2408 n1324 n1471 25.600000000000001
r2409 n1470 n1471 2.7733333333333334
r2410 n1325 n1472 51.200000000000003
r2411 n1471 n1472 2.5600000000000001
r2412 n1326 n1473 15.753846153846155
r2413 n1472 n1473 3.6266666666666665
r2414 n1327 n1474 29.257142857142856
r2415 n1473 n1474 4.2666666666666666
r2416 n1328 n1475 7.5851851851851855
r2417 n1474 n1475 7.253333333333333
r2418 n1329 n1476 102.40000000000001
r2419 n1475 n1476 6.1866666666666665
r2420 n1330 n1477 40.960000000000001
r2421 n1476 n1477 1.4933333333333334
r2422 n1331 n1478 7.5851851851851855
r2423 n1477 n1478 6.8266666666666671
r2424 n1332 n1479 102.40000000000001
r2425 n1478 n1479 6.1866666666666665
r2426 n1333 n1480 6.4000000000000004
r2427 n1479 n1480 7.253333333333333
r2428 n1334 n1481 6.0235294117647058
r2429 n1480 n1481 14.08
r2430 n1335 n1482 6.0235294117647058
r2431 n1481 n1482 14.506666666666666
r2432 n1336 n1483 6.0235294117647058
r2433 n1482 n1483 14.506666666666666
r2434 n1337 n1484 6.0235294117647058
r2435 n1483 n1484 14.506666666666666
r2436 n1338 n1485 6.0235294117647058
r2437 n1484 n1485 14.506666666666666
r2438 n1339 n1486 6.0235294117647058
r2439 n1485 n1486 14.506666666666666
r2440 n1340 n1487 6.0235294117647058
r2441 n1486 n1487 14.506666666666666
r2442 n1341 n1488 6.0235294117647058
r2443 n1487 n1488 14.506666666666666
r2444 n1342 n1489 6.0235294117647058
r2445 n1488 n1489 14.506666666666666
r2446 n1343 n1490 6.0235294117647058
r2447 n1489 n1490 14.506666666666666
r2448 n1344 n1491 6.0235294117647058
r2449 n1490 n1491 14.506666666666666
r2450 n1345 n1492 6.0235294117647058
r2451 n1491 n1492 14.506666666666666
r2452 n1346 n1493 6.0235294117647058
r2453 n1492 n1493 14.506666666666666
r2454 n1347 n1494 6.0235294117647058
r2455 n1493 n1494 14.506666666666666
r2456 n1348 n1495 6.0235294117647058
r2457 n1494 n1495 14.506666666666666
r2458 n1349 n1496 6.0235294117647058
r2459 n1495 n1496 14.506666666666666
r2460 n1350 n1497 6.0235294117647058
r2461 n1496 n1497 14.506666666666666
r2462 n1351 n1498 6.0235294117647058
r2463 n1497 n1498 14.506666666666666
r2464 n1352 n1499 6.0235294117647058
r2465 n1498 n1499 14.506666666666666
r2466 n1353 n1500 6.0235294117647058
r2467 n1499 n1500 14.506666666666666
r2468 n1354 n1501 6.0235294117647058
r2469 n1500 n1501 14.506666666666666
r2470 n1355 n1502 6.0235294117647058
r2471 n1501 n1502 14.506666666666666
r2472 n1356 n1503 18.618181818181817
r2473 n1502 n1503 9.5999999999999996
r2474 n1357 n1504 8.9043478260869566
r2475 n1503 n1504 7.253333333333333
r2476 n1358 n1505 102.40000000000001
r2477 n1504 n1505 5.333333333333333
r2478 n1359 n1506 6.8266666666666671
r2479 n1505 n1506 6.8266666666666671
r2480 n1360 n1507 102.40000000000001
r2481 n1506 n1507 6.8266666666666671
r2482 n1361 n1508 8.9043478260869566
r2483 n1507 n1508 5.333333333333333
r2484 n1362 n1509 18.618181818181817
r2485 n1508 n1509 7.253333333333333
r2486 n1363 n1510 6.0235294117647058
r2487 n1509 n1510 9.5999999999999996
r2488 n1364 n1511 6.0235294117647058
r2489 n1510 n1511 14.506666666666666
r2490 n1365 n1512 6.0235294117647058
r2491 n1511 n1512 14.506666666666666
r2492 n1366 n1513 6.0235294117647058
r2493 n1512 n1513 14.506666666666666
r2494 n1367 n1514 6.0235294117647058
r2495 n1513 n1514 14.506666666666666
r2496 n1368 n1515 6.0235294117647058
r2497 n1514 n1515 14.506666666666666
r2498 n1369 n1516 6.0235294117647058
r2499 n1515 n1516 14.506666666666666
r2500 n1370 n1517 6.0235294117647058
r2501 n1516 n1517 14.506666666666666
r2502 n1371 n1518 6.0235294117647058
r2503 n1517 n1518 14.506666666666666
r2504 n1372 n1519 6.0235294117647058
r2505 n1518 n1519 14.506666666666666
r2506 n1373 n1520 6.0235294117647058
r2507 n1519 n1520 14.506666666666666
r2508 n1374 n1521 6.0235294117647058
r2509 n1520 n1521 14.506666666666666
r2510 n1375 n1522 6.0235294117647058
r2511 n1521 n1522 14.506666666666666
r2512 n1376 n1523 6.0235294117647058
r2513 n1522 n1523 14.506666666666666
r2514 n1377 n1524 6.0235294117647058
r2515 n1523 n1524 14.506666666666666
r2516 n1378 n1525 6.0235294117647058
r2517 n1524 n1525 14.506666666666666
r2518 n1379 n1526 6.0235294117647058
r2519 n1525 n1526 14.506666666666666
r2520 n1380 n1527 6.0235294117647058
r2521 n1526 n1527 14.506666666666666
r2522 n1381 n1528 6.0235294117647058
r2523 n1527 n1528 14.506666666666666
r2524 n1382 n1529 6.0235294117647058
r2525 n1528 n1529 14.506666666666666
r2526 n1383 n1530 6.0235294117647058
r2527 n1529 n1530 14.506666666666666
r2528 n1384 n1531 6.0235294117647058
r2529 n1530 n1531 14.506666666666666
r2530 n1385 n1532 6.0235294117647058
r2531 n1531 n1532 14.506666666666666
r2532 n1386 n1533 7.5851851851851855
r2533 n1532 n1533 13.013333333333334
r2534 n1387 n1534 29.257142857142856
r2535 n1533 n1534 7.253333333333333
r2536 n1388 n1535 6.0235294117647058
r2537 n1534 n1535 8.7466666666666661
r2538 n1389 n1536 6.0235294117647058
r2539 n1535 n1536 14.506666666666666
r2540 n1390 n1537 6.0235294117647058
r2541 n1536 n1537 14.506666666666666
r2542 n1391 n1538 6.0235294117647058
r2543 n1537 n1538 14.506666666666666
r2544 n1392 n1539 7.5851851851851855
r2545 n1538 n1539 13.013333333333334
r2546 n1393 n1540 29.257142857142856
r2547 n1539 n1540 7.253333333333333
r2548 n1394 n1541 11.377777777777778
r2549 n1540 n1541 5.333333333333333
r2550 n1395 n1542 12.800000000000001
r2551 n1541 n1542 7.253333333333333
r2552 n1396 n1543 14.628571428571428
r2553 n1542 n1543 6.4000000000000004
r2554 n1397 n1544 10.24
r2555 n1543 n1544 7.253333333333333
r2556 n1398 n1545 40.960000000000001
r2557 n1544 n1545 5.333333333333333
r2558 n1399 n1546 7.0620689655172413
r2559 n1545 n1546 7.253333333333333
r2560 n1400 n1547 6.0235294117647058
r2561 n1546 n1547 13.44
r2562 n1401 n1548 6.0235294117647058
r2563 n1547 n1548 14.506666666666666
r2564 n1402 n1549 6.0235294117647058
r2565 n1548 n1549 14.506666666666666
r2566 n1403 n1550 5.1200000000000001
r2567 n1549 n1550 15.786666666666667
r2568 n1404 n1551 6.0235294117647058
r2569 n1550 n1551 15.786666666666667
r2570 n1405 n1552 6.0235294117647058
r2571 n1551 n1552 14.506666666666666
r2572 n1406 n1553 6.0235294117647058
r2573 n1552 n1553 14.506666666666666
r2574 n1407 n1554 12.047058823529412
r2575 n1553 n1554 10.880000000000001
r2576 n1408 n1555 12.047058823529412
r2577 n1554 n1555 7.253333333333333
r2578 n1409 n1556 6.0235294117647058
r2579 n1410 n1557 7.4744525547445253
r2580 n1556 n1557 196.48000000000002
r2581 n1411 n1558 7.4202898550724639
r2582 n1557 n1558 176
r2583 n1412 n1559 6.0235294117647058
r2584 n1558 n1559 197.12
r2585 n1413 n1560 15.753846153846155
r2586 n1559 n1560 150.40000000000001
r2587 n1414 n1561 5.1200000000000001
r2588 n1560 n1561 169.59999999999999
r2589 n1415 n1562 204.80000000000001
r2590 n1561 n1562 131.19999999999999
r2591 n1416 n1563 6.2060606060606061
r2592 n1562 n1563 108.8
r2593 n1417 n1564 204.80000000000001
r2594 n1563 n1564 108.8
r2595 n1418 n1565 8.9043478260869566
r2596 n1564 n1565 76.799999999999997
r2597 n1419 n1566 51.200000000000003
r2598 n1565 n1566 86.400000000000006
r2599 n1420 n1567 34.133333333333333
r2600 n1566 n1567 32
r2601 n1421 n1568 40.960000000000001
r2602 n1567 n1568 35.200000000000003
r2603 n1422 n1569 204.80000000000001
r2604 n1568 n1569 19.199999999999999
r2605 n1423 n1570 15.753846153846155
r2606 n1569 n1570 44.799999999999997
r2607 n1424 n1571 20.48
r2608 n1570 n1571 73.599999999999994
r2609 n1425 n1572 40.960000000000001
r2610 n1571 n1572 48
r2611 n1426 n1573 40.960000000000001
r2612 n1572 n1573 32
r2613 n1427 n1574 204.80000000000001
r2614 n1573 n1574 19.199999999999999
r2615 n1428 n1575 68.266666666666666
r2616 n1574 n1575 12.800000000000001
r2617 n1429 n1576 204.80000000000001
r2618 n1575 n1576 12.800000000000001
r2619 n1430 n1577 22.755555555555556
r2620 n1576 n1577 32
r2621 n1431 n1578 20.48
r2622 n1577 n1578 60.799999999999997
r2623 n1432 n1579 40.960000000000001
r2624 n1578 n1579 48
r2625 n1433 n1580 40.960000000000001
r2626 n1579 n1580 32
r2627 n1434 n1581 204.80000000000001
r2628 n1580 n1581 19.199999999999999
r2629 n1435 n1582 102.40000000000001
r2630 n1581 n1582 9.5999999999999996
r2631 n1436 n1583 204.80000000000001
r2632 n1582 n1583 9.5999999999999996
r2633 n1437 n1584 204.80000000000001
r2634 n1583 n1584 6.4000000000000004
r2635 n1438 n1585 204.80000000000001
r2636 n1584 n1585 6.4000000000000004
r2637 n1439 n1586 51.200000000000003
r2638 n1585 n1586 16
r2639 n1440 n1587 40.960000000000001
r2640 n1586 n1587 28.800000000000001
r2641 n1441 n1588 204.80000000000001
r2642 n1587 n1588 19.199999999999999
r2643 n1442 n1589 20.48
r2644 n1588 n1589 35.200000000000003
r2645 n1443 n1590 68.266666666666666
r2646 n1589 n1590 41.600000000000001
r2647 n1444 n1591 34.133333333333333
r2648 n1590 n1591 28.800000000000001
r2649 n1445 n1592 102.40000000000001
r2650 n1591 n1592 25.600000000000001
r2651 n1446 n1593 204.80000000000001
r2652 n1592 n1593 9.5999999999999996
r2653 n1447 n1594 204.80000000000001
r2654 n1593 n1594 6.4000000000000004
r2655 n1448 n1595 34.133333333333333
r2656 n1594 n1595 22.399999999999999
r2657 n1449 n1596 40.960000000000001
r2658 n1595 n1596 35.200000000000003
r2659 n1450 n1597 204.80000000000001
r2660 n1596 n1597 19.199999999999999
r2661 n1451 n1598 51.200000000000003
r2662 n1597 n1598 16
r2663 n1452 n1599 40.960000000000001
r2664 n1598 n1599 28.800000000000001
r2665 n1453 n1600 68.266666666666666
r2666 n1599 n1600 25.600000000000001
r2667 n1454 n1601 29.257142857142856
r2668 n1600 n1601 32
r2669 n1455 n1602 34.133333333333333
r2670 n1601 n1602 41.600000000000001
r2671 n1456 n1603 20.48
r2672 n1602 n1603 51.200000000000003
r2673 n1457 n1604 51.200000000000003
r2674 n1603 n1604 44.799999999999997
r2675 n1458 n1605 29.257142857142856
r2676 n1604 n1605 35.200000000000003
r2677 n1459 n1606 22.755555555555556
r2678 n1605 n1606 51.200000000000003
r2679 n1460 n1607 51.200000000000003
r2680 n1606 n1607 41.600000000000001
r2681 n1461 n1608 25.600000000000001
r2682 n1607 n1608 38.399999999999999
r2683 n1462 n1609 40.960000000000001
r2684 n1608 n1609 41.600000000000001
r2685 n1463 n1610 34.133333333333333
r2686 n1609 n1610 35.200000000000003
r2687 n1464 n1611 102.40000000000001
r2688 n1610 n1611 25.600000000000001
r2689 n1465 n1612 12.047058823529412
r2690 n1611 n1612 60.799999999999997
r2691 n1466 n1613 15.753846153846155
r2692 n1612 n1613 96
r2693 n1467 n1614 102.40000000000001
r2694 n1613 n1614 48
r2695 n1468 n1615 102.40000000000001
r2696 n1614 n1615 12.800000000000001
r2697 n1469 n1616 51.200000000000003
r2698 n1615 n1616 19.199999999999999
r2699 n1470 n1617 40.960000000000001
r2700 n1616 n1617 28.800000000000001
r2701 n1471 n1618 25.600000000000001
r2702 n1617 n1618 41.600000000000001
r2703 n1472 n1619 51.200000000000003
r2704 n1618 n1619 38.399999999999999
r2705 n1473 n1620 15.753846153846155
r2706 n1619 n1620 54.399999999999999
r2707 n1474 n1621 29.257142857142856
r2708 n1620 n1621 64
r2709 n1475 n1622 7.5851851851851855
r2710 n1621 n1622 108.8
r2711 n1476 n1623 102.40000000000001
r2712 n1622 n1623 92.799999999999997
r2713 n1477 n1624 40.960000000000001
r2714 n1623 n1624 22.399999999999999
r2715 n1478 n1625 7.5851851851851855
r2716 n1624 n1625 102.40000000000001
r2717 n1479 n1626 102.40000000000001
r2718 n1625 n1626 92.799999999999997
r2719 n1480 n1627 6.4000000000000004
r2720 n1626 n1627 108.8
r2721 n1481 n1628 6.0235294117647058
r2722 n1627 n1628 211.19999999999999
r2723 n1482 n1629 6.0235294117647058
r2724 n1628 n1629 217.59999999999999
r2725 n1483 n1630 6.0235294117647058
r2726 n1629 n1630 217.59999999999999
r2727 n1484 n1631 6.0235294117647058
r2728 n1630 n1631 217.59999999999999
r2729 n1485 n1632 6.0235294117647058
r2730 n1631 n1632 217.59999999999999
r2731 n1486 n1633 6.0235294117647058
r2732 n1632 n1633 217.59999999999999
r2733 n1487 n1634 6.0235294117647058
r2734 n1633 n1634 217.59999999999999
r2735 n1488 n1635 6.0235294117647058
r2736 n1634 n1635 217.59999999999999
r2737 n1489 n1636 6.0235294117647058
r2738 n1635 n1636 217.59999999999999
r2739 n1490 n1637 6.0235294117647058
r2740 n1636 n1637 217.59999999999999
r2741 n1491 n1638 6.0235294117647058
r2742 n1637 n1638 217.59999999999999
r2743 n1492 n1639 6.0235294117647058
r2744 n1638 n1639 217.59999999999999
r2745 n1493 n1640 6.0235294117647058
r2746 n1639 n1640 217.59999999999999
r2747 n1494 n1641 6.0235294117647058
r2748 n1640 n1641 217.59999999999999
r2749 n1495 n1642 6.0235294117647058
r2750 n1641 n1642 217.59999999999999
r2751 n1496 n1643 6.0235294117647058
r2752 n1642 n1643 217.59999999999999
r2753 n1497 n1644 6.0235294117647058
r2754 n1643 n1644 217.59999999999999
r2755 n1498 n1645 6.0235294117647058
r2756 n1644 n1645 217.59999999999999
r2757 n1499 n1646 6.0235294117647058
r2758 n1645 n1646 217.59999999999999
r2759 n1500 n1647 6.0235294117647058
r2760 n1646 n1647 217.59999999999999
r2761 n1501 n1648 6.0235294117647058
r2762 n1647 n1648 217.59999999999999
r2763 n1502 n1649 6.0235294117647058
r2764 n1648 n1649 217.59999999999999
r2765 n1503 n1650 18.618181818181817
r2766 n1649 n1650 144
r2767 n1504 n1651 8.9043478260869566
r2768 n1650 n1651 108.8
r2769 n1505 n1652 102.40000000000001
r2770 n1651 n1652 80
r2771 n1506 n1653 6.8266666666666671
r2772 n1652 n1653 102.40000000000001
r2773 n1507 n1654 102.40000000000001
r2774 n1653 n1654 102.40000000000001
r2775 n1508 n1655 8.9043478260869566
r2776 n1654 n1655 80
r2777 n1509 n1656 18.618181818181817
r2778 n1655 n1656 108.8
r2779 n1510 n1657 6.0235294117647058
r2780 n1656 n1657 144
r2781 n1511 n1658 6.0235294117647058
r2782 n1657 n1658 217.59999999999999
r2783 n1512 n1659 6.0235294117647058
r2784 n1658 n1659 217.59999999999999
r2785 n1513 n1660 6.0235294117647058
r2786 n1659 n1660 217.59999999999999
r2787 n1514 n1661 6.0235294117647058
r2788 n1660 n1661 217.59999999999999
r2789 n1515 n1662 6.0235294117647058
r2790 n1661 n1662 217.59999999999999
r2791 n1516 n1663 6.0235294117647058
r2792 n1662 n1663 217.59999999999999
r2793 n1517 n1664 6.0235294117647058
r2794 n1663 n1664 217.59999999999999
r2795 n1518 n1665 6.0235294117647058
r2796 n1664 n1665 217.59999999999999
r2797 n1519 n1666 6.0235294117647058
r2798 n1665 n1666 217.59999999999999
r2799 n1520 n1667 6.0235294117647058
r2800 n1666 n1667 217.59999999999999
r2801 n1521 n1668 6.0235294117647058
r2802 n1667 n1668 217.59999999999999
r2803 n1522 n1669 6.0235294117647058
r2804 n1668 n1669 217.59999999999999
r2805 n1523 n1670 6.0235294117647058
r2806 n1669 n1670 217.59999999999999
r2807 n1524 n1671 6.0235294117647058
r2808 n1670 n1671 217.59999999999999
r2809 n1525 n1672 6.0235294117647058
r2810 n1671 n1672 217.59999999999999
r2811 n1526 n1673 6.0235294117647058
r2812 n1672 n1673 217.59999999999999
r2813 n1527 n1674 6.0235294117647058
r2814 n1673 n1674 217.59999999999999
r2815 n1528 n1675 6.0235294117647058
r2816 n1674 n1675 217.59999999999999
r2817 n1529 n1676 6.0235294117647058
r2818 n1675 n1676 217.59999999999999
r2819 n1530 n1677 6.0235294117647058
r2820 n1676 n1677 217.59999999999999
r2821 n1531 n1678 6.0235294117647058
r2822 n1677 n1678 217.59999999999999
r2823 n1532 n1679 6.0235294117647058
r2824 n1678 n1679 217.59999999999999
r2825 n1533 n1680 7.5851851851851855
r2826 n1679 n1680 195.19999999999999
r2827 n1534 n1681 29.257142857142856
r2828 n1680 n1681 108.8
r2829 n1535 n1682 6.0235294117647058
r2830 n1681 n1682 131.19999999999999
r2831 n1536 n1683 6.0235294117647058
r2832 n1682 n1683 217.59999999999999
r2833 n1537 n1684 6.0235294117647058
r2834 n1683 n1684 217.59999999999999
r2835 n1538 n1685 6.0235294117647058
r2836 n1684 n1685 217.59999999999999
r2837 n1539 n1686 7.5851851851851855
r2838 n1685 n1686 195.19999999999999
r2839 n1540 n1687 29.257142857142856
r2840 n1686 n1687 108.8
r2841 n1541 n1688 11.377777777777778
r2842 n1687 n1688 80
r2843 n1542 n1689 12.800000000000001
r2844 n1688 n1689 108.8
r2845 n1543 n1690 14.628571428571428
r2846 n1689 n1690 96
r2847 n1544 n1691 10.24
r2848 n1690 n1691 108.8
r2849 n1545 n1692 40.960000000000001
r2850 n1691 n1692 80
r2851 n1546 n1693 7.0620689655172413
r2852 n1692 n1693 108.8
r2853 n1547 n1694 6.0235294117647058
r2854 n1693 n1694 201.59999999999999
r2855 n1548 n1695 6.0235294117647058
r2856 n1694 n1695 217.59999999999999
r2857 n1549 n1696 6.0235294117647058
r2858 n1695 n1696 217.59999999999999
r2859 n1550 n1697 5.1200000000000001
r2860 n1696 n1697 236.80000000000001
r2861 n1551 n1698 6.0235294117647058
r2862 n1697 n1698 236.80000000000001
r2863 n1552 n1699 6.0235294117647058
r2864 n1698 n1699 217.59999999999999
r2865 n1553 n1700 6.0235294117647058
r2866 n1699 n1700 217.59999999999999
r2867 n1554 n1701 12.047058823529412
r2868 n1700 n1701 163.19999999999999
r2869 n1555 n1702 12.047058823529412
r2870 n1701 n1702 108.8
r2871 n1556 n1703 2.447058823529412
r2872 n1701 n1704 4.8941176470588239
r2873 n1702 n1705 4.8941176470588239
r2874 n1704 n1705 19.781818181818181
r2875 n1703 n1706 2.447058823529412
r2876 n1704 n1707 4.8941176470588239
r2877 n1705 n1708 4.8941176470588239
r2878 n1707 n1708 108.8
r2879 n1706 n1709 6.7011764705882353
r2880 n1707 n1710 13.402352941176471
r2881 n1708 n1711 13.402352941176471
r2882 n1710 n1711 6.4761904761904763
r2883 n1709 n1712 12.611764705882353
r2884 n1710 n1713 25.223529411764705
r2885 n1711 n1714 25.223529411764705
r2886 n1713 n1714 6.5149700598802394
r2887 n1712 n1715 8.357647058823531
r2888 n1713 n1716 16.715294117647062
r2889 n1714 n1717 16.715294117647062
r2890 n1716 n1717 19.781818181818181
r2891 n1715 n1718 3.9529411764705884
r2892 n1716 n1719 7.9058823529411768
r2893 n1717 n1720 7.9058823529411768
r2894 n1719 n1720 21.760000000000002
r2895 n1718 n1721 2.2588235294117647
r2896 n1719 n1722 4.5176470588235293
r2897 n1720 n1723 4.5176470588235293
r2898 n1722 n1723 108.8
r2899 n1721 n1724 0.94117647058823528
r2900 n1722 n1725 1.8823529411764706
r2901 n1723 n1726 1.8823529411764706
r2902 n1725 n1726 72.533333333333331
r2903 n1724 n1727 1.5058823529411764
r2904 n1725 n1728 3.0117647058823529
r2905 n1726 n1729 3.0117647058823529
r2906 n1728 n1729 43.520000000000003
r2907 n1727 n1730 1.5058823529411764
r2908 n1728 n1731 3.0117647058823529
r2909 n1729 n1732 3.0117647058823529
r2910 n1731 n1732 72.533333333333331
r2911 n1730 n1733 0.94117647058823528
r2912 n1731 n1734 1.8823529411764706
r2913 n1732 n1735 1.8823529411764706
r2914 n1734 n1735 108.8
r2915 n1733 n1736 6.0235294117647058
r2916 n1734 n1737 12.047058823529412
r2917 n1735 n1738 12.047058823529412
r2918 n1737 n1738 7.253333333333333
r2919 n1736 n1739 6.0235294117647058
r2920 n1737 n1740 12.047058823529412
r2921 n1738 n1741 12.047058823529412
r2922 n1740 n1741 108.8
r2923 n1739 n1742 0.94117647058823528
r2924 n1740 n1743 1.8823529411764706
r2925 n1741 n1744 1.8823529411764706
r2926 n1743 n1744 72.533333333333331
r2927 n1742 n1745 1.5058823529411764
r2928 n1743 n1746 3.0117647058823529
r2929 n1744 n1747 3.0117647058823529
r2930 n1746 n1747 43.520000000000003
r2931 n1745 n1748 1.5058823529411764
r2932 n1746 n1749 3.0117647058823529
r2933 n1747 n1750 3.0117647058823529
r2934 n1749 n1750 72.533333333333331
r2935 n1748 n1751 0.94117647058823528
r2936 n1749 n1752 1.8823529411764706
r2937 n1750 n1753 1.8823529411764706
r2938 n1752 n1753 108.8
r2939 n1751 n1754 2.2588235294117647
r2940 n1752 n1755 4.5176470588235293
r2941 n1753 n1756 4.5176470588235293
r2942 n1755 n1756 21.760000000000002
r2943 n1754 n1757 3.9529411764705884
r2944 n1755 n1758 7.9058823529411768
r2945 n1756 n1759 7.9058823529411768
r2946 n1758 n1759 19.781818181818181
r2947 n1757 n1760 9.5999999999999996
r2948 n1758 n1761 19.199999999999999
r2949 n1759 n1762 19.199999999999999
r2950 n1761 n1762 5.4400000000000004
r2951 n1760 n1763 15.058823529411764
r2952 n1761 n1764 30.117647058823529
r2953 n1762 n1765 30.117647058823529
r2954 n1764 n1765 5.4400000000000004
r2955 n1763 n1766 13.929411764705883
r2956 n1766 n1767 11.55764705882353
r2957 n1767 n1768 10.352941176470589
r2958 n1768 n1769 11.595294117647059
r2959 n1769 n1770 8.8470588235294123
r2960 n1770 n1771 9.9764705882352942
r2961 n1771 n1772 7.7176470588235295
r2962 n1772 n1773 6.4000000000000004
r2963 n1773 n1774 6.4000000000000004
r2964 n1774 n1775 4.5176470588235293
r2965 n1775 n1776 5.0823529411764703
r2966 n1776 n1777 1.8823529411764706
r2967 n1777 n1778 2.0705882352941178
r2968 n1778 n1779 1.1294117647058823
r2969 n1779 n1780 2.6352941176470588
r2970 n1780 n1781 4.3294117647058821
r2971 n1781 n1782 2.8235294117647061
r2972 n1782 n1783 1.8823529411764706
r2973 n1783 n1784 1.1294117647058823
r2974 n1784 n1785 0.75294117647058822
r2975 n1785 n1786 0.75294117647058822
r2976 n1786 n1787 1.8823529411764706
r2977 n1787 n1788 3.5764705882352943
r2978 n1788 n1789 2.8235294117647061
r2979 n1789 n1790 1.8823529411764706
r2980 n1790 n1791 1.1294117647058823
r2981 n1791 n1792 0.56470588235294117
r2982 n1792 n1793 0.56470588235294117
r2983 n1793 n1794 0.37647058823529411
r2984 n1794 n1795 0.37647058823529411
r2985 n1795 n1796 0.94117647058823528
r2986 n1796 n1797 1.6941176470588235
r2987 n1797 n1798 1.1294117647058823
r2988 n1798 n1799 2.0705882352941178
r2989 n1799 n1800 2.447058823529412
r2990 n1800 n1801 1.6941176470588235
r2991 n1801 n1802 1.5058823529411764
r2992 n1802 n1803 0.56470588235294117
r2993 n1803 n1804 0.37647058823529411
r2994 n1804 n1805 1.3176470588235294
r2995 n1805 n1806 2.0705882352941178
r2996 n1806 n1807 1.1294117647058823
r2997 n1807 n1808 0.94117647058823528
r2998 n1808 n1809 1.6941176470588235
r2999 n1809 n1810 1.5058823529411764
r3000 n1810 n1811 1.8823529411764706
r3001 n1811 n1812 2.447058823529412
r3002 n1812 n1813 3.0117647058823529
r3003 n1813 n1814 2.6352941176470588
r3004 n1814 n1815 2.0705882352941178
r3005 n1815 n1816 3.0117647058823529
r3006 n1816 n1817 2.447058823529412
r3007 n1817 n1818 2.2588235294117647
r3008 n1818 n1819 2.447058823529412
r3009 n1819 n1820 2.0705882352941178
r3010 n1820 n1821 1.5058823529411764
r3011 n1821 n1822 3.5764705882352943
r3012 n1822 n1823 5.6470588235294121
r3013 n1823 n1824 2.8235294117647061
r3014 n1824 n1825 0.75294117647058822
r3015 n1825 n1826 1.1294117647058823
r3016 n1826 n1827 1.6941176470588235
r3017 n1827 n1828 2.447058823529412
r3018 n1828 n1829 2.2588235294117647
r3019 n1829 n1830 3.2000000000000002
r3020 n1830 n1831 3.7647058823529411
r3021 n1831 n1832 6.4000000000000004
r3022 n1832 n1833 5.4588235294117649
r3023 n1833 n1834 1.3176470588235294
r3024 n1834 n1835 6.0235294117647058
r3025 n1835 n1836 5.4588235294117649
r3026 n1836 n1837 6.4000000000000004
r3027 n1837 n1838 12.423529411764706
r3028 n1838 n1839 12.800000000000001
r3029 n1839 n1840 12.800000000000001
r3030 n1840 n1841 12.800000000000001
r3031 n1841 n1842 12.800000000000001
r3032 n1842 n1843 12.800000000000001
r3033 n1843 n1844 12.800000000000001
r3034 n1844 n1845 12.800000000000001
r3035 n1845 n1846 12.800000000000001
r3036 n1846 n1847 12.800000000000001
r3037 n1847 n1848 12.800000000000001
r3038 n1848 n1849 12.800000000000001
r3039 n1849 n1850 12.800000000000001
r3040 n1850 n1851 12.800000000000001
r3041 n1851 n1852 12.800000000000001
r3042 n1852 n1853 12.800000000000001
r3043 n1853 n1854 12.800000000000001
r3044 n1854 n1855 12.800000000000001
r3045 n1855 n1856 12.800000000000001
r3046 n1856 n1857 12.800000000000001
r3047 n1857 n1858 12.800000000000001
r3048 n1858 n1859 12.800000000000001
r3049 n1859 n1860 8.4705882352941178
r3050 n1860 n1861 6.4000000000000004
r3051 n1861 n1862 4.7058823529411766
r3052 n1862 n1863 6.0235294117647058
r3053 n1863 n1864 6.0235294117647058
r3054 n1864 n1865 4.7058823529411766
r3055 n1865 n1866 6.4000000000000004
r3056 n1866 n1867 8.4705882352941178
r3057 n1867 n1868 12.800000000000001
r3058 n1868 n1869 12.800000000000001
r3059 n1869 n1870 12.800000000000001
r3060 n1870 n1871 12.800000000000001
r3061 n1871 n1872 12.800000000000001
r3062 n1872 n1873 12.800000000000001
r3063 n1873 n1874 12.800000000000001
r3064 n1874 n1875 12.800000000000001
r3065 n1875 n1876 12.800000000000001
r3066 n1876 n1877 12.800000000000001
r3067 n1877 n1878 12.800000000000001
r3068 n1878 n1879 12.800000000000001
r3069 n1879 n1880 12.800000000000001
r3070 n1880 n1881 12.800000000000001
r3071 n1881 n1882 12.800000000000001
r3072 n1882 n1883 12.800000000000001
r3073 n1883 n1884 12.800000000000001
r3074 n1884 n1885 12.800000000000001
r3075 n1885 n1886 12.800000000000001
r3076 n1886 n1887 12.800000000000001
r3077 n1887 n1888 12.800000000000001
r3078 n1888 n1889 12.800000000000001
r3079 n1889 n1890 11.482352941176471
r3080 n1890 n1891 6.4000000000000004
r3081 n1891 n1892 7.7176470588235295
r3082 n1892 n1893 12.800000000000001
r3083 n1893 n1894 12.800000000000001
r3084 n1894 n1895 12.800000000000001
r3085 n1895 n1896 11.482352941176471
r3086 n1896 n1897 6.4000000000000004
r3087 n1897 n1898 4.7058823529411766
r3088 n1898 n1899 6.4000000000000004
r3089 n1899 n1900 5.6470588235294121
r3090 n1900 n1901 6.4000000000000004
r3091 n1901 n1902 4.7058823529411766
r3092 n1902 n1903 6.4000000000000004
r3093 n1903 n1904 11.858823529411765
r3094 n1904 n1905 12.800000000000001
r3095 n1905 n1906 12.800000000000001
r3096 n1906 n1907 13.929411764705883
r3097 n1907 n1908 13.929411764705883
r3098 n1908 n1909 12.800000000000001
r3099 n1909 n1910 12.800000000000001
r3100 n1764 n1911 27.858823529411765
r3101 n1910 n1911 9.5999999999999996
r3102 n1765 n1912 27.858823529411765
r3103 n1911 n1912 6.4000000000000004
r3104 vdd n2041 0.22321428571428573
r3105 n2041 n2042 22.035714285714285
r3106 n2042 n2043 43.959821428571431
r3107 n2043 n2044 44.071428571428569
r3108 n2044 n2045 44.071428571428569
r3109 n2045 n2046 44.071428571428569
r3110 n2046 n2047 44.071428571428569
r3111 n2047 n2048 44.071428571428569
r3112 n2048 n2049 44.071428571428569
r3113 n2049 n2050 44.071428571428569
r3114 n2050 n2051 44.071428571428569
r3115 n2051 n2052 44.071428571428569
r3116 n2052 n2053 44.071428571428569
r3117 n2053 n2054 44.071428571428569
r3118 n2054 n2055 44.071428571428569
r3119 n2055 n2056 44.071428571428569
r3120 n2056 n2057 44.071428571428569
r3121 n2057 n2058 44.071428571428569
r3122 n2058 n2059 44.071428571428569
r3123 n2059 n2060 44.071428571428569
r3124 n2060 n2061 43.959821428571431
r3125 n2061 n2062 22.035714285714285
r3126 n2062 n2070 0.20758928571428573
r3127 n2070 n2078 0.171875
r3128 n2078 n2086 0.171875
r3129 n2086 n2087 0.20758928571428573
r3130 n2087 n2088 0.22321428571428573
r3131 n2088 n2089 0.22232142857142856
r3132 n2089 n2090 0.22142857142857142
r3133 n2090 n2091 0.22142857142857142
r3134 n2091 n2092 0.22142857142857142
r3135 n2092 n2093 0.22142857142857142
r3136 n2093 n2094 0.22142857142857142
r3137 n2094 n2095 0.22098214285714285
r3138 n2095 n2096 0.22098214285714285
r3139 n2096 n2097 0.22142857142857142
r3140 n2097 n2098 0.22142857142857142
r3141 n2098 n2099 0.22142857142857142
r3142 n2099 n2100 0.22142857142857142
r3143 n2100 n2101 0.22142857142857142
r3144 n2101 n2102 0.22142857142857142
r3145 n2102 n2103 0.22142857142857142
r3146 n2103 n2104 0.22142857142857142
r3147 n2104 n2105 0.22142857142857142
r3148 n2105 n2106 0.22098214285714285
r3149 n2106 n2107 0.22098214285714285
r3150 n2107 n2108 0.22142857142857142
r3151 n2108 n2109 0.22142857142857142
r3152 n2109 n2110 0.22142857142857142
r3153 n2110 n2111 0.22142857142857142
r3154 n2111 n2112 0.22142857142857142
r3155 n2112 n2113 0.22142857142857142
r3156 n2113 n2114 0.22142857142857142
r3157 n2114 n2115 0.22142857142857142
r3158 n2115 n2116 0.22142857142857142
r3159 n2116 n2117 0.22142857142857142
r3160 n2117 n2118 0.22142857142857142
r3161 n2118 n2119 0.22098214285714285
r3162 n2119 n2120 0.22098214285714285
r3163 n2120 n2121 0.22142857142857142
r3164 n2121 n2122 0.22142857142857142
r3165 n2122 n2123 0.22142857142857142
r3166 n2123 n2124 0.22142857142857142
r3167 n2124 n2125 0.22142857142857142
r3168 n2125 n2126 0.22142857142857142
r3169 n2126 n2127 0.22142857142857142
r3170 n2127 n2128 0.22142857142857142
r3171 n2128 n2129 0.22142857142857142
r3172 n2129 n2130 0.22098214285714285
r3173 n2130 n2131 0.22098214285714285
r3174 n2131 n2132 0.22142857142857142
r3175 n2132 n2133 0.22142857142857142
r3176 n2133 n2134 0.22142857142857142
r3177 n2134 n2135 0.22142857142857142
r3178 n2135 n2136 0.22142857142857142
r3179 n2136 n2137 0.22232142857142856
r3180 n2137 n2138 0.22321428571428573
r3181 n2139 n2140 0.13437499999999999
r3182 n2140 n2141 0.109375
r3183 n2141 n2142 0.10000000000000001
r3184 n2142 n2143 0.10000000000000001
r3185 n2143 n2144 0.109375
r3186 n2144 n2145 0.13437499999999999
r3187 n2138 n2146 0.15625
r3188 n2139 n2147 0.26874999999999999
r3189 n2140 n2148 0.081439393939393936
r3190 n2147 n2148 0.11684782608695653
r3191 n2141 n2149 1.34375
r3192 n2148 n2149 0.095108695652173919
r3193 n2142 n2150 0.089583333333333334
r3194 n2149 n2150 0.086956521739130432
r3195 n2143 n2151 1.34375
r3196 n2150 n2151 0.086956521739130432
r3197 n2144 n2152 0.081439393939393936
r3198 n2151 n2152 0.095108695652173919
r3199 n2145 n2153 0.26874999999999999
r3200 n2152 n2153 0.11684782608695653
r3201 n2154 n2155 0.070652173913043473
r3202 n2146 n2156 0.095982142857142863
r3203 n2155 n2156 0.07880434782608696
r3204 n2156 n2157 0.07880434782608696
r3205 n2157 n2158 0.070652173913043473
r3206 n2147 n2159 0.15625
r3207 n2148 n2160 0.047348484848484848
r3208 n2159 n2160 1.34375
r3209 n2149 n2161 0.78125
r3210 n2160 n2161 1.09375
r3211 n2150 n2162 0.052083333333333336
r3212 n2161 n2162 1
r3213 n2151 n2163 0.78125
r3214 n2162 n2163 1
r3215 n2152 n2164 0.047348484848484848
r3216 n2163 n2164 1.09375
r3217 n2153 n2165 0.15625
r3218 n2164 n2165 1.34375
r3219 n2154 n2166 0.0625
r3220 n2155 n2167 1.5625
r3221 n2166 n2167 0.8125
r3222 n2156 n2168 0.055803571428571432
r3223 n2167 n2168 0.90625
r3224 n2157 n2169 1.5625
r3225 n2168 n2169 0.90625
r3226 n2158 n2170 0.0625
r3227 n2169 n2170 0.8125
r3228 n2159 n2171 0.20000000000000001
r3229 n2160 n2172 0.060606060606060608
r3230 n2171 n2172 0.089583333333333334
r3231 n2161 n2173 1
r3232 n2172 n2173 0.072916666666666671
r3233 n2162 n2174 0.066666666666666666
r3234 n2173 n2174 0.066666666666666666
r3235 n2163 n2175 1
r3236 n2174 n2175 0.066666666666666666
r3237 n2164 n2176 0.060606060606060608
r3238 n2175 n2176 0.072916666666666671
r3239 n2165 n2177 0.20000000000000001
r3240 n2176 n2177 0.089583333333333334
r3241 n2166 n2178 0.080000000000000002
r3242 n2167 n2179 2
r3243 n2178 n2179 0.054166666666666669
r3244 n2168 n2180 0.071428571428571425
r3245 n2179 n2180 0.060416666666666667
r3246 n2169 n2181 2
r3247 n2180 n2181 0.060416666666666667
r3248 n2170 n2182 0.080000000000000002
r3249 n2181 n2182 0.054166666666666669
r3250 n2171 n2183 0.20000000000000001
r3251 n2172 n2184 0.060606060606060608
r3252 n2183 n2184 1.34375
r3253 n2173 n2185 1
r3254 n2184 n2185 1.09375
r3255 n2174 n2186 0.066666666666666666
r3256 n2185 n2186 1
r3257 n2175 n2187 1
r3258 n2186 n2187 1
r3259 n2176 n2188 0.060606060606060608
r3260 n2187 n2188 1.09375
r3261 n2177 n2189 0.20000000000000001
r3262 n2188 n2189 1.34375
r3263 n2178 n2190 0.080000000000000002
r3264 n2179 n2191 2
r3265 n2190 n2191 0.8125
r3266 n2180 n2192 0.071428571428571425
r3267 n2191 n2192 0.90625
r3268 n2181 n2193 2
r3269 n2192 n2193 0.90625
r3270 n2182 n2194 0.080000000000000002
r3271 n2193 n2194 0.8125
r3272 n2183 n2195 0.15625
r3273 n2184 n2196 0.047348484848484848
r3274 n2195 n2196 0.11684782608695653
r3275 n2185 n2197 0.78125
r3276 n2196 n2197 0.095108695652173919
r3277 n2186 n2198 0.052083333333333336
r3278 n2197 n2198 0.086956521739130432
r3279 n2187 n2199 0.78125
r3280 n2198 n2199 0.086956521739130432
r3281 n2188 n2200 0.047348484848484848
r3282 n2199 n2200 0.095108695652173919
r3283 n2189 n2201 0.15625
r3284 n2200 n2201 0.11684782608695653
r3285 n2190 n2202 0.0625
r3286 n2191 n2203 1.5625
r3287 n2202 n2203 0.070652173913043473
r3288 n2192 n2204 0.055803571428571432
r3289 n2203 n2204 0.07880434782608696
r3290 n2193 n2205 1.5625
r3291 n2204 n2205 0.07880434782608696
r3292 n2194 n2206 0.0625
r3293 n2205 n2206 0.070652173913043473
r3294 n2195 n2207 0.26874999999999999
r3295 n2196 n2208 0.081439393939393936
r3296 n2207 n2208 0.13437499999999999
r3297 n2197 n2209 1.34375
r3298 n2208 n2209 0.109375
r3299 n2198 n2210 0.089583333333333334
r3300 n2209 n2210 0.10000000000000001
r3301 n2199 n2211 1.34375
r3302 n2210 n2211 0.10000000000000001
r3303 n2200 n2212 0.081439393939393936
r3304 n2211 n2212 0.109375
r3305 n2201 n2213 0.26874999999999999
r3306 n2212 n2213 0.13437499999999999
r3307 n2214 n2215 0.46875
r3308 n2215 n2216 0.3125
r3309 n2216 n2217 0.1875
r3310 n2217 n2218 0.09375
r3311 n2218 n2219 0.09375
r3312 n2219 n2220 0.0625
r3313 n2220 n2221 0.0625
r3314 n2221 n2222 0.15625
r3315 n2222 n2223 0.28125
r3316 n2223 n2224 0.1875
r3317 n2224 n2225 0.34375
r3318 n2225 n2226 0.40625
r3319 n2226 n2227 0.28125
r3320 n2227 n2228 0.25
r3321 n2228 n2229 0.09375
r3322 n2229 n2230 0.0625
r3323 n2230 n2231 0.21875
r3324 n2231 n2232 0.34375
r3325 n2232 n2233 0.1875
r3326 n2233 n2234 0.15625
r3327 n2234 n2235 0.28125
r3328 n2214 n2236 0.081250000000000003
r3329 n2215 n2237 0.16250000000000001
r3330 n2236 n2237 0.085227272727272721
r3331 n2216 n2238 0.16250000000000001
r3332 n2237 n2238 0.056818181818181816
r3333 n2217 n2239 0.8125
r3334 n2238 n2239 0.034090909090909088
r3335 n2218 n2240 0.40625
r3336 n2239 n2240 0.017045454545454544
r3337 n2219 n2241 0.8125
r3338 n2240 n2241 0.017045454545454544
r3339 n2220 n2242 0.8125
r3340 n2241 n2242 0.011363636363636364
r3341 n2221 n2243 0.8125
r3342 n2242 n2243 0.011363636363636364
r3343 n2222 n2244 0.203125
r3344 n2243 n2244 0.028409090909090908
r3345 n2223 n2245 0.16250000000000001
r3346 n2244 n2245 0.05113636363636364
r3347 n2224 n2246 0.8125
r3348 n2245 n2246 0.034090909090909088
r3349 n2225 n2247 0.081250000000000003
r3350 n2246 n2247 0.0625
r3351 n2226 n2248 0.27083333333333331
r3352 n2247 n2248 0.073863636363636367
r3353 n2227 n2249 0.13541666666666666
r3354 n2248 n2249 0.05113636363636364
r3355 n2228 n2250 0.40625
r3356 n2249 n2250 0.045454545454545456
r3357 n2229 n2251 0.8125
r3358 n2250 n2251 0.017045454545454544
r3359 n2230 n2252 0.8125
r3360 n2251 n2252 0.011363636363636364
r3361 n2231 n2253 0.13541666666666666
r3362 n2252 n2253 0.039772727272727272
r3363 n2232 n2254 0.16250000000000001
r3364 n2253 n2254 0.0625
r3365 n2233 n2255 0.8125
r3366 n2254 n2255 0.034090909090909088
r3367 n2234 n2256 0.203125
r3368 n2255 n2256 0.028409090909090908
r3369 n2235 n2257 0.16250000000000001
r3370 n2256 n2257 0.05113636363636364
r3371 n2236 n2258 0.081250000000000003
r3372 n2237 n2259 0.16250000000000001
r3373 n2258 n2259 0.46875
r3374 n2238 n2260 0.16250000000000001
r3375 n2259 n2260 0.3125
r3376 n2239 n2261 0.8125
r3377 n2260 n2261 0.1875
r3378 n2240 n2262 0.40625
r3379 n2261 n2262 0.09375
r3380 n2241 n2263 0.8125
r3381 n2262 n2263 0.09375
r3382 n2242 n2264 0.8125
r3383 n2263 n2264 0.0625
r3384 n2243 n2265 0.8125
r3385 n2264 n2265 0.0625
r3386 n2244 n2266 0.203125
r3387 n2265 n2266 0.15625
r3388 n2245 n2267 0.16250000000000001
r3389 n2266 n2267 0.28125
r3390 n2246 n2268 0.8125
r3391 n2267 n2268 0.1875
r3392 n2247 n2269 0.081250000000000003
r3393 n2268 n2269 0.34375
r3394 n2248 n2270 0.27083333333333331
r3395 n2269 n2270 0.40625
r3396 n2249 n2271 0.13541666666666666
r3397 n2270 n2271 0.28125
r3398 n2250 n2272 0.40625
r3399 n2271 n2272 0.25
r3400 n2251 n2273 0.8125
r3401 n2272 n2273 0.09375
r3402 n2252 n2274 0.8125
r3403 n2273 n2274 0.0625
r3404 n2253 n2275 0.13541666666666666
r3405 n2274 n2275 0.21875
r3406 n2254 n2276 0.16250000000000001
r3407 n2275 n2276 0.34375
r3408 n2255 n2277 0.8125
r3409 n2276 n2277 0.1875
r3410 n2256 n2278 0.203125
r3411 n2277 n2278 0.15625
r3412 n2257 n2279 0.16250000000000001
r3413 n2278 n2279 0.28125
r3414 n2258 n2280 0.20000000000000001
r3415 n2259 n2281 0.40000000000000002
r3416 n2280 n2281 0.03125
r3417 n2260 n2282 0.40000000000000002
r3418 n2281 n2282 0.020833333333333332
r3419 n2261 n2283 2
r3420 n2282 n2283 0.012500000000000001
r3421 n2262 n2284 1
r3422 n2283 n2284 0.0062500000000000003
r3423 n2263 n2285 2
r3424 n2284 n2285 0.0062500000000000003
r3425 n2264 n2286 2
r3426 n2285 n2286 0.0041666666666666666
r3427 n2265 n2287 2
r3428 n2286 n2287 0.0041666666666666666
r3429 n2266 n2288 0.5
r3430 n2287 n2288 0.010416666666666666
r3431 n2267 n2289 0.40000000000000002
r3432 n2288 n2289 0.018749999999999999
r3433 n2268 n2290 2
r3434 n2289 n2290 0.012500000000000001
r3435 n2269 n2291 0.20000000000000001
r3436 n2290 n2291 0.022916666666666665
r3437 n2270 n2292 0.66666666666666663
r3438 n2291 n2292 0.027083333333333334
r3439 n2271 n2293 0.33333333333333331
r3440 n2292 n2293 0.018749999999999999
r3441 n2272 n2294 1
r3442 n2293 n2294 0.016666666666666666
r3443 n2273 n2295 2
r3444 n2294 n2295 0.0062500000000000003
r3445 n2274 n2296 2
r3446 n2295 n2296 0.0041666666666666666
r3447 n2275 n2297 0.33333333333333331
r3448 n2296 n2297 0.014583333333333334
r3449 n2276 n2298 0.40000000000000002
r3450 n2297 n2298 0.022916666666666665
r3451 n2277 n2299 2
r3452 n2298 n2299 0.012500000000000001
r3453 n2278 n2300 0.5
r3454 n2299 n2300 0.010416666666666666
r3455 n2279 n2301 0.40000000000000002
r3456 n2300 n2301 0.018749999999999999
r3457 n2280 n2302 0.20000000000000001
r3458 n2281 n2303 0.40000000000000002
r3459 n2302 n2303 0.46875
r3460 n2282 n2304 0.40000000000000002
r3461 n2303 n2304 0.3125
r3462 n2283 n2305 2
r3463 n2304 n2305 0.1875
r3464 n2284 n2306 1
r3465 n2305 n2306 0.09375
r3466 n2285 n2307 2
r3467 n2306 n2307 0.09375
r3468 n2286 n2308 2
r3469 n2307 n2308 0.0625
r3470 n2287 n2309 2
r3471 n2308 n2309 0.0625
r3472 n2288 n2310 0.5
r3473 n2309 n2310 0.15625
r3474 n2289 n2311 0.40000000000000002
r3475 n2310 n2311 0.28125
r3476 n2290 n2312 2
r3477 n2311 n2312 0.1875
r3478 n2291 n2313 0.20000000000000001
r3479 n2312 n2313 0.34375
r3480 n2292 n2314 0.66666666666666663
r3481 n2313 n2314 0.40625
r3482 n2293 n2315 0.33333333333333331
r3483 n2314 n2315 0.28125
r3484 n2294 n2316 1
r3485 n2315 n2316 0.25
r3486 n2295 n2317 2
r3487 n2316 n2317 0.09375
r3488 n2296 n2318 2
r3489 n2317 n2318 0.0625
r3490 n2297 n2319 0.33333333333333331
r3491 n2318 n2319 0.21875
r3492 n2298 n2320 0.40000000000000002
r3493 n2319 n2320 0.34375
r3494 n2299 n2321 2
r3495 n2320 n2321 0.1875
r3496 n2300 n2322 0.5
r3497 n2321 n2322 0.15625
r3498 n2301 n2323 0.40000000000000002
r3499 n2322 n2323 0.28125
r3500 n2302 n2324 0.081250000000000003
r3501 n2303 n2325 0.16250000000000001
r3502 n2324 n2325 0.085227272727272721
r3503 n2304 n2326 0.16250000000000001
r3504 n2325 n2326 0.056818181818181816
r3505 n2305 n2327 0.8125
r3506 n2326 n2327 0.034090909090909088
r3507 n2306 n2328 0.40625
r3508 n2327 n2328 0.017045454545454544
r3509 n2307 n2329 0.8125
r3510 n2328 n2329 0.017045454545454544
r3511 n2308 n2330 0.8125
r3512 n2329 n2330 0.011363636363636364
r3513 n2309 n2331 0.8125
r3514 n2330 n2331 0.011363636363636364
r3515 n2310 n2332 0.203125
r3516 n2331 n2332 0.028409090909090908
r3517 n2311 n2333 0.16250000000000001
r3518 n2332 n2333 0.05113636363636364
r3519 n2312 n2334 0.8125
r3520 n2333 n2334 0.034090909090909088
r3521 n2313 n2335 0.081250000000000003
r3522 n2334 n2335 0.0625
r3523 n2314 n2336 0.27083333333333331
r3524 n2335 n2336 0.073863636363636367
r3525 n2315 n2337 0.13541666666666666
r3526 n2336 n2337 0.05113636363636364
r3527 n2316 n2338 0.40625
r3528 n2337 n2338 0.045454545454545456
r3529 n2317 n2339 0.8125
r3530 n2338 n2339 0.017045454545454544
r3531 n2318 n2340 0.8125
r3532 n2339 n2340 0.011363636363636364
r3533 n2319 n2341 0.13541666666666666
r3534 n2340 n2341 0.039772727272727272
r3535 n2320 n2342 0.16250000000000001
r3536 n2341 n2342 0.0625
r3537 n2321 n2343 0.8125
r3538 n2342 n2343 0.034090909090909088
r3539 n2322 n2344 0.203125
r3540 n2343 n2344 0.028409090909090908
r3541 n2323 n2345 0.16250000000000001
r3542 n2344 n2345 0.05113636363636364
r3543 n2324 n2346 0.081250000000000003
r3544 n2325 n2347 0.16250000000000001
r3545 n2346 n2347 0.46875
r3546 n2326 n2348 0.16250000000000001
r3547 n2347 n2348 0.3125
r3548 n2327 n2349 0.8125
r3549 n2348 n2349 0.1875
r3550 n2328 n2350 0.40625
r3551 n2349 n2350 0.09375
r3552 n2329 n2351 0.8125
r3553 n2350 n2351 0.09375
r3554 n2330 n2352 0.8125
r3555 n2351 n2352 0.0625
r3556 n2331 n2353 0.8125
r3557 n2352 n2353 0.0625
r3558 n2332 n2354 0.203125
r3559 n2353 n2354 0.15625
r3560 n2333 n2355 0.16250000000000001
r3561 n2354 n2355 0.28125
r3562 n2334 n2356 0.8125
r3563 n2355 n2356 0.1875
r3564 n2335 n2357 0.081250000000000003
r3565 n2356 n2357 0.34375
r3566 n2336 n2358 0.27083333333333331
r3567 n2357 n2358 0.40625
r3568 n2337 n2359 0.13541666666666666
r3569 n2358 n2359 0.28125
r3570 n2338 n2360 0.40625
r3571 n2359 n2360 0.25
r3572 n2339 n2361 0.8125
r3573 n2360 n2361 0.09375
r3574 n2340 n2362 0.8125
r3575 n2361 n2362 0.0625
r3576 n2341 n2363 0.13541666666666666
r3577 n2362 n2363 0.21875
r3578 n2342 n2364 0.16250000000000001
r3579 n2363 n2364 0.34375
r3580 n2343 n2365 0.8125
r3581 n2364 n2365 0.1875
r3582 n2344 n2366 0.203125
r3583 n2365 n2366 0.15625
r3584 n2345 n2367 0.16250000000000001
r3585 n2366 n2367 0.28125
r3586 n2368 n2369 0.46875
r3587 n2369 n2370 0.3125
r3588 n2370 n2371 0.1875
r3589 n2371 n2372 0.125
r3590 n2372 n2373 0.125
r3591 n2373 n2374 0.3125
r3592 n2374 n2375 0.59375
r3593 n2375 n2376 0.46875
r3594 n2376 n2377 0.3125
r3595 n2377 n2378 0.1875
r3596 n2378 n2379 0.09375
r3597 n2379 n2380 0.09375
r3598 n2380 n2381 0.0625
r3599 n2381 n2382 0.0625
r3600 n2382 n2383 0.15625
r3601 n2383 n2384 0.28125
r3602 n2384 n2385 0.1875
r3603 n2385 n2386 0.34375
r3604 n2368 n2387 0.043749999999999997
r3605 n2369 n2388 0.087499999999999994
r3606 n2387 n2388 0.1875
r3607 n2370 n2389 0.087499999999999994
r3608 n2388 n2389 0.125
r3609 n2371 n2390 0.4375
r3610 n2389 n2390 0.074999999999999997
r3611 n2372 n2391 0.14583333333333334
r3612 n2390 n2391 0.050000000000000003
r3613 n2373 n2392 0.4375
r3614 n2391 n2392 0.050000000000000003
r3615 n2374 n2393 0.048611111111111112
r3616 n2392 n2393 0.125
r3617 n2375 n2394 0.043749999999999997
r3618 n2393 n2394 0.23749999999999999
r3619 n2376 n2395 0.087499999999999994
r3620 n2394 n2395 0.1875
r3621 n2377 n2396 0.087499999999999994
r3622 n2395 n2396 0.125
r3623 n2378 n2397 0.4375
r3624 n2396 n2397 0.074999999999999997
r3625 n2379 n2398 0.21875
r3626 n2397 n2398 0.037499999999999999
r3627 n2380 n2399 0.4375
r3628 n2398 n2399 0.037499999999999999
r3629 n2381 n2400 0.4375
r3630 n2399 n2400 0.025000000000000001
r3631 n2382 n2401 0.4375
r3632 n2400 n2401 0.025000000000000001
r3633 n2383 n2402 0.109375
r3634 n2401 n2402 0.0625
r3635 n2384 n2403 0.087499999999999994
r3636 n2402 n2403 0.1125
r3637 n2385 n2404 0.4375
r3638 n2403 n2404 0.074999999999999997
r3639 n2386 n2405 0.043749999999999997
r3640 n2404 n2405 0.13750000000000001
r3641 n2406 n2407 0.11458333333333333
r3642 n2407 n2408 0.0625
r3643 n2408 n2409 0.14583333333333334
r3644 n2387 n2410 0.068750000000000006
r3645 n2409 n2410 0.23958333333333334
r3646 n2388 n2411 0.13750000000000001
r3647 n2410 n2411 0.15625
r3648 n2389 n2412 0.13750000000000001
r3649 n2411 n2412 0.10416666666666667
r3650 n2390 n2413 0.6875
r3651 n2412 n2413 0.0625
r3652 n2391 n2414 0.22916666666666666
r3653 n2413 n2414 0.041666666666666664
r3654 n2392 n2415 0.6875
r3655 n2414 n2415 0.041666666666666664
r3656 n2393 n2416 0.076388888888888895
r3657 n2415 n2416 0.10416666666666667
r3658 n2394 n2417 0.068750000000000006
r3659 n2416 n2417 0.19791666666666666
r3660 n2395 n2418 0.13750000000000001
r3661 n2417 n2418 0.15625
r3662 n2396 n2419 0.13750000000000001
r3663 n2418 n2419 0.10416666666666667
r3664 n2397 n2420 0.6875
r3665 n2419 n2420 0.0625
r3666 n2398 n2421 0.34375
r3667 n2420 n2421 0.03125
r3668 n2399 n2422 0.6875
r3669 n2421 n2422 0.03125
r3670 n2400 n2423 0.6875
r3671 n2422 n2423 0.020833333333333332
r3672 n2401 n2424 0.6875
r3673 n2423 n2424 0.020833333333333332
r3674 n2402 n2425 0.171875
r3675 n2424 n2425 0.052083333333333336
r3676 n2403 n2426 0.13750000000000001
r3677 n2425 n2426 0.09375
r3678 n2404 n2427 0.6875
r3679 n2426 n2427 0.0625
r3680 n2405 n2428 0.068750000000000006
r3681 n2427 n2428 0.11458333333333333
r3682 n2428 n2429 0.13541666666666666
r3683 n2429 n2430 0.09375
r3684 n2430 n2431 0.083333333333333329
r3685 n2431 n2432 0.03125
r3686 n2432 n2433 0.020833333333333332
r3687 n2433 n2434 0.072916666666666671
r3688 n2434 n2435 0.11458333333333333
r3689 n2435 n2436 0.0625
r3690 n2406 n2437 0.083333333333333329
r3691 n2407 n2438 0.10000000000000001
r3692 n2437 n2438 0.34375
r3693 n2408 n2439 0.5
r3694 n2438 n2439 0.1875
r3695 n2409 n2440 0.038461538461538464
r3696 n2439 n2440 0.4375
r3697 n2410 n2441 0.050000000000000003
r3698 n2440 n2441 0.71875
r3699 n2411 n2442 0.10000000000000001
r3700 n2441 n2442 0.46875
r3701 n2412 n2443 0.10000000000000001
r3702 n2442 n2443 0.3125
r3703 n2413 n2444 0.5
r3704 n2443 n2444 0.1875
r3705 n2414 n2445 0.16666666666666666
r3706 n2444 n2445 0.125
r3707 n2415 n2446 0.5
r3708 n2445 n2446 0.125
r3709 n2416 n2447 0.055555555555555552
r3710 n2446 n2447 0.3125
r3711 n2417 n2448 0.050000000000000003
r3712 n2447 n2448 0.59375
r3713 n2418 n2449 0.10000000000000001
r3714 n2448 n2449 0.46875
r3715 n2419 n2450 0.10000000000000001
r3716 n2449 n2450 0.3125
r3717 n2420 n2451 0.5
r3718 n2450 n2451 0.1875
r3719 n2421 n2452 0.25
r3720 n2451 n2452 0.09375
r3721 n2422 n2453 0.5
r3722 n2452 n2453 0.09375
r3723 n2423 n2454 0.5
r3724 n2453 n2454 0.0625
r3725 n2424 n2455 0.5
r3726 n2454 n2455 0.0625
r3727 n2425 n2456 0.125
r3728 n2455 n2456 0.15625
r3729 n2426 n2457 0.10000000000000001
r3730 n2456 n2457 0.28125
r3731 n2427 n2458 0.5
r3732 n2457 n2458 0.1875
r3733 n2428 n2459 0.050000000000000003
r3734 n2458 n2459 0.34375
r3735 n2429 n2460 0.16666666666666666
r3736 n2459 n2460 0.40625
r3737 n2430 n2461 0.083333333333333329
r3738 n2460 n2461 0.28125
r3739 n2431 n2462 0.25
r3740 n2461 n2462 0.25
r3741 n2432 n2463 0.5
r3742 n2462 n2463 0.09375
r3743 n2433 n2464 0.5
r3744 n2463 n2464 0.0625
r3745 n2434 n2465 0.083333333333333329
r3746 n2464 n2465 0.21875
r3747 n2435 n2466 0.10000000000000001
r3748 n2465 n2466 0.34375
r3749 n2436 n2467 0.5
r3750 n2466 n2467 0.1875
r3751 n2437 n2468 0.1875
r3752 n2438 n2469 0.22500000000000001
r3753 n2468 n2469 0.04296875
r3754 n2439 n2470 1.125
r3755 n2469 n2470 0.0234375
r3756 n2440 n2471 0.086538461538461536
r3757 n2470 n2471 0.0546875
r3758 n2441 n2472 0.1125
r3759 n2471 n2472 0.08984375
r3760 n2442 n2473 0.22500000000000001
r3761 n2472 n2473 0.05859375
r3762 n2443 n2474 0.22500000000000001
r3763 n2473 n2474 0.0390625
r3764 n2444 n2475 1.125
r3765 n2474 n2475 0.0234375
r3766 n2445 n2476 0.375
r3767 n2475 n2476 0.015625
r3768 n2446 n2477 1.125
r3769 n2476 n2477 0.015625
r3770 n2447 n2478 0.125
r3771 n2477 n2478 0.0390625
r3772 n2448 n2479 0.1125
r3773 n2478 n2479 0.07421875
r3774 n2449 n2480 0.22500000000000001
r3775 n2479 n2480 0.05859375
r3776 n2450 n2481 0.22500000000000001
r3777 n2480 n2481 0.0390625
r3778 n2451 n2482 1.125
r3779 n2481 n2482 0.0234375
r3780 n2452 n2483 0.5625
r3781 n2482 n2483 0.01171875
r3782 n2453 n2484 1.125
r3783 n2483 n2484 0.01171875
r3784 n2454 n2485 1.125
r3785 n2484 n2485 0.0078125
r3786 n2455 n2486 1.125
r3787 n2485 n2486 0.0078125
r3788 n2456 n2487 0.28125
r3789 n2486 n2487 0.01953125
r3790 n2457 n2488 0.22500000000000001
r3791 n2487 n2488 0.03515625
r3792 n2458 n2489 1.125
r3793 n2488 n2489 0.0234375
r3794 n2459 n2490 0.1125
r3795 n2489 n2490 0.04296875
r3796 n2460 n2491 0.375
r3797 n2490 n2491 0.05078125
r3798 n2461 n2492 0.1875
r3799 n2491 n2492 0.03515625
r3800 n2462 n2493 0.5625
r3801 n2492 n2493 0.03125
r3802 n2463 n2494 1.125
r3803 n2493 n2494 0.01171875
r3804 n2464 n2495 1.125
r3805 n2494 n2495 0.0078125
r3806 n2465 n2496 0.1875
r3807 n2495 n2496 0.02734375
r3808 n2466 n2497 0.22500000000000001
r3809 n2496 n2497 0.04296875
r3810 n2467 n2498 1.125
r3811 n2497 n2498 0.0234375
r3812 n2468 n2499 0.3125
r3813 n2469 n2500 0.375
r3814 n2499 n2500 0.049107142857142856
r3815 n2470 n2501 1.875
r3816 n2500 n2501 0.026785714285714284
r3817 n2471 n2502 0.14423076923076922
r3818 n2501 n2502 0.0625
r3819 n2472 n2503 0.1875
r3820 n2502 n2503 0.10267857142857142
r3821 n2473 n2504 0.375
r3822 n2503 n2504 0.066964285714285712
r3823 n2474 n2505 0.375
r3824 n2504 n2505 0.044642857142857144
r3825 n2475 n2506 1.875
r3826 n2505 n2506 0.026785714285714284
r3827 n2476 n2507 0.625
r3828 n2506 n2507 0.017857142857142856
r3829 n2477 n2508 1.875
r3830 n2507 n2508 0.017857142857142856
r3831 n2478 n2509 0.20833333333333334
r3832 n2508 n2509 0.044642857142857144
r3833 n2479 n2510 0.1875
r3834 n2509 n2510 0.084821428571428575
r3835 n2480 n2511 0.375
r3836 n2510 n2511 0.066964285714285712
r3837 n2481 n2512 0.375
r3838 n2511 n2512 0.044642857142857144
r3839 n2482 n2513 1.875
r3840 n2512 n2513 0.026785714285714284
r3841 n2483 n2514 0.9375
r3842 n2513 n2514 0.013392857142857142
r3843 n2484 n2515 1.875
r3844 n2514 n2515 0.013392857142857142
r3845 n2485 n2516 1.875
r3846 n2515 n2516 0.0089285714285714281
r3847 n2486 n2517 1.875
r3848 n2516 n2517 0.0089285714285714281
r3849 n2487 n2518 0.46875
r3850 n2517 n2518 0.022321428571428572
r3851 n2488 n2519 0.375
r3852 n2518 n2519 0.040178571428571432
r3853 n2489 n2520 1.875
r3854 n2519 n2520 0.026785714285714284
r3855 n2490 n2521 0.1875
r3856 n2520 n2521 0.049107142857142856
r3857 n2491 n2522 0.625
r3858 n2521 n2522 0.058035714285714288
r3859 n2492 n2523 0.3125
r3860 n2522 n2523 0.040178571428571432
r3861 n2493 n2524 0.9375
r3862 n2523 n2524 0.035714285714285712
r3863 n2494 n2525 1.875
r3864 n2524 n2525 0.013392857142857142
r3865 n2495 n2526 1.875
r3866 n2525 n2526 0.0089285714285714281
r3867 n2496 n2527 0.3125
r3868 n2526 n2527 0.03125
r3869 n2497 n2528 0.375
r3870 n2527 n2528 0.049107142857142856
r3871 n2498 n2529 1.875
r3872 n2528 n2529 0.026785714285714284
r3873 n2499 n2530 0.16666666666666666
r3874 n2500 n2531 0.20000000000000001
r3875 n2530 n2531 0.34375
r3876 n2501 n2532 1
r3877 n2531 n2532 0.1875
r3878 n2502 n2533 0.076923076923076927
r3879 n2532 n2533 0.4375
r3880 n2503 n2534 0.10000000000000001
r3881 n2533 n2534 0.71875
r3882 n2504 n2535 0.20000000000000001
r3883 n2534 n2535 0.46875
r3884 n2505 n2536 0.20000000000000001
r3885 n2535 n2536 0.3125
r3886 n2506 n2537 1
r3887 n2536 n2537 0.1875
r3888 n2507 n2538 0.33333333333333331
r3889 n2537 n2538 0.125
r3890 n2508 n2539 1
r3891 n2538 n2539 0.125
r3892 n2509 n2540 0.1111111111111111
r3893 n2539 n2540 0.3125
r3894 n2510 n2541 0.10000000000000001
r3895 n2540 n2541 0.59375
r3896 n2511 n2542 0.20000000000000001
r3897 n2541 n2542 0.46875
r3898 n2512 n2543 0.20000000000000001
r3899 n2542 n2543 0.3125
r3900 n2513 n2544 1
r3901 n2543 n2544 0.1875
r3902 n2514 n2545 0.5
r3903 n2544 n2545 0.09375
r3904 n2515 n2546 1
r3905 n2545 n2546 0.09375
r3906 n2516 n2547 1
r3907 n2546 n2547 0.0625
r3908 n2517 n2548 1
r3909 n2547 n2548 0.0625
r3910 n2518 n2549 0.25
r3911 n2548 n2549 0.15625
r3912 n2519 n2550 0.20000000000000001
r3913 n2549 n2550 0.28125
r3914 n2520 n2551 1
r3915 n2550 n2551 0.1875
r3916 n2521 n2552 0.10000000000000001
r3917 n2551 n2552 0.34375
r3918 n2522 n2553 0.33333333333333331
r3919 n2552 n2553 0.40625
r3920 n2523 n2554 0.16666666666666666
r3921 n2553 n2554 0.28125
r3922 n2524 n2555 0.5
r3923 n2554 n2555 0.25
r3924 n2525 n2556 1
r3925 n2555 n2556 0.09375
r3926 n2526 n2557 1
r3927 n2556 n2557 0.0625
r3928 n2527 n2558 0.16666666666666666
r3929 n2557 n2558 0.21875
r3930 n2528 n2559 0.20000000000000001
r3931 n2558 n2559 0.34375
r3932 n2529 n2560 1
r3933 n2559 n2560 0.1875
r3934 n2530 n2561 0.0625
r3935 n2531 n2562 0.074999999999999997
r3936 n2561 n2562 0.171875
r3937 n2532 n2563 0.375
r3938 n2562 n2563 0.09375
r3939 n2533 n2564 0.028846153846153848
r3940 n2563 n2564 0.21875
r3941 n2534 n2565 0.037499999999999999
r3942 n2564 n2565 0.359375
r3943 n2535 n2566 0.074999999999999997
r3944 n2565 n2566 0.234375
r3945 n2536 n2567 0.074999999999999997
r3946 n2566 n2567 0.15625
r3947 n2537 n2568 0.375
r3948 n2567 n2568 0.09375
r3949 n2538 n2569 0.125
r3950 n2568 n2569 0.0625
r3951 n2539 n2570 0.375
r3952 n2569 n2570 0.0625
r3953 n2540 n2571 0.041666666666666664
r3954 n2570 n2571 0.15625
r3955 n2541 n2572 0.037499999999999999
r3956 n2571 n2572 0.296875
r3957 n2542 n2573 0.074999999999999997
r3958 n2572 n2573 0.234375
r3959 n2543 n2574 0.074999999999999997
r3960 n2573 n2574 0.15625
r3961 n2544 n2575 0.375
r3962 n2574 n2575 0.09375
r3963 n2545 n2576 0.1875
r3964 n2575 n2576 0.046875
r3965 n2546 n2577 0.375
r3966 n2576 n2577 0.046875
r3967 n2547 n2578 0.375
r3968 n2577 n2578 0.03125
r3969 n2548 n2579 0.375
r3970 n2578 n2579 0.03125
r3971 n2549 n2580 0.09375
r3972 n2579 n2580 0.078125
r3973 n2550 n2581 0.074999999999999997
r3974 n2580 n2581 0.140625
r3975 n2551 n2582 0.375
r3976 n2581 n2582 0.09375
r3977 n2552 n2583 0.037499999999999999
r3978 n2582 n2583 0.171875
r3979 n2553 n2584 0.125
r3980 n2583 n2584 0.203125
r3981 n2554 n2585 0.0625
r3982 n2584 n2585 0.140625
r3983 n2555 n2586 0.1875
r3984 n2585 n2586 0.125
r3985 n2556 n2587 0.375
r3986 n2586 n2587 0.046875
r3987 n2557 n2588 0.375
r3988 n2587 n2588 0.03125
r3989 n2558 n2589 0.0625
r3990 n2588 n2589 0.109375
r3991 n2559 n2590 0.074999999999999997
r3992 n2589 n2590 0.171875
r3993 n2560 n2591 0.375
r3994 n2590 n2591 0.09375
r3995 n2592 n2593 0.125
r3996 n2593 n2594 0.296875
r3997 n2594 n2595 0.46875
r3998 n2595 n2596 0.234375
r3999 n2596 n2597 0.0625
r4000 n2597 n2598 0.09375
r4001 n2561 n2599 0.0625
r4002 n2562 n2600 0.074999999999999997
r4003 n2599 n2600 0.34375
r4004 n2563 n2601 0.375
r4005 n2600 n2601 0.1875
r4006 n2564 n2602 0.028846153846153848
r4007 n2601 n2602 0.4375
r4008 n2565 n2603 0.037499999999999999
r4009 n2602 n2603 0.71875
r4010 n2566 n2604 0.074999999999999997
r4011 n2603 n2604 0.46875
r4012 n2567 n2605 0.074999999999999997
r4013 n2604 n2605 0.3125
r4014 n2568 n2606 0.375
r4015 n2605 n2606 0.1875
r4016 n2569 n2607 0.125
r4017 n2606 n2607 0.125
r4018 n2570 n2608 0.375
r4019 n2607 n2608 0.125
r4020 n2571 n2609 0.041666666666666664
r4021 n2608 n2609 0.3125
r4022 n2572 n2610 0.037499999999999999
r4023 n2609 n2610 0.59375
r4024 n2573 n2611 0.074999999999999997
r4025 n2610 n2611 0.46875
r4026 n2574 n2612 0.074999999999999997
r4027 n2611 n2612 0.3125
r4028 n2575 n2613 0.375
r4029 n2612 n2613 0.1875
r4030 n2576 n2614 0.1875
r4031 n2613 n2614 0.09375
r4032 n2577 n2615 0.375
r4033 n2614 n2615 0.09375
r4034 n2578 n2616 0.375
r4035 n2615 n2616 0.0625
r4036 n2579 n2617 0.375
r4037 n2616 n2617 0.0625
r4038 n2580 n2618 0.09375
r4039 n2617 n2618 0.15625
r4040 n2581 n2619 0.074999999999999997
r4041 n2618 n2619 0.28125
r4042 n2582 n2620 0.375
r4043 n2619 n2620 0.1875
r4044 n2583 n2621 0.037499999999999999
r4045 n2620 n2621 0.34375
r4046 n2584 n2622 0.125
r4047 n2621 n2622 0.40625
r4048 n2585 n2623 0.0625
r4049 n2622 n2623 0.28125
r4050 n2586 n2624 0.1875
r4051 n2623 n2624 0.25
r4052 n2587 n2625 0.375
r4053 n2624 n2625 0.09375
r4054 n2588 n2626 0.375
r4055 n2625 n2626 0.0625
r4056 n2589 n2627 0.0625
r4057 n2626 n2627 0.21875
r4058 n2590 n2628 0.074999999999999997
r4059 n2627 n2628 0.34375
r4060 n2591 n2629 0.375
r4061 n2628 n2629 0.1875
r4062 n2592 n2630 0.0625
r4063 n2593 n2631 0.1875
r4064 n2630 n2631 0.25
r4065 n2594 n2632 0.022058823529411766
r4066 n2631 n2632 0.59375
r4067 n2595 n2633 0.028846153846153848
r4068 n2632 n2633 0.9375
r4069 n2596 n2634 0.1875
r4070 n2633 n2634 0.46875
r4071 n2597 n2635 0.1875
r4072 n2634 n2635 0.125
r4073 n2598 n2636 0.09375
r4074 n2635 n2636 0.1875
r4075 n2603 n2637 0.018749999999999999
r4076 n2604 n2638 0.037499999999999999
r4077 n2637 n2638 0.9375
r4078 n2605 n2639 0.037499999999999999
r4079 n2638 n2639 0.625
r4080 n2606 n2640 0.1875
r4081 n2639 n2640 0.375
r4082 n2607 n2641 0.0625
r4083 n2640 n2641 0.25
r4084 n2608 n2642 0.1875
r4085 n2641 n2642 0.25
r4086 n2609 n2643 0.020833333333333332
r4087 n2642 n2643 0.625
r4088 n2610 n2644 0.018749999999999999
r4089 n2643 n2644 1.1875
r4090 n2611 n2645 0.037499999999999999
r4091 n2644 n2645 0.9375
r4092 n2612 n2646 0.037499999999999999
r4093 n2645 n2646 0.625
r4094 n2613 n2647 0.1875
r4095 n2646 n2647 0.375
r4096 n2614 n2648 0.09375
r4097 n2647 n2648 0.1875
r4098 n2615 n2649 0.1875
r4099 n2648 n2649 0.1875
r4100 n2616 n2650 0.1875
r4101 n2649 n2650 0.125
r4102 n2617 n2651 0.1875
r4103 n2650 n2651 0.125
r4104 n2618 n2652 0.046875
r4105 n2651 n2652 0.3125
r4106 n2619 n2653 0.037499999999999999
r4107 n2652 n2653 0.5625
r4108 n2620 n2654 0.1875
r4109 n2653 n2654 0.375
r4110 n2621 n2655 0.018749999999999999
r4111 n2654 n2655 0.6875
r4112 n2630 n2656 0.03125
r4113 n2631 n2657 0.09375
r4114 n2656 n2657 0.5
r4115 n2632 n2658 0.011029411764705883
r4116 n2657 n2658 1.1875
r4117 n2633 n2659 0.014423076923076924
r4118 n2658 n2659 1.875
r4119 n2634 n2660 0.09375
r4120 n2659 n2660 0.9375
r4121 n2635 n2661 0.09375
r4122 n2660 n2661 0.25
r4123 n2636 n2662 0.046875
r4124 n2661 n2662 0.375
r4125 n2637 n2663 0.03125
r4126 n2638 n2664 0.0625
r4127 n2663 n2664 0.234375
r4128 n2639 n2665 0.0625
r4129 n2664 n2665 0.15625
r4130 n2640 n2666 0.3125
r4131 n2665 n2666 0.09375
r4132 n2641 n2667 0.10416666666666667
r4133 n2666 n2667 0.0625
r4134 n2642 n2668 0.3125
r4135 n2667 n2668 0.0625
r4136 n2643 n2669 0.034722222222222224
r4137 n2668 n2669 0.15625
r4138 n2644 n2670 0.03125
r4139 n2669 n2670 0.296875
r4140 n2645 n2671 0.0625
r4141 n2670 n2671 0.234375
r4142 n2646 n2672 0.0625
r4143 n2671 n2672 0.15625
r4144 n2647 n2673 0.3125
r4145 n2672 n2673 0.09375
r4146 n2648 n2674 0.15625
r4147 n2673 n2674 0.046875
r4148 n2649 n2675 0.3125
r4149 n2674 n2675 0.046875
r4150 n2650 n2676 0.3125
r4151 n2675 n2676 0.03125
r4152 n2651 n2677 0.3125
r4153 n2676 n2677 0.03125
r4154 n2652 n2678 0.078125
r4155 n2677 n2678 0.078125
r4156 n2653 n2679 0.0625
r4157 n2678 n2679 0.140625
r4158 n2654 n2680 0.3125
r4159 n2679 n2680 0.09375
r4160 n2655 n2681 0.03125
r4161 n2680 n2681 0.171875
r4162 n2682 n2683 0.1875
r4163 n2683 n2684 0.203125
r4164 n2656 n2685 0.052083333333333336
r4165 n2684 n2685 0.171875
r4166 n2657 n2686 0.15625
r4167 n2685 n2686 0.125
r4168 n2658 n2687 0.018382352941176471
r4169 n2686 n2687 0.296875
r4170 n2659 n2688 0.02403846153846154
r4171 n2687 n2688 0.46875
r4172 n2660 n2689 0.15625
r4173 n2688 n2689 0.234375
r4174 n2661 n2690 0.15625
r4175 n2689 n2690 0.0625
r4176 n2662 n2691 0.078125
r4177 n2690 n2691 0.09375
r4178 n2691 n2692 0.140625
r4179 n2692 n2693 0.203125
r4180 n2693 n2694 0.1875
r4181 n2663 n2695 0.037499999999999999
r4182 n2664 n2696 0.074999999999999997
r4183 n2695 n2696 0.46875
r4184 n2665 n2697 0.074999999999999997
r4185 n2696 n2697 0.3125
r4186 n2666 n2698 0.375
r4187 n2697 n2698 0.1875
r4188 n2667 n2699 0.125
r4189 n2698 n2699 0.125
r4190 n2668 n2700 0.375
r4191 n2699 n2700 0.125
r4192 n2669 n2701 0.041666666666666664
r4193 n2700 n2701 0.3125
r4194 n2670 n2702 0.037499999999999999
r4195 n2701 n2702 0.59375
r4196 n2671 n2703 0.074999999999999997
r4197 n2702 n2703 0.46875
r4198 n2672 n2704 0.074999999999999997
r4199 n2703 n2704 0.3125
r4200 n2673 n2705 0.375
r4201 n2704 n2705 0.1875
r4202 n2674 n2706 0.1875
r4203 n2705 n2706 0.09375
r4204 n2675 n2707 0.375
r4205 n2706 n2707 0.09375
r4206 n2676 n2708 0.375
r4207 n2707 n2708 0.0625
r4208 n2677 n2709 0.375
r4209 n2708 n2709 0.0625
r4210 n2678 n2710 0.09375
r4211 n2709 n2710 0.15625
r4212 n2679 n2711 0.074999999999999997
r4213 n2710 n2711 0.28125
r4214 n2680 n2712 0.375
r4215 n2711 n2712 0.1875
r4216 n2681 n2713 0.037499999999999999
r4217 n2712 n2713 0.34375
r4218 n2682 n2714 0.09375
r4219 n2683 n2715 0.046875
r4220 n2714 n2715 0.375
r4221 n2684 n2716 0.074999999999999997
r4222 n2715 n2716 0.40625
r4223 n2685 n2717 0.0625
r4224 n2716 n2717 0.34375
r4225 n2686 n2718 0.1875
r4226 n2717 n2718 0.25
r4227 n2687 n2719 0.022058823529411766
r4228 n2718 n2719 0.59375
r4229 n2688 n2720 0.028846153846153848
r4230 n2719 n2720 0.9375
r4231 n2689 n2721 0.1875
r4232 n2720 n2721 0.46875
r4233 n2690 n2722 0.1875
r4234 n2721 n2722 0.125
r4235 n2691 n2723 0.09375
r4236 n2722 n2723 0.1875
r4237 n2692 n2724 0.074999999999999997
r4238 n2723 n2724 0.28125
r4239 n2693 n2725 0.046875
r4240 n2724 n2725 0.40625
r4241 n2694 n2726 0.09375
r4242 n2725 n2726 0.375
r4243 n2714 n2727 0.109375
r4244 n2715 n2728 0.0546875
r4245 n2727 n2728 0.14999999999999999
r4246 n2716 n2729 0.087499999999999994
r4247 n2728 n2729 0.16250000000000001
r4248 n2717 n2730 0.072916666666666671
r4249 n2729 n2730 0.13750000000000001
r4250 n2718 n2731 0.21875
r4251 n2730 n2731 0.10000000000000001
r4252 n2719 n2732 0.025735294117647058
r4253 n2731 n2732 0.23749999999999999
r4254 n2720 n2733 0.033653846153846152
r4255 n2732 n2733 0.375
r4256 n2721 n2734 0.21875
r4257 n2733 n2734 0.1875
r4258 n2722 n2735 0.21875
r4259 n2734 n2735 0.050000000000000003
r4260 n2723 n2736 0.109375
r4261 n2735 n2736 0.074999999999999997
r4262 n2724 n2737 0.087499999999999994
r4263 n2736 n2737 0.1125
r4264 n2725 n2738 0.0546875
r4265 n2737 n2738 0.16250000000000001
r4266 n2726 n2739 0.109375
r4267 n2738 n2739 0.14999999999999999
r4268 n2727 n2740 0.109375
r4269 n2728 n2741 0.0546875
r4270 n2740 n2741 0.375
r4271 n2729 n2742 0.087499999999999994
r4272 n2741 n2742 0.40625
r4273 n2730 n2743 0.072916666666666671
r4274 n2742 n2743 0.34375
r4275 n2731 n2744 0.21875
r4276 n2743 n2744 0.25
r4277 n2732 n2745 0.025735294117647058
r4278 n2744 n2745 0.59375
r4279 n2733 n2746 0.033653846153846152
r4280 n2745 n2746 0.9375
r4281 n2734 n2747 0.21875
r4282 n2746 n2747 0.46875
r4283 n2735 n2748 0.21875
r4284 n2747 n2748 0.125
r4285 n2736 n2749 0.109375
r4286 n2748 n2749 0.1875
r4287 n2737 n2750 0.087499999999999994
r4288 n2749 n2750 0.28125
r4289 n2738 n2751 0.0546875
r4290 n2750 n2751 0.40625
r4291 n2739 n2752 0.109375
r4292 n2751 n2752 0.375
r4293 n2740 n2753 0.0625
r4294 n2741 n2754 0.03125
r4295 n2753 n2754 0.375
r4296 n2742 n2755 0.050000000000000003
r4297 n2754 n2755 0.40625
r4298 n2743 n2756 0.041666666666666664
r4299 n2755 n2756 0.34375
r4300 n2744 n2757 0.125
r4301 n2756 n2757 0.25
r4302 n2745 n2758 0.014705882352941176
r4303 n2757 n2758 0.59375
r4304 n2746 n2759 0.019230769230769232
r4305 n2758 n2759 0.9375
r4306 n2747 n2760 0.125
r4307 n2759 n2760 0.46875
r4308 n2748 n2761 0.125
r4309 n2760 n2761 0.125
r4310 n2749 n2762 0.0625
r4311 n2761 n2762 0.1875
r4312 n2750 n2763 0.050000000000000003
r4313 n2762 n2763 0.28125
r4314 n2751 n2764 0.03125
r4315 n2763 n2764 0.40625
r4316 n2752 n2765 0.0625
r4317 n2764 n2765 0.375
r4318 n2753 n2766 0.46875
r4319 n2754 n2767 0.234375
r4320 n2766 n2767 0.026785714285714284
r4321 n2755 n2768 0.375
r4322 n2767 n2768 0.029017857142857144
r4323 n2756 n2769 0.3125
r4324 n2768 n2769 0.024553571428571428
r4325 n2757 n2770 0.9375
r4326 n2769 n2770 0.017857142857142856
r4327 n2758 n2771 0.11029411764705882
r4328 n2770 n2771 0.042410714285714288
r4329 n2759 n2772 0.14423076923076922
r4330 n2771 n2772 0.066964285714285712
r4331 n2760 n2773 0.9375
r4332 n2772 n2773 0.033482142857142856
r4333 n2761 n2774 0.9375
r4334 n2773 n2774 0.0089285714285714281
r4335 n2762 n2775 0.46875
r4336 n2774 n2775 0.013392857142857142
r4337 n2763 n2776 0.375
r4338 n2775 n2776 0.020089285714285716
r4339 n2764 n2777 0.234375
r4340 n2776 n2777 0.029017857142857144
r4341 n2765 n2778 0.46875
r4342 n2777 n2778 0.026785714285714284
r4343 n2766 n2779 0.46875
r4344 n2767 n2780 0.234375
r4345 n2779 n2780 0.375
r4346 n2768 n2781 0.375
r4347 n2780 n2781 0.40625
r4348 n2769 n2782 0.3125
r4349 n2781 n2782 0.34375
r4350 n2770 n2783 0.9375
r4351 n2782 n2783 0.25
r4352 n2771 n2784 0.11029411764705882
r4353 n2783 n2784 0.59375
r4354 n2772 n2785 0.14423076923076922
r4355 n2784 n2785 0.9375
r4356 n2773 n2786 0.9375
r4357 n2785 n2786 0.46875
r4358 n2774 n2787 0.9375
r4359 n2786 n2787 0.125
r4360 n2775 n2788 0.46875
r4361 n2787 n2788 0.1875
r4362 n2776 n2789 0.375
r4363 n2788 n2789 0.28125
r4364 n2777 n2790 0.234375
r4365 n2789 n2790 0.40625
r4366 n2778 n2791 0.46875
r4367 n2790 n2791 0.375
r4368 n2779 n2792 0.0625
r4369 n2780 n2793 0.03125
r4370 n2792 n2793 0.375
r4371 n2781 n2794 0.050000000000000003
r4372 n2793 n2794 0.40625
r4373 n2782 n2795 0.041666666666666664
r4374 n2794 n2795 0.34375
r4375 n2783 n2796 0.125
r4376 n2795 n2796 0.25
r4377 n2784 n2797 0.014705882352941176
r4378 n2796 n2797 0.59375
r4379 n2785 n2798 0.019230769230769232
r4380 n2797 n2798 0.9375
r4381 n2786 n2799 0.125
r4382 n2798 n2799 0.46875
r4383 n2787 n2800 0.125
r4384 n2799 n2800 0.125
r4385 n2788 n2801 0.0625
r4386 n2800 n2801 0.1875
r4387 n2789 n2802 0.050000000000000003
r4388 n2801 n2802 0.28125
r4389 n2790 n2803 0.03125
r4390 n2802 n2803 0.40625
r4391 n2791 n2804 0.0625
r4392 n2803 n2804 0.375
r4393 n2792 n2805 0.0625
r4394 n2793 n2806 0.03125
r4395 n2805 n2806 0.375
r4396 n2794 n2807 0.050000000000000003
r4397 n2806 n2807 0.40625
r4398 n2795 n2808 0.041666666666666664
r4399 n2807 n2808 0.34375
r4400 n2796 n2809 0.125
r4401 n2808 n2809 0.25
r4402 n2797 n2810 0.014705882352941176
r4403 n2809 n2810 0.59375
r4404 n2798 n2811 0.019230769230769232
r4405 n2810 n2811 0.9375
r4406 n2799 n2812 0.125
r4407 n2811 n2812 0.46875
r4408 n2800 n2813 0.125
r4409 n2812 n2813 0.125
r4410 n2801 n2814 0.0625
r4411 n2813 n2814 0.1875
r4412 n2802 n2815 0.050000000000000003
r4413 n2814 n2815 0.28125
r4414 n2803 n2816 0.03125
r4415 n2815 n2816 0.40625
r4416 n2804 n2817 0.0625
r4417 n2816 n2817 0.375
r4418 n2805 n2818 0.09375
r4419 n2806 n2819 0.046875
r4420 n2818 n2819 0.1875
r4421 n2807 n2820 0.074999999999999997
r4422 n2819 n2820 0.203125
r4423 n2808 n2821 0.0625
r4424 n2820 n2821 0.171875
r4425 n2809 n2822 0.1875
r4426 n2821 n2822 0.125
r4427 n2810 n2823 0.022058823529411766
r4428 n2822 n2823 0.296875
r4429 n2811 n2824 0.028846153846153848
r4430 n2823 n2824 0.46875
r4431 n2812 n2825 0.1875
r4432 n2824 n2825 0.234375
r4433 n2813 n2826 0.1875
r4434 n2825 n2826 0.0625
r4435 n2814 n2827 0.09375
r4436 n2826 n2827 0.09375
r4437 n2815 n2828 0.074999999999999997
r4438 n2827 n2828 0.140625
r4439 n2816 n2829 0.046875
r4440 n2828 n2829 0.203125
r4441 n2817 n2830 0.09375
r4442 n2829 n2830 0.1875
r4443 n2831 n2832 0.13392857142857142
r4444 n2832 n2833 0.089285714285714288
r4445 n2833 n2834 0.053571428571428568
r4446 n2834 n2835 0.035714285714285712
r4447 n2835 n2836 0.035714285714285712
r4448 n2836 n2837 0.089285714285714288
r4449 n2837 n2838 0.16964285714285715
r4450 n2838 n2839 0.13392857142857142
r4451 n2839 n2840 0.089285714285714288
r4452 n2840 n2841 0.053571428571428568
r4453 n2841 n2842 0.026785714285714284
r4454 n2842 n2843 0.026785714285714284
r4455 n2843 n2844 0.017857142857142856
r4456 n2844 n2845 0.017857142857142856
r4457 n2845 n2846 0.044642857142857144
r4458 n2846 n2847 0.080357142857142863
r4459 n2847 n2848 0.053571428571428568
r4460 n2848 n2849 0.098214285714285712
r4461 n2818 n2850 0.171875
r4462 n2819 n2851 0.0859375
r4463 n2850 n2851 0.10714285714285714
r4464 n2820 n2852 0.13750000000000001
r4465 n2851 n2852 0.11607142857142858
r4466 n2821 n2853 0.11458333333333333
r4467 n2852 n2853 0.098214285714285712
r4468 n2822 n2854 0.34375
r4469 n2853 n2854 0.071428571428571425
r4470 n2823 n2855 0.040441176470588237
r4471 n2854 n2855 0.16964285714285715
r4472 n2824 n2856 0.052884615384615384
r4473 n2855 n2856 0.26785714285714285
r4474 n2825 n2857 0.34375
r4475 n2856 n2857 0.13392857142857142
r4476 n2826 n2858 0.34375
r4477 n2857 n2858 0.035714285714285712
r4478 n2827 n2859 0.171875
r4479 n2858 n2859 0.053571428571428568
r4480 n2828 n2860 0.13750000000000001
r4481 n2859 n2860 0.080357142857142863
r4482 n2829 n2861 0.0859375
r4483 n2860 n2861 0.11607142857142858
r4484 n2830 n2862 0.171875
r4485 n2861 n2862 0.10714285714285714
r4486 n2863 n2864 0.22916666666666666
r4487 n2864 n2865 0.125
r4488 n2865 n2866 0.29166666666666669
r4489 n2831 n2867 0.0625
r4490 n2866 n2867 0.47916666666666669
r4491 n2832 n2868 0.125
r4492 n2867 n2868 0.3125
r4493 n2833 n2869 0.125
r4494 n2868 n2869 0.20833333333333334
r4495 n2834 n2870 0.625
r4496 n2869 n2870 0.125
r4497 n2835 n2871 0.20833333333333334
r4498 n2870 n2871 0.083333333333333329
r4499 n2836 n2872 0.625
r4500 n2871 n2872 0.083333333333333329
r4501 n2837 n2873 0.069444444444444448
r4502 n2872 n2873 0.20833333333333334
r4503 n2838 n2874 0.0625
r4504 n2873 n2874 0.39583333333333331
r4505 n2839 n2875 0.125
r4506 n2874 n2875 0.3125
r4507 n2840 n2876 0.125
r4508 n2875 n2876 0.20833333333333334
r4509 n2841 n2877 0.625
r4510 n2876 n2877 0.125
r4511 n2842 n2878 0.3125
r4512 n2877 n2878 0.0625
r4513 n2843 n2879 0.625
r4514 n2878 n2879 0.0625
r4515 n2844 n2880 0.625
r4516 n2879 n2880 0.041666666666666664
r4517 n2845 n2881 0.625
r4518 n2880 n2881 0.041666666666666664
r4519 n2846 n2882 0.15625
r4520 n2881 n2882 0.10416666666666667
r4521 n2847 n2883 0.125
r4522 n2882 n2883 0.1875
r4523 n2848 n2884 0.625
r4524 n2883 n2884 0.125
r4525 n2849 n2885 0.0625
r4526 n2884 n2885 0.22916666666666666
r4527 n2885 n2886 0.27083333333333331
r4528 n2886 n2887 0.1875
r4529 n2887 n2888 0.16666666666666666
r4530 n2888 n2889 0.0625
r4531 n2889 n2890 0.041666666666666664
r4532 n2890 n2891 0.14583333333333334
r4533 n2891 n2892 0.22916666666666666
r4534 n2892 n2893 0.125
r4535 n2853 n2894 0.10416666666666667
r4536 n2854 n2895 0.3125
r4537 n2894 n2895 0.16666666666666666
r4538 n2855 n2896 0.036764705882352942
r4539 n2895 n2896 0.39583333333333331
r4540 n2856 n2897 0.04807692307692308
r4541 n2896 n2897 0.625
r4542 n2857 n2898 0.3125
r4543 n2897 n2898 0.3125
r4544 n2858 n2899 0.3125
r4545 n2898 n2899 0.083333333333333329
r4546 n2859 n2900 0.15625
r4547 n2899 n2900 0.125
r4548 n2863 n2901 0.0625
r4549 n2864 n2902 0.074999999999999997
r4550 n2901 n2902 0.22916666666666666
r4551 n2865 n2903 0.375
r4552 n2902 n2903 0.125
r4553 n2866 n2904 0.028846153846153848
r4554 n2903 n2904 0.29166666666666669
r4555 n2867 n2905 0.037499999999999999
r4556 n2904 n2905 0.47916666666666669
r4557 n2868 n2906 0.074999999999999997
r4558 n2905 n2906 0.3125
r4559 n2869 n2907 0.074999999999999997
r4560 n2906 n2907 0.20833333333333334
r4561 n2870 n2908 0.375
r4562 n2907 n2908 0.125
r4563 n2871 n2909 0.125
r4564 n2908 n2909 0.083333333333333329
r4565 n2872 n2910 0.375
r4566 n2909 n2910 0.083333333333333329
r4567 n2873 n2911 0.041666666666666664
r4568 n2910 n2911 0.20833333333333334
r4569 n2874 n2912 0.037499999999999999
r4570 n2911 n2912 0.39583333333333331
r4571 n2875 n2913 0.074999999999999997
r4572 n2912 n2913 0.3125
r4573 n2876 n2914 0.074999999999999997
r4574 n2913 n2914 0.20833333333333334
r4575 n2877 n2915 0.375
r4576 n2914 n2915 0.125
r4577 n2878 n2916 0.1875
r4578 n2915 n2916 0.0625
r4579 n2879 n2917 0.375
r4580 n2916 n2917 0.0625
r4581 n2880 n2918 0.375
r4582 n2917 n2918 0.041666666666666664
r4583 n2881 n2919 0.375
r4584 n2918 n2919 0.041666666666666664
r4585 n2882 n2920 0.09375
r4586 n2919 n2920 0.10416666666666667
r4587 n2883 n2921 0.074999999999999997
r4588 n2920 n2921 0.1875
r4589 n2884 n2922 0.375
r4590 n2921 n2922 0.125
r4591 n2885 n2923 0.037499999999999999
r4592 n2922 n2923 0.22916666666666666
r4593 n2886 n2924 0.125
r4594 n2923 n2924 0.27083333333333331
r4595 n2887 n2925 0.0625
r4596 n2924 n2925 0.1875
r4597 n2888 n2926 0.1875
r4598 n2925 n2926 0.16666666666666666
r4599 n2889 n2927 0.375
r4600 n2926 n2927 0.0625
r4601 n2890 n2928 0.375
r4602 n2927 n2928 0.041666666666666664
r4603 n2891 n2929 0.0625
r4604 n2928 n2929 0.14583333333333334
r4605 n2892 n2930 0.074999999999999997
r4606 n2929 n2930 0.22916666666666666
r4607 n2893 n2931 0.375
r4608 n2930 n2931 0.125
r4609 n2894 n2932 0.0625
r4610 n2895 n2933 0.1875
r4611 n2932 n2933 0.16666666666666666
r4612 n2896 n2934 0.022058823529411766
r4613 n2933 n2934 0.39583333333333331
r4614 n2897 n2935 0.028846153846153848
r4615 n2934 n2935 0.625
r4616 n2898 n2936 0.1875
r4617 n2935 n2936 0.3125
r4618 n2899 n2937 0.1875
r4619 n2936 n2937 0.083333333333333329
r4620 n2900 n2938 0.09375
r4621 n2937 n2938 0.125
r4622 n2901 n2939 0.052083333333333336
r4623 n2902 n2940 0.0625
r4624 n2939 n2940 0.34375
r4625 n2903 n2941 0.3125
r4626 n2940 n2941 0.1875
r4627 n2904 n2942 0.02403846153846154
r4628 n2941 n2942 0.4375
r4629 n2905 n2943 0.03125
r4630 n2942 n2943 0.71875
r4631 n2906 n2944 0.0625
r4632 n2943 n2944 0.46875
r4633 n2907 n2945 0.0625
r4634 n2944 n2945 0.3125
r4635 n2908 n2946 0.3125
r4636 n2945 n2946 0.1875
r4637 n2909 n2947 0.10416666666666667
r4638 n2946 n2947 0.125
r4639 n2910 n2948 0.3125
r4640 n2947 n2948 0.125
r4641 n2911 n2949 0.034722222222222224
r4642 n2948 n2949 0.3125
r4643 n2912 n2950 0.03125
r4644 n2949 n2950 0.59375
r4645 n2913 n2951 0.0625
r4646 n2950 n2951 0.46875
r4647 n2914 n2952 0.0625
r4648 n2951 n2952 0.3125
r4649 n2915 n2953 0.3125
r4650 n2952 n2953 0.1875
r4651 n2916 n2954 0.15625
r4652 n2953 n2954 0.09375
r4653 n2917 n2955 0.3125
r4654 n2954 n2955 0.09375
r4655 n2918 n2956 0.3125
r4656 n2955 n2956 0.0625
r4657 n2919 n2957 0.3125
r4658 n2956 n2957 0.0625
r4659 n2920 n2958 0.078125
r4660 n2957 n2958 0.15625
r4661 n2921 n2959 0.0625
r4662 n2958 n2959 0.28125
r4663 n2922 n2960 0.3125
r4664 n2959 n2960 0.1875
r4665 n2923 n2961 0.03125
r4666 n2960 n2961 0.34375
r4667 n2924 n2962 0.10416666666666667
r4668 n2961 n2962 0.40625
r4669 n2925 n2963 0.052083333333333336
r4670 n2962 n2963 0.28125
r4671 n2926 n2964 0.15625
r4672 n2963 n2964 0.25
r4673 n2927 n2965 0.3125
r4674 n2964 n2965 0.09375
r4675 n2928 n2966 0.3125
r4676 n2965 n2966 0.0625
r4677 n2929 n2967 0.052083333333333336
r4678 n2966 n2967 0.21875
r4679 n2930 n2968 0.0625
r4680 n2967 n2968 0.34375
r4681 n2931 n2969 0.3125
r4682 n2968 n2969 0.1875
r4683 n2939 n2970 0.17708333333333334
r4684 n2940 n2971 0.21249999999999999
r4685 n2970 n2971 0.04583333333333333
r4686 n2941 n2972 1.0625
r4687 n2971 n2972 0.025000000000000001
r4688 n2942 n2973 0.081730769230769232
r4689 n2972 n2973 0.058333333333333334
r4690 n2943 n2974 0.10625
r4691 n2973 n2974 0.09583333333333334
r4692 n2944 n2975 0.21249999999999999
r4693 n2974 n2975 0.0625
r4694 n2945 n2976 0.21249999999999999
r4695 n2975 n2976 0.041666666666666664
r4696 n2946 n2977 1.0625
r4697 n2976 n2977 0.025000000000000001
r4698 n2947 n2978 0.35416666666666669
r4699 n2977 n2978 0.016666666666666666
r4700 n2948 n2979 1.0625
r4701 n2978 n2979 0.016666666666666666
r4702 n2949 n2980 0.11805555555555555
r4703 n2979 n2980 0.041666666666666664
r4704 n2950 n2981 0.10625
r4705 n2980 n2981 0.079166666666666663
r4706 n2951 n2982 0.21249999999999999
r4707 n2981 n2982 0.0625
r4708 n2952 n2983 0.21249999999999999
r4709 n2982 n2983 0.041666666666666664
r4710 n2953 n2984 1.0625
r4711 n2983 n2984 0.025000000000000001
r4712 n2954 n2985 0.53125
r4713 n2984 n2985 0.012500000000000001
r4714 n2955 n2986 1.0625
r4715 n2985 n2986 0.012500000000000001
r4716 n2956 n2987 1.0625
r4717 n2986 n2987 0.0083333333333333332
r4718 n2957 n2988 1.0625
r4719 n2987 n2988 0.0083333333333333332
r4720 n2958 n2989 0.265625
r4721 n2988 n2989 0.020833333333333332
r4722 n2959 n2990 0.21249999999999999
r4723 n2989 n2990 0.037499999999999999
r4724 n2960 n2991 1.0625
r4725 n2990 n2991 0.025000000000000001
r4726 n2961 n2992 0.10625
r4727 n2991 n2992 0.04583333333333333
r4728 n2962 n2993 0.35416666666666669
r4729 n2992 n2993 0.054166666666666669
r4730 n2963 n2994 0.17708333333333334
r4731 n2993 n2994 0.037499999999999999
r4732 n2964 n2995 0.53125
r4733 n2994 n2995 0.033333333333333333
r4734 n2965 n2996 1.0625
r4735 n2995 n2996 0.012500000000000001
r4736 n2966 n2997 1.0625
r4737 n2996 n2997 0.0083333333333333332
r4738 n2967 n2998 0.17708333333333334
r4739 n2997 n2998 0.029166666666666667
r4740 n2968 n2999 0.21249999999999999
r4741 n2998 n2999 0.04583333333333333
r4742 n2969 n3000 1.0625
r4743 n2999 n3000 0.025000000000000001
r4744 n2970 n3001 0.3125
r4745 n2971 n3002 0.375
r4746 n3001 n3002 0.04583333333333333
r4747 n2972 n3003 1.875
r4748 n3002 n3003 0.025000000000000001
r4749 n2973 n3004 0.14423076923076922
r4750 n3003 n3004 0.058333333333333334
r4751 n2974 n3005 0.1875
r4752 n3004 n3005 0.09583333333333334
r4753 n2975 n3006 0.375
r4754 n3005 n3006 0.0625
r4755 n2976 n3007 0.375
r4756 n3006 n3007 0.041666666666666664
r4757 n2977 n3008 1.875
r4758 n3007 n3008 0.025000000000000001
r4759 n2978 n3009 0.625
r4760 n3008 n3009 0.016666666666666666
r4761 n2979 n3010 1.875
r4762 n3009 n3010 0.016666666666666666
r4763 n2980 n3011 0.20833333333333334
r4764 n3010 n3011 0.041666666666666664
r4765 n2981 n3012 0.1875
r4766 n3011 n3012 0.079166666666666663
r4767 n2982 n3013 0.375
r4768 n3012 n3013 0.0625
r4769 n2983 n3014 0.375
r4770 n3013 n3014 0.041666666666666664
r4771 n2984 n3015 1.875
r4772 n3014 n3015 0.025000000000000001
r4773 n2985 n3016 0.9375
r4774 n3015 n3016 0.012500000000000001
r4775 n2986 n3017 1.875
r4776 n3016 n3017 0.012500000000000001
r4777 n2987 n3018 1.875
r4778 n3017 n3018 0.0083333333333333332
r4779 n2988 n3019 1.875
r4780 n3018 n3019 0.0083333333333333332
r4781 n2989 n3020 0.46875
r4782 n3019 n3020 0.020833333333333332
r4783 n2990 n3021 0.375
r4784 n3020 n3021 0.037499999999999999
r4785 n2991 n3022 1.875
r4786 n3021 n3022 0.025000000000000001
r4787 n2992 n3023 0.1875
r4788 n3022 n3023 0.04583333333333333
r4789 n2993 n3024 0.625
r4790 n3023 n3024 0.054166666666666669
r4791 n2994 n3025 0.3125
r4792 n3024 n3025 0.037499999999999999
r4793 n2995 n3026 0.9375
r4794 n3025 n3026 0.033333333333333333
r4795 n2996 n3027 1.875
r4796 n3026 n3027 0.012500000000000001
r4797 n2997 n3028 1.875
r4798 n3027 n3028 0.0083333333333333332
r4799 n2998 n3029 0.3125
r4800 n3028 n3029 0.029166666666666667
r4801 n2999 n3030 0.375
r4802 n3029 n3030 0.04583333333333333
r4803 n3000 n3031 1.875
r4804 n3030 n3031 0.025000000000000001
r4805 n3001 n3032 0.17708333333333334
r4806 n3002 n3033 0.21249999999999999
r4807 n3032 n3033 0.34375
r4808 n3003 n3034 1.0625
r4809 n3033 n3034 0.1875
r4810 n3004 n3035 0.081730769230769232
r4811 n3034 n3035 0.4375
r4812 n3005 n3036 0.10625
r4813 n3035 n3036 0.71875
r4814 n3006 n3037 0.21249999999999999
r4815 n3036 n3037 0.46875
r4816 n3007 n3038 0.21249999999999999
r4817 n3037 n3038 0.3125
r4818 n3008 n3039 1.0625
r4819 n3038 n3039 0.1875
r4820 n3009 n3040 0.35416666666666669
r4821 n3039 n3040 0.125
r4822 n3010 n3041 1.0625
r4823 n3040 n3041 0.125
r4824 n3011 n3042 0.11805555555555555
r4825 n3041 n3042 0.3125
r4826 n3012 n3043 0.10625
r4827 n3042 n3043 0.59375
r4828 n3013 n3044 0.21249999999999999
r4829 n3043 n3044 0.46875
r4830 n3014 n3045 0.21249999999999999
r4831 n3044 n3045 0.3125
r4832 n3015 n3046 1.0625
r4833 n3045 n3046 0.1875
r4834 n3016 n3047 0.53125
r4835 n3046 n3047 0.09375
r4836 n3017 n3048 1.0625
r4837 n3047 n3048 0.09375
r4838 n3018 n3049 1.0625
r4839 n3048 n3049 0.0625
r4840 n3019 n3050 1.0625
r4841 n3049 n3050 0.0625
r4842 n3020 n3051 0.265625
r4843 n3050 n3051 0.15625
r4844 n3021 n3052 0.21249999999999999
r4845 n3051 n3052 0.28125
r4846 n3022 n3053 1.0625
r4847 n3052 n3053 0.1875
r4848 n3023 n3054 0.10625
r4849 n3053 n3054 0.34375
r4850 n3024 n3055 0.35416666666666669
r4851 n3054 n3055 0.40625
r4852 n3025 n3056 0.17708333333333334
r4853 n3055 n3056 0.28125
r4854 n3026 n3057 0.53125
r4855 n3056 n3057 0.25
r4856 n3027 n3058 1.0625
r4857 n3057 n3058 0.09375
r4858 n3028 n3059 1.0625
r4859 n3058 n3059 0.0625
r4860 n3029 n3060 0.17708333333333334
r4861 n3059 n3060 0.21875
r4862 n3030 n3061 0.21249999999999999
r4863 n3060 n3061 0.34375
r4864 n3031 n3062 1.0625
r4865 n3061 n3062 0.1875
r4866 n3032 n3063 0.052083333333333336
r4867 n3033 n3064 0.0625
r4868 n3063 n3064 0.22916666666666666
r4869 n3034 n3065 0.3125
r4870 n3064 n3065 0.125
r4871 n3035 n3066 0.02403846153846154
r4872 n3065 n3066 0.29166666666666669
r4873 n3036 n3067 0.03125
r4874 n3066 n3067 0.47916666666666669
r4875 n3037 n3068 0.0625
r4876 n3067 n3068 0.3125
r4877 n3038 n3069 0.0625
r4878 n3068 n3069 0.20833333333333334
r4879 n3039 n3070 0.3125
r4880 n3069 n3070 0.125
r4881 n3040 n3071 0.10416666666666667
r4882 n3070 n3071 0.083333333333333329
r4883 n3041 n3072 0.3125
r4884 n3071 n3072 0.083333333333333329
r4885 n3042 n3073 0.034722222222222224
r4886 n3072 n3073 0.20833333333333334
r4887 n3043 n3074 0.03125
r4888 n3073 n3074 0.39583333333333331
r4889 n3044 n3075 0.0625
r4890 n3074 n3075 0.3125
r4891 n3045 n3076 0.0625
r4892 n3075 n3076 0.20833333333333334
r4893 n3046 n3077 0.3125
r4894 n3076 n3077 0.125
r4895 n3047 n3078 0.15625
r4896 n3077 n3078 0.0625
r4897 n3048 n3079 0.3125
r4898 n3078 n3079 0.0625
r4899 n3049 n3080 0.3125
r4900 n3079 n3080 0.041666666666666664
r4901 n3050 n3081 0.3125
r4902 n3080 n3081 0.041666666666666664
r4903 n3051 n3082 0.078125
r4904 n3081 n3082 0.10416666666666667
r4905 n3052 n3083 0.0625
r4906 n3082 n3083 0.1875
r4907 n3053 n3084 0.3125
r4908 n3083 n3084 0.125
r4909 n3054 n3085 0.03125
r4910 n3084 n3085 0.22916666666666666
r4911 n3055 n3086 0.10416666666666667
r4912 n3085 n3086 0.27083333333333331
r4913 n3056 n3087 0.052083333333333336
r4914 n3086 n3087 0.1875
r4915 n3057 n3088 0.15625
r4916 n3087 n3088 0.16666666666666666
r4917 n3058 n3089 0.3125
r4918 n3088 n3089 0.0625
r4919 n3059 n3090 0.3125
r4920 n3089 n3090 0.041666666666666664
r4921 n3060 n3091 0.052083333333333336
r4922 n3090 n3091 0.14583333333333334
r4923 n3061 n3092 0.0625
r4924 n3091 n3092 0.22916666666666666
r4925 n3062 n3093 0.3125
r4926 n3092 n3093 0.125
r4927 n3063 n3094 0.0625
r4928 n3064 n3095 0.074999999999999997
r4929 n3094 n3095 0.22916666666666666
r4930 n3065 n3096 0.375
r4931 n3095 n3096 0.125
r4932 n3066 n3097 0.028846153846153848
r4933 n3096 n3097 0.29166666666666669
r4934 n3067 n3098 0.037499999999999999
r4935 n3097 n3098 0.47916666666666669
r4936 n3068 n3099 0.074999999999999997
r4937 n3098 n3099 0.3125
r4938 n3069 n3100 0.074999999999999997
r4939 n3099 n3100 0.20833333333333334
r4940 n3070 n3101 0.375
r4941 n3100 n3101 0.125
r4942 n3071 n3102 0.125
r4943 n3101 n3102 0.083333333333333329
r4944 n3072 n3103 0.375
r4945 n3102 n3103 0.083333333333333329
r4946 n3073 n3104 0.041666666666666664
r4947 n3103 n3104 0.20833333333333334
r4948 n3074 n3105 0.037499999999999999
r4949 n3104 n3105 0.39583333333333331
r4950 n3075 n3106 0.074999999999999997
r4951 n3105 n3106 0.3125
r4952 n3076 n3107 0.074999999999999997
r4953 n3106 n3107 0.20833333333333334
r4954 n3077 n3108 0.375
r4955 n3107 n3108 0.125
r4956 n3078 n3109 0.1875
r4957 n3108 n3109 0.0625
r4958 n3079 n3110 0.375
r4959 n3109 n3110 0.0625
r4960 n3080 n3111 0.375
r4961 n3110 n3111 0.041666666666666664
r4962 n3081 n3112 0.375
r4963 n3111 n3112 0.041666666666666664
r4964 n3082 n3113 0.09375
r4965 n3112 n3113 0.10416666666666667
r4966 n3083 n3114 0.074999999999999997
r4967 n3113 n3114 0.1875
r4968 n3084 n3115 0.375
r4969 n3114 n3115 0.125
r4970 n3085 n3116 0.037499999999999999
r4971 n3115 n3116 0.22916666666666666
r4972 n3086 n3117 0.125
r4973 n3116 n3117 0.27083333333333331
r4974 n3087 n3118 0.0625
r4975 n3117 n3118 0.1875
r4976 n3088 n3119 0.1875
r4977 n3118 n3119 0.16666666666666666
r4978 n3089 n3120 0.375
r4979 n3119 n3120 0.0625
r4980 n3090 n3121 0.375
r4981 n3120 n3121 0.041666666666666664
r4982 n3091 n3122 0.0625
r4983 n3121 n3122 0.14583333333333334
r4984 n3092 n3123 0.074999999999999997
r4985 n3122 n3123 0.22916666666666666
r4986 n3093 n3124 0.375
r4987 n3123 n3124 0.125
r4988 n3098 n3125 0.0625
r4989 n3099 n3126 0.125
r4990 n3125 n3126 0.13392857142857142
r4991 n3100 n3127 0.125
r4992 n3126 n3127 0.089285714285714288
r4993 n3101 n3128 0.625
r4994 n3127 n3128 0.053571428571428568
r4995 n3102 n3129 0.20833333333333334
r4996 n3128 n3129 0.035714285714285712
r4997 n3103 n3130 0.625
r4998 n3129 n3130 0.035714285714285712
r4999 n3104 n3131 0.069444444444444448
r5000 n3130 n3131 0.089285714285714288
r5001 n3105 n3132 0.0625
r5002 n3131 n3132 0.16964285714285715
r5003 n3106 n3133 0.125
r5004 n3132 n3133 0.13392857142857142
r5005 n3107 n3134 0.125
r5006 n3133 n3134 0.089285714285714288
r5007 n3108 n3135 0.625
r5008 n3134 n3135 0.053571428571428568
r5009 n3109 n3136 0.3125
r5010 n3135 n3136 0.026785714285714284
r5011 n3110 n3137 0.625
r5012 n3136 n3137 0.026785714285714284
r5013 n3111 n3138 0.625
r5014 n3137 n3138 0.017857142857142856
r5015 n3112 n3139 0.625
r5016 n3138 n3139 0.017857142857142856
r5017 n3113 n3140 0.15625
r5018 n3139 n3140 0.044642857142857144
r5019 n3114 n3141 0.125
r5020 n3140 n3141 0.080357142857142863
r5021 n3115 n3142 0.625
r5022 n3141 n3142 0.053571428571428568
r5023 n3116 n3143 0.0625
r5024 n3142 n3143 0.098214285714285712
r5025 n3144 n3145 0.78125
r5026 n3145 n3146 1
r5027 n3146 n3147 1
r5028 n3147 n3148 0.78125
r5029 n3144 n3149 0.035326086956521736
r5030 n3145 n3150 0.40625
r5031 n3149 n3150 0.14204545454545456
r5032 n3146 n3151 0.027083333333333334
r5033 n3150 n3151 0.18181818181818182
r5034 n3147 n3152 0.40625
r5035 n3151 n3152 0.18181818181818182
r5036 n3148 n3153 0.035326086956521736
r5037 n3152 n3153 0.14204545454545456
r5038 n3149 n3154 0.035326086956521736
r5039 n3150 n3155 0.40625
r5040 n3154 n3155 0.78125
r5041 n3151 n3156 0.027083333333333334
r5042 n3155 n3156 1
r5043 n3152 n3157 0.40625
r5044 n3156 n3157 1
r5045 n3153 n3158 0.035326086956521736
r5046 n3157 n3158 0.78125
r5047 n3154 n3159 0.086956521739130432
r5048 n3155 n3160 1
r5049 n3159 n3160 0.052083333333333336
r5050 n3156 n3161 0.066666666666666666
r5051 n3160 n3161 0.066666666666666666
r5052 n3157 n3162 1
r5053 n3161 n3162 0.066666666666666666
r5054 n3158 n3163 0.086956521739130432
r5055 n3162 n3163 0.052083333333333336
r5056 n3159 n3164 0.086956521739130432
r5057 n3160 n3165 1
r5058 n3164 n3165 0.78125
r5059 n3161 n3166 0.066666666666666666
r5060 n3165 n3166 1
r5061 n3162 n3167 1
r5062 n3166 n3167 1
r5063 n3163 n3168 0.086956521739130432
r5064 n3167 n3168 0.78125
r5065 n3164 n3169 0.035326086956521736
r5066 n3165 n3170 0.40625
r5067 n3169 n3170 0.14204545454545456
r5068 n3166 n3171 0.027083333333333334
r5069 n3170 n3171 0.18181818181818182
r5070 n3167 n3172 0.40625
r5071 n3171 n3172 0.18181818181818182
r5072 n3168 n3173 0.035326086956521736
r5073 n3172 n3173 0.14204545454545456
r5074 n3169 n3174 0.035326086956521736
r5075 n3170 n3175 0.40625
r5076 n3174 n3175 0.78125
r5077 n3171 n3176 0.027083333333333334
r5078 n3175 n3176 1
r5079 n3172 n3177 0.40625
r5080 n3176 n3177 1
r5081 n3173 n3178 0.035326086956521736
r5082 n3177 n3178 0.78125
r5083 n3179 n3180 0.3125
r5084 n3180 n3181 0.1875
r5085 n3181 n3182 0.09375
r5086 n3182 n3183 0.09375
r5087 n3183 n3184 0.0625
r5088 n3184 n3185 0.0625
r5089 n3185 n3186 0.15625
r5090 n3186 n3187 0.28125
r5091 n3187 n3188 0.1875
r5092 n3188 n3189 0.34375
r5093 n3189 n3190 0.40625
r5094 n3190 n3191 0.28125
r5095 n3191 n3192 0.25
r5096 n3192 n3193 0.09375
r5097 n3193 n3194 0.0625
r5098 n3194 n3195 0.21875
r5099 n3195 n3196 0.34375
r5100 n3196 n3197 0.1875
r5101 n3197 n3198 0.15625
r5102 n3198 n3199 0.28125
r5103 n3199 n3200 0.25
r5104 n3200 n3201 0.3125
r5105 n3202 n3203 0.78125
r5106 n3203 n3204 1.0625
r5107 n3204 n3205 0.9375
r5108 n3205 n3206 1.0625
r5109 n3206 n3207 0.78125
r5110 n3179 n3208 0.0625
r5111 n3180 n3209 0.0625
r5112 n3208 n3209 0.20833333333333334
r5113 n3181 n3210 0.3125
r5114 n3209 n3210 0.125
r5115 n3182 n3211 0.15625
r5116 n3210 n3211 0.0625
r5117 n3183 n3212 0.3125
r5118 n3211 n3212 0.0625
r5119 n3184 n3213 0.3125
r5120 n3212 n3213 0.041666666666666664
r5121 n3185 n3214 0.3125
r5122 n3213 n3214 0.041666666666666664
r5123 n3186 n3215 0.078125
r5124 n3214 n3215 0.10416666666666667
r5125 n3187 n3216 0.0625
r5126 n3215 n3216 0.1875
r5127 n3188 n3217 0.3125
r5128 n3216 n3217 0.125
r5129 n3189 n3218 0.03125
r5130 n3217 n3218 0.22916666666666666
r5131 n3190 n3219 0.10416666666666667
r5132 n3218 n3219 0.27083333333333331
r5133 n3191 n3220 0.052083333333333336
r5134 n3219 n3220 0.1875
r5135 n3192 n3221 0.15625
r5136 n3220 n3221 0.16666666666666666
r5137 n3193 n3222 0.3125
r5138 n3221 n3222 0.0625
r5139 n3194 n3223 0.3125
r5140 n3222 n3223 0.041666666666666664
r5141 n3195 n3224 0.052083333333333336
r5142 n3223 n3224 0.14583333333333334
r5143 n3196 n3225 0.0625
r5144 n3224 n3225 0.22916666666666666
r5145 n3197 n3226 0.3125
r5146 n3225 n3226 0.125
r5147 n3198 n3227 0.078125
r5148 n3226 n3227 0.10416666666666667
r5149 n3199 n3228 0.0625
r5150 n3227 n3228 0.1875
r5151 n3200 n3229 0.10416666666666667
r5152 n3228 n3229 0.16666666666666666
r5153 n3201 n3230 0.044642857142857144
r5154 n3229 n3230 0.20833333333333334
r5155 n3202 n3231 0.044642857142857144
r5156 n3203 n3232 0.017361111111111112
r5157 n3231 n3232 0.52083333333333337
r5158 n3204 n3233 0.01953125
r5159 n3232 n3233 0.70833333333333337
r5160 n3205 n3234 0.022321428571428572
r5161 n3233 n3234 0.625
r5162 n3206 n3235 0.015625
r5163 n3234 n3235 0.70833333333333337
r5164 n3207 n3236 0.0625
r5165 n3235 n3236 0.52083333333333337
r5166 n3208 t_r1_a 0.10000000000000001
r5167 n3209 t_r1_a 0.10000000000000001
r5168 n3210 t_r1_a 0.5
r5169 n3211 t_r1_a 0.25
r5170 n3212 t_r1_a 0.5
r5171 n3213 t_r1_a 0.5
r5172 n3214 t_r1_a 0.5
r5173 n3215 t_r1_a 0.125
r5174 n3216 t_r1_a 0.10000000000000001
r5175 n3217 t_r1_a 0.5
r5176 n3218 t_r1_a 0.050000000000000003
r5177 n3219 t_r1_a 0.16666666666666666
r5178 n3220 t_r1_a 0.083333333333333329
r5179 n3221 t_r1_a 0.25
r5180 n3222 t_r1_a 0.5
r5181 n3223 t_r1_a 0.5
r5182 n3224 t_r1_a 0.083333333333333329
r5183 n3225 t_r1_a 0.10000000000000001
r5184 n3226 t_r1_a 0.5
r5185 n3227 t_r1_a 0.125
r5186 n3228 t_r1_a 0.10000000000000001
r5187 n3229 t_r1_a 0.16666666666666666
r5188 n3230 t_r1_a 0.071428571428571425
r5189 n3231 t_r1_b 0.071428571428571425
r5190 n3232 t_r1_b 0.027777777777777776
r5191 n3233 t_r1_b 0.03125
r5192 n3234 t_r1_b 0.035714285714285712
r5193 n3235 t_r1_b 0.025000000000000001
r5194 n3236 t_r1_b 0.10000000000000001
r5195 t_r1_a n3804 0.10000000000000001
r5196 t_r1_a n3805 0.10000000000000001
r5197 n3804 n3805 0.20833333333333334
r5198 t_r1_a n3806 0.5
r5199 n3805 n3806 0.125
r5200 t_r1_a n3807 0.25
r5201 n3806 n3807 0.0625
r5202 t_r1_a n3808 0.5
r5203 n3807 n3808 0.0625
r5204 t_r1_a n3809 0.5
r5205 n3808 n3809 0.041666666666666664
r5206 t_r1_a n3810 0.5
r5207 n3809 n3810 0.041666666666666664
r5208 t_r1_a n3811 0.125
r5209 n3810 n3811 0.10416666666666667
r5210 t_r1_a n3812 0.10000000000000001
r5211 n3811 n3812 0.1875
r5212 t_r1_a n3813 0.5
r5213 n3812 n3813 0.125
r5214 t_r1_a n3814 0.050000000000000003
r5215 n3813 n3814 0.22916666666666666
r5216 t_r1_a n3815 0.16666666666666666
r5217 n3814 n3815 0.27083333333333331
r5218 t_r1_a n3816 0.083333333333333329
r5219 n3815 n3816 0.1875
r5220 t_r1_a n3817 0.25
r5221 n3816 n3817 0.16666666666666666
r5222 t_r1_a n3818 0.5
r5223 n3817 n3818 0.0625
r5224 t_r1_a n3819 0.5
r5225 n3818 n3819 0.041666666666666664
r5226 t_r1_a n3820 0.083333333333333329
r5227 n3819 n3820 0.14583333333333334
r5228 t_r1_a n3821 0.10000000000000001
r5229 n3820 n3821 0.22916666666666666
r5230 t_r1_a n3822 0.5
r5231 n3821 n3822 0.125
r5232 t_r1_a n3823 0.125
r5233 n3822 n3823 0.10416666666666667
r5234 t_r1_a n3824 0.10000000000000001
r5235 n3823 n3824 0.1875
r5236 t_r1_a n3825 0.16666666666666666
r5237 n3824 n3825 0.16666666666666666
r5238 t_r1_a n3826 0.071428571428571425
r5239 n3825 n3826 0.20833333333333334
r5240 t_r1_b n3827 0.071428571428571425
r5241 t_r1_b n3828 0.027777777777777776
r5242 n3827 n3828 0.52083333333333337
r5243 t_r1_b n3829 0.03125
r5244 n3828 n3829 0.70833333333333337
r5245 t_r1_b n3830 0.035714285714285712
r5246 n3829 n3830 0.625
r5247 t_r1_b n3831 0.025000000000000001
r5248 n3830 n3831 0.70833333333333337
r5249 t_r1_b n3832 0.10000000000000001
r5250 n3831 n3832 0.52083333333333337
r5251 n3804 n3833 0.0625
r5252 n3805 n3834 0.0625
r5253 n3833 n3834 0.3125
r5254 n3806 n3835 0.3125
r5255 n3834 n3835 0.1875
r5256 n3807 n3836 0.15625
r5257 n3835 n3836 0.09375
r5258 n3808 n3837 0.3125
r5259 n3836 n3837 0.09375
r5260 n3809 n3838 0.3125
r5261 n3837 n3838 0.0625
r5262 n3810 n3839 0.3125
r5263 n3838 n3839 0.0625
r5264 n3811 n3840 0.078125
r5265 n3839 n3840 0.15625
r5266 n3812 n3841 0.0625
r5267 n3840 n3841 0.28125
r5268 n3813 n3842 0.3125
r5269 n3841 n3842 0.1875
r5270 n3814 n3843 0.03125
r5271 n3842 n3843 0.34375
r5272 n3815 n3844 0.10416666666666667
r5273 n3843 n3844 0.40625
r5274 n3816 n3845 0.052083333333333336
r5275 n3844 n3845 0.28125
r5276 n3817 n3846 0.15625
r5277 n3845 n3846 0.25
r5278 n3818 n3847 0.3125
r5279 n3846 n3847 0.09375
r5280 n3819 n3848 0.3125
r5281 n3847 n3848 0.0625
r5282 n3820 n3849 0.052083333333333336
r5283 n3848 n3849 0.21875
r5284 n3821 n3850 0.0625
r5285 n3849 n3850 0.34375
r5286 n3822 n3851 0.3125
r5287 n3850 n3851 0.1875
r5288 n3823 n3852 0.078125
r5289 n3851 n3852 0.15625
r5290 n3824 n3853 0.0625
r5291 n3852 n3853 0.28125
r5292 n3825 n3854 0.10416666666666667
r5293 n3853 n3854 0.25
r5294 n3826 n3855 0.044642857142857144
r5295 n3854 n3855 0.3125
r5296 n3827 n3856 0.044642857142857144
r5297 n3828 n3857 0.017361111111111112
r5298 n3856 n3857 0.78125
r5299 n3829 n3858 0.01953125
r5300 n3857 n3858 1.0625
r5301 n3830 n3859 0.022321428571428572
r5302 n3858 n3859 0.9375
r5303 n3831 n3860 0.015625
r5304 n3859 n3860 1.0625
r5305 n3832 n3861 0.0625
r5306 n3860 n3861 0.78125
r5307 n3862 n3863 0.13437499999999999
r5308 n3863 n3864 0.109375
r5309 n3864 n3865 0.10000000000000001
r5310 n3865 n3866 0.10000000000000001
r5311 n3866 n3867 0.109375
r5312 n3867 n3868 0.13437499999999999
r5313 n3887 n3888 0.0625
r5314 n3888 n3889 0.109375
r5315 n3889 n3890 0.081250000000000003
r5316 n3890 n3891 0.090624999999999997
r5317 n3891 n3892 0.090624999999999997
r5318 n3892 n3893 0.081250000000000003
r5319 n3893 n3894 0.109375
r5320 n3894 n3895 0.0625
r5321 n3862 n3896 0.26874999999999999
r5322 n3863 n3897 0.081439393939393936
r5323 n3896 n3897 0.11684782608695653
r5324 n3864 n3898 1.34375
r5325 n3897 n3898 0.095108695652173919
r5326 n3865 n3899 0.089583333333333334
r5327 n3898 n3899 0.086956521739130432
r5328 n3866 n3900 1.34375
r5329 n3899 n3900 0.086956521739130432
r5330 n3867 n3901 0.081439393939393936
r5331 n3900 n3901 0.095108695652173919
r5332 n3868 n3902 0.26874999999999999
r5333 n3901 n3902 0.11684782608695653
r5334 n3887 n3921 0.26874999999999999
r5335 n3888 n3922 0.26874999999999999
r5336 n3921 n3922 0.05434782608695652
r5337 n3889 n3923 0.1075
r5338 n3922 n3923 0.095108695652173919
r5339 n3890 n3924 2.6875
r5340 n3923 n3924 0.070652173913043473
r5341 n3891 n3925 0.095982142857142863
r5342 n3924 n3925 0.07880434782608696
r5343 n3892 n3926 2.6875
r5344 n3925 n3926 0.07880434782608696
r5345 n3893 n3927 0.1075
r5346 n3926 n3927 0.070652173913043473
r5347 n3894 n3928 0.26874999999999999
r5348 n3927 n3928 0.095108695652173919
r5349 n3895 n3929 0.26874999999999999
r5350 n3928 n3929 0.05434782608695652
r5351 n3896 n3930 0.15625
r5352 n3897 n3931 0.047348484848484848
r5353 n3930 n3931 1.34375
r5354 n3898 n3932 0.78125
r5355 n3931 n3932 1.09375
r5356 n3899 n3933 0.052083333333333336
r5357 n3932 n3933 1
r5358 n3900 n3934 0.78125
r5359 n3933 n3934 1
r5360 n3901 n3935 0.047348484848484848
r5361 n3934 n3935 1.09375
r5362 n3902 n3936 0.15625
r5363 n3935 n3936 1.34375
r5364 n3921 n3955 0.15625
r5365 n3922 n3956 0.15625
r5366 n3955 n3956 0.625
r5367 n3923 n3957 0.0625
r5368 n3956 n3957 1.09375
r5369 n3924 n3958 1.5625
r5370 n3957 n3958 0.8125
r5371 n3925 n3959 0.055803571428571432
r5372 n3958 n3959 0.90625
r5373 n3926 n3960 1.5625
r5374 n3959 n3960 0.90625
r5375 n3927 n3961 0.0625
r5376 n3960 n3961 0.8125
r5377 n3928 n3962 0.15625
r5378 n3961 n3962 1.09375
r5379 n3929 n3963 0.15625
r5380 n3962 n3963 0.625
r5381 n3930 n3964 0.20000000000000001
r5382 n3931 n3965 0.060606060606060608
r5383 n3964 n3965 0.089583333333333334
r5384 n3932 n3966 1
r5385 n3965 n3966 0.072916666666666671
r5386 n3933 n3967 0.066666666666666666
r5387 n3966 n3967 0.066666666666666666
r5388 n3934 n3968 1
r5389 n3967 n3968 0.066666666666666666
r5390 n3935 n3969 0.060606060606060608
r5391 n3968 n3969 0.072916666666666671
r5392 n3936 n3970 0.20000000000000001
r5393 n3969 n3970 0.089583333333333334
r5394 n3955 n3989 0.20000000000000001
r5395 n3956 n3990 0.20000000000000001
r5396 n3989 n3990 0.041666666666666664
r5397 n3957 n3991 0.080000000000000002
r5398 n3990 n3991 0.072916666666666671
r5399 n3958 n3992 2
r5400 n3991 n3992 0.054166666666666669
r5401 n3959 n3993 0.071428571428571425
r5402 n3992 n3993 0.060416666666666667
r5403 n3960 n3994 2
r5404 n3993 n3994 0.060416666666666667
r5405 n3961 n3995 0.080000000000000002
r5406 n3994 n3995 0.054166666666666669
r5407 n3962 n3996 0.20000000000000001
r5408 n3995 n3996 0.072916666666666671
r5409 n3963 n3997 0.20000000000000001
r5410 n3996 n3997 0.041666666666666664
r5411 n3964 n3998 0.20000000000000001
r5412 n3965 n3999 0.060606060606060608
r5413 n3998 n3999 1.34375
r5414 n3966 n4000 1
r5415 n3999 n4000 1.09375
r5416 n3967 n4001 0.066666666666666666
r5417 n4000 n4001 1
r5418 n3968 n4002 1
r5419 n4001 n4002 1
r5420 n3969 n4003 0.060606060606060608
r5421 n4002 n4003 1.09375
r5422 n3970 n4004 0.20000000000000001
r5423 n4003 n4004 1.34375
r5424 n3989 n4023 0.20000000000000001
r5425 n3990 n4024 0.20000000000000001
r5426 n4023 n4024 0.625
r5427 n3991 n4025 0.080000000000000002
r5428 n4024 n4025 1.09375
r5429 n3992 n4026 2
r5430 n4025 n4026 0.8125
r5431 n3993 n4027 0.071428571428571425
r5432 n4026 n4027 0.90625
r5433 n3994 n4028 2
r5434 n4027 n4028 0.90625
r5435 n3995 n4029 0.080000000000000002
r5436 n4028 n4029 0.8125
r5437 n3996 n4030 0.20000000000000001
r5438 n4029 n4030 1.09375
r5439 n3997 n4031 0.20000000000000001
r5440 n4030 n4031 0.625
r5441 n3998 n4032 0.15625
r5442 n3999 n4033 0.047348484848484848
r5443 n4032 n4033 0.11684782608695653
r5444 n4000 n4034 0.78125
r5445 n4033 n4034 0.095108695652173919
r5446 n4001 n4035 0.052083333333333336
r5447 n4034 n4035 0.086956521739130432
r5448 n4002 n4036 0.78125
r5449 n4035 n4036 0.086956521739130432
r5450 n4003 n4037 0.047348484848484848
r5451 n4036 n4037 0.095108695652173919
r5452 n4004 n4038 0.15625
r5453 n4037 n4038 0.11684782608695653
r5454 n4023 n4057 0.15625
r5455 n4024 n4058 0.15625
r5456 n4057 n4058 0.05434782608695652
r5457 n4025 n4059 0.0625
r5458 n4058 n4059 0.095108695652173919
r5459 n4026 n4060 1.5625
r5460 n4059 n4060 0.070652173913043473
r5461 n4027 n4061 0.055803571428571432
r5462 n4060 n4061 0.07880434782608696
r5463 n4028 n4062 1.5625
r5464 n4061 n4062 0.07880434782608696
r5465 n4029 n4063 0.0625
r5466 n4062 n4063 0.070652173913043473
r5467 n4030 n4064 0.15625
r5468 n4063 n4064 0.095108695652173919
r5469 n4031 n4065 0.15625
r5470 n4064 n4065 0.05434782608695652
r5471 n4032 n4066 0.26874999999999999
r5472 n4033 n4067 0.081439393939393936
r5473 n4066 n4067 0.13437499999999999
r5474 n4034 n4068 1.34375
r5475 n4067 n4068 0.109375
r5476 n4035 n4069 0.089583333333333334
r5477 n4068 n4069 0.10000000000000001
r5478 n4036 n4070 1.34375
r5479 n4069 n4070 0.10000000000000001
r5480 n4037 n4071 0.081439393939393936
r5481 n4070 n4071 0.109375
r5482 n4038 n4072 0.26874999999999999
r5483 n4071 n4072 0.13437499999999999
r5484 n4057 n4091 0.26874999999999999
r5485 n4058 n4092 0.26874999999999999
r5486 n4091 n4092 0.0625
r5487 n4059 n4093 0.1075
r5488 n4092 n4093 0.109375
r5489 n4060 n4094 2.6875
r5490 n4093 n4094 0.081250000000000003
r5491 n4061 n4095 0.095982142857142863
r5492 n4094 n4095 0.090624999999999997
r5493 n4062 n4096 2.6875
r5494 n4095 n4096 0.090624999999999997
r5495 n4063 n4097 0.1075
r5496 n4096 n4097 0.081250000000000003
r5497 n4064 n4098 0.26874999999999999
r5498 n4097 n4098 0.109375
r5499 n4065 n4099 0.26874999999999999
r5500 n4098 n4099 0.0625
r5501 n4067 n4100 0.12878787878787878
r5502 n4068 n4101 2.125
r5503 n4100 n4101 0.045572916666666664
r5504 n4069 n4102 0.14166666666666666
r5505 n4101 n4102 0.041666666666666664
r5506 n4070 n4103 2.125
r5507 n4102 n4103 0.041666666666666664
r5508 n4071 n4104 0.12878787878787878
r5509 n4103 n4104 0.045572916666666664
r5510 in n4105 0.84999999999999998
r5511 in n4106 0.70833333333333337
r5512 n4105 n4106 0.014322916666666666
r5513 in n4107 2.125
r5514 n4106 n4107 0.010416666666666666
r5515 in n4108 0.25
r5516 n4107 n4108 0.024739583333333332
r5517 in n4109 0.32692307692307693
r5518 n4108 n4109 0.0390625
r5519 in n4110 2.125
r5520 n4109 n4110 0.01953125
r5521 in n4111 2.125
r5522 n4110 n4111 0.005208333333333333
r5523 in n4112 1.0625
r5524 n4111 n4112 0.0078125
r5525 in n4113 0.84999999999999998
r5526 n4112 n4113 0.01171875
r5527 n4092 n4114 0.42499999999999999
r5528 n4093 n4115 0.17000000000000001
r5529 n4114 n4115 0.045572916666666664
r5530 n4094 n4116 4.25
r5531 n4115 n4116 0.033854166666666664
r5532 n4095 n4117 0.15178571428571427
r5533 n4116 n4117 0.037760416666666664
r5534 n4096 n4118 4.25
r5535 n4117 n4118 0.037760416666666664
r5536 n4097 n4119 0.17000000000000001
r5537 n4118 n4119 0.033854166666666664
r5538 n4098 n4120 0.42499999999999999
r5539 n4119 n4120 0.045572916666666664
r5540 n4100 n4121 0.18181818181818182
r5541 n4101 n4122 3
r5542 n4121 n4122 0.045572916666666664
r5543 n4102 n4123 0.20000000000000001
r5544 n4122 n4123 0.041666666666666664
r5545 n4103 n4124 3
r5546 n4123 n4124 0.041666666666666664
r5547 n4104 n4125 0.18181818181818182
r5548 n4124 n4125 0.045572916666666664
r5549 n4105 n4126 1.2
r5550 n4106 n4127 1
r5551 n4126 n4127 0.014322916666666666
r5552 n4107 n4128 3
r5553 n4127 n4128 0.010416666666666666
r5554 n4108 n4129 0.35294117647058826
r5555 n4128 n4129 0.024739583333333332
r5556 n4109 n4130 0.46153846153846156
r5557 n4129 n4130 0.0390625
r5558 n4110 n4131 3
r5559 n4130 n4131 0.01953125
r5560 n4111 n4132 3
r5561 n4131 n4132 0.005208333333333333
r5562 n4112 n4133 1.5
r5563 n4132 n4133 0.0078125
r5564 n4113 n4134 1.2
r5565 n4133 n4134 0.01171875
r5566 n4114 n4135 0.59999999999999998
r5567 n4115 n4136 0.23999999999999999
r5568 n4135 n4136 0.045572916666666664
r5569 n4116 n4137 6
r5570 n4136 n4137 0.033854166666666664
r5571 n4117 n4138 0.21428571428571427
r5572 n4137 n4138 0.037760416666666664
r5573 n4118 n4139 6
r5574 n4138 n4139 0.037760416666666664
r5575 n4119 n4140 0.23999999999999999
r5576 n4139 n4140 0.033854166666666664
r5577 n4120 n4141 0.59999999999999998
r5578 n4140 n4141 0.045572916666666664
r5579 n4121 n4142 0.18181818181818182
r5580 n4122 n4143 3
r5581 n4142 n4143 0.045572916666666664
r5582 n4123 n4144 0.20000000000000001
r5583 n4143 n4144 0.041666666666666664
r5584 n4124 n4145 3
r5585 n4144 n4145 0.041666666666666664
r5586 n4125 n4146 0.18181818181818182
r5587 n4145 n4146 0.045572916666666664
r5588 n4126 n4147 1.2
r5589 n4127 n4148 1
r5590 n4147 n4148 0.014322916666666666
r5591 n4128 n4149 3
r5592 n4148 n4149 0.010416666666666666
r5593 n4129 n4150 0.35294117647058826
r5594 n4149 n4150 0.024739583333333332
r5595 n4130 n4151 0.46153846153846156
r5596 n4150 n4151 0.0390625
r5597 n4131 n4152 3
r5598 n4151 n4152 0.01953125
r5599 n4132 n4153 3
r5600 n4152 n4153 0.005208333333333333
r5601 n4133 n4154 1.5
r5602 n4153 n4154 0.0078125
r5603 n4134 n4155 1.2
r5604 n4154 n4155 0.01171875
r5605 n4135 n4156 0.59999999999999998
r5606 n4136 n4157 0.23999999999999999
r5607 n4156 n4157 0.045572916666666664
r5608 n4137 n4158 6
r5609 n4157 n4158 0.033854166666666664
r5610 n4138 n4159 0.21428571428571427
r5611 n4158 n4159 0.037760416666666664
r5612 n4139 n4160 6
r5613 n4159 n4160 0.037760416666666664
r5614 n4140 n4161 0.23999999999999999
r5615 n4160 n4161 0.033854166666666664
r5616 n4141 n4162 0.59999999999999998
r5617 n4161 n4162 0.045572916666666664
r5618 n4142 n4163 0.094696969696969696
r5619 n4143 n4164 1.5625
r5620 n4163 n4164 1.09375
r5621 n4144 n4165 0.10416666666666667
r5622 n4164 n4165 1
r5623 n4145 n4166 1.5625
r5624 n4165 n4166 1
r5625 n4146 n4167 0.094696969696969696
r5626 n4166 n4167 1.09375
r5627 n4168 n4169 0.46875
r5628 n4169 n4170 0.3125
r5629 n4170 n4171 0.1875
r5630 n4171 n4172 0.09375
r5631 n4172 n4173 0.09375
r5632 n4173 n4174 0.0625
r5633 n4174 n4175 0.0625
r5634 n4175 n4176 0.15625
r5635 n4176 n4177 0.28125
r5636 n4177 n4178 0.1875
r5637 n4178 n4179 0.34375
r5638 n4179 n4180 0.40625
r5639 n4180 n4181 0.28125
r5640 n4181 n4182 0.25
r5641 n4182 n4183 0.09375
r5642 n4183 n4184 0.0625
r5643 n4184 n4185 0.21875
r5644 n4185 n4186 0.34375
r5645 n4186 n4187 0.1875
r5646 n4187 n4188 0.15625
r5647 n4188 n4189 0.28125
r5648 n4147 n4190 0.625
r5649 n4148 n4191 0.52083333333333337
r5650 n4190 n4191 0.34375
r5651 n4149 n4192 1.5625
r5652 n4191 n4192 0.25
r5653 n4150 n4193 0.18382352941176472
r5654 n4192 n4193 0.59375
r5655 n4151 n4194 0.24038461538461539
r5656 n4193 n4194 0.9375
r5657 n4152 n4195 1.5625
r5658 n4194 n4195 0.46875
r5659 n4153 n4196 1.5625
r5660 n4195 n4196 0.125
r5661 n4154 n4197 0.78125
r5662 n4196 n4197 0.1875
r5663 n4155 n4198 0.625
r5664 n4197 n4198 0.28125
r5665 n4156 n4199 0.3125
r5666 n4157 n4200 0.125
r5667 n4199 n4200 1.09375
r5668 n4158 n4201 3.125
r5669 n4200 n4201 0.8125
r5670 n4159 n4202 0.11160714285714286
r5671 n4201 n4202 0.90625
r5672 n4160 n4203 3.125
r5673 n4202 n4203 0.90625
r5674 n4161 n4204 0.125
r5675 n4203 n4204 0.8125
r5676 n4162 n4205 0.3125
r5677 n4204 n4205 1.09375
r5678 n4163 n4206 0.02462121212121212
r5679 n4164 n4207 0.40625
r5680 n4206 n4207 0.19886363636363635
r5681 n4165 n4208 0.027083333333333334
r5682 n4207 n4208 0.18181818181818182
r5683 n4166 n4209 0.40625
r5684 n4208 n4209 0.18181818181818182
r5685 n4167 n4210 0.02462121212121212
r5686 n4209 n4210 0.19886363636363635
r5687 n4210 n4211 0.24431818181818182
r5688 n4211 n4212 0.085227272727272721
r5689 n4212 n4213 0.25227272727272726
r5690 n4213 n4214 0.44659090909090909
r5691 n4214 n4215 0.44659090909090909
r5692 n4215 n4216 0.41704545454545455
r5693 n4216 n4217 0.34886363636363638
r5694 n4217 n4218 0.3125
r5695 n4218 n4219 0.34999999999999998
r5696 n4219 n4220 0.26704545454545453
r5697 n4220 n4221 0.30113636363636365
r5698 n4221 n4222 0.23295454545454544
r5699 n4222 n4223 0.19318181818181818
r5700 n4223 n4224 0.19318181818181818
r5701 n4224 n4225 0.13636363636363635
r5702 n4225 n4226 0.15340909090909091
r5703 n4226 n4227 0.056818181818181816
r5704 n4227 n4228 0.0625
r5705 n4228 n4229 0.034090909090909088
r5706 n4229 n4230 0.079545454545454544
r5707 n4230 n4231 0.13068181818181818
r5708 n4231 n4232 0.085227272727272721
r5709 n4232 n4233 0.056818181818181816
r5710 n4233 n4234 0.034090909090909088
r5711 n4234 n4235 0.022727272727272728
r5712 n4235 n4236 0.022727272727272728
r5713 n4236 n4237 0.056818181818181816
r5714 n4168 n4238 0.081250000000000003
r5715 n4237 n4238 0.10795454545454546
r5716 n4169 n4239 0.16250000000000001
r5717 n4238 n4239 0.085227272727272721
r5718 n4170 n4240 0.16250000000000001
r5719 n4239 n4240 0.056818181818181816
r5720 n4171 n4241 0.8125
r5721 n4240 n4241 0.034090909090909088
r5722 n4172 n4242 0.40625
r5723 n4241 n4242 0.017045454545454544
r5724 n4173 n4243 0.8125
r5725 n4242 n4243 0.017045454545454544
r5726 n4174 n4244 0.8125
r5727 n4243 n4244 0.011363636363636364
r5728 n4175 n4245 0.8125
r5729 n4244 n4245 0.011363636363636364
r5730 n4176 n4246 0.203125
r5731 n4245 n4246 0.028409090909090908
r5732 n4177 n4247 0.16250000000000001
r5733 n4246 n4247 0.05113636363636364
r5734 n4178 n4248 0.8125
r5735 n4247 n4248 0.034090909090909088
r5736 n4179 n4249 0.081250000000000003
r5737 n4248 n4249 0.0625
r5738 n4180 n4250 0.27083333333333331
r5739 n4249 n4250 0.073863636363636367
r5740 n4181 n4251 0.13541666666666666
r5741 n4250 n4251 0.05113636363636364
r5742 n4182 n4252 0.40625
r5743 n4251 n4252 0.045454545454545456
r5744 n4183 n4253 0.8125
r5745 n4252 n4253 0.017045454545454544
r5746 n4184 n4254 0.8125
r5747 n4253 n4254 0.011363636363636364
r5748 n4185 n4255 0.13541666666666666
r5749 n4254 n4255 0.039772727272727272
r5750 n4186 n4256 0.16250000000000001
r5751 n4255 n4256 0.0625
r5752 n4187 n4257 0.8125
r5753 n4256 n4257 0.034090909090909088
r5754 n4188 n4258 0.203125
r5755 n4257 n4258 0.028409090909090908
r5756 n4189 n4259 0.16250000000000001
r5757 n4258 n4259 0.05113636363636364
r5758 n4190 n4260 0.16250000000000001
r5759 n4191 n4261 0.13541666666666666
r5760 n4260 n4261 0.0625
r5761 n4192 n4262 0.40625
r5762 n4261 n4262 0.045454545454545456
r5763 n4193 n4263 0.04779411764705882
r5764 n4262 n4263 0.10795454545454546
r5765 n4194 n4264 0.0625
r5766 n4263 n4264 0.17045454545454544
r5767 n4195 n4265 0.40625
r5768 n4264 n4265 0.085227272727272721
r5769 n4196 n4266 0.40625
r5770 n4265 n4266 0.022727272727272728
r5771 n4197 n4267 0.203125
r5772 n4266 n4267 0.034090909090909088
r5773 n4198 n4268 0.16250000000000001
r5774 n4267 n4268 0.05113636363636364
r5775 n4199 n4269 0.081250000000000003
r5776 n4200 n4270 0.032500000000000001
r5777 n4269 n4270 0.19886363636363635
r5778 n4201 n4271 0.8125
r5779 n4270 n4271 0.14772727272727273
r5780 n4202 n4272 0.029017857142857144
r5781 n4271 n4272 0.16477272727272727
r5782 n4203 n4273 0.8125
r5783 n4272 n4273 0.16477272727272727
r5784 n4204 n4274 0.032500000000000001
r5785 n4273 n4274 0.14772727272727273
r5786 n4205 n4275 0.081250000000000003
r5787 n4274 n4275 0.19886363636363635
r5788 n4206 n4276 0.02462121212121212
r5789 n4207 n4277 0.40625
r5790 n4276 n4277 1.09375
r5791 n4208 n4278 0.027083333333333334
r5792 n4277 n4278 1
r5793 n4209 n4279 0.40625
r5794 n4278 n4279 1
r5795 n4210 n4280 0.02462121212121212
r5796 n4279 n4280 1.09375
r5797 n4211 n4281 0.081250000000000003
r5798 n4280 n4281 1.34375
r5799 n4212 n4282 0.16250000000000001
r5800 n4281 n4282 0.46875
r5801 n4213 n4283 0.020621827411167512
r5802 n4282 n4283 1.3875
r5803 n4214 n4284 0.020727040816326529
r5804 n4283 n4284 2.4562499999999998
r5805 n4215 n4285 0.020621827411167512
r5806 n4284 n4285 2.4562499999999998
r5807 n4216 n4286 0.02389705882352941
r5808 n4285 n4286 2.2937500000000002
r5809 n4217 n4287 0.029653284671532845
r5810 n4286 n4287 1.91875
r5811 n4218 n4288 0.029438405797101448
r5812 n4287 n4288 1.71875
r5813 n4219 n4289 0.02389705882352941
r5814 n4288 n4289 1.925
r5815 n4220 n4290 0.0625
r5816 n4289 n4290 1.46875
r5817 n4221 n4291 0.020312500000000001
r5818 n4290 n4291 1.65625
r5819 n4222 n4292 0.8125
r5820 n4291 n4292 1.28125
r5821 n4223 n4293 0.02462121212121212
r5822 n4292 n4293 1.0625
r5823 n4224 n4294 0.8125
r5824 n4293 n4294 1.0625
r5825 n4225 n4295 0.035326086956521736
r5826 n4294 n4295 0.75
r5827 n4226 n4296 0.203125
r5828 n4295 n4296 0.84375
r5829 n4227 n4297 0.13541666666666666
r5830 n4296 n4297 0.3125
r5831 n4228 n4298 0.16250000000000001
r5832 n4297 n4298 0.34375
r5833 n4229 n4299 0.8125
r5834 n4298 n4299 0.1875
r5835 n4230 n4300 0.0625
r5836 n4299 n4300 0.4375
r5837 n4231 n4301 0.081250000000000003
r5838 n4300 n4301 0.71875
r5839 n4232 n4302 0.16250000000000001
r5840 n4301 n4302 0.46875
r5841 n4233 n4303 0.16250000000000001
r5842 n4302 n4303 0.3125
r5843 n4234 n4304 0.8125
r5844 n4303 n4304 0.1875
r5845 n4235 n4305 0.27083333333333331
r5846 n4304 n4305 0.125
r5847 n4236 n4306 0.8125
r5848 n4305 n4306 0.125
r5849 n4237 n4307 0.090277777777777776
r5850 n4306 n4307 0.3125
r5851 n4238 n4308 0.081250000000000003
r5852 n4307 n4308 0.59375
r5853 n4239 n4309 0.16250000000000001
r5854 n4308 n4309 0.46875
r5855 n4240 n4310 0.16250000000000001
r5856 n4309 n4310 0.3125
r5857 n4241 n4311 0.8125
r5858 n4310 n4311 0.1875
r5859 n4242 n4312 0.40625
r5860 n4311 n4312 0.09375
r5861 n4243 n4313 0.8125
r5862 n4312 n4313 0.09375
r5863 n4244 n4314 0.8125
r5864 n4313 n4314 0.0625
r5865 n4245 n4315 0.8125
r5866 n4314 n4315 0.0625
r5867 n4246 n4316 0.203125
r5868 n4315 n4316 0.15625
r5869 n4247 n4317 0.16250000000000001
r5870 n4316 n4317 0.28125
r5871 n4248 n4318 0.8125
r5872 n4317 n4318 0.1875
r5873 n4249 n4319 0.081250000000000003
r5874 n4318 n4319 0.34375
r5875 n4250 n4320 0.27083333333333331
r5876 n4319 n4320 0.40625
r5877 n4251 n4321 0.13541666666666666
r5878 n4320 n4321 0.28125
r5879 n4252 n4322 0.40625
r5880 n4321 n4322 0.25
r5881 n4253 n4323 0.8125
r5882 n4322 n4323 0.09375
r5883 n4254 n4324 0.8125
r5884 n4323 n4324 0.0625
r5885 n4255 n4325 0.13541666666666666
r5886 n4324 n4325 0.21875
r5887 n4256 n4326 0.16250000000000001
r5888 n4325 n4326 0.34375
r5889 n4257 n4327 0.8125
r5890 n4326 n4327 0.1875
r5891 n4258 n4328 0.203125
r5892 n4327 n4328 0.15625
r5893 n4259 n4329 0.16250000000000001
r5894 n4328 n4329 0.28125
r5895 n4260 n4330 0.16250000000000001
r5896 n4261 n4331 0.13541666666666666
r5897 n4330 n4331 0.34375
r5898 n4262 n4332 0.40625
r5899 n4331 n4332 0.25
r5900 n4263 n4333 0.04779411764705882
r5901 n4332 n4333 0.59375
r5902 n4264 n4334 0.0625
r5903 n4333 n4334 0.9375
r5904 n4265 n4335 0.40625
r5905 n4334 n4335 0.46875
r5906 n4266 n4336 0.40625
r5907 n4335 n4336 0.125
r5908 n4267 n4337 0.203125
r5909 n4336 n4337 0.1875
r5910 n4268 n4338 0.16250000000000001
r5911 n4337 n4338 0.28125
r5912 n4269 n4339 0.081250000000000003
r5913 n4270 n4340 0.032500000000000001
r5914 n4339 n4340 1.09375
r5915 n4271 n4341 0.8125
r5916 n4340 n4341 0.8125
r5917 n4272 n4342 0.029017857142857144
r5918 n4341 n4342 0.90625
r5919 n4273 n4343 0.8125
r5920 n4342 n4343 0.90625
r5921 n4274 n4344 0.032500000000000001
r5922 n4343 n4344 0.8125
r5923 n4275 n4345 0.081250000000000003
r5924 n4344 n4345 1.09375
r5925 n4276 n4346 0.060606060606060608
r5926 n4277 n4347 1
r5927 n4346 n4347 0.072916666666666671
r5928 n4278 n4348 0.066666666666666666
r5929 n4347 n4348 0.066666666666666666
r5930 n4279 n4349 1
r5931 n4348 n4349 0.066666666666666666
r5932 n4280 n4350 0.060606060606060608
r5933 n4349 n4350 0.072916666666666671
r5934 n4281 n4351 0.20000000000000001
r5935 n4350 n4351 0.089583333333333334
r5936 n4282 n4352 0.40000000000000002
r5937 n4351 n4352 0.03125
r5938 n4283 n4353 0.050761421319796954
r5939 n4352 n4353 0.092499999999999999
r5940 n4284 n4354 0.051020408163265307
r5941 n4353 n4354 0.16375000000000001
r5942 n4285 n4355 0.050761421319796954
r5943 n4354 n4355 0.16375000000000001
r5944 n4286 n4356 0.058823529411764705
r5945 n4355 n4356 0.15291666666666667
r5946 n4287 n4357 0.072992700729927001
r5947 n4356 n4357 0.12791666666666668
r5948 n4288 n4358 0.072463768115942032
r5949 n4357 n4358 0.11458333333333333
r5950 n4289 n4359 0.058823529411764705
r5951 n4358 n4359 0.12833333333333333
r5952 n4290 n4360 0.15384615384615385
r5953 n4359 n4360 0.097916666666666666
r5954 n4291 n4361 0.050000000000000003
r5955 n4360 n4361 0.11041666666666666
r5956 n4292 n4362 2
r5957 n4361 n4362 0.085416666666666669
r5958 n4293 n4363 0.060606060606060608
r5959 n4362 n4363 0.070833333333333331
r5960 n4294 n4364 2
r5961 n4363 n4364 0.070833333333333331
r5962 n4295 n4365 0.086956521739130432
r5963 n4364 n4365 0.050000000000000003
r5964 n4296 n4366 0.5
r5965 n4365 n4366 0.056250000000000001
r5966 n4297 n4367 0.33333333333333331
r5967 n4366 n4367 0.020833333333333332
r5968 n4298 n4368 0.40000000000000002
r5969 n4367 n4368 0.022916666666666665
r5970 n4299 n4369 2
r5971 n4368 n4369 0.012500000000000001
r5972 n4300 n4370 0.15384615384615385
r5973 n4369 n4370 0.029166666666666667
r5974 n4301 n4371 0.20000000000000001
r5975 n4370 n4371 0.04791666666666667
r5976 n4302 n4372 0.40000000000000002
r5977 n4371 n4372 0.03125
r5978 n4303 n4373 0.40000000000000002
r5979 n4372 n4373 0.020833333333333332
r5980 n4304 n4374 2
r5981 n4373 n4374 0.012500000000000001
r5982 n4305 n4375 0.66666666666666663
r5983 n4374 n4375 0.0083333333333333332
r5984 n4306 n4376 2
r5985 n4375 n4376 0.0083333333333333332
r5986 n4307 n4377 0.22222222222222221
r5987 n4376 n4377 0.020833333333333332
r5988 n4308 n4378 0.20000000000000001
r5989 n4377 n4378 0.039583333333333331
r5990 n4309 n4379 0.40000000000000002
r5991 n4378 n4379 0.03125
r5992 n4310 n4380 0.40000000000000002
r5993 n4379 n4380 0.020833333333333332
r5994 n4311 n4381 2
r5995 n4380 n4381 0.012500000000000001
r5996 n4312 n4382 1
r5997 n4381 n4382 0.0062500000000000003
r5998 n4313 n4383 2
r5999 n4382 n4383 0.0062500000000000003
r6000 n4314 n4384 2
r6001 n4383 n4384 0.0041666666666666666
r6002 n4315 n4385 2
r6003 n4384 n4385 0.0041666666666666666
r6004 n4316 n4386 0.5
r6005 n4385 n4386 0.010416666666666666
r6006 n4317 n4387 0.40000000000000002
r6007 n4386 n4387 0.018749999999999999
r6008 n4318 n4388 2
r6009 n4387 n4388 0.012500000000000001
r6010 n4319 n4389 0.20000000000000001
r6011 n4388 n4389 0.022916666666666665
r6012 n4320 n4390 0.66666666666666663
r6013 n4389 n4390 0.027083333333333334
r6014 n4321 n4391 0.33333333333333331
r6015 n4390 n4391 0.018749999999999999
r6016 n4322 n4392 1
r6017 n4391 n4392 0.016666666666666666
r6018 n4323 n4393 2
r6019 n4392 n4393 0.0062500000000000003
r6020 n4324 n4394 2
r6021 n4393 n4394 0.0041666666666666666
r6022 n4325 n4395 0.33333333333333331
r6023 n4394 n4395 0.014583333333333334
r6024 n4326 n4396 0.40000000000000002
r6025 n4395 n4396 0.022916666666666665
r6026 n4327 n4397 2
r6027 n4396 n4397 0.012500000000000001
r6028 n4328 n4398 0.5
r6029 n4397 n4398 0.010416666666666666
r6030 n4329 n4399 0.40000000000000002
r6031 n4398 n4399 0.018749999999999999
r6032 n4330 n4400 0.40000000000000002
r6033 n4331 n4401 0.33333333333333331
r6034 n4400 n4401 0.022916666666666665
r6035 n4332 n4402 1
r6036 n4401 n4402 0.016666666666666666
r6037 n4333 n4403 0.11764705882352941
r6038 n4402 n4403 0.039583333333333331
r6039 n4334 n4404 0.15384615384615385
r6040 n4403 n4404 0.0625
r6041 n4335 n4405 1
r6042 n4404 n4405 0.03125
r6043 n4336 n4406 1
r6044 n4405 n4406 0.0083333333333333332
r6045 n4337 n4407 0.5
r6046 n4406 n4407 0.012500000000000001
r6047 n4338 n4408 0.40000000000000002
r6048 n4407 n4408 0.018749999999999999
r6049 n4339 n4409 0.20000000000000001
r6050 n4340 n4410 0.080000000000000002
r6051 n4409 n4410 0.072916666666666671
r6052 n4341 n4411 2
r6053 n4410 n4411 0.054166666666666669
r6054 n4342 n4412 0.071428571428571425
r6055 n4411 n4412 0.060416666666666667
r6056 n4343 n4413 2
r6057 n4412 n4413 0.060416666666666667
r6058 n4344 n4414 0.080000000000000002
r6059 n4413 n4414 0.054166666666666669
r6060 n4345 n4415 0.20000000000000001
r6061 n4414 n4415 0.072916666666666671
r6062 n4346 n4416 0.060606060606060608
r6063 n4347 n4417 1
r6064 n4416 n4417 1.09375
r6065 n4348 n4418 0.066666666666666666
r6066 n4417 n4418 1
r6067 n4349 n4419 1
r6068 n4418 n4419 1
r6069 n4350 n4420 0.060606060606060608
r6070 n4419 n4420 1.09375
r6071 n4351 n4421 0.20000000000000001
r6072 n4420 n4421 1.34375
r6073 n4352 n4422 0.40000000000000002
r6074 n4421 n4422 0.46875
r6075 n4353 n4423 0.050761421319796954
r6076 n4422 n4423 1.3875
r6077 n4354 n4424 0.051020408163265307
r6078 n4423 n4424 2.4562499999999998
r6079 n4355 n4425 0.050761421319796954
r6080 n4424 n4425 2.4562499999999998
r6081 n4356 n4426 0.058823529411764705
r6082 n4425 n4426 2.2937500000000002
r6083 n4357 n4427 0.072992700729927001
r6084 n4426 n4427 1.91875
r6085 n4358 n4428 0.072463768115942032
r6086 n4427 n4428 1.71875
r6087 n4359 n4429 0.058823529411764705
r6088 n4428 n4429 1.925
r6089 n4360 n4430 0.15384615384615385
r6090 n4429 n4430 1.46875
r6091 n4361 n4431 0.050000000000000003
r6092 n4430 n4431 1.65625
r6093 n4362 n4432 2
r6094 n4431 n4432 1.28125
r6095 n4363 n4433 0.060606060606060608
r6096 n4432 n4433 1.0625
r6097 n4364 n4434 2
r6098 n4433 n4434 1.0625
r6099 n4365 n4435 0.086956521739130432
r6100 n4434 n4435 0.75
r6101 n4366 n4436 0.5
r6102 n4435 n4436 0.84375
r6103 n4367 n4437 0.33333333333333331
r6104 n4436 n4437 0.3125
r6105 n4368 n4438 0.40000000000000002
r6106 n4437 n4438 0.34375
r6107 n4369 n4439 2
r6108 n4438 n4439 0.1875
r6109 n4370 n4440 0.15384615384615385
r6110 n4439 n4440 0.4375
r6111 n4371 n4441 0.20000000000000001
r6112 n4440 n4441 0.71875
r6113 n4372 n4442 0.40000000000000002
r6114 n4441 n4442 0.46875
r6115 n4373 n4443 0.40000000000000002
r6116 n4442 n4443 0.3125
r6117 n4374 n4444 2
r6118 n4443 n4444 0.1875
r6119 n4375 n4445 0.66666666666666663
r6120 n4444 n4445 0.125
r6121 n4376 n4446 2
r6122 n4445 n4446 0.125
r6123 n4377 n4447 0.22222222222222221
r6124 n4446 n4447 0.3125
r6125 n4378 n4448 0.20000000000000001
r6126 n4447 n4448 0.59375
r6127 n4379 n4449 0.40000000000000002
r6128 n4448 n4449 0.46875
r6129 n4380 n4450 0.40000000000000002
r6130 n4449 n4450 0.3125
r6131 n4381 n4451 2
r6132 n4450 n4451 0.1875
r6133 n4382 n4452 1
r6134 n4451 n4452 0.09375
r6135 n4383 n4453 2
r6136 n4452 n4453 0.09375
r6137 n4384 n4454 2
r6138 n4453 n4454 0.0625
r6139 n4385 n4455 2
r6140 n4454 n4455 0.0625
r6141 n4386 n4456 0.5
r6142 n4455 n4456 0.15625
r6143 n4387 n4457 0.40000000000000002
r6144 n4456 n4457 0.28125
r6145 n4388 n4458 2
r6146 n4457 n4458 0.1875
r6147 n4389 n4459 0.20000000000000001
r6148 n4458 n4459 0.34375
r6149 n4390 n4460 0.66666666666666663
r6150 n4459 n4460 0.40625
r6151 n4391 n4461 0.33333333333333331
r6152 n4460 n4461 0.28125
r6153 n4392 n4462 1
r6154 n4461 n4462 0.25
r6155 n4393 n4463 2
r6156 n4462 n4463 0.09375
r6157 n4394 n4464 2
r6158 n4463 n4464 0.0625
r6159 n4395 n4465 0.33333333333333331
r6160 n4464 n4465 0.21875
r6161 n4396 n4466 0.40000000000000002
r6162 n4465 n4466 0.34375
r6163 n4397 n4467 2
r6164 n4466 n4467 0.1875
r6165 n4398 n4468 0.5
r6166 n4467 n4468 0.15625
r6167 n4399 n4469 0.40000000000000002
r6168 n4468 n4469 0.28125
r6169 n4400 n4470 0.40000000000000002
r6170 n4401 n4471 0.33333333333333331
r6171 n4470 n4471 0.34375
r6172 n4402 n4472 1
r6173 n4471 n4472 0.25
r6174 n4403 n4473 0.11764705882352941
r6175 n4472 n4473 0.59375
r6176 n4404 n4474 0.15384615384615385
r6177 n4473 n4474 0.9375
r6178 n4405 n4475 1
r6179 n4474 n4475 0.46875
r6180 n4406 n4476 1
r6181 n4475 n4476 0.125
r6182 n4407 n4477 0.5
r6183 n4476 n4477 0.1875
r6184 n4408 n4478 0.40000000000000002
r6185 n4477 n4478 0.28125
r6186 n4409 n4479 0.20000000000000001
r6187 n4410 n4480 0.080000000000000002
r6188 n4479 n4480 1.09375
r6189 n4411 n4481 2
r6190 n4480 n4481 0.8125
r6191 n4412 n4482 0.071428571428571425
r6192 n4481 n4482 0.90625
r6193 n4413 n4483 2
r6194 n4482 n4483 0.90625
r6195 n4414 n4484 0.080000000000000002
r6196 n4483 n4484 0.8125
r6197 n4415 n4485 0.20000000000000001
r6198 n4484 n4485 1.09375
r6199 n4416 n4486 0.02462121212121212
r6200 n4417 n4487 0.40625
r6201 n4486 n4487 0.19886363636363635
r6202 n4418 n4488 0.027083333333333334
r6203 n4487 n4488 0.18181818181818182
r6204 n4419 n4489 0.40625
r6205 n4488 n4489 0.18181818181818182
r6206 n4420 n4490 0.02462121212121212
r6207 n4489 n4490 0.19886363636363635
r6208 n4421 n4491 0.081250000000000003
r6209 n4490 n4491 0.24431818181818182
r6210 n4422 n4492 0.16250000000000001
r6211 n4491 n4492 0.085227272727272721
r6212 n4423 n4493 0.020621827411167512
r6213 n4492 n4493 0.25227272727272726
r6214 n4424 n4494 0.020727040816326529
r6215 n4493 n4494 0.44659090909090909
r6216 n4425 n4495 0.020621827411167512
r6217 n4494 n4495 0.44659090909090909
r6218 n4426 n4496 0.02389705882352941
r6219 n4495 n4496 0.41704545454545455
r6220 n4427 n4497 0.029653284671532845
r6221 n4496 n4497 0.34886363636363638
r6222 n4428 n4498 0.029438405797101448
r6223 n4497 n4498 0.3125
r6224 n4429 n4499 0.02389705882352941
r6225 n4498 n4499 0.34999999999999998
r6226 n4430 n4500 0.0625
r6227 n4499 n4500 0.26704545454545453
r6228 n4431 n4501 0.020312500000000001
r6229 n4500 n4501 0.30113636363636365
r6230 n4432 n4502 0.8125
r6231 n4501 n4502 0.23295454545454544
r6232 n4433 n4503 0.02462121212121212
r6233 n4502 n4503 0.19318181818181818
r6234 n4434 n4504 0.8125
r6235 n4503 n4504 0.19318181818181818
r6236 n4435 n4505 0.035326086956521736
r6237 n4504 n4505 0.13636363636363635
r6238 n4436 n4506 0.203125
r6239 n4505 n4506 0.15340909090909091
r6240 n4437 n4507 0.13541666666666666
r6241 n4506 n4507 0.056818181818181816
r6242 n4438 n4508 0.16250000000000001
r6243 n4507 n4508 0.0625
r6244 n4439 n4509 0.8125
r6245 n4508 n4509 0.034090909090909088
r6246 n4440 n4510 0.0625
r6247 n4509 n4510 0.079545454545454544
r6248 n4441 n4511 0.081250000000000003
r6249 n4510 n4511 0.13068181818181818
r6250 n4442 n4512 0.16250000000000001
r6251 n4511 n4512 0.085227272727272721
r6252 n4443 n4513 0.16250000000000001
r6253 n4512 n4513 0.056818181818181816
r6254 n4444 n4514 0.8125
r6255 n4513 n4514 0.034090909090909088
r6256 n4445 n4515 0.27083333333333331
r6257 n4514 n4515 0.022727272727272728
r6258 n4446 n4516 0.8125
r6259 n4515 n4516 0.022727272727272728
r6260 n4447 n4517 0.090277777777777776
r6261 n4516 n4517 0.056818181818181816
r6262 n4448 n4518 0.081250000000000003
r6263 n4517 n4518 0.10795454545454546
r6264 n4449 n4519 0.16250000000000001
r6265 n4518 n4519 0.085227272727272721
r6266 n4450 n4520 0.16250000000000001
r6267 n4519 n4520 0.056818181818181816
r6268 n4451 n4521 0.8125
r6269 n4520 n4521 0.034090909090909088
r6270 n4452 n4522 0.40625
r6271 n4521 n4522 0.017045454545454544
r6272 n4453 n4523 0.8125
r6273 n4522 n4523 0.017045454545454544
r6274 n4454 n4524 0.8125
r6275 n4523 n4524 0.011363636363636364
r6276 n4455 n4525 0.8125
r6277 n4524 n4525 0.011363636363636364
r6278 n4456 n4526 0.203125
r6279 n4525 n4526 0.028409090909090908
r6280 n4457 n4527 0.16250000000000001
r6281 n4526 n4527 0.05113636363636364
r6282 n4458 n4528 0.8125
r6283 n4527 n4528 0.034090909090909088
r6284 n4459 n4529 0.081250000000000003
r6285 n4528 n4529 0.0625
r6286 n4460 n4530 0.27083333333333331
r6287 n4529 n4530 0.073863636363636367
r6288 n4461 n4531 0.13541666666666666
r6289 n4530 n4531 0.05113636363636364
r6290 n4462 n4532 0.40625
r6291 n4531 n4532 0.045454545454545456
r6292 n4463 n4533 0.8125
r6293 n4532 n4533 0.017045454545454544
r6294 n4464 n4534 0.8125
r6295 n4533 n4534 0.011363636363636364
r6296 n4465 n4535 0.13541666666666666
r6297 n4534 n4535 0.039772727272727272
r6298 n4466 n4536 0.16250000000000001
r6299 n4535 n4536 0.0625
r6300 n4467 n4537 0.8125
r6301 n4536 n4537 0.034090909090909088
r6302 n4468 n4538 0.203125
r6303 n4537 n4538 0.028409090909090908
r6304 n4469 n4539 0.16250000000000001
r6305 n4538 n4539 0.05113636363636364
r6306 n4470 n4540 0.16250000000000001
r6307 n4471 n4541 0.13541666666666666
r6308 n4540 n4541 0.0625
r6309 n4472 n4542 0.40625
r6310 n4541 n4542 0.045454545454545456
r6311 n4473 n4543 0.04779411764705882
r6312 n4542 n4543 0.10795454545454546
r6313 n4474 n4544 0.0625
r6314 n4543 n4544 0.17045454545454544
r6315 n4475 n4545 0.40625
r6316 n4544 n4545 0.085227272727272721
r6317 n4476 n4546 0.40625
r6318 n4545 n4546 0.022727272727272728
r6319 n4477 n4547 0.203125
r6320 n4546 n4547 0.034090909090909088
r6321 n4478 n4548 0.16250000000000001
r6322 n4547 n4548 0.05113636363636364
r6323 n4479 n4549 0.081250000000000003
r6324 n4480 n4550 0.032500000000000001
r6325 n4549 n4550 0.19886363636363635
r6326 n4481 n4551 0.8125
r6327 n4550 n4551 0.14772727272727273
r6328 n4482 n4552 0.029017857142857144
r6329 n4551 n4552 0.16477272727272727
r6330 n4483 n4553 0.8125
r6331 n4552 n4553 0.16477272727272727
r6332 n4484 n4554 0.032500000000000001
r6333 n4553 n4554 0.14772727272727273
r6334 n4485 n4555 0.081250000000000003
r6335 n4554 n4555 0.19886363636363635
r6336 n4486 n4556 0.02462121212121212
r6337 n4487 n4557 0.40625
r6338 n4556 n4557 1.09375
r6339 n4488 n4558 0.027083333333333334
r6340 n4557 n4558 1
r6341 n4489 n4559 0.40625
r6342 n4558 n4559 1
r6343 n4490 n4560 0.02462121212121212
r6344 n4559 n4560 1.09375
r6345 n4518 n4561 0.081250000000000003
r6346 n4519 n4562 0.16250000000000001
r6347 n4561 n4562 0.46875
r6348 n4520 n4563 0.16250000000000001
r6349 n4562 n4563 0.3125
r6350 n4521 n4564 0.8125
r6351 n4563 n4564 0.1875
r6352 n4522 n4565 0.40625
r6353 n4564 n4565 0.09375
r6354 n4523 n4566 0.8125
r6355 n4565 n4566 0.09375
r6356 n4524 n4567 0.8125
r6357 n4566 n4567 0.0625
r6358 n4525 n4568 0.8125
r6359 n4567 n4568 0.0625
r6360 n4526 n4569 0.203125
r6361 n4568 n4569 0.15625
r6362 n4527 n4570 0.16250000000000001
r6363 n4569 n4570 0.28125
r6364 n4528 n4571 0.8125
r6365 n4570 n4571 0.1875
r6366 n4529 n4572 0.081250000000000003
r6367 n4571 n4572 0.34375
r6368 n4530 n4573 0.27083333333333331
r6369 n4572 n4573 0.40625
r6370 n4531 n4574 0.13541666666666666
r6371 n4573 n4574 0.28125
r6372 n4532 n4575 0.40625
r6373 n4574 n4575 0.25
r6374 n4533 n4576 0.8125
r6375 n4575 n4576 0.09375
r6376 n4534 n4577 0.8125
r6377 n4576 n4577 0.0625
r6378 n4535 n4578 0.13541666666666666
r6379 n4577 n4578 0.21875
r6380 n4536 n4579 0.16250000000000001
r6381 n4578 n4579 0.34375
r6382 n4537 n4580 0.8125
r6383 n4579 n4580 0.1875
r6384 n4538 n4581 0.203125
r6385 n4580 n4581 0.15625
r6386 n4539 n4582 0.16250000000000001
r6387 n4581 n4582 0.28125
r6388 n4540 n4583 0.16250000000000001
r6389 n4541 n4584 0.13541666666666666
r6390 n4583 n4584 0.34375
r6391 n4542 n4585 0.40625
r6392 n4584 n4585 0.25
r6393 n4543 n4586 0.04779411764705882
r6394 n4585 n4586 0.59375
r6395 n4544 n4587 0.0625
r6396 n4586 n4587 0.9375
r6397 n4545 n4588 0.40625
r6398 n4587 n4588 0.46875
r6399 n4546 n4589 0.40625
r6400 n4588 n4589 0.125
r6401 n4547 n4590 0.203125
r6402 n4589 n4590 0.1875
r6403 n4548 n4591 0.16250000000000001
r6404 n4590 n4591 0.28125
r6405 n4549 n4592 0.081250000000000003
r6406 n4550 n4593 0.032500000000000001
r6407 n4592 n4593 1.09375
r6408 n4551 n4594 0.8125
r6409 n4593 n4594 0.8125
r6410 n4552 n4595 0.029017857142857144
r6411 n4594 n4595 0.90625
r6412 n4553 n4596 0.8125
r6413 n4595 n4596 0.90625
r6414 n4554 n4597 0.032500000000000001
r6415 n4596 n4597 0.8125
r6416 n4555 n4598 0.081250000000000003
r6417 n4597 n4598 1.09375
r6418 n4556 n4599 0.070075757575757569
r6419 n4557 n4600 1.15625
r6420 n4599 n4600 0.0625
r6421 n4558 n4601 0.077083333333333337
r6422 n4600 n4601 0.057142857142857141
r6423 n4559 n4602 1.15625
r6424 n4601 n4602 0.057142857142857141
r6425 n4560 n4603 0.070075757575757569
r6426 n4602 n4603 0.0625
r6427 n4583 n4604 0.46250000000000002
r6428 n4584 n4605 0.38541666666666669
r6429 n4604 n4605 0.019642857142857142
r6430 n4585 n4606 1.15625
r6431 n4605 n4606 0.014285714285714285
r6432 n4586 n4607 0.13602941176470587
r6433 n4606 n4607 0.033928571428571426
r6434 n4587 n4608 0.17788461538461539
r6435 n4607 n4608 0.053571428571428568
r6436 n4588 n4609 1.15625
r6437 n4608 n4609 0.026785714285714284
r6438 n4589 n4610 1.15625
r6439 n4609 n4610 0.0071428571428571426
r6440 n4590 n4611 0.578125
r6441 n4610 n4611 0.010714285714285714
r6442 n4591 n4612 0.46250000000000002
r6443 n4611 n4612 0.01607142857142857
r6444 n4592 n4613 0.23125000000000001
r6445 n4593 n4614 0.092499999999999999
r6446 n4613 n4614 0.0625
r6447 n4594 n4615 2.3125
r6448 n4614 n4615 0.04642857142857143
r6449 n4595 n4616 0.082589285714285712
r6450 n4615 n4616 0.051785714285714289
r6451 n4596 n4617 2.3125
r6452 n4616 n4617 0.051785714285714289
r6453 n4597 n4618 0.092499999999999999
r6454 n4617 n4618 0.04642857142857143
r6455 n4598 n4619 0.23125000000000001
r6456 n4618 n4619 0.0625
r6457 n4599 n4620 0.13068181818181818
r6458 n4600 n4621 2.15625
r6459 n4620 n4621 0.064338235294117641
r6460 n4601 n4622 0.14374999999999999
r6461 n4621 n4622 0.058823529411764705
r6462 n4602 n4623 2.15625
r6463 n4622 n4623 0.058823529411764705
r6464 n4603 n4624 0.13068181818181818
r6465 n4623 n4624 0.064338235294117641
r6466 n4604 n4625 0.86250000000000004
r6467 n4605 n4626 0.71875
r6468 n4625 n4626 0.020220588235294119
r6469 n4606 n4627 2.15625
r6470 n4626 n4627 0.014705882352941176
r6471 n4607 n4628 0.25367647058823528
r6472 n4627 n4628 0.034926470588235295
r6473 n4608 n4629 0.33173076923076922
r6474 n4628 n4629 0.05514705882352941
r6475 n4609 n4630 2.15625
r6476 n4629 n4630 0.027573529411764705
r6477 n4610 n4631 2.15625
r6478 n4630 n4631 0.0073529411764705881
r6479 n4611 n4632 1.078125
r6480 n4631 n4632 0.011029411764705883
r6481 n4612 n4633 0.86250000000000004
r6482 n4632 n4633 0.016544117647058824
r6483 n4613 n4634 0.43125000000000002
r6484 n4614 n4635 0.17249999999999999
r6485 n4634 n4635 0.064338235294117641
r6486 n4615 n4636 4.3125
r6487 n4635 n4636 0.04779411764705882
r6488 n4616 n4637 0.15401785714285715
r6489 n4636 n4637 0.053308823529411763
r6490 n4617 n4638 4.3125
r6491 n4637 n4638 0.053308823529411763
r6492 n4618 n4639 0.17249999999999999
r6493 n4638 n4639 0.04779411764705882
r6494 n4619 n4640 0.43125000000000002
r6495 n4639 n4640 0.064338235294117641
r6496 n4620 n4641 0.077651515151515152
r6497 n4621 n4642 1.28125
r6498 n4641 n4642 0.3125
r6499 n4622 n4643 0.085416666666666669
r6500 n4642 n4643 0.2857142857142857
r6501 n4623 n4644 1.28125
r6502 n4643 n4644 0.2857142857142857
r6503 n4624 n4645 0.077651515151515152
r6504 n4644 n4645 0.3125
r6505 n4625 n4646 0.51249999999999996
r6506 n4626 n4647 0.42708333333333331
r6507 n4646 n4647 0.098214285714285712
r6508 n4627 n4648 1.28125
r6509 n4647 n4648 0.071428571428571425
r6510 n4628 n4649 0.15073529411764705
r6511 n4648 n4649 0.16964285714285715
r6512 n4629 n4650 0.19711538461538461
r6513 n4649 n4650 0.26785714285714285
r6514 n4630 n4651 1.28125
r6515 n4650 n4651 0.13392857142857142
r6516 n4631 n4652 1.28125
r6517 n4651 n4652 0.035714285714285712
r6518 n4632 n4653 0.640625
r6519 n4652 n4653 0.053571428571428568
r6520 n4633 n4654 0.51249999999999996
r6521 n4653 n4654 0.080357142857142863
r6522 n4634 n4655 0.25624999999999998
r6523 n4635 n4656 0.10249999999999999
r6524 n4655 n4656 0.3125
r6525 n4636 n4657 2.5625
r6526 n4656 n4657 0.23214285714285715
r6527 n4637 n4658 0.091517857142857137
r6528 n4657 n4658 0.25892857142857145
r6529 n4638 n4659 2.5625
r6530 n4658 n4659 0.25892857142857145
r6531 n4639 n4660 0.10249999999999999
r6532 n4659 n4660 0.23214285714285715
r6533 n4640 n4661 0.25624999999999998
r6534 n4660 n4661 0.3125
r6535 n4641 n4662 0.017045454545454544
r6536 n4642 n4663 0.28125
r6537 n4662 n4663 1.09375
r6538 n4643 n4664 0.018749999999999999
r6539 n4663 n4664 1
r6540 n4644 n4665 0.28125
r6541 n4664 n4665 1
r6542 n4645 n4666 0.017045454545454544
r6543 n4665 n4666 1.09375
r6544 n4667 n4668 0.46875
r6545 n4668 n4669 0.3125
r6546 n4669 n4670 0.1875
r6547 n4670 n4671 0.125
r6548 n4671 n4672 0.125
r6549 n4672 n4673 0.3125
r6550 n4673 n4674 0.59375
r6551 n4674 n4675 0.46875
r6552 n4675 n4676 0.3125
r6553 n4676 n4677 0.1875
r6554 n4677 n4678 0.09375
r6555 n4678 n4679 0.09375
r6556 n4679 n4680 0.0625
r6557 n4680 n4681 0.0625
r6558 n4681 n4682 0.15625
r6559 n4682 n4683 0.28125
r6560 n4683 n4684 0.1875
r6561 n4684 n4685 0.34375
r6562 n4646 n4686 0.1125
r6563 n4647 n4687 0.09375
r6564 n4686 n4687 0.34375
r6565 n4648 n4688 0.28125
r6566 n4687 n4688 0.25
r6567 n4649 n4689 0.033088235294117647
r6568 n4688 n4689 0.59375
r6569 n4650 n4690 0.043269230769230768
r6570 n4689 n4690 0.9375
r6571 n4651 n4691 0.28125
r6572 n4690 n4691 0.46875
r6573 n4652 n4692 0.28125
r6574 n4691 n4692 0.125
r6575 n4653 n4693 0.140625
r6576 n4692 n4693 0.1875
r6577 n4654 n4694 0.1125
r6578 n4693 n4694 0.28125
r6579 n4655 n4695 0.056250000000000001
r6580 n4656 n4696 0.022499999999999999
r6581 n4695 n4696 1.09375
r6582 n4657 n4697 0.5625
r6583 n4696 n4697 0.8125
r6584 n4658 n4698 0.020089285714285716
r6585 n4697 n4698 0.90625
r6586 n4659 n4699 0.5625
r6587 n4698 n4699 0.90625
r6588 n4660 n4700 0.022499999999999999
r6589 n4699 n4700 0.8125
r6590 n4661 n4701 0.056250000000000001
r6591 n4700 n4701 1.09375
r6592 n4662 n4702 0.013257575757575758
r6593 n4663 n4703 0.21875
r6594 n4702 n4703 0.4375
r6595 n4664 n4704 0.014583333333333334
r6596 n4703 n4704 0.40000000000000002
r6597 n4665 n4705 0.21875
r6598 n4704 n4705 0.40000000000000002
r6599 n4666 n4706 0.013257575757575758
r6600 n4705 n4706 0.4375
r6601 n4706 n4707 0.53749999999999998
r6602 n4707 n4708 0.1875
r6603 n4708 n4709 0.55500000000000005
r6604 n4709 n4710 0.98250000000000004
r6605 n4710 n4711 0.98250000000000004
r6606 n4711 n4712 0.91749999999999998
r6607 n4712 n4713 0.76749999999999996
r6608 n4713 n4714 0.6875
r6609 n4714 n4715 0.77000000000000002
r6610 n4715 n4716 0.58750000000000002
r6611 n4716 n4717 0.66249999999999998
r6612 n4717 n4718 0.51249999999999996
r6613 n4718 n4719 0.42499999999999999
r6614 n4719 n4720 0.42499999999999999
r6615 n4720 n4721 0.29999999999999999
r6616 n4721 n4722 0.33750000000000002
r6617 n4722 n4723 0.125
r6618 n4723 n4724 0.13750000000000001
r6619 n4724 n4725 0.074999999999999997
r6620 n4725 n4726 0.17499999999999999
r6621 n4667 n4727 0.043749999999999997
r6622 n4726 n4727 0.28749999999999998
r6623 n4668 n4728 0.087499999999999994
r6624 n4727 n4728 0.1875
r6625 n4669 n4729 0.087499999999999994
r6626 n4728 n4729 0.125
r6627 n4670 n4730 0.4375
r6628 n4729 n4730 0.074999999999999997
r6629 n4671 n4731 0.14583333333333334
r6630 n4730 n4731 0.050000000000000003
r6631 n4672 n4732 0.4375
r6632 n4731 n4732 0.050000000000000003
r6633 n4673 n4733 0.048611111111111112
r6634 n4732 n4733 0.125
r6635 n4674 n4734 0.043749999999999997
r6636 n4733 n4734 0.23749999999999999
r6637 n4675 n4735 0.087499999999999994
r6638 n4734 n4735 0.1875
r6639 n4676 n4736 0.087499999999999994
r6640 n4735 n4736 0.125
r6641 n4677 n4737 0.4375
r6642 n4736 n4737 0.074999999999999997
r6643 n4678 n4738 0.21875
r6644 n4737 n4738 0.037499999999999999
r6645 n4679 n4739 0.4375
r6646 n4738 n4739 0.037499999999999999
r6647 n4680 n4740 0.4375
r6648 n4739 n4740 0.025000000000000001
r6649 n4681 n4741 0.4375
r6650 n4740 n4741 0.025000000000000001
r6651 n4682 n4742 0.109375
r6652 n4741 n4742 0.0625
r6653 n4683 n4743 0.087499999999999994
r6654 n4742 n4743 0.1125
r6655 n4684 n4744 0.4375
r6656 n4743 n4744 0.074999999999999997
r6657 n4685 n4745 0.043749999999999997
r6658 n4744 n4745 0.13750000000000001
r6659 n4686 n4746 0.087499999999999994
r6660 n4687 n4747 0.072916666666666671
r6661 n4746 n4747 0.13750000000000001
r6662 n4688 n4748 0.21875
r6663 n4747 n4748 0.10000000000000001
r6664 n4689 n4749 0.025735294117647058
r6665 n4748 n4749 0.23749999999999999
r6666 n4690 n4750 0.033653846153846152
r6667 n4749 n4750 0.375
r6668 n4691 n4751 0.21875
r6669 n4750 n4751 0.1875
r6670 n4692 n4752 0.21875
r6671 n4751 n4752 0.050000000000000003
r6672 n4693 n4753 0.109375
r6673 n4752 n4753 0.074999999999999997
r6674 n4694 n4754 0.087499999999999994
r6675 n4753 n4754 0.1125
r6676 n4695 n4755 0.043749999999999997
r6677 n4696 n4756 0.017500000000000002
r6678 n4755 n4756 0.4375
r6679 n4697 n4757 0.4375
r6680 n4756 n4757 0.32500000000000001
r6681 n4698 n4758 0.015625
r6682 n4757 n4758 0.36249999999999999
r6683 n4699 n4759 0.4375
r6684 n4758 n4759 0.36249999999999999
r6685 n4700 n4760 0.017500000000000002
r6686 n4759 n4760 0.32500000000000001
r6687 n4701 n4761 0.043749999999999997
r6688 n4760 n4761 0.4375
r6689 n4702 n4762 0.020833333333333332
r6690 n4703 n4763 0.34375
r6691 n4762 n4763 0.36458333333333331
r6692 n4704 n4764 0.022916666666666665
r6693 n4763 n4764 0.33333333333333331
r6694 n4705 n4765 0.34375
r6695 n4764 n4765 0.33333333333333331
r6696 n4706 n4766 0.020833333333333332
r6697 n4765 n4766 0.36458333333333331
r6698 n4707 n4767 0.068750000000000006
r6699 n4766 n4767 0.44791666666666669
r6700 n4708 n4768 0.13750000000000001
r6701 n4767 n4768 0.15625
r6702 n4709 n4769 0.017449238578680203
r6703 n4768 n4769 0.46250000000000002
r6704 n4710 n4770 0.017538265306122448
r6705 n4769 n4770 0.81874999999999998
r6706 n4711 n4771 0.017449238578680203
r6707 n4770 n4771 0.81874999999999998
r6708 n4712 n4772 0.020220588235294119
r6709 n4771 n4772 0.76458333333333328
r6710 n4713 n4773 0.025091240875912409
r6711 n4772 n4773 0.63958333333333328
r6712 n4714 n4774 0.024909420289855072
r6713 n4773 n4774 0.57291666666666663
r6714 n4715 n4775 0.020220588235294119
r6715 n4774 n4775 0.64166666666666672
r6716 n4716 n4776 0.052884615384615384
r6717 n4775 n4776 0.48958333333333331
r6718 n4717 n4777 0.017187500000000001
r6719 n4776 n4777 0.55208333333333337
r6720 n4718 n4778 0.6875
r6721 n4777 n4778 0.42708333333333331
r6722 n4719 n4779 0.020833333333333332
r6723 n4778 n4779 0.35416666666666669
r6724 n4720 n4780 0.6875
r6725 n4779 n4780 0.35416666666666669
r6726 n4721 n4781 0.029891304347826088
r6727 n4780 n4781 0.25
r6728 n4722 n4782 0.171875
r6729 n4781 n4782 0.28125
r6730 n4723 n4783 0.11458333333333333
r6731 n4782 n4783 0.10416666666666667
r6732 n4724 n4784 0.13750000000000001
r6733 n4783 n4784 0.11458333333333333
r6734 n4725 n4785 0.6875
r6735 n4784 n4785 0.0625
r6736 n4726 n4786 0.052884615384615384
r6737 n4785 n4786 0.14583333333333334
r6738 n4727 n4787 0.068750000000000006
r6739 n4786 n4787 0.23958333333333334
r6740 n4728 n4788 0.13750000000000001
r6741 n4787 n4788 0.15625
r6742 n4729 n4789 0.13750000000000001
r6743 n4788 n4789 0.10416666666666667
r6744 n4730 n4790 0.6875
r6745 n4789 n4790 0.0625
r6746 n4731 n4791 0.22916666666666666
r6747 n4790 n4791 0.041666666666666664
r6748 n4732 n4792 0.6875
r6749 n4791 n4792 0.041666666666666664
r6750 n4733 n4793 0.076388888888888895
r6751 n4792 n4793 0.10416666666666667
r6752 n4734 n4794 0.068750000000000006
r6753 n4793 n4794 0.19791666666666666
r6754 n4735 n4795 0.13750000000000001
r6755 n4794 n4795 0.15625
r6756 n4736 n4796 0.13750000000000001
r6757 n4795 n4796 0.10416666666666667
r6758 n4737 n4797 0.6875
r6759 n4796 n4797 0.0625
r6760 n4738 n4798 0.34375
r6761 n4797 n4798 0.03125
r6762 n4739 n4799 0.6875
r6763 n4798 n4799 0.03125
r6764 n4740 n4800 0.6875
r6765 n4799 n4800 0.020833333333333332
r6766 n4741 n4801 0.6875
r6767 n4800 n4801 0.020833333333333332
r6768 n4742 n4802 0.171875
r6769 n4801 n4802 0.052083333333333336
r6770 n4743 n4803 0.13750000000000001
r6771 n4802 n4803 0.09375
r6772 n4744 n4804 0.6875
r6773 n4803 n4804 0.0625
r6774 n4745 n4805 0.068750000000000006
r6775 n4804 n4805 0.11458333333333333
r6776 n4746 n4806 0.13750000000000001
r6777 n4747 n4807 0.11458333333333333
r6778 n4806 n4807 0.11458333333333333
r6779 n4748 n4808 0.34375
r6780 n4807 n4808 0.083333333333333329
r6781 n4749 n4809 0.040441176470588237
r6782 n4808 n4809 0.19791666666666666
r6783 n4750 n4810 0.052884615384615384
r6784 n4809 n4810 0.3125
r6785 n4751 n4811 0.34375
r6786 n4810 n4811 0.15625
r6787 n4752 n4812 0.34375
r6788 n4811 n4812 0.041666666666666664
r6789 n4753 n4813 0.171875
r6790 n4812 n4813 0.0625
r6791 n4754 n4814 0.13750000000000001
r6792 n4813 n4814 0.09375
r6793 n4755 n4815 0.068750000000000006
r6794 n4756 n4816 0.0275
r6795 n4815 n4816 0.36458333333333331
r6796 n4757 n4817 0.6875
r6797 n4816 n4817 0.27083333333333331
r6798 n4758 n4818 0.024553571428571428
r6799 n4817 n4818 0.30208333333333331
r6800 n4759 n4819 0.6875
r6801 n4818 n4819 0.30208333333333331
r6802 n4760 n4820 0.0275
r6803 n4819 n4820 0.27083333333333331
r6804 n4761 n4821 0.068750000000000006
r6805 n4820 n4821 0.36458333333333331
r6806 n4762 n4822 0.015151515151515152
r6807 n4763 n4823 0.25
r6808 n4822 n4823 1.09375
r6809 n4764 n4824 0.016666666666666666
r6810 n4823 n4824 1
r6811 n4765 n4825 0.25
r6812 n4824 n4825 1
r6813 n4766 n4826 0.015151515151515152
r6814 n4825 n4826 1.09375
r6815 n4767 n4827 0.050000000000000003
r6816 n4826 n4827 1.34375
r6817 n4768 n4828 0.10000000000000001
r6818 n4827 n4828 0.46875
r6819 n4769 n4829 0.012690355329949238
r6820 n4828 n4829 1.3875
r6821 n4770 n4830 0.012755102040816327
r6822 n4829 n4830 2.4562499999999998
r6823 n4771 n4831 0.012690355329949238
r6824 n4830 n4831 2.4562499999999998
r6825 n4772 n4832 0.014705882352941176
r6826 n4831 n4832 2.2937500000000002
r6827 n4773 n4833 0.01824817518248175
r6828 n4832 n4833 1.91875
r6829 n4774 n4834 0.018115942028985508
r6830 n4833 n4834 1.71875
r6831 n4775 n4835 0.014705882352941176
r6832 n4834 n4835 1.925
r6833 n4776 n4836 0.038461538461538464
r6834 n4835 n4836 1.46875
r6835 n4777 n4837 0.012500000000000001
r6836 n4836 n4837 1.65625
r6837 n4778 n4838 0.5
r6838 n4837 n4838 1.28125
r6839 n4779 n4839 0.015151515151515152
r6840 n4838 n4839 1.0625
r6841 n4780 n4840 0.5
r6842 n4839 n4840 1.0625
r6843 n4781 n4841 0.021739130434782608
r6844 n4840 n4841 0.75
r6845 n4782 n4842 0.125
r6846 n4841 n4842 0.84375
r6847 n4783 n4843 0.083333333333333329
r6848 n4842 n4843 0.3125
r6849 n4784 n4844 0.10000000000000001
r6850 n4843 n4844 0.34375
r6851 n4785 n4845 0.5
r6852 n4844 n4845 0.1875
r6853 n4786 n4846 0.038461538461538464
r6854 n4845 n4846 0.4375
r6855 n4787 n4847 0.050000000000000003
r6856 n4846 n4847 0.71875
r6857 n4788 n4848 0.10000000000000001
r6858 n4847 n4848 0.46875
r6859 n4789 n4849 0.10000000000000001
r6860 n4848 n4849 0.3125
r6861 n4790 n4850 0.5
r6862 n4849 n4850 0.1875
r6863 n4791 n4851 0.16666666666666666
r6864 n4850 n4851 0.125
r6865 n4792 n4852 0.5
r6866 n4851 n4852 0.125
r6867 n4793 n4853 0.055555555555555552
r6868 n4852 n4853 0.3125
r6869 n4794 n4854 0.050000000000000003
r6870 n4853 n4854 0.59375
r6871 n4795 n4855 0.10000000000000001
r6872 n4854 n4855 0.46875
r6873 n4796 n4856 0.10000000000000001
r6874 n4855 n4856 0.3125
r6875 n4797 n4857 0.5
r6876 n4856 n4857 0.1875
r6877 n4798 n4858 0.25
r6878 n4857 n4858 0.09375
r6879 n4799 n4859 0.5
r6880 n4858 n4859 0.09375
r6881 n4800 n4860 0.5
r6882 n4859 n4860 0.0625
r6883 n4801 n4861 0.5
r6884 n4860 n4861 0.0625
r6885 n4802 n4862 0.125
r6886 n4861 n4862 0.15625
r6887 n4803 n4863 0.10000000000000001
r6888 n4862 n4863 0.28125
r6889 n4804 n4864 0.5
r6890 n4863 n4864 0.1875
r6891 n4805 n4865 0.050000000000000003
r6892 n4864 n4865 0.34375
r6893 n4806 n4866 0.10000000000000001
r6894 n4807 n4867 0.083333333333333329
r6895 n4866 n4867 0.34375
r6896 n4808 n4868 0.25
r6897 n4867 n4868 0.25
r6898 n4809 n4869 0.029411764705882353
r6899 n4868 n4869 0.59375
r6900 n4810 n4870 0.038461538461538464
r6901 n4869 n4870 0.9375
r6902 n4811 n4871 0.25
r6903 n4870 n4871 0.46875
r6904 n4812 n4872 0.25
r6905 n4871 n4872 0.125
r6906 n4813 n4873 0.125
r6907 n4872 n4873 0.1875
r6908 n4814 n4874 0.10000000000000001
r6909 n4873 n4874 0.28125
r6910 n4815 n4875 0.050000000000000003
r6911 n4816 n4876 0.02
r6912 n4875 n4876 1.09375
r6913 n4817 n4877 0.5
r6914 n4876 n4877 0.8125
r6915 n4818 n4878 0.017857142857142856
r6916 n4877 n4878 0.90625
r6917 n4819 n4879 0.5
r6918 n4878 n4879 0.90625
r6919 n4820 n4880 0.02
r6920 n4879 n4880 0.8125
r6921 n4821 n4881 0.050000000000000003
r6922 n4880 n4881 1.09375
r6923 n4822 n4882 0.034090909090909088
r6924 n4823 n4883 0.5625
r6925 n4882 n4883 0.13671875
r6926 n4824 n4884 0.037499999999999999
r6927 n4883 n4884 0.125
r6928 n4825 n4885 0.5625
r6929 n4884 n4885 0.125
r6930 n4826 n4886 0.034090909090909088
r6931 n4885 n4886 0.13671875
r6932 n4827 n4887 0.1125
r6933 n4886 n4887 0.16796875
r6934 n4828 n4888 0.22500000000000001
r6935 n4887 n4888 0.05859375
r6936 n4829 n4889 0.028553299492385786
r6937 n4888 n4889 0.17343749999999999
r6938 n4830 n4890 0.028698979591836735
r6939 n4889 n4890 0.30703124999999998
r6940 n4831 n4891 0.028553299492385786
r6941 n4890 n4891 0.30703124999999998
r6942 n4832 n4892 0.033088235294117647
r6943 n4891 n4892 0.28671875000000002
r6944 n4833 n4893 0.04105839416058394
r6945 n4892 n4893 0.23984374999999999
r6946 n4834 n4894 0.040760869565217392
r6947 n4893 n4894 0.21484375
r6948 n4835 n4895 0.033088235294117647
r6949 n4894 n4895 0.24062500000000001
r6950 n4836 n4896 0.086538461538461536
r6951 n4895 n4896 0.18359375
r6952 n4837 n4897 0.028125000000000001
r6953 n4896 n4897 0.20703125
r6954 n4838 n4898 1.125
r6955 n4897 n4898 0.16015625
r6956 n4839 n4899 0.034090909090909088
r6957 n4898 n4899 0.1328125
r6958 n4840 n4900 1.125
r6959 n4899 n4900 0.1328125
r6960 n4841 n4901 0.048913043478260872
r6961 n4900 n4901 0.09375
r6962 n4842 n4902 0.28125
r6963 n4901 n4902 0.10546875
r6964 n4843 n4903 0.1875
r6965 n4902 n4903 0.0390625
r6966 n4844 n4904 0.22500000000000001
r6967 n4903 n4904 0.04296875
r6968 n4845 n4905 1.125
r6969 n4904 n4905 0.0234375
r6970 n4846 n4906 0.086538461538461536
r6971 n4905 n4906 0.0546875
r6972 n4847 n4907 0.1125
r6973 n4906 n4907 0.08984375
r6974 n4848 n4908 0.22500000000000001
r6975 n4907 n4908 0.05859375
r6976 n4849 n4909 0.22500000000000001
r6977 n4908 n4909 0.0390625
r6978 n4850 n4910 1.125
r6979 n4909 n4910 0.0234375
r6980 n4851 n4911 0.375
r6981 n4910 n4911 0.015625
r6982 n4852 n4912 1.125
r6983 n4911 n4912 0.015625
r6984 n4853 n4913 0.125
r6985 n4912 n4913 0.0390625
r6986 n4854 n4914 0.1125
r6987 n4913 n4914 0.07421875
r6988 n4855 n4915 0.22500000000000001
r6989 n4914 n4915 0.05859375
r6990 n4856 n4916 0.22500000000000001
r6991 n4915 n4916 0.0390625
r6992 n4857 n4917 1.125
r6993 n4916 n4917 0.0234375
r6994 n4858 n4918 0.5625
r6995 n4917 n4918 0.01171875
r6996 n4859 n4919 1.125
r6997 n4918 n4919 0.01171875
r6998 n4860 n4920 1.125
r6999 n4919 n4920 0.0078125
r7000 n4861 n4921 1.125
r7001 n4920 n4921 0.0078125
r7002 n4862 n4922 0.28125
r7003 n4921 n4922 0.01953125
r7004 n4863 n4923 0.22500000000000001
r7005 n4922 n4923 0.03515625
r7006 n4864 n4924 1.125
r7007 n4923 n4924 0.0234375
r7008 n4865 n4925 0.1125
r7009 n4924 n4925 0.04296875
r7010 n4866 n4926 0.22500000000000001
r7011 n4867 n4927 0.1875
r7012 n4926 n4927 0.04296875
r7013 n4868 n4928 0.5625
r7014 n4927 n4928 0.03125
r7015 n4869 n4929 0.066176470588235295
r7016 n4928 n4929 0.07421875
r7017 n4870 n4930 0.086538461538461536
r7018 n4929 n4930 0.1171875
r7019 n4871 n4931 0.5625
r7020 n4930 n4931 0.05859375
r7021 n4872 n4932 0.5625
r7022 n4931 n4932 0.015625
r7023 n4873 n4933 0.28125
r7024 n4932 n4933 0.0234375
r7025 n4874 n4934 0.22500000000000001
r7026 n4933 n4934 0.03515625
r7027 n4875 n4935 0.1125
r7028 n4876 n4936 0.044999999999999998
r7029 n4935 n4936 0.13671875
r7030 n4877 n4937 1.125
r7031 n4936 n4937 0.1015625
r7032 n4878 n4938 0.040178571428571432
r7033 n4937 n4938 0.11328125
r7034 n4879 n4939 1.125
r7035 n4938 n4939 0.11328125
r7036 n4880 n4940 0.044999999999999998
r7037 n4939 n4940 0.1015625
r7038 n4881 n4941 0.1125
r7039 n4940 n4941 0.13671875
r7040 n4882 n4942 0.056818181818181816
r7041 n4883 n4943 0.9375
r7042 n4942 n4943 0.15625
r7043 n4884 n4944 0.0625
r7044 n4943 n4944 0.14285714285714285
r7045 n4885 n4945 0.9375
r7046 n4944 n4945 0.14285714285714285
r7047 n4886 n4946 0.056818181818181816
r7048 n4945 n4946 0.15625
r7049 n4887 n4947 0.1875
r7050 n4946 n4947 0.19196428571428573
r7051 n4888 n4948 0.375
r7052 n4947 n4948 0.066964285714285712
r7053 n4889 n4949 0.047588832487309642
r7054 n4948 n4949 0.1982142857142857
r7055 n4890 n4950 0.047831632653061222
r7056 n4949 n4950 0.35089285714285712
r7057 n4891 n4951 0.047588832487309642
r7058 n4950 n4951 0.35089285714285712
r7059 n4892 n4952 0.05514705882352941
r7060 n4951 n4952 0.32767857142857143
r7061 n4893 n4953 0.068430656934306569
r7062 n4952 n4953 0.27410714285714288
r7063 n4894 n4954 0.067934782608695649
r7064 n4953 n4954 0.24553571428571427
r7065 n4895 n4955 0.05514705882352941
r7066 n4954 n4955 0.27500000000000002
r7067 n4896 n4956 0.14423076923076922
r7068 n4955 n4956 0.20982142857142858
r7069 n4897 n4957 0.046875
r7070 n4956 n4957 0.23660714285714285
r7071 n4898 n4958 1.875
r7072 n4957 n4958 0.18303571428571427
r7073 n4899 n4959 0.056818181818181816
r7074 n4958 n4959 0.15178571428571427
r7075 n4900 n4960 1.875
r7076 n4959 n4960 0.15178571428571427
r7077 n4901 n4961 0.081521739130434784
r7078 n4960 n4961 0.10714285714285714
r7079 n4902 n4962 0.46875
r7080 n4961 n4962 0.12053571428571429
r7081 n4903 n4963 0.3125
r7082 n4962 n4963 0.044642857142857144
r7083 n4904 n4964 0.375
r7084 n4963 n4964 0.049107142857142856
r7085 n4905 n4965 1.875
r7086 n4964 n4965 0.026785714285714284
r7087 n4906 n4966 0.14423076923076922
r7088 n4965 n4966 0.0625
r7089 n4907 n4967 0.1875
r7090 n4966 n4967 0.10267857142857142
r7091 n4908 n4968 0.375
r7092 n4967 n4968 0.066964285714285712
r7093 n4909 n4969 0.375
r7094 n4968 n4969 0.044642857142857144
r7095 n4910 n4970 1.875
r7096 n4969 n4970 0.026785714285714284
r7097 n4911 n4971 0.625
r7098 n4970 n4971 0.017857142857142856
r7099 n4912 n4972 1.875
r7100 n4971 n4972 0.017857142857142856
r7101 n4913 n4973 0.20833333333333334
r7102 n4972 n4973 0.044642857142857144
r7103 n4914 n4974 0.1875
r7104 n4973 n4974 0.084821428571428575
r7105 n4915 n4975 0.375
r7106 n4974 n4975 0.066964285714285712
r7107 n4916 n4976 0.375
r7108 n4975 n4976 0.044642857142857144
r7109 n4917 n4977 1.875
r7110 n4976 n4977 0.026785714285714284
r7111 n4918 n4978 0.9375
r7112 n4977 n4978 0.013392857142857142
r7113 n4919 n4979 1.875
r7114 n4978 n4979 0.013392857142857142
r7115 n4920 n4980 1.875
r7116 n4979 n4980 0.0089285714285714281
r7117 n4921 n4981 1.875
r7118 n4980 n4981 0.0089285714285714281
r7119 n4922 n4982 0.46875
r7120 n4981 n4982 0.022321428571428572
r7121 n4923 n4983 0.375
r7122 n4982 n4983 0.040178571428571432
r7123 n4924 n4984 1.875
r7124 n4983 n4984 0.026785714285714284
r7125 n4925 n4985 0.1875
r7126 n4984 n4985 0.049107142857142856
r7127 n4926 n4986 0.375
r7128 n4927 n4987 0.3125
r7129 n4986 n4987 0.049107142857142856
r7130 n4928 n4988 0.9375
r7131 n4987 n4988 0.035714285714285712
r7132 n4929 n4989 0.11029411764705882
r7133 n4988 n4989 0.084821428571428575
r7134 n4930 n4990 0.14423076923076922
r7135 n4989 n4990 0.13392857142857142
r7136 n4931 n4991 0.9375
r7137 n4990 n4991 0.066964285714285712
r7138 n4932 n4992 0.9375
r7139 n4991 n4992 0.017857142857142856
r7140 n4933 n4993 0.46875
r7141 n4992 n4993 0.026785714285714284
r7142 n4934 n4994 0.375
r7143 n4993 n4994 0.040178571428571432
r7144 n4935 n4995 0.1875
r7145 n4936 n4996 0.074999999999999997
r7146 n4995 n4996 0.15625
r7147 n4937 n4997 1.875
r7148 n4996 n4997 0.11607142857142858
r7149 n4938 n4998 0.066964285714285712
r7150 n4997 n4998 0.12946428571428573
r7151 n4939 n4999 1.875
r7152 n4998 n4999 0.12946428571428573
r7153 n4940 n5000 0.074999999999999997
r7154 n4999 n5000 0.11607142857142858
r7155 n4941 n5001 0.1875
r7156 n5000 n5001 0.15625
r7157 n4942 n5002 0.030303030303030304
r7158 n4943 n5003 0.5
r7159 n5002 n5003 1.09375
r7160 n4944 n5004 0.033333333333333333
r7161 n5003 n5004 1
r7162 n4945 n5005 0.5
r7163 n5004 n5005 1
r7164 n4946 n5006 0.030303030303030304
r7165 n5005 n5006 1.09375
r7166 n4947 n5007 0.10000000000000001
r7167 n5006 n5007 1.34375
r7168 n4948 n5008 0.20000000000000001
r7169 n5007 n5008 0.46875
r7170 n4949 n5009 0.025380710659898477
r7171 n5008 n5009 1.3875
r7172 n4950 n5010 0.025510204081632654
r7173 n5009 n5010 2.4562499999999998
r7174 n4951 n5011 0.025380710659898477
r7175 n5010 n5011 2.4562499999999998
r7176 n4952 n5012 0.029411764705882353
r7177 n5011 n5012 2.2937500000000002
r7178 n4953 n5013 0.036496350364963501
r7179 n5012 n5013 1.91875
r7180 n4954 n5014 0.036231884057971016
r7181 n5013 n5014 1.71875
r7182 n4955 n5015 0.029411764705882353
r7183 n5014 n5015 1.925
r7184 n4956 n5016 0.076923076923076927
r7185 n5015 n5016 1.46875
r7186 n4957 n5017 0.025000000000000001
r7187 n5016 n5017 1.65625
r7188 n4958 n5018 1
r7189 n5017 n5018 1.28125
r7190 n4959 n5019 0.030303030303030304
r7191 n5018 n5019 1.0625
r7192 n4960 n5020 1
r7193 n5019 n5020 1.0625
r7194 n4961 n5021 0.043478260869565216
r7195 n5020 n5021 0.75
r7196 n4962 n5022 0.25
r7197 n5021 n5022 0.84375
r7198 n4963 n5023 0.16666666666666666
r7199 n5022 n5023 0.3125
r7200 n4964 n5024 0.20000000000000001
r7201 n5023 n5024 0.34375
r7202 n4965 n5025 1
r7203 n5024 n5025 0.1875
r7204 n4966 n5026 0.076923076923076927
r7205 n5025 n5026 0.4375
r7206 n4967 n5027 0.10000000000000001
r7207 n5026 n5027 0.71875
r7208 n4968 n5028 0.20000000000000001
r7209 n5027 n5028 0.46875
r7210 n4969 n5029 0.20000000000000001
r7211 n5028 n5029 0.3125
r7212 n4970 n5030 1
r7213 n5029 n5030 0.1875
r7214 n4971 n5031 0.33333333333333331
r7215 n5030 n5031 0.125
r7216 n4972 n5032 1
r7217 n5031 n5032 0.125
r7218 n4973 n5033 0.1111111111111111
r7219 n5032 n5033 0.3125
r7220 n4974 n5034 0.10000000000000001
r7221 n5033 n5034 0.59375
r7222 n4975 n5035 0.20000000000000001
r7223 n5034 n5035 0.46875
r7224 n4976 n5036 0.20000000000000001
r7225 n5035 n5036 0.3125
r7226 n4977 n5037 1
r7227 n5036 n5037 0.1875
r7228 n4978 n5038 0.5
r7229 n5037 n5038 0.09375
r7230 n4979 n5039 1
r7231 n5038 n5039 0.09375
r7232 n4980 n5040 1
r7233 n5039 n5040 0.0625
r7234 n4981 n5041 1
r7235 n5040 n5041 0.0625
r7236 n4982 n5042 0.25
r7237 n5041 n5042 0.15625
r7238 n4983 n5043 0.20000000000000001
r7239 n5042 n5043 0.28125
r7240 n4984 n5044 1
r7241 n5043 n5044 0.1875
r7242 n4985 n5045 0.10000000000000001
r7243 n5044 n5045 0.34375
r7244 n4986 n5046 0.20000000000000001
r7245 n4987 n5047 0.16666666666666666
r7246 n5046 n5047 0.34375
r7247 n4988 n5048 0.5
r7248 n5047 n5048 0.25
r7249 n4989 n5049 0.058823529411764705
r7250 n5048 n5049 0.59375
r7251 n4990 n5050 0.076923076923076927
r7252 n5049 n5050 0.9375
r7253 n4991 n5051 0.5
r7254 n5050 n5051 0.46875
r7255 n4992 n5052 0.5
r7256 n5051 n5052 0.125
r7257 n4993 n5053 0.25
r7258 n5052 n5053 0.1875
r7259 n4994 n5054 0.20000000000000001
r7260 n5053 n5054 0.28125
r7261 n4995 n5055 0.10000000000000001
r7262 n4996 n5056 0.040000000000000001
r7263 n5055 n5056 1.09375
r7264 n4997 n5057 1
r7265 n5056 n5057 0.8125
r7266 n4998 n5058 0.035714285714285712
r7267 n5057 n5058 0.90625
r7268 n4999 n5059 1
r7269 n5058 n5059 0.90625
r7270 n5000 n5060 0.040000000000000001
r7271 n5059 n5060 0.8125
r7272 n5001 n5061 0.10000000000000001
r7273 n5060 n5061 1.09375
r7274 n5002 n5062 0.011363636363636364
r7275 n5003 n5063 0.1875
r7276 n5062 n5063 0.546875
r7277 n5004 n5064 0.012500000000000001
r7278 n5063 n5064 0.5
r7279 n5005 n5065 0.1875
r7280 n5064 n5065 0.5
r7281 n5006 n5066 0.011363636363636364
r7282 n5065 n5066 0.546875
r7283 n5007 n5067 0.037499999999999999
r7284 n5066 n5067 0.671875
r7285 n5008 n5068 0.074999999999999997
r7286 n5067 n5068 0.234375
r7287 n5009 n5069 0.0095177664974619297
r7288 n5068 n5069 0.69374999999999998
r7289 n5010 n5070 0.0095663265306122451
r7290 n5069 n5070 1.2281249999999999
r7291 n5011 n5071 0.0095177664974619297
r7292 n5070 n5071 1.2281249999999999
r7293 n5012 n5072 0.011029411764705883
r7294 n5071 n5072 1.1468750000000001
r7295 n5013 n5073 0.013686131386861315
r7296 n5072 n5073 0.95937499999999998
r7297 n5014 n5074 0.01358695652173913
r7298 n5073 n5074 0.859375
r7299 n5015 n5075 0.011029411764705883
r7300 n5074 n5075 0.96250000000000002
r7301 n5016 n5076 0.028846153846153848
r7302 n5075 n5076 0.734375
r7303 n5017 n5077 0.0093749999999999997
r7304 n5076 n5077 0.828125
r7305 n5018 n5078 0.375
r7306 n5077 n5078 0.640625
r7307 n5019 n5079 0.011363636363636364
r7308 n5078 n5079 0.53125
r7309 n5020 n5080 0.375
r7310 n5079 n5080 0.53125
r7311 n5021 n5081 0.016304347826086956
r7312 n5080 n5081 0.375
r7313 n5022 n5082 0.09375
r7314 n5081 n5082 0.421875
r7315 n5023 n5083 0.0625
r7316 n5082 n5083 0.15625
r7317 n5024 n5084 0.074999999999999997
r7318 n5083 n5084 0.171875
r7319 n5025 n5085 0.375
r7320 n5084 n5085 0.09375
r7321 n5026 n5086 0.028846153846153848
r7322 n5085 n5086 0.21875
r7323 n5027 n5087 0.037499999999999999
r7324 n5086 n5087 0.359375
r7325 n5028 n5088 0.074999999999999997
r7326 n5087 n5088 0.234375
r7327 n5029 n5089 0.074999999999999997
r7328 n5088 n5089 0.15625
r7329 n5030 n5090 0.375
r7330 n5089 n5090 0.09375
r7331 n5031 n5091 0.125
r7332 n5090 n5091 0.0625
r7333 n5032 n5092 0.375
r7334 n5091 n5092 0.0625
r7335 n5033 n5093 0.041666666666666664
r7336 n5092 n5093 0.15625
r7337 n5034 n5094 0.037499999999999999
r7338 n5093 n5094 0.296875
r7339 n5035 n5095 0.074999999999999997
r7340 n5094 n5095 0.234375
r7341 n5036 n5096 0.074999999999999997
r7342 n5095 n5096 0.15625
r7343 n5037 n5097 0.375
r7344 n5096 n5097 0.09375
r7345 n5038 n5098 0.1875
r7346 n5097 n5098 0.046875
r7347 n5039 n5099 0.375
r7348 n5098 n5099 0.046875
r7349 n5040 n5100 0.375
r7350 n5099 n5100 0.03125
r7351 n5041 n5101 0.375
r7352 n5100 n5101 0.03125
r7353 n5042 n5102 0.09375
r7354 n5101 n5102 0.078125
r7355 n5043 n5103 0.074999999999999997
r7356 n5102 n5103 0.140625
r7357 n5044 n5104 0.375
r7358 n5103 n5104 0.09375
r7359 n5045 n5105 0.037499999999999999
r7360 n5104 n5105 0.171875
r7361 n5046 n5106 0.074999999999999997
r7362 n5047 n5107 0.0625
r7363 n5106 n5107 0.171875
r7364 n5048 n5108 0.1875
r7365 n5107 n5108 0.125
r7366 n5049 n5109 0.022058823529411766
r7367 n5108 n5109 0.296875
r7368 n5050 n5110 0.028846153846153848
r7369 n5109 n5110 0.46875
r7370 n5051 n5111 0.1875
r7371 n5110 n5111 0.234375
r7372 n5052 n5112 0.1875
r7373 n5111 n5112 0.0625
r7374 n5053 n5113 0.09375
r7375 n5112 n5113 0.09375
r7376 n5054 n5114 0.074999999999999997
r7377 n5113 n5114 0.140625
r7378 n5055 n5115 0.037499999999999999
r7379 n5056 n5116 0.014999999999999999
r7380 n5115 n5116 0.546875
r7381 n5057 n5117 0.375
r7382 n5116 n5117 0.40625
r7383 n5058 n5118 0.013392857142857142
r7384 n5117 n5118 0.453125
r7385 n5059 n5119 0.375
r7386 n5118 n5119 0.453125
r7387 n5060 n5120 0.014999999999999999
r7388 n5119 n5120 0.40625
r7389 n5061 n5121 0.037499999999999999
r7390 n5120 n5121 0.546875
r7391 n5062 n5122 0.011363636363636364
r7392 n5063 n5123 0.1875
r7393 n5122 n5123 1.09375
r7394 n5064 n5124 0.012500000000000001
r7395 n5123 n5124 1
r7396 n5065 n5125 0.1875
r7397 n5124 n5125 1
r7398 n5066 n5126 0.011363636363636364
r7399 n5125 n5126 1.09375
r7400 n5067 n5127 0.037499999999999999
r7401 n5126 n5127 1.34375
r7402 n5068 n5128 0.074999999999999997
r7403 n5127 n5128 0.46875
r7404 n5069 n5129 0.0095177664974619297
r7405 n5128 n5129 1.3875
r7406 n5070 n5130 0.0095663265306122451
r7407 n5129 n5130 2.4562499999999998
r7408 n5071 n5131 0.0095177664974619297
r7409 n5130 n5131 2.4562499999999998
r7410 n5072 n5132 0.011029411764705883
r7411 n5131 n5132 2.2937500000000002
r7412 n5073 n5133 0.013686131386861315
r7413 n5132 n5133 1.91875
r7414 n5074 n5134 0.01358695652173913
r7415 n5133 n5134 1.71875
r7416 n5075 n5135 0.011029411764705883
r7417 n5134 n5135 1.925
r7418 n5076 n5136 0.028846153846153848
r7419 n5135 n5136 1.46875
r7420 n5077 n5137 0.0093749999999999997
r7421 n5136 n5137 1.65625
r7422 n5078 n5138 0.375
r7423 n5137 n5138 1.28125
r7424 n5079 n5139 0.011363636363636364
r7425 n5138 n5139 1.0625
r7426 n5080 n5140 0.375
r7427 n5139 n5140 1.0625
r7428 n5081 n5141 0.016304347826086956
r7429 n5140 n5141 0.75
r7430 n5082 n5142 0.09375
r7431 n5141 n5142 0.84375
r7432 n5083 n5143 0.0625
r7433 n5142 n5143 0.3125
r7434 n5084 n5144 0.074999999999999997
r7435 n5143 n5144 0.34375
r7436 n5085 n5145 0.375
r7437 n5144 n5145 0.1875
r7438 n5086 n5146 0.028846153846153848
r7439 n5145 n5146 0.4375
r7440 n5087 n5147 0.037499999999999999
r7441 n5146 n5147 0.71875
r7442 n5088 n5148 0.074999999999999997
r7443 n5147 n5148 0.46875
r7444 n5089 n5149 0.074999999999999997
r7445 n5148 n5149 0.3125
r7446 n5090 n5150 0.375
r7447 n5149 n5150 0.1875
r7448 n5091 n5151 0.125
r7449 n5150 n5151 0.125
r7450 n5092 n5152 0.375
r7451 n5151 n5152 0.125
r7452 n5093 n5153 0.041666666666666664
r7453 n5152 n5153 0.3125
r7454 n5094 n5154 0.037499999999999999
r7455 n5153 n5154 0.59375
r7456 n5095 n5155 0.074999999999999997
r7457 n5154 n5155 0.46875
r7458 n5096 n5156 0.074999999999999997
r7459 n5155 n5156 0.3125
r7460 n5097 n5157 0.375
r7461 n5156 n5157 0.1875
r7462 n5098 n5158 0.1875
r7463 n5157 n5158 0.09375
r7464 n5099 n5159 0.375
r7465 n5158 n5159 0.09375
r7466 n5100 n5160 0.375
r7467 n5159 n5160 0.0625
r7468 n5101 n5161 0.375
r7469 n5160 n5161 0.0625
r7470 n5102 n5162 0.09375
r7471 n5161 n5162 0.15625
r7472 n5103 n5163 0.074999999999999997
r7473 n5162 n5163 0.28125
r7474 n5104 n5164 0.375
r7475 n5163 n5164 0.1875
r7476 n5105 n5165 0.037499999999999999
r7477 n5164 n5165 0.34375
r7478 n5106 n5166 0.074999999999999997
r7479 n5107 n5167 0.0625
r7480 n5166 n5167 0.34375
r7481 n5108 n5168 0.1875
r7482 n5167 n5168 0.25
r7483 n5109 n5169 0.022058823529411766
r7484 n5168 n5169 0.59375
r7485 n5110 n5170 0.028846153846153848
r7486 n5169 n5170 0.9375
r7487 n5111 n5171 0.1875
r7488 n5170 n5171 0.46875
r7489 n5112 n5172 0.1875
r7490 n5171 n5172 0.125
r7491 n5113 n5173 0.09375
r7492 n5172 n5173 0.1875
r7493 n5114 n5174 0.074999999999999997
r7494 n5173 n5174 0.28125
r7495 n5115 n5175 0.037499999999999999
r7496 n5116 n5176 0.014999999999999999
r7497 n5175 n5176 1.09375
r7498 n5117 n5177 0.375
r7499 n5176 n5177 0.8125
r7500 n5118 n5178 0.013392857142857142
r7501 n5177 n5178 0.90625
r7502 n5119 n5179 0.375
r7503 n5178 n5179 0.90625
r7504 n5120 n5180 0.014999999999999999
r7505 n5179 n5180 0.8125
r7506 n5121 n5181 0.037499999999999999
r7507 n5180 n5181 1.09375
r7508 n5122 n5182 0.005681818181818182
r7509 n5123 n5183 0.09375
r7510 n5182 n5183 2.1875
r7511 n5124 n5184 0.0062500000000000003
r7512 n5183 n5184 2
r7513 n5125 n5185 0.09375
r7514 n5184 n5185 2
r7515 n5126 n5186 0.005681818181818182
r7516 n5185 n5186 2.1875
r7517 n5127 n5187 0.018749999999999999
r7518 n5186 n5187 2.6875
r7519 n5128 n5188 0.037499999999999999
r7520 n5187 n5188 0.9375
r7521 n5129 n5189 0.0047588832487309649
r7522 n5188 n5189 2.7749999999999999
r7523 n5130 n5190 0.0047831632653061226
r7524 n5189 n5190 4.9124999999999996
r7525 n5131 n5191 0.0047588832487309649
r7526 n5190 n5191 4.9124999999999996
r7527 n5132 n5192 0.0055147058823529415
r7528 n5191 n5192 4.5875000000000004
r7529 n5133 n5193 0.0068430656934306573
r7530 n5192 n5193 3.8374999999999999
r7531 n5134 n5194 0.006793478260869565
r7532 n5193 n5194 3.4375
r7533 n5135 n5195 0.0055147058823529415
r7534 n5194 n5195 3.8500000000000001
r7535 n5136 n5196 0.014423076923076924
r7536 n5195 n5196 2.9375
r7537 n5137 n5197 0.0046874999999999998
r7538 n5196 n5197 3.3125
r7539 n5138 n5198 0.1875
r7540 n5197 n5198 2.5625
r7541 n5139 n5199 0.005681818181818182
r7542 n5198 n5199 2.125
r7543 n5140 n5200 0.1875
r7544 n5199 n5200 2.125
r7545 n5141 n5201 0.008152173913043478
r7546 n5200 n5201 1.5
r7547 n5142 n5202 0.046875
r7548 n5201 n5202 1.6875
r7549 n5143 n5203 0.03125
r7550 n5202 n5203 0.625
r7551 n5144 n5204 0.037499999999999999
r7552 n5203 n5204 0.6875
r7553 n5145 n5205 0.1875
r7554 n5204 n5205 0.375
r7555 n5146 n5206 0.014423076923076924
r7556 n5205 n5206 0.875
r7557 n5147 n5207 0.018749999999999999
r7558 n5206 n5207 1.4375
r7559 n5148 n5208 0.037499999999999999
r7560 n5207 n5208 0.9375
r7561 n5149 n5209 0.037499999999999999
r7562 n5208 n5209 0.625
r7563 n5150 n5210 0.1875
r7564 n5209 n5210 0.375
r7565 n5151 n5211 0.0625
r7566 n5210 n5211 0.25
r7567 n5152 n5212 0.1875
r7568 n5211 n5212 0.25
r7569 n5153 n5213 0.020833333333333332
r7570 n5212 n5213 0.625
r7571 n5154 n5214 0.018749999999999999
r7572 n5213 n5214 1.1875
r7573 n5155 n5215 0.037499999999999999
r7574 n5214 n5215 0.9375
r7575 n5156 n5216 0.037499999999999999
r7576 n5215 n5216 0.625
r7577 n5157 n5217 0.1875
r7578 n5216 n5217 0.375
r7579 n5158 n5218 0.09375
r7580 n5217 n5218 0.1875
r7581 n5159 n5219 0.1875
r7582 n5218 n5219 0.1875
r7583 n5160 n5220 0.1875
r7584 n5219 n5220 0.125
r7585 n5161 n5221 0.1875
r7586 n5220 n5221 0.125
r7587 n5162 n5222 0.046875
r7588 n5221 n5222 0.3125
r7589 n5163 n5223 0.037499999999999999
r7590 n5222 n5223 0.5625
r7591 n5164 n5224 0.1875
r7592 n5223 n5224 0.375
r7593 n5165 n5225 0.018749999999999999
r7594 n5224 n5225 0.6875
r7595 n5166 n5226 0.037499999999999999
r7596 n5167 n5227 0.03125
r7597 n5226 n5227 0.6875
r7598 n5168 n5228 0.09375
r7599 n5227 n5228 0.5
r7600 n5169 n5229 0.011029411764705883
r7601 n5228 n5229 1.1875
r7602 n5170 n5230 0.014423076923076924
r7603 n5229 n5230 1.875
r7604 n5171 n5231 0.09375
r7605 n5230 n5231 0.9375
r7606 n5172 n5232 0.09375
r7607 n5231 n5232 0.25
r7608 n5173 n5233 0.046875
r7609 n5232 n5233 0.375
r7610 n5174 n5234 0.037499999999999999
r7611 n5233 n5234 0.5625
r7612 n5175 n5235 0.018749999999999999
r7613 n5176 n5236 0.0074999999999999997
r7614 n5235 n5236 2.1875
r7615 n5177 n5237 0.1875
r7616 n5236 n5237 1.625
r7617 n5178 n5238 0.0066964285714285711
r7618 n5237 n5238 1.8125
r7619 n5179 n5239 0.1875
r7620 n5238 n5239 1.8125
r7621 n5180 n5240 0.0074999999999999997
r7622 n5239 n5240 1.625
r7623 n5181 n5241 0.018749999999999999
r7624 n5240 n5241 2.1875
r7625 n5182 n5242 0.00946969696969697
r7626 n5183 n5243 0.15625
r7627 n5242 n5243 0.546875
r7628 n5184 n5244 0.010416666666666666
r7629 n5243 n5244 0.5
r7630 n5185 n5245 0.15625
r7631 n5244 n5245 0.5
r7632 n5186 n5246 0.00946969696969697
r7633 n5245 n5246 0.546875
r7634 n5187 n5247 0.03125
r7635 n5246 n5247 0.671875
r7636 n5188 n5248 0.0625
r7637 n5247 n5248 0.234375
r7638 n5189 n5249 0.0079314720812182736
r7639 n5248 n5249 0.69374999999999998
r7640 n5190 n5250 0.0079719387755102043
r7641 n5249 n5250 1.2281249999999999
r7642 n5191 n5251 0.0079314720812182736
r7643 n5250 n5251 1.2281249999999999
r7644 n5192 n5252 0.0091911764705882356
r7645 n5251 n5252 1.1468750000000001
r7646 n5193 n5253 0.011405109489051095
r7647 n5252 n5253 0.95937499999999998
r7648 n5194 n5254 0.011322463768115942
r7649 n5253 n5254 0.859375
r7650 n5195 n5255 0.0091911764705882356
r7651 n5254 n5255 0.96250000000000002
r7652 n5196 n5256 0.02403846153846154
r7653 n5255 n5256 0.734375
r7654 n5197 n5257 0.0078125
r7655 n5256 n5257 0.828125
r7656 n5198 n5258 0.3125
r7657 n5257 n5258 0.640625
r7658 n5199 n5259 0.00946969696969697
r7659 n5258 n5259 0.53125
r7660 n5200 n5260 0.3125
r7661 n5259 n5260 0.53125
r7662 n5201 n5261 0.01358695652173913
r7663 n5260 n5261 0.375
r7664 n5202 n5262 0.078125
r7665 n5261 n5262 0.421875
r7666 n5203 n5263 0.052083333333333336
r7667 n5262 n5263 0.15625
r7668 n5204 n5264 0.0625
r7669 n5263 n5264 0.171875
r7670 n5205 n5265 0.3125
r7671 n5264 n5265 0.09375
r7672 n5206 n5266 0.02403846153846154
r7673 n5265 n5266 0.21875
r7674 n5207 n5267 0.03125
r7675 n5266 n5267 0.359375
r7676 n5208 n5268 0.0625
r7677 n5267 n5268 0.234375
r7678 n5209 n5269 0.0625
r7679 n5268 n5269 0.15625
r7680 n5210 n5270 0.3125
r7681 n5269 n5270 0.09375
r7682 n5211 n5271 0.10416666666666667
r7683 n5270 n5271 0.0625
r7684 n5212 n5272 0.3125
r7685 n5271 n5272 0.0625
r7686 n5213 n5273 0.034722222222222224
r7687 n5272 n5273 0.15625
r7688 n5214 n5274 0.03125
r7689 n5273 n5274 0.296875
r7690 n5215 n5275 0.0625
r7691 n5274 n5275 0.234375
r7692 n5216 n5276 0.0625
r7693 n5275 n5276 0.15625
r7694 n5217 n5277 0.3125
r7695 n5276 n5277 0.09375
r7696 n5218 n5278 0.15625
r7697 n5277 n5278 0.046875
r7698 n5219 n5279 0.3125
r7699 n5278 n5279 0.046875
r7700 n5220 n5280 0.3125
r7701 n5279 n5280 0.03125
r7702 n5221 n5281 0.3125
r7703 n5280 n5281 0.03125
r7704 n5222 n5282 0.078125
r7705 n5281 n5282 0.078125
r7706 n5223 n5283 0.0625
r7707 n5282 n5283 0.140625
r7708 n5224 n5284 0.3125
r7709 n5283 n5284 0.09375
r7710 n5225 n5285 0.03125
r7711 n5284 n5285 0.171875
r7712 n5286 n5287 0.1875
r7713 n5226 n5288 0.0625
r7714 n5287 n5288 0.203125
r7715 n5227 n5289 0.052083333333333336
r7716 n5288 n5289 0.171875
r7717 n5228 n5290 0.15625
r7718 n5289 n5290 0.125
r7719 n5229 n5291 0.018382352941176471
r7720 n5290 n5291 0.296875
r7721 n5230 n5292 0.02403846153846154
r7722 n5291 n5292 0.46875
r7723 n5231 n5293 0.15625
r7724 n5292 n5293 0.234375
r7725 n5232 n5294 0.15625
r7726 n5293 n5294 0.0625
r7727 n5233 n5295 0.078125
r7728 n5294 n5295 0.09375
r7729 n5234 n5296 0.0625
r7730 n5295 n5296 0.140625
r7731 n5296 n5297 0.203125
r7732 n5297 n5298 0.1875
r7733 n5235 n5299 0.03125
r7734 n5236 n5300 0.012500000000000001
r7735 n5299 n5300 0.546875
r7736 n5237 n5301 0.3125
r7737 n5300 n5301 0.40625
r7738 n5238 n5302 0.011160714285714286
r7739 n5301 n5302 0.453125
r7740 n5239 n5303 0.3125
r7741 n5302 n5303 0.453125
r7742 n5240 n5304 0.012500000000000001
r7743 n5303 n5304 0.40625
r7744 n5241 n5305 0.03125
r7745 n5304 n5305 0.546875
r7746 n5242 n5306 0.011363636363636364
r7747 n5243 n5307 0.1875
r7748 n5306 n5307 1.09375
r7749 n5244 n5308 0.012500000000000001
r7750 n5307 n5308 1
r7751 n5245 n5309 0.1875
r7752 n5308 n5309 1
r7753 n5246 n5310 0.011363636363636364
r7754 n5309 n5310 1.09375
r7755 n5267 n5311 0.037499999999999999
r7756 n5268 n5312 0.074999999999999997
r7757 n5311 n5312 0.46875
r7758 n5269 n5313 0.074999999999999997
r7759 n5312 n5313 0.3125
r7760 n5270 n5314 0.375
r7761 n5313 n5314 0.1875
r7762 n5271 n5315 0.125
r7763 n5314 n5315 0.125
r7764 n5272 n5316 0.375
r7765 n5315 n5316 0.125
r7766 n5273 n5317 0.041666666666666664
r7767 n5316 n5317 0.3125
r7768 n5274 n5318 0.037499999999999999
r7769 n5317 n5318 0.59375
r7770 n5275 n5319 0.074999999999999997
r7771 n5318 n5319 0.46875
r7772 n5276 n5320 0.074999999999999997
r7773 n5319 n5320 0.3125
r7774 n5277 n5321 0.375
r7775 n5320 n5321 0.1875
r7776 n5278 n5322 0.1875
r7777 n5321 n5322 0.09375
r7778 n5279 n5323 0.375
r7779 n5322 n5323 0.09375
r7780 n5280 n5324 0.375
r7781 n5323 n5324 0.0625
r7782 n5281 n5325 0.375
r7783 n5324 n5325 0.0625
r7784 n5282 n5326 0.09375
r7785 n5325 n5326 0.15625
r7786 n5283 n5327 0.074999999999999997
r7787 n5326 n5327 0.28125
r7788 n5284 n5328 0.375
r7789 n5327 n5328 0.1875
r7790 n5285 n5329 0.037499999999999999
r7791 n5328 n5329 0.34375
r7792 n5286 n5330 0.09375
r7793 n5287 n5331 0.046875
r7794 n5330 n5331 0.375
r7795 n5288 n5332 0.074999999999999997
r7796 n5331 n5332 0.40625
r7797 n5289 n5333 0.0625
r7798 n5332 n5333 0.34375
r7799 n5290 n5334 0.1875
r7800 n5333 n5334 0.25
r7801 n5291 n5335 0.022058823529411766
r7802 n5334 n5335 0.59375
r7803 n5292 n5336 0.028846153846153848
r7804 n5335 n5336 0.9375
r7805 n5293 n5337 0.1875
r7806 n5336 n5337 0.46875
r7807 n5294 n5338 0.1875
r7808 n5337 n5338 0.125
r7809 n5295 n5339 0.09375
r7810 n5338 n5339 0.1875
r7811 n5296 n5340 0.074999999999999997
r7812 n5339 n5340 0.28125
r7813 n5297 n5341 0.046875
r7814 n5340 n5341 0.40625
r7815 n5298 n5342 0.09375
r7816 n5341 n5342 0.375
r7817 n5299 n5343 0.037499999999999999
r7818 n5300 n5344 0.014999999999999999
r7819 n5343 n5344 1.09375
r7820 n5301 n5345 0.375
r7821 n5344 n5345 0.8125
r7822 n5302 n5346 0.013392857142857142
r7823 n5345 n5346 0.90625
r7824 n5303 n5347 0.375
r7825 n5346 n5347 0.90625
r7826 n5304 n5348 0.014999999999999999
r7827 n5347 n5348 0.8125
r7828 n5305 n5349 0.037499999999999999
r7829 n5348 n5349 1.09375
r7830 n5306 n5350 0.013257575757575758
r7831 n5307 n5351 0.21875
r7832 n5350 n5351 0.4375
r7833 n5308 n5352 0.014583333333333334
r7834 n5351 n5352 0.40000000000000002
r7835 n5309 n5353 0.21875
r7836 n5352 n5353 0.40000000000000002
r7837 n5310 n5354 0.013257575757575758
r7838 n5353 n5354 0.4375
r7839 n5330 n5355 0.109375
r7840 n5331 n5356 0.0546875
r7841 n5355 n5356 0.14999999999999999
r7842 n5332 n5357 0.087499999999999994
r7843 n5356 n5357 0.16250000000000001
r7844 n5333 n5358 0.072916666666666671
r7845 n5357 n5358 0.13750000000000001
r7846 n5334 n5359 0.21875
r7847 n5358 n5359 0.10000000000000001
r7848 n5335 n5360 0.025735294117647058
r7849 n5359 n5360 0.23749999999999999
r7850 n5336 n5361 0.033653846153846152
r7851 n5360 n5361 0.375
r7852 n5337 n5362 0.21875
r7853 n5361 n5362 0.1875
r7854 n5338 n5363 0.21875
r7855 n5362 n5363 0.050000000000000003
r7856 n5339 n5364 0.109375
r7857 n5363 n5364 0.074999999999999997
r7858 n5340 n5365 0.087499999999999994
r7859 n5364 n5365 0.1125
r7860 n5341 n5366 0.0546875
r7861 n5365 n5366 0.16250000000000001
r7862 n5342 n5367 0.109375
r7863 n5366 n5367 0.14999999999999999
r7864 n5343 n5368 0.043749999999999997
r7865 n5344 n5369 0.017500000000000002
r7866 n5368 n5369 0.4375
r7867 n5345 n5370 0.4375
r7868 n5369 n5370 0.32500000000000001
r7869 n5346 n5371 0.015625
r7870 n5370 n5371 0.36249999999999999
r7871 n5347 n5372 0.4375
r7872 n5371 n5372 0.36249999999999999
r7873 n5348 n5373 0.017500000000000002
r7874 n5372 n5373 0.32500000000000001
r7875 n5349 n5374 0.043749999999999997
r7876 n5373 n5374 0.4375
r7877 n5350 n5375 0.013257575757575758
r7878 n5351 n5376 0.21875
r7879 n5375 n5376 1.09375
r7880 n5352 n5377 0.014583333333333334
r7881 n5376 n5377 1
r7882 n5353 n5378 0.21875
r7883 n5377 n5378 1
r7884 n5354 n5379 0.013257575757575758
r7885 n5378 n5379 1.09375
r7886 n5355 n5380 0.109375
r7887 n5356 n5381 0.0546875
r7888 n5380 n5381 0.375
r7889 n5357 n5382 0.087499999999999994
r7890 n5381 n5382 0.40625
r7891 n5358 n5383 0.072916666666666671
r7892 n5382 n5383 0.34375
r7893 n5359 n5384 0.21875
r7894 n5383 n5384 0.25
r7895 n5360 n5385 0.025735294117647058
r7896 n5384 n5385 0.59375
r7897 n5361 n5386 0.033653846153846152
r7898 n5385 n5386 0.9375
r7899 n5362 n5387 0.21875
r7900 n5386 n5387 0.46875
r7901 n5363 n5388 0.21875
r7902 n5387 n5388 0.125
r7903 n5364 n5389 0.109375
r7904 n5388 n5389 0.1875
r7905 n5365 n5390 0.087499999999999994
r7906 n5389 n5390 0.28125
r7907 n5366 n5391 0.0546875
r7908 n5390 n5391 0.40625
r7909 n5367 n5392 0.109375
r7910 n5391 n5392 0.375
r7911 n5368 n5393 0.043749999999999997
r7912 n5369 n5394 0.017500000000000002
r7913 n5393 n5394 1.09375
r7914 n5370 n5395 0.4375
r7915 n5394 n5395 0.8125
r7916 n5371 n5396 0.015625
r7917 n5395 n5396 0.90625
r7918 n5372 n5397 0.4375
r7919 n5396 n5397 0.90625
r7920 n5373 n5398 0.017500000000000002
r7921 n5397 n5398 0.8125
r7922 n5374 n5399 0.043749999999999997
r7923 n5398 n5399 1.09375
r7924 n5375 n5400 0.007575757575757576
r7925 n5376 n5401 0.125
r7926 n5400 n5401 1.09375
r7927 n5377 n5402 0.0083333333333333332
r7928 n5401 n5402 1
r7929 n5378 n5403 0.125
r7930 n5402 n5403 1
r7931 n5379 n5404 0.007575757575757576
r7932 n5403 n5404 1.09375
r7933 n5380 n5405 0.0625
r7934 n5381 n5406 0.03125
r7935 n5405 n5406 0.375
r7936 n5382 n5407 0.050000000000000003
r7937 n5406 n5407 0.40625
r7938 n5383 n5408 0.041666666666666664
r7939 n5407 n5408 0.34375
r7940 n5384 n5409 0.125
r7941 n5408 n5409 0.25
r7942 n5385 n5410 0.014705882352941176
r7943 n5409 n5410 0.59375
r7944 n5386 n5411 0.019230769230769232
r7945 n5410 n5411 0.9375
r7946 n5387 n5412 0.125
r7947 n5411 n5412 0.46875
r7948 n5388 n5413 0.125
r7949 n5412 n5413 0.125
r7950 n5389 n5414 0.0625
r7951 n5413 n5414 0.1875
r7952 n5390 n5415 0.050000000000000003
r7953 n5414 n5415 0.28125
r7954 n5391 n5416 0.03125
r7955 n5415 n5416 0.40625
r7956 n5392 n5417 0.0625
r7957 n5416 n5417 0.375
r7958 n5393 n5418 0.025000000000000001
r7959 n5394 n5419 0.01
r7960 n5418 n5419 1.09375
r7961 n5395 n5420 0.25
r7962 n5419 n5420 0.8125
r7963 n5396 n5421 0.0089285714285714281
r7964 n5420 n5421 0.90625
r7965 n5397 n5422 0.25
r7966 n5421 n5422 0.90625
r7967 n5398 n5423 0.01
r7968 n5422 n5423 0.8125
r7969 n5399 n5424 0.025000000000000001
r7970 n5423 n5424 1.09375
r7971 n5400 n5425 0.056818181818181816
r7972 n5401 n5426 0.9375
r7973 n5425 n5426 0.078125
r7974 n5402 n5427 0.0625
r7975 n5426 n5427 0.071428571428571425
r7976 n5403 n5428 0.9375
r7977 n5427 n5428 0.071428571428571425
r7978 n5404 n5429 0.056818181818181816
r7979 n5428 n5429 0.078125
r7980 n5405 n5430 0.46875
r7981 n5406 n5431 0.234375
r7982 n5430 n5431 0.026785714285714284
r7983 n5407 n5432 0.375
r7984 n5431 n5432 0.029017857142857144
r7985 n5408 n5433 0.3125
r7986 n5432 n5433 0.024553571428571428
r7987 n5409 n5434 0.9375
r7988 n5433 n5434 0.017857142857142856
r7989 n5410 n5435 0.11029411764705882
r7990 n5434 n5435 0.042410714285714288
r7991 n5411 n5436 0.14423076923076922
r7992 n5435 n5436 0.066964285714285712
r7993 n5412 n5437 0.9375
r7994 n5436 n5437 0.033482142857142856
r7995 n5413 n5438 0.9375
r7996 n5437 n5438 0.0089285714285714281
r7997 n5414 n5439 0.46875
r7998 n5438 n5439 0.013392857142857142
r7999 n5415 n5440 0.375
r8000 n5439 n5440 0.020089285714285716
r8001 n5416 n5441 0.234375
r8002 n5440 n5441 0.029017857142857144
r8003 n5417 n5442 0.46875
r8004 n5441 n5442 0.026785714285714284
r8005 n5418 n5443 0.1875
r8006 n5419 n5444 0.074999999999999997
r8007 n5443 n5444 0.078125
r8008 n5420 n5445 1.875
r8009 n5444 n5445 0.058035714285714288
r8010 n5421 n5446 0.066964285714285712
r8011 n5445 n5446 0.064732142857142863
r8012 n5422 n5447 1.875
r8013 n5446 n5447 0.064732142857142863
r8014 n5423 n5448 0.074999999999999997
r8015 n5447 n5448 0.058035714285714288
r8016 n5424 n5449 0.1875
r8017 n5448 n5449 0.078125
r8018 n5425 n5450 0.056818181818181816
r8019 n5426 n5451 0.9375
r8020 n5450 n5451 1.09375
r8021 n5427 n5452 0.0625
r8022 n5451 n5452 1
r8023 n5428 n5453 0.9375
r8024 n5452 n5453 1
r8025 n5429 n5454 0.056818181818181816
r8026 n5453 n5454 1.09375
r8027 n5455 n5456 0.46875
r8028 n5456 n5457 0.3125
r8029 n5457 n5458 0.1875
r8030 n5458 n5459 0.125
r8031 n5459 n5460 0.125
r8032 n5460 n5461 0.3125
r8033 n5461 n5462 0.59375
r8034 n5462 n5463 0.46875
r8035 n5463 n5464 0.3125
r8036 n5464 n5465 0.1875
r8037 n5465 n5466 0.09375
r8038 n5466 n5467 0.09375
r8039 n5467 n5468 0.0625
r8040 n5468 n5469 0.0625
r8041 n5469 n5470 0.15625
r8042 n5470 n5471 0.28125
r8043 n5471 n5472 0.1875
r8044 n5472 n5473 0.34375
r8045 n5430 n5474 0.46875
r8046 n5431 n5475 0.234375
r8047 n5474 n5475 0.375
r8048 n5432 n5476 0.375
r8049 n5475 n5476 0.40625
r8050 n5433 n5477 0.3125
r8051 n5476 n5477 0.34375
r8052 n5434 n5478 0.9375
r8053 n5477 n5478 0.25
r8054 n5435 n5479 0.11029411764705882
r8055 n5478 n5479 0.59375
r8056 n5436 n5480 0.14423076923076922
r8057 n5479 n5480 0.9375
r8058 n5437 n5481 0.9375
r8059 n5480 n5481 0.46875
r8060 n5438 n5482 0.9375
r8061 n5481 n5482 0.125
r8062 n5439 n5483 0.46875
r8063 n5482 n5483 0.1875
r8064 n5440 n5484 0.375
r8065 n5483 n5484 0.28125
r8066 n5441 n5485 0.234375
r8067 n5484 n5485 0.40625
r8068 n5442 n5486 0.46875
r8069 n5485 n5486 0.375
r8070 n5443 n5487 0.1875
r8071 n5444 n5488 0.074999999999999997
r8072 n5487 n5488 1.09375
r8073 n5445 n5489 1.875
r8074 n5488 n5489 0.8125
r8075 n5446 n5490 0.066964285714285712
r8076 n5489 n5490 0.90625
r8077 n5447 n5491 1.875
r8078 n5490 n5491 0.90625
r8079 n5448 n5492 0.074999999999999997
r8080 n5491 n5492 0.8125
r8081 n5449 n5493 0.1875
r8082 n5492 n5493 1.09375
r8083 n5450 n5494 0.007575757575757576
r8084 n5451 n5495 0.125
r8085 n5494 n5495 1.09375
r8086 n5452 n5496 0.0083333333333333332
r8087 n5495 n5496 1
r8088 n5453 n5497 0.125
r8089 n5496 n5497 1
r8090 n5454 n5498 0.007575757575757576
r8091 n5497 n5498 1.09375
r8092 n5455 n5499 0.025000000000000001
r8093 n5456 n5500 0.050000000000000003
r8094 n5499 n5500 0.46875
r8095 n5457 n5501 0.050000000000000003
r8096 n5500 n5501 0.3125
r8097 n5458 n5502 0.25
r8098 n5501 n5502 0.1875
r8099 n5459 n5503 0.083333333333333329
r8100 n5502 n5503 0.125
r8101 n5460 n5504 0.25
r8102 n5503 n5504 0.125
r8103 n5461 n5505 0.027777777777777776
r8104 n5504 n5505 0.3125
r8105 n5462 n5506 0.025000000000000001
r8106 n5505 n5506 0.59375
r8107 n5463 n5507 0.050000000000000003
r8108 n5506 n5507 0.46875
r8109 n5464 n5508 0.050000000000000003
r8110 n5507 n5508 0.3125
r8111 n5465 n5509 0.25
r8112 n5508 n5509 0.1875
r8113 n5466 n5510 0.125
r8114 n5509 n5510 0.09375
r8115 n5467 n5511 0.25
r8116 n5510 n5511 0.09375
r8117 n5468 n5512 0.25
r8118 n5511 n5512 0.0625
r8119 n5469 n5513 0.25
r8120 n5512 n5513 0.0625
r8121 n5470 n5514 0.0625
r8122 n5513 n5514 0.15625
r8123 n5471 n5515 0.050000000000000003
r8124 n5514 n5515 0.28125
r8125 n5472 n5516 0.25
r8126 n5515 n5516 0.1875
r8127 n5473 n5517 0.025000000000000001
r8128 n5516 n5517 0.34375
r8129 n5474 n5518 0.0625
r8130 n5475 n5519 0.03125
r8131 n5518 n5519 0.375
r8132 n5476 n5520 0.050000000000000003
r8133 n5519 n5520 0.40625
r8134 n5477 n5521 0.041666666666666664
r8135 n5520 n5521 0.34375
r8136 n5478 n5522 0.125
r8137 n5521 n5522 0.25
r8138 n5479 n5523 0.014705882352941176
r8139 n5522 n5523 0.59375
r8140 n5480 n5524 0.019230769230769232
r8141 n5523 n5524 0.9375
r8142 n5481 n5525 0.125
r8143 n5524 n5525 0.46875
r8144 n5482 n5526 0.125
r8145 n5525 n5526 0.125
r8146 n5483 n5527 0.0625
r8147 n5526 n5527 0.1875
r8148 n5484 n5528 0.050000000000000003
r8149 n5527 n5528 0.28125
r8150 n5485 n5529 0.03125
r8151 n5528 n5529 0.40625
r8152 n5486 n5530 0.0625
r8153 n5529 n5530 0.375
r8154 n5487 n5531 0.025000000000000001
r8155 n5488 n5532 0.01
r8156 n5531 n5532 1.09375
r8157 n5489 n5533 0.25
r8158 n5532 n5533 0.8125
r8159 n5490 n5534 0.0089285714285714281
r8160 n5533 n5534 0.90625
r8161 n5491 n5535 0.25
r8162 n5534 n5535 0.90625
r8163 n5492 n5536 0.01
r8164 n5535 n5536 0.8125
r8165 n5493 n5537 0.025000000000000001
r8166 n5536 n5537 1.09375
r8167 n5494 n5538 0.007575757575757576
r8168 n5495 n5539 0.125
r8169 n5538 n5539 1.09375
r8170 n5496 n5540 0.0083333333333333332
r8171 n5539 n5540 1
r8172 n5497 n5541 0.125
r8173 n5540 n5541 1
r8174 n5498 n5542 0.007575757575757576
r8175 n5541 n5542 1.09375
r8176 n5499 n5543 0.025000000000000001
r8177 n5500 n5544 0.050000000000000003
r8178 n5543 n5544 0.46875
r8179 n5501 n5545 0.050000000000000003
r8180 n5544 n5545 0.3125
r8181 n5502 n5546 0.25
r8182 n5545 n5546 0.1875
r8183 n5503 n5547 0.083333333333333329
r8184 n5546 n5547 0.125
r8185 n5504 n5548 0.25
r8186 n5547 n5548 0.125
r8187 n5505 n5549 0.027777777777777776
r8188 n5548 n5549 0.3125
r8189 n5506 n5550 0.025000000000000001
r8190 n5549 n5550 0.59375
r8191 n5507 n5551 0.050000000000000003
r8192 n5550 n5551 0.46875
r8193 n5508 n5552 0.050000000000000003
r8194 n5551 n5552 0.3125
r8195 n5509 n5553 0.25
r8196 n5552 n5553 0.1875
r8197 n5510 n5554 0.125
r8198 n5553 n5554 0.09375
r8199 n5511 n5555 0.25
r8200 n5554 n5555 0.09375
r8201 n5512 n5556 0.25
r8202 n5555 n5556 0.0625
r8203 n5513 n5557 0.25
r8204 n5556 n5557 0.0625
r8205 n5514 n5558 0.0625
r8206 n5557 n5558 0.15625
r8207 n5515 n5559 0.050000000000000003
r8208 n5558 n5559 0.28125
r8209 n5516 n5560 0.25
r8210 n5559 n5560 0.1875
r8211 n5517 n5561 0.025000000000000001
r8212 n5560 n5561 0.34375
r8213 n5518 n5562 0.0625
r8214 n5519 n5563 0.03125
r8215 n5562 n5563 0.375
r8216 n5520 n5564 0.050000000000000003
r8217 n5563 n5564 0.40625
r8218 n5521 n5565 0.041666666666666664
r8219 n5564 n5565 0.34375
r8220 n5522 n5566 0.125
r8221 n5565 n5566 0.25
r8222 n5523 n5567 0.014705882352941176
r8223 n5566 n5567 0.59375
r8224 n5524 n5568 0.019230769230769232
r8225 n5567 n5568 0.9375
r8226 n5525 n5569 0.125
r8227 n5568 n5569 0.46875
r8228 n5526 n5570 0.125
r8229 n5569 n5570 0.125
r8230 n5527 n5571 0.0625
r8231 n5570 n5571 0.1875
r8232 n5528 n5572 0.050000000000000003
r8233 n5571 n5572 0.28125
r8234 n5529 n5573 0.03125
r8235 n5572 n5573 0.40625
r8236 n5530 n5574 0.0625
r8237 n5573 n5574 0.375
r8238 n5531 n5575 0.025000000000000001
r8239 n5532 n5576 0.01
r8240 n5575 n5576 1.09375
r8241 n5533 n5577 0.25
r8242 n5576 n5577 0.8125
r8243 n5534 n5578 0.0089285714285714281
r8244 n5577 n5578 0.90625
r8245 n5535 n5579 0.25
r8246 n5578 n5579 0.90625
r8247 n5536 n5580 0.01
r8248 n5579 n5580 0.8125
r8249 n5537 n5581 0.025000000000000001
r8250 n5580 n5581 1.09375
r8251 n5538 n5582 0.011363636363636364
r8252 n5539 n5583 0.1875
r8253 n5582 n5583 0.546875
r8254 n5540 n5584 0.012500000000000001
r8255 n5583 n5584 0.5
r8256 n5541 n5585 0.1875
r8257 n5584 n5585 0.5
r8258 n5542 n5586 0.011363636363636364
r8259 n5585 n5586 0.546875
r8260 n5543 n5587 0.037499999999999999
r8261 n5544 n5588 0.074999999999999997
r8262 n5587 n5588 0.234375
r8263 n5545 n5589 0.074999999999999997
r8264 n5588 n5589 0.15625
r8265 n5546 n5590 0.375
r8266 n5589 n5590 0.09375
r8267 n5547 n5591 0.125
r8268 n5590 n5591 0.0625
r8269 n5548 n5592 0.375
r8270 n5591 n5592 0.0625
r8271 n5549 n5593 0.041666666666666664
r8272 n5592 n5593 0.15625
r8273 n5550 n5594 0.037499999999999999
r8274 n5593 n5594 0.296875
r8275 n5551 n5595 0.074999999999999997
r8276 n5594 n5595 0.234375
r8277 n5552 n5596 0.074999999999999997
r8278 n5595 n5596 0.15625
r8279 n5553 n5597 0.375
r8280 n5596 n5597 0.09375
r8281 n5554 n5598 0.1875
r8282 n5597 n5598 0.046875
r8283 n5555 n5599 0.375
r8284 n5598 n5599 0.046875
r8285 n5556 n5600 0.375
r8286 n5599 n5600 0.03125
r8287 n5557 n5601 0.375
r8288 n5600 n5601 0.03125
r8289 n5558 n5602 0.09375
r8290 n5601 n5602 0.078125
r8291 n5559 n5603 0.074999999999999997
r8292 n5602 n5603 0.140625
r8293 n5560 n5604 0.375
r8294 n5603 n5604 0.09375
r8295 n5561 n5605 0.037499999999999999
r8296 n5604 n5605 0.171875
r8297 n5562 n5606 0.09375
r8298 n5563 n5607 0.046875
r8299 n5606 n5607 0.1875
r8300 n5564 n5608 0.074999999999999997
r8301 n5607 n5608 0.203125
r8302 n5565 n5609 0.0625
r8303 n5608 n5609 0.171875
r8304 n5566 n5610 0.1875
r8305 n5609 n5610 0.125
r8306 n5567 n5611 0.022058823529411766
r8307 n5610 n5611 0.296875
r8308 n5568 n5612 0.028846153846153848
r8309 n5611 n5612 0.46875
r8310 n5569 n5613 0.1875
r8311 n5612 n5613 0.234375
r8312 n5570 n5614 0.1875
r8313 n5613 n5614 0.0625
r8314 n5571 n5615 0.09375
r8315 n5614 n5615 0.09375
r8316 n5572 n5616 0.074999999999999997
r8317 n5615 n5616 0.140625
r8318 n5573 n5617 0.046875
r8319 n5616 n5617 0.203125
r8320 n5574 n5618 0.09375
r8321 n5617 n5618 0.1875
r8322 n5575 n5619 0.037499999999999999
r8323 n5576 n5620 0.014999999999999999
r8324 n5619 n5620 0.546875
r8325 n5577 n5621 0.375
r8326 n5620 n5621 0.40625
r8327 n5578 n5622 0.013392857142857142
r8328 n5621 n5622 0.453125
r8329 n5579 n5623 0.375
r8330 n5622 n5623 0.453125
r8331 n5580 n5624 0.014999999999999999
r8332 n5623 n5624 0.40625
r8333 n5581 n5625 0.037499999999999999
r8334 n5624 n5625 0.546875
r8335 n5582 n5626 0.020833333333333332
r8336 n5583 n5627 0.34375
r8337 n5626 n5627 0.3125
r8338 n5584 n5628 0.022916666666666665
r8339 n5627 n5628 0.2857142857142857
r8340 n5585 n5629 0.34375
r8341 n5628 n5629 0.2857142857142857
r8342 n5586 n5630 0.020833333333333332
r8343 n5629 n5630 0.3125
r8344 n5587 n5631 0.068750000000000006
r8345 n5588 n5632 0.13750000000000001
r8346 n5631 n5632 0.13392857142857142
r8347 n5589 n5633 0.13750000000000001
r8348 n5632 n5633 0.089285714285714288
r8349 n5590 n5634 0.6875
r8350 n5633 n5634 0.053571428571428568
r8351 n5591 n5635 0.22916666666666666
r8352 n5634 n5635 0.035714285714285712
r8353 n5592 n5636 0.6875
r8354 n5635 n5636 0.035714285714285712
r8355 n5593 n5637 0.076388888888888895
r8356 n5636 n5637 0.089285714285714288
r8357 n5594 n5638 0.068750000000000006
r8358 n5637 n5638 0.16964285714285715
r8359 n5595 n5639 0.13750000000000001
r8360 n5638 n5639 0.13392857142857142
r8361 n5596 n5640 0.13750000000000001
r8362 n5639 n5640 0.089285714285714288
r8363 n5597 n5641 0.6875
r8364 n5640 n5641 0.053571428571428568
r8365 n5598 n5642 0.34375
r8366 n5641 n5642 0.026785714285714284
r8367 n5599 n5643 0.6875
r8368 n5642 n5643 0.026785714285714284
r8369 n5600 n5644 0.6875
r8370 n5643 n5644 0.017857142857142856
r8371 n5601 n5645 0.6875
r8372 n5644 n5645 0.017857142857142856
r8373 n5602 n5646 0.171875
r8374 n5645 n5646 0.044642857142857144
r8375 n5603 n5647 0.13750000000000001
r8376 n5646 n5647 0.080357142857142863
r8377 n5604 n5648 0.6875
r8378 n5647 n5648 0.053571428571428568
r8379 n5605 n5649 0.068750000000000006
r8380 n5648 n5649 0.098214285714285712
r8381 n5606 n5650 0.171875
r8382 n5607 n5651 0.0859375
r8383 n5650 n5651 0.10714285714285714
r8384 n5608 n5652 0.13750000000000001
r8385 n5651 n5652 0.11607142857142858
r8386 n5609 n5653 0.11458333333333333
r8387 n5652 n5653 0.098214285714285712
r8388 n5610 n5654 0.34375
r8389 n5653 n5654 0.071428571428571425
r8390 n5611 n5655 0.040441176470588237
r8391 n5654 n5655 0.16964285714285715
r8392 n5612 n5656 0.052884615384615384
r8393 n5655 n5656 0.26785714285714285
r8394 n5613 n5657 0.34375
r8395 n5656 n5657 0.13392857142857142
r8396 n5614 n5658 0.34375
r8397 n5657 n5658 0.035714285714285712
r8398 n5615 n5659 0.171875
r8399 n5658 n5659 0.053571428571428568
r8400 n5616 n5660 0.13750000000000001
r8401 n5659 n5660 0.080357142857142863
r8402 n5617 n5661 0.0859375
r8403 n5660 n5661 0.11607142857142858
r8404 n5618 n5662 0.171875
r8405 n5661 n5662 0.10714285714285714
r8406 n5619 n5663 0.068750000000000006
r8407 n5620 n5664 0.0275
r8408 n5663 n5664 0.3125
r8409 n5621 n5665 0.6875
r8410 n5664 n5665 0.23214285714285715
r8411 n5622 n5666 0.024553571428571428
r8412 n5665 n5666 0.25892857142857145
r8413 n5623 n5667 0.6875
r8414 n5666 n5667 0.25892857142857145
r8415 n5624 n5668 0.0275
r8416 n5667 n5668 0.23214285714285715
r8417 n5625 n5669 0.068750000000000006
r8418 n5668 n5669 0.3125
r8419 n5626 n5670 0.01893939393939394
r8420 n5627 n5671 0.3125
r8421 n5670 n5671 0.72916666666666663
r8422 n5628 n5672 0.020833333333333332
r8423 n5671 n5672 0.66666666666666663
r8424 n5629 n5673 0.3125
r8425 n5672 n5673 0.66666666666666663
r8426 n5630 n5674 0.01893939393939394
r8427 n5673 n5674 0.72916666666666663
r8428 n5631 n5675 0.0625
r8429 n5632 n5676 0.125
r8430 n5675 n5676 0.3125
r8431 n5633 n5677 0.125
r8432 n5676 n5677 0.20833333333333334
r8433 n5634 n5678 0.625
r8434 n5677 n5678 0.125
r8435 n5635 n5679 0.20833333333333334
r8436 n5678 n5679 0.083333333333333329
r8437 n5636 n5680 0.625
r8438 n5679 n5680 0.083333333333333329
r8439 n5637 n5681 0.069444444444444448
r8440 n5680 n5681 0.20833333333333334
r8441 n5638 n5682 0.0625
r8442 n5681 n5682 0.39583333333333331
r8443 n5639 n5683 0.125
r8444 n5682 n5683 0.3125
r8445 n5640 n5684 0.125
r8446 n5683 n5684 0.20833333333333334
r8447 n5641 n5685 0.625
r8448 n5684 n5685 0.125
r8449 n5642 n5686 0.3125
r8450 n5685 n5686 0.0625
r8451 n5643 n5687 0.625
r8452 n5686 n5687 0.0625
r8453 n5644 n5688 0.625
r8454 n5687 n5688 0.041666666666666664
r8455 n5645 n5689 0.625
r8456 n5688 n5689 0.041666666666666664
r8457 n5646 n5690 0.15625
r8458 n5689 n5690 0.10416666666666667
r8459 n5647 n5691 0.125
r8460 n5690 n5691 0.1875
r8461 n5648 n5692 0.625
r8462 n5691 n5692 0.125
r8463 n5649 n5693 0.0625
r8464 n5692 n5693 0.22916666666666666
r8465 n5663 n5694 0.0625
r8466 n5664 n5695 0.025000000000000001
r8467 n5694 n5695 0.72916666666666663
r8468 n5665 n5696 0.625
r8469 n5695 n5696 0.54166666666666663
r8470 n5666 n5697 0.022321428571428572
r8471 n5696 n5697 0.60416666666666663
r8472 n5667 n5698 0.625
r8473 n5697 n5698 0.60416666666666663
r8474 n5668 n5699 0.025000000000000001
r8475 n5698 n5699 0.54166666666666663
r8476 n5669 n5700 0.0625
r8477 n5699 n5700 0.72916666666666663
r8478 n5670 n5701 0.011363636363636364
r8479 n5671 n5702 0.1875
r8480 n5701 n5702 0.72916666666666663
r8481 n5672 n5703 0.012500000000000001
r8482 n5702 n5703 0.66666666666666663
r8483 n5673 n5704 0.1875
r8484 n5703 n5704 0.66666666666666663
r8485 n5674 n5705 0.011363636363636364
r8486 n5704 n5705 0.72916666666666663
r8487 n5675 n5706 0.037499999999999999
r8488 n5676 n5707 0.074999999999999997
r8489 n5706 n5707 0.3125
r8490 n5677 n5708 0.074999999999999997
r8491 n5707 n5708 0.20833333333333334
r8492 n5678 n5709 0.375
r8493 n5708 n5709 0.125
r8494 n5679 n5710 0.125
r8495 n5709 n5710 0.083333333333333329
r8496 n5680 n5711 0.375
r8497 n5710 n5711 0.083333333333333329
r8498 n5681 n5712 0.041666666666666664
r8499 n5711 n5712 0.20833333333333334
r8500 n5682 n5713 0.037499999999999999
r8501 n5712 n5713 0.39583333333333331
r8502 n5683 n5714 0.074999999999999997
r8503 n5713 n5714 0.3125
r8504 n5684 n5715 0.074999999999999997
r8505 n5714 n5715 0.20833333333333334
r8506 n5685 n5716 0.375
r8507 n5715 n5716 0.125
r8508 n5686 n5717 0.1875
r8509 n5716 n5717 0.0625
r8510 n5687 n5718 0.375
r8511 n5717 n5718 0.0625
r8512 n5688 n5719 0.375
r8513 n5718 n5719 0.041666666666666664
r8514 n5689 n5720 0.375
r8515 n5719 n5720 0.041666666666666664
r8516 n5690 n5721 0.09375
r8517 n5720 n5721 0.10416666666666667
r8518 n5691 n5722 0.074999999999999997
r8519 n5721 n5722 0.1875
r8520 n5692 n5723 0.375
r8521 n5722 n5723 0.125
r8522 n5693 n5724 0.037499999999999999
r8523 n5723 n5724 0.22916666666666666
r8524 n5694 n5725 0.037499999999999999
r8525 n5695 n5726 0.014999999999999999
r8526 n5725 n5726 0.72916666666666663
r8527 n5696 n5727 0.375
r8528 n5726 n5727 0.54166666666666663
r8529 n5697 n5728 0.013392857142857142
r8530 n5727 n5728 0.60416666666666663
r8531 n5698 n5729 0.375
r8532 n5728 n5729 0.60416666666666663
r8533 n5699 n5730 0.014999999999999999
r8534 n5729 n5730 0.54166666666666663
r8535 n5700 n5731 0.037499999999999999
r8536 n5730 n5731 0.72916666666666663
r8537 n5701 n5732 0.00946969696969697
r8538 n5702 n5733 0.15625
r8539 n5732 n5733 1.09375
r8540 n5703 n5734 0.010416666666666666
r8541 n5733 n5734 1
r8542 n5704 n5735 0.15625
r8543 n5734 n5735 1
r8544 n5705 n5736 0.00946969696969697
r8545 n5735 n5736 1.09375
r8546 n5706 n5737 0.03125
r8547 n5707 n5738 0.0625
r8548 n5737 n5738 0.46875
r8549 n5708 n5739 0.0625
r8550 n5738 n5739 0.3125
r8551 n5709 n5740 0.3125
r8552 n5739 n5740 0.1875
r8553 n5710 n5741 0.10416666666666667
r8554 n5740 n5741 0.125
r8555 n5711 n5742 0.3125
r8556 n5741 n5742 0.125
r8557 n5712 n5743 0.034722222222222224
r8558 n5742 n5743 0.3125
r8559 n5713 n5744 0.03125
r8560 n5743 n5744 0.59375
r8561 n5714 n5745 0.0625
r8562 n5744 n5745 0.46875
r8563 n5715 n5746 0.0625
r8564 n5745 n5746 0.3125
r8565 n5716 n5747 0.3125
r8566 n5746 n5747 0.1875
r8567 n5717 n5748 0.15625
r8568 n5747 n5748 0.09375
r8569 n5718 n5749 0.3125
r8570 n5748 n5749 0.09375
r8571 n5719 n5750 0.3125
r8572 n5749 n5750 0.0625
r8573 n5720 n5751 0.3125
r8574 n5750 n5751 0.0625
r8575 n5721 n5752 0.078125
r8576 n5751 n5752 0.15625
r8577 n5722 n5753 0.0625
r8578 n5752 n5753 0.28125
r8579 n5723 n5754 0.3125
r8580 n5753 n5754 0.1875
r8581 n5724 n5755 0.03125
r8582 n5754 n5755 0.34375
r8583 n5725 n5756 0.03125
r8584 n5726 n5757 0.012500000000000001
r8585 n5756 n5757 1.09375
r8586 n5727 n5758 0.3125
r8587 n5757 n5758 0.8125
r8588 n5728 n5759 0.011160714285714286
r8589 n5758 n5759 0.90625
r8590 n5729 n5760 0.3125
r8591 n5759 n5760 0.90625
r8592 n5730 n5761 0.012500000000000001
r8593 n5760 n5761 0.8125
r8594 n5731 n5762 0.03125
r8595 n5761 n5762 1.09375
r8596 n5732 n5763 0.032196969696969696
r8597 n5733 n5764 0.53125
r8598 n5763 n5764 0.14583333333333334
r8599 n5734 n5765 0.035416666666666666
r8600 n5764 n5765 0.13333333333333333
r8601 n5735 n5766 0.53125
r8602 n5765 n5766 0.13333333333333333
r8603 n5736 n5767 0.032196969696969696
r8604 n5766 n5767 0.14583333333333334
r8605 n5737 n5768 0.10625
r8606 n5738 n5769 0.21249999999999999
r8607 n5768 n5769 0.0625
r8608 n5739 n5770 0.21249999999999999
r8609 n5769 n5770 0.041666666666666664
r8610 n5740 n5771 1.0625
r8611 n5770 n5771 0.025000000000000001
r8612 n5741 n5772 0.35416666666666669
r8613 n5771 n5772 0.016666666666666666
r8614 n5742 n5773 1.0625
r8615 n5772 n5773 0.016666666666666666
r8616 n5743 n5774 0.11805555555555555
r8617 n5773 n5774 0.041666666666666664
r8618 n5744 n5775 0.10625
r8619 n5774 n5775 0.079166666666666663
r8620 n5745 n5776 0.21249999999999999
r8621 n5775 n5776 0.0625
r8622 n5746 n5777 0.21249999999999999
r8623 n5776 n5777 0.041666666666666664
r8624 n5747 n5778 1.0625
r8625 n5777 n5778 0.025000000000000001
r8626 n5748 n5779 0.53125
r8627 n5778 n5779 0.012500000000000001
r8628 n5749 n5780 1.0625
r8629 n5779 n5780 0.012500000000000001
r8630 n5750 n5781 1.0625
r8631 n5780 n5781 0.0083333333333333332
r8632 n5751 n5782 1.0625
r8633 n5781 n5782 0.0083333333333333332
r8634 n5752 n5783 0.265625
r8635 n5782 n5783 0.020833333333333332
r8636 n5753 n5784 0.21249999999999999
r8637 n5783 n5784 0.037499999999999999
r8638 n5754 n5785 1.0625
r8639 n5784 n5785 0.025000000000000001
r8640 n5755 n5786 0.10625
r8641 n5785 n5786 0.04583333333333333
r8642 n5756 n5787 0.10625
r8643 n5757 n5788 0.042500000000000003
r8644 n5787 n5788 0.14583333333333334
r8645 n5758 n5789 1.0625
r8646 n5788 n5789 0.10833333333333334
r8647 n5759 n5790 0.037946428571428568
r8648 n5789 n5790 0.12083333333333333
r8649 n5760 n5791 1.0625
r8650 n5790 n5791 0.12083333333333333
r8651 n5761 n5792 0.042500000000000003
r8652 n5791 n5792 0.10833333333333334
r8653 n5762 n5793 0.10625
r8654 n5792 n5793 0.14583333333333334
r8655 n5763 n5794 0.056818181818181816
r8656 n5764 n5795 0.9375
r8657 n5794 n5795 0.14583333333333334
r8658 n5765 n5796 0.0625
r8659 n5795 n5796 0.13333333333333333
r8660 n5766 n5797 0.9375
r8661 n5796 n5797 0.13333333333333333
r8662 n5767 n5798 0.056818181818181816
r8663 n5797 n5798 0.14583333333333334
r8664 n5768 n5799 0.1875
r8665 n5769 n5800 0.375
r8666 n5799 n5800 0.0625
r8667 n5770 n5801 0.375
r8668 n5800 n5801 0.041666666666666664
r8669 n5771 n5802 1.875
r8670 n5801 n5802 0.025000000000000001
r8671 n5772 n5803 0.625
r8672 n5802 n5803 0.016666666666666666
r8673 n5773 n5804 1.875
r8674 n5803 n5804 0.016666666666666666
r8675 n5774 n5805 0.20833333333333334
r8676 n5804 n5805 0.041666666666666664
r8677 n5775 n5806 0.1875
r8678 n5805 n5806 0.079166666666666663
r8679 n5776 n5807 0.375
r8680 n5806 n5807 0.0625
r8681 n5777 n5808 0.375
r8682 n5807 n5808 0.041666666666666664
r8683 n5778 n5809 1.875
r8684 n5808 n5809 0.025000000000000001
r8685 n5779 n5810 0.9375
r8686 n5809 n5810 0.012500000000000001
r8687 n5780 n5811 1.875
r8688 n5810 n5811 0.012500000000000001
r8689 n5781 n5812 1.875
r8690 n5811 n5812 0.0083333333333333332
r8691 n5782 n5813 1.875
r8692 n5812 n5813 0.0083333333333333332
r8693 n5783 n5814 0.46875
r8694 n5813 n5814 0.020833333333333332
r8695 n5784 n5815 0.375
r8696 n5814 n5815 0.037499999999999999
r8697 n5785 n5816 1.875
r8698 n5815 n5816 0.025000000000000001
r8699 n5786 n5817 0.1875
r8700 n5816 n5817 0.04583333333333333
r8701 n5787 n5818 0.1875
r8702 n5788 n5819 0.074999999999999997
r8703 n5818 n5819 0.14583333333333334
r8704 n5789 n5820 1.875
r8705 n5819 n5820 0.10833333333333334
r8706 n5790 n5821 0.066964285714285712
r8707 n5820 n5821 0.12083333333333333
r8708 n5791 n5822 1.875
r8709 n5821 n5822 0.12083333333333333
r8710 n5792 n5823 0.074999999999999997
r8711 n5822 n5823 0.10833333333333334
r8712 n5793 n5824 0.1875
r8713 n5823 n5824 0.14583333333333334
r8714 n5794 n5825 0.032196969696969696
r8715 n5795 n5826 0.53125
r8716 n5825 n5826 1.09375
r8717 n5796 n5827 0.035416666666666666
r8718 n5826 n5827 1
r8719 n5797 n5828 0.53125
r8720 n5827 n5828 1
r8721 n5798 n5829 0.032196969696969696
r8722 n5828 n5829 1.09375
r8723 n5799 n5830 0.10625
r8724 n5800 n5831 0.21249999999999999
r8725 n5830 n5831 0.46875
r8726 n5801 n5832 0.21249999999999999
r8727 n5831 n5832 0.3125
r8728 n5802 n5833 1.0625
r8729 n5832 n5833 0.1875
r8730 n5803 n5834 0.35416666666666669
r8731 n5833 n5834 0.125
r8732 n5804 n5835 1.0625
r8733 n5834 n5835 0.125
r8734 n5805 n5836 0.11805555555555555
r8735 n5835 n5836 0.3125
r8736 n5806 n5837 0.10625
r8737 n5836 n5837 0.59375
r8738 n5807 n5838 0.21249999999999999
r8739 n5837 n5838 0.46875
r8740 n5808 n5839 0.21249999999999999
r8741 n5838 n5839 0.3125
r8742 n5809 n5840 1.0625
r8743 n5839 n5840 0.1875
r8744 n5810 n5841 0.53125
r8745 n5840 n5841 0.09375
r8746 n5811 n5842 1.0625
r8747 n5841 n5842 0.09375
r8748 n5812 n5843 1.0625
r8749 n5842 n5843 0.0625
r8750 n5813 n5844 1.0625
r8751 n5843 n5844 0.0625
r8752 n5814 n5845 0.265625
r8753 n5844 n5845 0.15625
r8754 n5815 n5846 0.21249999999999999
r8755 n5845 n5846 0.28125
r8756 n5816 n5847 1.0625
r8757 n5846 n5847 0.1875
r8758 n5817 n5848 0.10625
r8759 n5847 n5848 0.34375
r8760 n5818 n5849 0.10625
r8761 n5819 n5850 0.042500000000000003
r8762 n5849 n5850 1.09375
r8763 n5820 n5851 1.0625
r8764 n5850 n5851 0.8125
r8765 n5821 n5852 0.037946428571428568
r8766 n5851 n5852 0.90625
r8767 n5822 n5853 1.0625
r8768 n5852 n5853 0.90625
r8769 n5823 n5854 0.042500000000000003
r8770 n5853 n5854 0.8125
r8771 n5824 n5855 0.10625
r8772 n5854 n5855 1.09375
r8773 n5825 n5856 0.00946969696969697
r8774 n5826 n5857 0.15625
r8775 n5856 n5857 0.72916666666666663
r8776 n5827 n5858 0.010416666666666666
r8777 n5857 n5858 0.66666666666666663
r8778 n5828 n5859 0.15625
r8779 n5858 n5859 0.66666666666666663
r8780 n5829 n5860 0.00946969696969697
r8781 n5859 n5860 0.72916666666666663
r8782 n5830 n5861 0.03125
r8783 n5831 n5862 0.0625
r8784 n5861 n5862 0.3125
r8785 n5832 n5863 0.0625
r8786 n5862 n5863 0.20833333333333334
r8787 n5833 n5864 0.3125
r8788 n5863 n5864 0.125
r8789 n5834 n5865 0.10416666666666667
r8790 n5864 n5865 0.083333333333333329
r8791 n5835 n5866 0.3125
r8792 n5865 n5866 0.083333333333333329
r8793 n5836 n5867 0.034722222222222224
r8794 n5866 n5867 0.20833333333333334
r8795 n5837 n5868 0.03125
r8796 n5867 n5868 0.39583333333333331
r8797 n5838 n5869 0.0625
r8798 n5868 n5869 0.3125
r8799 n5839 n5870 0.0625
r8800 n5869 n5870 0.20833333333333334
r8801 n5840 n5871 0.3125
r8802 n5870 n5871 0.125
r8803 n5841 n5872 0.15625
r8804 n5871 n5872 0.0625
r8805 n5842 n5873 0.3125
r8806 n5872 n5873 0.0625
r8807 n5843 n5874 0.3125
r8808 n5873 n5874 0.041666666666666664
r8809 n5844 n5875 0.3125
r8810 n5874 n5875 0.041666666666666664
r8811 n5845 n5876 0.078125
r8812 n5875 n5876 0.10416666666666667
r8813 n5846 n5877 0.0625
r8814 n5876 n5877 0.1875
r8815 n5847 n5878 0.3125
r8816 n5877 n5878 0.125
r8817 n5848 n5879 0.03125
r8818 n5878 n5879 0.22916666666666666
r8819 n5849 n5880 0.03125
r8820 n5850 n5881 0.012500000000000001
r8821 n5880 n5881 0.72916666666666663
r8822 n5851 n5882 0.3125
r8823 n5881 n5882 0.54166666666666663
r8824 n5852 n5883 0.011160714285714286
r8825 n5882 n5883 0.60416666666666663
r8826 n5853 n5884 0.3125
r8827 n5883 n5884 0.60416666666666663
r8828 n5854 n5885 0.012500000000000001
r8829 n5884 n5885 0.54166666666666663
r8830 n5855 n5886 0.03125
r8831 n5885 n5886 0.72916666666666663
r8832 n5856 n5887 0.011363636363636364
r8833 n5857 n5888 0.1875
r8834 n5887 n5888 0.72916666666666663
r8835 n5858 n5889 0.012500000000000001
r8836 n5888 n5889 0.66666666666666663
r8837 n5859 n5890 0.1875
r8838 n5889 n5890 0.66666666666666663
r8839 n5860 n5891 0.011363636363636364
r8840 n5890 n5891 0.72916666666666663
r8841 n5861 n5892 0.037499999999999999
r8842 n5862 n5893 0.074999999999999997
r8843 n5892 n5893 0.3125
r8844 n5863 n5894 0.074999999999999997
r8845 n5893 n5894 0.20833333333333334
r8846 n5864 n5895 0.375
r8847 n5894 n5895 0.125
r8848 n5865 n5896 0.125
r8849 n5895 n5896 0.083333333333333329
r8850 n5866 n5897 0.375
r8851 n5896 n5897 0.083333333333333329
r8852 n5867 n5898 0.041666666666666664
r8853 n5897 n5898 0.20833333333333334
r8854 n5868 n5899 0.037499999999999999
r8855 n5898 n5899 0.39583333333333331
r8856 n5869 n5900 0.074999999999999997
r8857 n5899 n5900 0.3125
r8858 n5870 n5901 0.074999999999999997
r8859 n5900 n5901 0.20833333333333334
r8860 n5871 n5902 0.375
r8861 n5901 n5902 0.125
r8862 n5872 n5903 0.1875
r8863 n5902 n5903 0.0625
r8864 n5873 n5904 0.375
r8865 n5903 n5904 0.0625
r8866 n5874 n5905 0.375
r8867 n5904 n5905 0.041666666666666664
r8868 n5875 n5906 0.375
r8869 n5905 n5906 0.041666666666666664
r8870 n5876 n5907 0.09375
r8871 n5906 n5907 0.10416666666666667
r8872 n5877 n5908 0.074999999999999997
r8873 n5907 n5908 0.1875
r8874 n5878 n5909 0.375
r8875 n5908 n5909 0.125
r8876 n5879 n5910 0.037499999999999999
r8877 n5909 n5910 0.22916666666666666
r8878 n5880 n5911 0.037499999999999999
r8879 n5881 n5912 0.014999999999999999
r8880 n5911 n5912 0.72916666666666663
r8881 n5882 n5913 0.375
r8882 n5912 n5913 0.54166666666666663
r8883 n5883 n5914 0.013392857142857142
r8884 n5913 n5914 0.60416666666666663
r8885 n5884 n5915 0.375
r8886 n5914 n5915 0.60416666666666663
r8887 n5885 n5916 0.014999999999999999
r8888 n5915 n5916 0.54166666666666663
r8889 n5886 n5917 0.037499999999999999
r8890 n5916 n5917 0.72916666666666663
r8891 n5887 n5918 0.01893939393939394
r8892 n5888 n5919 0.3125
r8893 n5918 n5919 0.3125
r8894 n5889 n5920 0.020833333333333332
r8895 n5919 n5920 0.2857142857142857
r8896 n5890 n5921 0.3125
r8897 n5920 n5921 0.2857142857142857
r8898 n5891 n5922 0.01893939393939394
r8899 n5921 n5922 0.3125
r8900 n5892 n5923 0.0625
r8901 n5893 n5924 0.125
r8902 n5923 n5924 0.13392857142857142
r8903 n5894 n5925 0.125
r8904 n5924 n5925 0.089285714285714288
r8905 n5895 n5926 0.625
r8906 n5925 n5926 0.053571428571428568
r8907 n5896 n5927 0.20833333333333334
r8908 n5926 n5927 0.035714285714285712
r8909 n5897 n5928 0.625
r8910 n5927 n5928 0.035714285714285712
r8911 n5898 n5929 0.069444444444444448
r8912 n5928 n5929 0.089285714285714288
r8913 n5899 n5930 0.0625
r8914 n5929 n5930 0.16964285714285715
r8915 n5900 n5931 0.125
r8916 n5930 n5931 0.13392857142857142
r8917 n5901 n5932 0.125
r8918 n5931 n5932 0.089285714285714288
r8919 n5902 n5933 0.625
r8920 n5932 n5933 0.053571428571428568
r8921 n5903 n5934 0.3125
r8922 n5933 n5934 0.026785714285714284
r8923 n5904 n5935 0.625
r8924 n5934 n5935 0.026785714285714284
r8925 n5905 n5936 0.625
r8926 n5935 n5936 0.017857142857142856
r8927 n5906 n5937 0.625
r8928 n5936 n5937 0.017857142857142856
r8929 n5907 n5938 0.15625
r8930 n5937 n5938 0.044642857142857144
r8931 n5908 n5939 0.125
r8932 n5938 n5939 0.080357142857142863
r8933 n5909 n5940 0.625
r8934 n5939 n5940 0.053571428571428568
r8935 n5910 n5941 0.0625
r8936 n5940 n5941 0.098214285714285712
r8937 n5911 n5942 0.0625
r8938 n5912 n5943 0.025000000000000001
r8939 n5942 n5943 0.3125
r8940 n5913 n5944 0.625
r8941 n5943 n5944 0.23214285714285715
r8942 n5914 n5945 0.022321428571428572
r8943 n5944 n5945 0.25892857142857145
r8944 n5915 n5946 0.625
r8945 n5945 n5946 0.25892857142857145
r8946 n5916 n5947 0.025000000000000001
r8947 n5946 n5947 0.23214285714285715
r8948 n5917 n5948 0.0625
r8949 n5947 n5948 0.3125
r8950 n5918 n5949 0.028409090909090908
r8951 n5919 n5950 0.46875
r8952 n5949 n5950 0.2734375
r8953 n5920 n5951 0.03125
r8954 n5950 n5951 0.25
r8955 n5921 n5952 0.46875
r8956 n5951 n5952 0.25
r8957 n5922 n5953 0.028409090909090908
r8958 n5952 n5953 0.2734375
r8959 n5923 n5954 0.09375
r8960 n5924 n5955 0.1875
r8961 n5954 n5955 0.1171875
r8962 n5925 n5956 0.1875
r8963 n5955 n5956 0.078125
r8964 n5926 n5957 0.9375
r8965 n5956 n5957 0.046875
r8966 n5927 n5958 0.3125
r8967 n5957 n5958 0.03125
r8968 n5928 n5959 0.9375
r8969 n5958 n5959 0.03125
r8970 n5929 n5960 0.10416666666666667
r8971 n5959 n5960 0.078125
r8972 n5930 n5961 0.09375
r8973 n5960 n5961 0.1484375
r8974 n5931 n5962 0.1875
r8975 n5961 n5962 0.1171875
r8976 n5932 n5963 0.1875
r8977 n5962 n5963 0.078125
r8978 n5933 n5964 0.9375
r8979 n5963 n5964 0.046875
r8980 n5934 n5965 0.46875
r8981 n5964 n5965 0.0234375
r8982 n5935 n5966 0.9375
r8983 n5965 n5966 0.0234375
r8984 n5936 n5967 0.9375
r8985 n5966 n5967 0.015625
r8986 n5937 n5968 0.9375
r8987 n5967 n5968 0.015625
r8988 n5938 n5969 0.234375
r8989 n5968 n5969 0.0390625
r8990 n5939 n5970 0.1875
r8991 n5969 n5970 0.0703125
r8992 n5940 n5971 0.9375
r8993 n5970 n5971 0.046875
r8994 n5941 n5972 0.09375
r8995 n5971 n5972 0.0859375
r8996 n5942 n5973 0.09375
r8997 n5943 n5974 0.037499999999999999
r8998 n5973 n5974 0.2734375
r8999 n5944 n5975 0.9375
r9000 n5974 n5975 0.203125
r9001 n5945 n5976 0.033482142857142856
r9002 n5975 n5976 0.2265625
r9003 n5946 n5977 0.9375
r9004 n5976 n5977 0.2265625
r9005 n5947 n5978 0.037499999999999999
r9006 n5977 n5978 0.203125
r9007 n5948 n5979 0.09375
r9008 n5978 n5979 0.2734375
r9009 n5949 n5980 0.01893939393939394
r9010 n5950 n5981 0.3125
r9011 n5980 n5981 1.09375
r9012 n5951 n5982 0.020833333333333332
r9013 n5981 n5982 1
r9014 n5952 n5983 0.3125
r9015 n5982 n5983 1
r9016 n5953 n5984 0.01893939393939394
r9017 n5983 n5984 1.09375
r9018 n5954 n5985 0.0625
r9019 n5955 n5986 0.125
r9020 n5985 n5986 0.46875
r9021 n5956 n5987 0.125
r9022 n5986 n5987 0.3125
r9023 n5957 n5988 0.625
r9024 n5987 n5988 0.1875
r9025 n5958 n5989 0.20833333333333334
r9026 n5988 n5989 0.125
r9027 n5959 n5990 0.625
r9028 n5989 n5990 0.125
r9029 n5960 n5991 0.069444444444444448
r9030 n5990 n5991 0.3125
r9031 n5961 n5992 0.0625
r9032 n5991 n5992 0.59375
r9033 n5962 n5993 0.125
r9034 n5992 n5993 0.46875
r9035 n5963 n5994 0.125
r9036 n5993 n5994 0.3125
r9037 n5964 n5995 0.625
r9038 n5994 n5995 0.1875
r9039 n5965 n5996 0.3125
r9040 n5995 n5996 0.09375
r9041 n5966 n5997 0.625
r9042 n5996 n5997 0.09375
r9043 n5967 n5998 0.625
r9044 n5997 n5998 0.0625
r9045 n5968 n5999 0.625
r9046 n5998 n5999 0.0625
r9047 n5969 n6000 0.15625
r9048 n5999 n6000 0.15625
r9049 n5970 n6001 0.125
r9050 n6000 n6001 0.28125
r9051 n5971 n6002 0.625
r9052 n6001 n6002 0.1875
r9053 n5972 n6003 0.0625
r9054 n6002 n6003 0.34375
r9055 n5973 n6004 0.0625
r9056 n5974 n6005 0.025000000000000001
r9057 n6004 n6005 1.09375
r9058 n5975 n6006 0.625
r9059 n6005 n6006 0.8125
r9060 n5976 n6007 0.022321428571428572
r9061 n6006 n6007 0.90625
r9062 n5977 n6008 0.625
r9063 n6007 n6008 0.90625
r9064 n5978 n6009 0.025000000000000001
r9065 n6008 n6009 0.8125
r9066 n5979 n6010 0.0625
r9067 n6009 n6010 1.09375
r9068 n5980 n6011 0.064393939393939392
r9069 n5981 n6012 1.0625
r9070 n6011 n6012 0.068359375
r9071 n5982 n6013 0.070833333333333331
r9072 n6012 n6013 0.0625
r9073 n5983 n6014 1.0625
r9074 n6013 n6014 0.0625
r9075 n5984 n6015 0.064393939393939392
r9076 n6014 n6015 0.068359375
r9077 n6004 n6016 0.21249999999999999
r9078 n6005 n6017 0.085000000000000006
r9079 n6016 n6017 0.068359375
r9080 n6006 n6018 2.125
r9081 n6017 n6018 0.05078125
r9082 n6007 n6019 0.075892857142857137
r9083 n6018 n6019 0.056640625
r9084 n6008 n6020 2.125
r9085 n6019 n6020 0.056640625
r9086 n6009 n6021 0.085000000000000006
r9087 n6020 n6021 0.05078125
r9088 n6010 n6022 0.21249999999999999
r9089 n6021 n6022 0.068359375
r9090 n6011 n6023 0.14962121212121213
r9091 n6012 n6024 2.46875
r9092 n6023 n6024 0.046542553191489359
r9093 n6013 n6025 0.16458333333333333
r9094 n6024 n6025 0.042553191489361701
r9095 n6014 n6026 2.46875
r9096 n6025 n6026 0.042553191489361701
r9097 n6015 n6027 0.14962121212121213
r9098 n6026 n6027 0.046542553191489359
r9099 n6016 n6028 0.49375000000000002
r9100 n6017 n6029 0.19750000000000001
r9101 n6028 n6029 0.046542553191489359
r9102 n6018 n6030 4.9375
r9103 n6029 n6030 0.034574468085106384
r9104 n6019 n6031 0.17633928571428573
r9105 n6030 n6031 0.038563829787234043
r9106 n6020 n6032 4.9375
r9107 n6031 n6032 0.038563829787234043
r9108 n6021 n6033 0.19750000000000001
r9109 n6032 n6033 0.034574468085106384
r9110 n6022 n6034 0.49375000000000002
r9111 n6033 n6034 0.046542553191489359
r9112 n6023 n6035 0.15340909090909091
r9113 n6024 n6036 2.53125
r9114 n6035 n6036 0.064338235294117641
r9115 n6025 n6037 0.16875000000000001
r9116 n6036 n6037 0.058823529411764705
r9117 n6026 n6038 2.53125
r9118 n6037 n6038 0.058823529411764705
r9119 n6027 n6039 0.15340909090909091
r9120 n6038 n6039 0.064338235294117641
r9121 n6028 n6040 0.50624999999999998
r9122 n6029 n6041 0.20250000000000001
r9123 n6040 n6041 0.064338235294117641
r9124 n6030 n6042 5.0625
r9125 n6041 n6042 0.04779411764705882
r9126 n6031 n6043 0.18080357142857142
r9127 n6042 n6043 0.053308823529411763
r9128 n6032 n6044 5.0625
r9129 n6043 n6044 0.053308823529411763
r9130 n6033 n6045 0.20250000000000001
r9131 n6044 n6045 0.04779411764705882
r9132 n6034 n6046 0.50624999999999998
r9133 n6045 n6046 0.064338235294117641
r9134 n6035 n6047 0.15643939393939393
r9135 n6036 n6048 2.5812499999999998
r9136 n6047 n6048 0.045010288065843625
r9137 n6037 n6049 0.17208333333333334
r9138 n6048 n6049 0.041152263374485597
r9139 n6038 n6050 2.5812499999999998
r9140 n6049 n6050 0.041152263374485597
r9141 n6039 n6051 0.15643939393939393
r9142 n6050 n6051 0.045010288065843625
r9143 n6040 n6052 0.51624999999999999
r9144 n6041 n6053 0.20649999999999999
r9145 n6052 n6053 0.045010288065843625
r9146 n6042 n6054 5.1624999999999996
r9147 n6053 n6054 0.033436213991769548
r9148 n6043 n6055 0.18437500000000001
r9149 n6054 n6055 0.037294238683127569
r9150 n6044 n6056 5.1624999999999996
r9151 n6055 n6056 0.037294238683127569
r9152 n6045 n6057 0.20649999999999999
r9153 n6056 n6057 0.033436213991769548
r9154 n6046 n6058 0.51624999999999999
r9155 n6057 n6058 0.045010288065843625
r9156 n6047 n6059 0.18446969696969698
r9157 n6048 n6060 3.0437500000000002
r9158 n6059 n6060 0.044825819672131145
r9159 n6049 n6061 0.20291666666666666
r9160 n6060 n6061 0.040983606557377046
r9161 n6050 n6062 3.0437500000000002
r9162 n6061 n6062 0.040983606557377046
r9163 n6051 n6063 0.18446969696969698
r9164 n6062 n6063 0.044825819672131145
r9165 n6052 n6064 0.60875000000000001
r9166 n6053 n6065 0.24349999999999999
r9167 n6064 n6065 0.044825819672131145
r9168 n6054 n6066 6.0875000000000004
r9169 n6065 n6066 0.033299180327868855
r9170 n6055 n6067 0.21741071428571429
r9171 n6066 n6067 0.037141393442622954
r9172 n6056 n6068 6.0875000000000004
r9173 n6067 n6068 0.037141393442622954
r9174 n6057 n6069 0.24349999999999999
r9175 n6068 n6069 0.033299180327868855
r9176 n6058 n6070 0.60875000000000001
r9177 n6069 n6070 0.044825819672131145
r9178 n6059 n6071 0.18446969696969698
r9179 n6060 n6072 3.0437500000000002
r9180 n6071 n6072 0.045010288065843625
r9181 n6061 n6073 0.20291666666666666
r9182 n6072 n6073 0.041152263374485597
r9183 n6062 n6074 3.0437500000000002
r9184 n6073 n6074 0.041152263374485597
r9185 n6063 n6075 0.18446969696969698
r9186 n6074 n6075 0.045010288065843625
r9187 n6064 n6076 0.60875000000000001
r9188 n6065 n6077 0.24349999999999999
r9189 n6076 n6077 0.045010288065843625
r9190 n6066 n6078 6.0875000000000004
r9191 n6077 n6078 0.033436213991769548
r9192 n6067 n6079 0.21741071428571429
r9193 n6078 n6079 0.037294238683127569
r9194 n6068 n6080 6.0875000000000004
r9195 n6079 n6080 0.037294238683127569
r9196 n6069 n6081 0.24349999999999999
r9197 n6080 n6081 0.033436213991769548
r9198 n6070 n6082 0.60875000000000001
r9199 n6081 n6082 0.045010288065843625
r9200 n6071 n6083 0.18409090909090908
r9201 n6072 n6084 3.0375000000000001
r9202 n6083 n6084 0.045010288065843625
r9203 n6073 n6085 0.20250000000000001
r9204 n6084 n6085 0.041152263374485597
r9205 n6074 n6086 3.0375000000000001
r9206 n6085 n6086 0.041152263374485597
r9207 n6075 n6087 0.18409090909090908
r9208 n6086 n6087 0.045010288065843625
r9209 n6076 n6088 0.60750000000000004
r9210 n6077 n6089 0.24299999999999999
r9211 n6088 n6089 0.045010288065843625
r9212 n6078 n6090 6.0750000000000002
r9213 n6089 n6090 0.033436213991769548
r9214 n6079 n6091 0.21696428571428572
r9215 n6090 n6091 0.037294238683127569
r9216 n6080 n6092 6.0750000000000002
r9217 n6091 n6092 0.037294238683127569
r9218 n6081 n6093 0.24299999999999999
r9219 n6092 n6093 0.033436213991769548
r9220 n6082 n6094 0.60750000000000004
r9221 n6093 n6094 0.045010288065843625
r9222 n6083 n6095 0.18446969696969698
r9223 n6084 n6096 3.0437500000000002
r9224 n6095 n6096 0.044825819672131145
r9225 n6085 n6097 0.20291666666666666
r9226 n6096 n6097 0.040983606557377046
r9227 n6086 n6098 3.0437500000000002
r9228 n6097 n6098 0.040983606557377046
r9229 n6087 n6099 0.18446969696969698
r9230 n6098 n6099 0.044825819672131145
r9231 n6088 n6100 0.60875000000000001
r9232 n6089 n6101 0.24349999999999999
r9233 n6100 n6101 0.044825819672131145
r9234 n6090 n6102 6.0875000000000004
r9235 n6101 n6102 0.033299180327868855
r9236 n6091 n6103 0.21741071428571429
r9237 n6102 n6103 0.037141393442622954
r9238 n6092 n6104 6.0875000000000004
r9239 n6103 n6104 0.037141393442622954
r9240 n6093 n6105 0.24349999999999999
r9241 n6104 n6105 0.033299180327868855
r9242 n6094 n6106 0.60875000000000001
r9243 n6105 n6106 0.044825819672131145
r9244 n6095 n6107 0.18446969696969698
r9245 n6096 n6108 3.0437500000000002
r9246 n6107 n6108 0.045010288065843625
r9247 n6097 n6109 0.20291666666666666
r9248 n6108 n6109 0.041152263374485597
r9249 n6098 n6110 3.0437500000000002
r9250 n6109 n6110 0.041152263374485597
r9251 n6099 n6111 0.18446969696969698
r9252 n6110 n6111 0.045010288065843625
r9253 n6100 n6112 0.60875000000000001
r9254 n6101 n6113 0.24349999999999999
r9255 n6112 n6113 0.045010288065843625
r9256 n6102 n6114 6.0875000000000004
r9257 n6113 n6114 0.033436213991769548
r9258 n6103 n6115 0.21741071428571429
r9259 n6114 n6115 0.037294238683127569
r9260 n6104 n6116 6.0875000000000004
r9261 n6115 n6116 0.037294238683127569
r9262 n6105 n6117 0.24349999999999999
r9263 n6116 n6117 0.033436213991769548
r9264 n6106 n6118 0.60875000000000001
r9265 n6117 n6118 0.045010288065843625
r9266 n6107 n6119 0.09583333333333334
r9267 n6108 n6120 1.58125
r9268 n6119 n6120 1.09375
r9269 n6109 n6121 0.10541666666666667
r9270 n6120 n6121 1
r9271 n6110 n6122 1.58125
r9272 n6121 n6122 1
r9273 n6111 n6123 0.09583333333333334
r9274 n6122 n6123 1.09375
r9275 n6124 n6125 0.78125
r9276 n6125 n6126 1
r9277 n6126 n6127 1
r9278 n6127 n6128 0.78125
r9279 n6112 n6129 0.31624999999999998
r9280 n6113 n6130 0.1265
r9281 n6129 n6130 1.09375
r9282 n6114 n6131 3.1625000000000001
r9283 n6130 n6131 0.8125
r9284 n6115 n6132 0.11294642857142857
r9285 n6131 n6132 0.90625
r9286 n6116 n6133 3.1625000000000001
r9287 n6132 n6133 0.90625
r9288 n6117 n6134 0.1265
r9289 n6133 n6134 0.8125
r9290 n6118 n6135 0.31624999999999998
r9291 n6134 n6135 1.09375
r9292 n6119 n6136 0.02462121212121212
r9293 n6120 n6137 0.40625
r9294 n6136 n6137 0.19886363636363635
r9295 n6121 n6138 0.027083333333333334
r9296 n6137 n6138 0.18181818181818182
r9297 n6122 n6139 0.40625
r9298 n6138 n6139 0.18181818181818182
r9299 n6123 n6140 0.02462121212121212
r9300 n6139 n6140 0.19886363636363635
r9301 n6140 n6141 0.24431818181818182
r9302 n6141 n6142 0.085227272727272721
r9303 n6142 n6143 0.25227272727272726
r9304 n6143 n6144 0.44659090909090909
r9305 n6144 n6145 0.44659090909090909
r9306 n6145 n6146 0.41704545454545455
r9307 n6146 n6147 0.34886363636363638
r9308 n6147 n6148 0.3125
r9309 n6148 n6149 0.34999999999999998
r9310 n6149 n6150 0.26704545454545453
r9311 n6150 n6151 0.30113636363636365
r9312 n6151 n6152 0.23295454545454544
r9313 n6152 n6153 0.19318181818181818
r9314 n6153 n6154 0.19318181818181818
r9315 n6154 n6155 0.13636363636363635
r9316 n6155 n6156 0.15340909090909091
r9317 n6156 n6157 0.056818181818181816
r9318 n6157 n6158 0.0625
r9319 n6158 n6159 0.034090909090909088
r9320 n6159 n6160 0.079545454545454544
r9321 n6160 n6161 0.13068181818181818
r9322 n6161 n6162 0.085227272727272721
r9323 n6162 n6163 0.056818181818181816
r9324 n6163 n6164 0.034090909090909088
r9325 n6164 n6165 0.022727272727272728
r9326 n6165 n6166 0.022727272727272728
r9327 n6166 n6167 0.056818181818181816
r9328 n6167 n6168 0.10795454545454546
r9329 n6168 n6169 0.085227272727272721
r9330 n6169 n6170 0.056818181818181816
r9331 n6170 n6171 0.034090909090909088
r9332 n6171 n6172 0.017045454545454544
r9333 n6172 n6173 0.017045454545454544
r9334 n6173 n6174 0.011363636363636364
r9335 n6174 n6175 0.011363636363636364
r9336 n6175 n6176 0.028409090909090908
r9337 n6176 n6177 0.05113636363636364
r9338 n6177 n6178 0.034090909090909088
r9339 n6178 n6179 0.0625
r9340 n6179 n6180 0.073863636363636367
r9341 n6180 n6181 0.05113636363636364
r9342 n6181 n6182 0.045454545454545456
r9343 n6182 n6183 0.017045454545454544
r9344 n6183 n6184 0.011363636363636364
r9345 n6184 n6185 0.039772727272727272
r9346 n6185 n6186 0.0625
r9347 n6186 n6187 0.034090909090909088
r9348 n6187 n6188 0.028409090909090908
r9349 n6188 n6189 0.05113636363636364
r9350 n6189 n6190 0.045454545454545456
r9351 n6190 n6191 0.056818181818181816
r9352 n6191 n6192 0.073863636363636367
r9353 n6192 n6193 0.090909090909090912
r9354 n6193 n6194 0.079545454545454544
r9355 n6194 n6195 0.0625
r9356 n6195 n6196 0.090909090909090912
r9357 n6196 n6197 0.073863636363636367
r9358 n6197 n6198 0.068181818181818177
r9359 n6198 n6199 0.073863636363636367
r9360 n6199 n6200 0.0625
r9361 n6200 n6201 0.045454545454545456
r9362 n6201 n6202 0.10795454545454546
r9363 n6202 n6203 0.17045454545454544
r9364 n6203 n6204 0.085227272727272721
r9365 n6204 n6205 0.022727272727272728
r9366 n6205 n6206 0.034090909090909088
r9367 n6206 n6207 0.05113636363636364
r9368 n6207 n6208 0.073863636363636367
r9369 n6208 n6209 0.068181818181818177
r9370 n6209 n6210 0.096590909090909088
r9371 n6210 n6211 0.11363636363636363
r9372 n6211 n6212 0.19318181818181818
r9373 n6212 n6213 0.16477272727272727
r9374 n6213 n6214 0.039772727272727272
r9375 n6214 n6215 0.18181818181818182
r9376 n6215 n6216 0.16477272727272727
r9377 n6216 n6217 0.19318181818181818
r9378 n6217 n6218 0.375
r9379 n6218 n6219 0.38636363636363635
r9380 n6219 n6220 0.38636363636363635
r9381 n6220 n6221 0.38636363636363635
r9382 n6221 n6222 0.38636363636363635
r9383 n6222 n6223 0.38636363636363635
r9384 n6223 n6224 0.38636363636363635
r9385 n6224 n6225 0.38636363636363635
r9386 n6225 n6226 0.38636363636363635
r9387 n6226 n6227 0.38636363636363635
r9388 n6227 n6228 0.38636363636363635
r9389 n6228 n6229 0.38636363636363635
r9390 n6229 n6230 0.38636363636363635
r9391 n6230 n6231 0.38636363636363635
r9392 n6231 n6232 0.38636363636363635
r9393 n6232 n6233 0.38636363636363635
r9394 n6233 n6234 0.38636363636363635
r9395 n6234 n6235 0.38636363636363635
r9396 n6235 n6236 0.38636363636363635
r9397 n6236 n6237 0.38636363636363635
r9398 n6237 n6238 0.38636363636363635
r9399 n6238 n6239 0.38636363636363635
r9400 n6239 n6240 0.25568181818181818
r9401 n6124 n6241 0.035326086956521736
r9402 n6240 n6241 0.19318181818181818
r9403 n6125 n6242 0.40625
r9404 n6241 n6242 0.14204545454545456
r9405 n6126 n6243 0.027083333333333334
r9406 n6242 n6243 0.18181818181818182
r9407 n6127 n6244 0.40625
r9408 n6243 n6244 0.18181818181818182
r9409 n6128 n6245 0.035326086956521736
r9410 n6244 n6245 0.14204545454545456
r9411 n6129 n6246 0.081250000000000003
r9412 n6130 n6247 0.032500000000000001
r9413 n6246 n6247 0.19886363636363635
r9414 n6131 n6248 0.8125
r9415 n6247 n6248 0.14772727272727273
r9416 n6132 n6249 0.029017857142857144
r9417 n6248 n6249 0.16477272727272727
r9418 n6133 n6250 0.8125
r9419 n6249 n6250 0.16477272727272727
r9420 n6134 n6251 0.032500000000000001
r9421 n6250 n6251 0.14772727272727273
r9422 n6135 n6252 0.081250000000000003
r9423 n6251 n6252 0.19886363636363635
r9424 n6136 n6253 0.02462121212121212
r9425 n6137 n6254 0.40625
r9426 n6253 n6254 1.09375
r9427 n6138 n6255 0.027083333333333334
r9428 n6254 n6255 1
r9429 n6139 n6256 0.40625
r9430 n6255 n6256 1
r9431 n6140 n6257 0.02462121212121212
r9432 n6256 n6257 1.09375
r9433 n6141 n6258 0.081250000000000003
r9434 n6257 n6258 1.34375
r9435 n6142 n6259 0.16250000000000001
r9436 n6258 n6259 0.46875
r9437 n6143 n6260 0.020621827411167512
r9438 n6259 n6260 1.3875
r9439 n6144 n6261 0.020727040816326529
r9440 n6260 n6261 2.4562499999999998
r9441 n6145 n6262 0.020621827411167512
r9442 n6261 n6262 2.4562499999999998
r9443 n6146 n6263 0.02389705882352941
r9444 n6262 n6263 2.2937500000000002
r9445 n6147 n6264 0.029653284671532845
r9446 n6263 n6264 1.91875
r9447 n6148 n6265 0.029438405797101448
r9448 n6264 n6265 1.71875
r9449 n6149 n6266 0.02389705882352941
r9450 n6265 n6266 1.925
r9451 n6150 n6267 0.0625
r9452 n6266 n6267 1.46875
r9453 n6151 n6268 0.020312500000000001
r9454 n6267 n6268 1.65625
r9455 n6152 n6269 0.8125
r9456 n6268 n6269 1.28125
r9457 n6153 n6270 0.02462121212121212
r9458 n6269 n6270 1.0625
r9459 n6154 n6271 0.8125
r9460 n6270 n6271 1.0625
r9461 n6155 n6272 0.035326086956521736
r9462 n6271 n6272 0.75
r9463 n6156 n6273 0.203125
r9464 n6272 n6273 0.84375
r9465 n6157 n6274 0.13541666666666666
r9466 n6273 n6274 0.3125
r9467 n6158 n6275 0.16250000000000001
r9468 n6274 n6275 0.34375
r9469 n6159 n6276 0.8125
r9470 n6275 n6276 0.1875
r9471 n6160 n6277 0.0625
r9472 n6276 n6277 0.4375
r9473 n6161 n6278 0.081250000000000003
r9474 n6277 n6278 0.71875
r9475 n6162 n6279 0.16250000000000001
r9476 n6278 n6279 0.46875
r9477 n6163 n6280 0.16250000000000001
r9478 n6279 n6280 0.3125
r9479 n6164 n6281 0.8125
r9480 n6280 n6281 0.1875
r9481 n6165 n6282 0.27083333333333331
r9482 n6281 n6282 0.125
r9483 n6166 n6283 0.8125
r9484 n6282 n6283 0.125
r9485 n6167 n6284 0.090277777777777776
r9486 n6283 n6284 0.3125
r9487 n6168 n6285 0.081250000000000003
r9488 n6284 n6285 0.59375
r9489 n6169 n6286 0.16250000000000001
r9490 n6285 n6286 0.46875
r9491 n6170 n6287 0.16250000000000001
r9492 n6286 n6287 0.3125
r9493 n6171 n6288 0.8125
r9494 n6287 n6288 0.1875
r9495 n6172 n6289 0.40625
r9496 n6288 n6289 0.09375
r9497 n6173 n6290 0.8125
r9498 n6289 n6290 0.09375
r9499 n6174 n6291 0.8125
r9500 n6290 n6291 0.0625
r9501 n6175 n6292 0.8125
r9502 n6291 n6292 0.0625
r9503 n6176 n6293 0.203125
r9504 n6292 n6293 0.15625
r9505 n6177 n6294 0.16250000000000001
r9506 n6293 n6294 0.28125
r9507 n6178 n6295 0.8125
r9508 n6294 n6295 0.1875
r9509 n6179 n6296 0.081250000000000003
r9510 n6295 n6296 0.34375
r9511 n6180 n6297 0.27083333333333331
r9512 n6296 n6297 0.40625
r9513 n6181 n6298 0.13541666666666666
r9514 n6297 n6298 0.28125
r9515 n6182 n6299 0.40625
r9516 n6298 n6299 0.25
r9517 n6183 n6300 0.8125
r9518 n6299 n6300 0.09375
r9519 n6184 n6301 0.8125
r9520 n6300 n6301 0.0625
r9521 n6185 n6302 0.13541666666666666
r9522 n6301 n6302 0.21875
r9523 n6186 n6303 0.16250000000000001
r9524 n6302 n6303 0.34375
r9525 n6187 n6304 0.8125
r9526 n6303 n6304 0.1875
r9527 n6188 n6305 0.203125
r9528 n6304 n6305 0.15625
r9529 n6189 n6306 0.16250000000000001
r9530 n6305 n6306 0.28125
r9531 n6190 n6307 0.27083333333333331
r9532 n6306 n6307 0.25
r9533 n6191 n6308 0.11607142857142858
r9534 n6307 n6308 0.3125
r9535 n6192 n6309 0.13541666666666666
r9536 n6308 n6309 0.40625
r9537 n6193 n6310 0.081250000000000003
r9538 n6309 n6310 0.5
r9539 n6194 n6311 0.203125
r9540 n6310 n6311 0.4375
r9541 n6195 n6312 0.11607142857142858
r9542 n6311 n6312 0.34375
r9543 n6196 n6313 0.090277777777777776
r9544 n6312 n6313 0.5
r9545 n6197 n6314 0.203125
r9546 n6313 n6314 0.40625
r9547 n6198 n6315 0.1015625
r9548 n6314 n6315 0.375
r9549 n6199 n6316 0.16250000000000001
r9550 n6315 n6316 0.40625
r9551 n6200 n6317 0.13541666666666666
r9552 n6316 n6317 0.34375
r9553 n6201 n6318 0.40625
r9554 n6317 n6318 0.25
r9555 n6202 n6319 0.04779411764705882
r9556 n6318 n6319 0.59375
r9557 n6203 n6320 0.0625
r9558 n6319 n6320 0.9375
r9559 n6204 n6321 0.40625
r9560 n6320 n6321 0.46875
r9561 n6205 n6322 0.40625
r9562 n6321 n6322 0.125
r9563 n6206 n6323 0.203125
r9564 n6322 n6323 0.1875
r9565 n6207 n6324 0.16250000000000001
r9566 n6323 n6324 0.28125
r9567 n6208 n6325 0.1015625
r9568 n6324 n6325 0.40625
r9569 n6209 n6326 0.203125
r9570 n6325 n6326 0.375
r9571 n6210 n6327 0.0625
r9572 n6326 n6327 0.53125
r9573 n6211 n6328 0.11607142857142858
r9574 n6327 n6328 0.625
r9575 n6212 n6329 0.030092592592592591
r9576 n6328 n6329 1.0625
r9577 n6213 n6330 0.40625
r9578 n6329 n6330 0.90625
r9579 n6214 n6331 0.16250000000000001
r9580 n6330 n6331 0.21875
r9581 n6215 n6332 0.030092592592592591
r9582 n6331 n6332 1
r9583 n6216 n6333 0.40625
r9584 n6332 n6333 0.90625
r9585 n6217 n6334 0.025390625
r9586 n6333 n6334 1.0625
r9587 n6218 n6335 0.02389705882352941
r9588 n6334 n6335 2.0625
r9589 n6219 n6336 0.02389705882352941
r9590 n6335 n6336 2.125
r9591 n6220 n6337 0.02389705882352941
r9592 n6336 n6337 2.125
r9593 n6221 n6338 0.02389705882352941
r9594 n6337 n6338 2.125
r9595 n6222 n6339 0.02389705882352941
r9596 n6338 n6339 2.125
r9597 n6223 n6340 0.02389705882352941
r9598 n6339 n6340 2.125
r9599 n6224 n6341 0.02389705882352941
r9600 n6340 n6341 2.125
r9601 n6225 n6342 0.02389705882352941
r9602 n6341 n6342 2.125
r9603 n6226 n6343 0.02389705882352941
r9604 n6342 n6343 2.125
r9605 n6227 n6344 0.02389705882352941
r9606 n6343 n6344 2.125
r9607 n6228 n6345 0.02389705882352941
r9608 n6344 n6345 2.125
r9609 n6229 n6346 0.02389705882352941
r9610 n6345 n6346 2.125
r9611 n6230 n6347 0.02389705882352941
r9612 n6346 n6347 2.125
r9613 n6231 n6348 0.02389705882352941
r9614 n6347 n6348 2.125
r9615 n6232 n6349 0.02389705882352941
r9616 n6348 n6349 2.125
r9617 n6233 n6350 0.02389705882352941
r9618 n6349 n6350 2.125
r9619 n6234 n6351 0.02389705882352941
r9620 n6350 n6351 2.125
r9621 n6235 n6352 0.02389705882352941
r9622 n6351 n6352 2.125
r9623 n6236 n6353 0.02389705882352941
r9624 n6352 n6353 2.125
r9625 n6237 n6354 0.02389705882352941
r9626 n6353 n6354 2.125
r9627 n6238 n6355 0.02389705882352941
r9628 n6354 n6355 2.125
r9629 n6239 n6356 0.02389705882352941
r9630 n6355 n6356 2.125
r9631 n6240 n6357 0.073863636363636367
r9632 n6356 n6357 1.40625
r9633 n6241 n6358 0.035326086956521736
r9634 n6357 n6358 1.0625
r9635 n6242 n6359 0.40625
r9636 n6358 n6359 0.78125
r9637 n6243 n6360 0.027083333333333334
r9638 n6359 n6360 1
r9639 n6244 n6361 0.40625
r9640 n6360 n6361 1
r9641 n6245 n6362 0.035326086956521736
r9642 n6361 n6362 0.78125
r9643 n6246 n6363 0.081250000000000003
r9644 n6247 n6364 0.032500000000000001
r9645 n6363 n6364 1.09375
r9646 n6248 n6365 0.8125
r9647 n6364 n6365 0.8125
r9648 n6249 n6366 0.029017857142857144
r9649 n6365 n6366 0.90625
r9650 n6250 n6367 0.8125
r9651 n6366 n6367 0.90625
r9652 n6251 n6368 0.032500000000000001
r9653 n6367 n6368 0.8125
r9654 n6252 n6369 0.081250000000000003
r9655 n6368 n6369 1.09375
r9656 n6253 n6370 0.060606060606060608
r9657 n6254 n6371 1
r9658 n6370 n6371 0.072916666666666671
r9659 n6255 n6372 0.066666666666666666
r9660 n6371 n6372 0.066666666666666666
r9661 n6256 n6373 1
r9662 n6372 n6373 0.066666666666666666
r9663 n6257 n6374 0.060606060606060608
r9664 n6373 n6374 0.072916666666666671
r9665 n6258 n6375 0.20000000000000001
r9666 n6374 n6375 0.089583333333333334
r9667 n6259 n6376 0.40000000000000002
r9668 n6375 n6376 0.03125
r9669 n6260 n6377 0.050761421319796954
r9670 n6376 n6377 0.092499999999999999
r9671 n6261 n6378 0.051020408163265307
r9672 n6377 n6378 0.16375000000000001
r9673 n6262 n6379 0.050761421319796954
r9674 n6378 n6379 0.16375000000000001
r9675 n6263 n6380 0.058823529411764705
r9676 n6379 n6380 0.15291666666666667
r9677 n6264 n6381 0.072992700729927001
r9678 n6380 n6381 0.12791666666666668
r9679 n6265 n6382 0.072463768115942032
r9680 n6381 n6382 0.11458333333333333
r9681 n6266 n6383 0.058823529411764705
r9682 n6382 n6383 0.12833333333333333
r9683 n6267 n6384 0.15384615384615385
r9684 n6383 n6384 0.097916666666666666
r9685 n6268 n6385 0.050000000000000003
r9686 n6384 n6385 0.11041666666666666
r9687 n6269 n6386 2
r9688 n6385 n6386 0.085416666666666669
r9689 n6270 n6387 0.060606060606060608
r9690 n6386 n6387 0.070833333333333331
r9691 n6271 n6388 2
r9692 n6387 n6388 0.070833333333333331
r9693 n6272 n6389 0.086956521739130432
r9694 n6388 n6389 0.050000000000000003
r9695 n6273 n6390 0.5
r9696 n6389 n6390 0.056250000000000001
r9697 n6274 n6391 0.33333333333333331
r9698 n6390 n6391 0.020833333333333332
r9699 n6275 n6392 0.40000000000000002
r9700 n6391 n6392 0.022916666666666665
r9701 n6276 n6393 2
r9702 n6392 n6393 0.012500000000000001
r9703 n6277 n6394 0.15384615384615385
r9704 n6393 n6394 0.029166666666666667
r9705 n6278 n6395 0.20000000000000001
r9706 n6394 n6395 0.04791666666666667
r9707 n6279 n6396 0.40000000000000002
r9708 n6395 n6396 0.03125
r9709 n6280 n6397 0.40000000000000002
r9710 n6396 n6397 0.020833333333333332
r9711 n6281 n6398 2
r9712 n6397 n6398 0.012500000000000001
r9713 n6282 n6399 0.66666666666666663
r9714 n6398 n6399 0.0083333333333333332
r9715 n6283 n6400 2
r9716 n6399 n6400 0.0083333333333333332
r9717 n6284 n6401 0.22222222222222221
r9718 n6400 n6401 0.020833333333333332
r9719 n6285 n6402 0.20000000000000001
r9720 n6401 n6402 0.039583333333333331
r9721 n6286 n6403 0.40000000000000002
r9722 n6402 n6403 0.03125
r9723 n6287 n6404 0.40000000000000002
r9724 n6403 n6404 0.020833333333333332
r9725 n6288 n6405 2
r9726 n6404 n6405 0.012500000000000001
r9727 n6289 n6406 1
r9728 n6405 n6406 0.0062500000000000003
r9729 n6290 n6407 2
r9730 n6406 n6407 0.0062500000000000003
r9731 n6291 n6408 2
r9732 n6407 n6408 0.0041666666666666666
r9733 n6292 n6409 2
r9734 n6408 n6409 0.0041666666666666666
r9735 n6293 n6410 0.5
r9736 n6409 n6410 0.010416666666666666
r9737 n6294 n6411 0.40000000000000002
r9738 n6410 n6411 0.018749999999999999
r9739 n6295 n6412 2
r9740 n6411 n6412 0.012500000000000001
r9741 n6296 n6413 0.20000000000000001
r9742 n6412 n6413 0.022916666666666665
r9743 n6297 n6414 0.66666666666666663
r9744 n6413 n6414 0.027083333333333334
r9745 n6298 n6415 0.33333333333333331
r9746 n6414 n6415 0.018749999999999999
r9747 n6299 n6416 1
r9748 n6415 n6416 0.016666666666666666
r9749 n6300 n6417 2
r9750 n6416 n6417 0.0062500000000000003
r9751 n6301 n6418 2
r9752 n6417 n6418 0.0041666666666666666
r9753 n6302 n6419 0.33333333333333331
r9754 n6418 n6419 0.014583333333333334
r9755 n6303 n6420 0.40000000000000002
r9756 n6419 n6420 0.022916666666666665
r9757 n6304 n6421 2
r9758 n6420 n6421 0.012500000000000001
r9759 n6305 n6422 0.5
r9760 n6421 n6422 0.010416666666666666
r9761 n6306 n6423 0.40000000000000002
r9762 n6422 n6423 0.018749999999999999
r9763 n6307 n6424 0.66666666666666663
r9764 n6423 n6424 0.016666666666666666
r9765 n6308 n6425 0.2857142857142857
r9766 n6424 n6425 0.020833333333333332
r9767 n6309 n6426 0.33333333333333331
r9768 n6425 n6426 0.027083333333333334
r9769 n6310 n6427 0.20000000000000001
r9770 n6426 n6427 0.033333333333333333
r9771 n6311 n6428 0.5
r9772 n6427 n6428 0.029166666666666667
r9773 n6312 n6429 0.2857142857142857
r9774 n6428 n6429 0.022916666666666665
r9775 n6313 n6430 0.22222222222222221
r9776 n6429 n6430 0.033333333333333333
r9777 n6314 n6431 0.5
r9778 n6430 n6431 0.027083333333333334
r9779 n6315 n6432 0.25
r9780 n6431 n6432 0.025000000000000001
r9781 n6316 n6433 0.40000000000000002
r9782 n6432 n6433 0.027083333333333334
r9783 n6317 n6434 0.33333333333333331
r9784 n6433 n6434 0.022916666666666665
r9785 n6318 n6435 1
r9786 n6434 n6435 0.016666666666666666
r9787 n6319 n6436 0.11764705882352941
r9788 n6435 n6436 0.039583333333333331
r9789 n6320 n6437 0.15384615384615385
r9790 n6436 n6437 0.0625
r9791 n6321 n6438 1
r9792 n6437 n6438 0.03125
r9793 n6322 n6439 1
r9794 n6438 n6439 0.0083333333333333332
r9795 n6323 n6440 0.5
r9796 n6439 n6440 0.012500000000000001
r9797 n6324 n6441 0.40000000000000002
r9798 n6440 n6441 0.018749999999999999
r9799 n6325 n6442 0.25
r9800 n6441 n6442 0.027083333333333334
r9801 n6326 n6443 0.5
r9802 n6442 n6443 0.025000000000000001
r9803 n6327 n6444 0.15384615384615385
r9804 n6443 n6444 0.035416666666666666
r9805 n6328 n6445 0.2857142857142857
r9806 n6444 n6445 0.041666666666666664
r9807 n6329 n6446 0.07407407407407407
r9808 n6445 n6446 0.070833333333333331
r9809 n6330 n6447 1
r9810 n6446 n6447 0.060416666666666667
r9811 n6331 n6448 0.40000000000000002
r9812 n6447 n6448 0.014583333333333334
r9813 n6332 n6449 0.07407407407407407
r9814 n6448 n6449 0.066666666666666666
r9815 n6333 n6450 1
r9816 n6449 n6450 0.060416666666666667
r9817 n6334 n6451 0.0625
r9818 n6450 n6451 0.070833333333333331
r9819 n6335 n6452 0.058823529411764705
r9820 n6451 n6452 0.13750000000000001
r9821 n6336 n6453 0.058823529411764705
r9822 n6452 n6453 0.14166666666666666
r9823 n6337 n6454 0.058823529411764705
r9824 n6453 n6454 0.14166666666666666
r9825 n6338 n6455 0.058823529411764705
r9826 n6454 n6455 0.14166666666666666
r9827 n6339 n6456 0.058823529411764705
r9828 n6455 n6456 0.14166666666666666
r9829 n6340 n6457 0.058823529411764705
r9830 n6456 n6457 0.14166666666666666
r9831 n6341 n6458 0.058823529411764705
r9832 n6457 n6458 0.14166666666666666
r9833 n6342 n6459 0.058823529411764705
r9834 n6458 n6459 0.14166666666666666
r9835 n6343 n6460 0.058823529411764705
r9836 n6459 n6460 0.14166666666666666
r9837 n6344 n6461 0.058823529411764705
r9838 n6460 n6461 0.14166666666666666
r9839 n6345 n6462 0.058823529411764705
r9840 n6461 n6462 0.14166666666666666
r9841 n6346 n6463 0.058823529411764705
r9842 n6462 n6463 0.14166666666666666
r9843 n6347 n6464 0.058823529411764705
r9844 n6463 n6464 0.14166666666666666
r9845 n6348 n6465 0.058823529411764705
r9846 n6464 n6465 0.14166666666666666
r9847 n6349 n6466 0.058823529411764705
r9848 n6465 n6466 0.14166666666666666
r9849 n6350 n6467 0.058823529411764705
r9850 n6466 n6467 0.14166666666666666
r9851 n6351 n6468 0.058823529411764705
r9852 n6467 n6468 0.14166666666666666
r9853 n6352 n6469 0.058823529411764705
r9854 n6468 n6469 0.14166666666666666
r9855 n6353 n6470 0.058823529411764705
r9856 n6469 n6470 0.14166666666666666
r9857 n6354 n6471 0.058823529411764705
r9858 n6470 n6471 0.14166666666666666
r9859 n6355 n6472 0.058823529411764705
r9860 n6471 n6472 0.14166666666666666
r9861 n6356 n6473 0.058823529411764705
r9862 n6472 n6473 0.14166666666666666
r9863 n6357 n6474 0.18181818181818182
r9864 n6473 n6474 0.09375
r9865 n6358 n6475 0.086956521739130432
r9866 n6474 n6475 0.070833333333333331
r9867 n6359 n6476 1
r9868 n6475 n6476 0.052083333333333336
r9869 n6360 n6477 0.066666666666666666
r9870 n6476 n6477 0.066666666666666666
r9871 n6361 n6478 1
r9872 n6477 n6478 0.066666666666666666
r9873 n6362 n6479 0.086956521739130432
r9874 n6478 n6479 0.052083333333333336
r9875 n6363 n6480 0.20000000000000001
r9876 n6364 n6481 0.080000000000000002
r9877 n6480 n6481 0.072916666666666671
r9878 n6365 n6482 2
r9879 n6481 n6482 0.054166666666666669
r9880 n6366 n6483 0.071428571428571425
r9881 n6482 n6483 0.060416666666666667
r9882 n6367 n6484 2
r9883 n6483 n6484 0.060416666666666667
r9884 n6368 n6485 0.080000000000000002
r9885 n6484 n6485 0.054166666666666669
r9886 n6369 n6486 0.20000000000000001
r9887 n6485 n6486 0.072916666666666671
r9888 n6370 n6487 0.060606060606060608
r9889 n6371 n6488 1
r9890 n6487 n6488 1.09375
r9891 n6372 n6489 0.066666666666666666
r9892 n6488 n6489 1
r9893 n6373 n6490 1
r9894 n6489 n6490 1
r9895 n6374 n6491 0.060606060606060608
r9896 n6490 n6491 1.09375
r9897 n6375 n6492 0.20000000000000001
r9898 n6491 n6492 1.34375
r9899 n6376 n6493 0.40000000000000002
r9900 n6492 n6493 0.46875
r9901 n6377 n6494 0.050761421319796954
r9902 n6493 n6494 1.3875
r9903 n6378 n6495 0.051020408163265307
r9904 n6494 n6495 2.4562499999999998
r9905 n6379 n6496 0.050761421319796954
r9906 n6495 n6496 2.4562499999999998
r9907 n6380 n6497 0.058823529411764705
r9908 n6496 n6497 2.2937500000000002
r9909 n6381 n6498 0.072992700729927001
r9910 n6497 n6498 1.91875
r9911 n6382 n6499 0.072463768115942032
r9912 n6498 n6499 1.71875
r9913 n6383 n6500 0.058823529411764705
r9914 n6499 n6500 1.925
r9915 n6384 n6501 0.15384615384615385
r9916 n6500 n6501 1.46875
r9917 n6385 n6502 0.050000000000000003
r9918 n6501 n6502 1.65625
r9919 n6386 n6503 2
r9920 n6502 n6503 1.28125
r9921 n6387 n6504 0.060606060606060608
r9922 n6503 n6504 1.0625
r9923 n6388 n6505 2
r9924 n6504 n6505 1.0625
r9925 n6389 n6506 0.086956521739130432
r9926 n6505 n6506 0.75
r9927 n6390 n6507 0.5
r9928 n6506 n6507 0.84375
r9929 n6391 n6508 0.33333333333333331
r9930 n6507 n6508 0.3125
r9931 n6392 n6509 0.40000000000000002
r9932 n6508 n6509 0.34375
r9933 n6393 n6510 2
r9934 n6509 n6510 0.1875
r9935 n6394 n6511 0.15384615384615385
r9936 n6510 n6511 0.4375
r9937 n6395 n6512 0.20000000000000001
r9938 n6511 n6512 0.71875
r9939 n6396 n6513 0.40000000000000002
r9940 n6512 n6513 0.46875
r9941 n6397 n6514 0.40000000000000002
r9942 n6513 n6514 0.3125
r9943 n6398 n6515 2
r9944 n6514 n6515 0.1875
r9945 n6399 n6516 0.66666666666666663
r9946 n6515 n6516 0.125
r9947 n6400 n6517 2
r9948 n6516 n6517 0.125
r9949 n6401 n6518 0.22222222222222221
r9950 n6517 n6518 0.3125
r9951 n6402 n6519 0.20000000000000001
r9952 n6518 n6519 0.59375
r9953 n6403 n6520 0.40000000000000002
r9954 n6519 n6520 0.46875
r9955 n6404 n6521 0.40000000000000002
r9956 n6520 n6521 0.3125
r9957 n6405 n6522 2
r9958 n6521 n6522 0.1875
r9959 n6406 n6523 1
r9960 n6522 n6523 0.09375
r9961 n6407 n6524 2
r9962 n6523 n6524 0.09375
r9963 n6408 n6525 2
r9964 n6524 n6525 0.0625
r9965 n6409 n6526 2
r9966 n6525 n6526 0.0625
r9967 n6410 n6527 0.5
r9968 n6526 n6527 0.15625
r9969 n6411 n6528 0.40000000000000002
r9970 n6527 n6528 0.28125
r9971 n6412 n6529 2
r9972 n6528 n6529 0.1875
r9973 n6413 n6530 0.20000000000000001
r9974 n6529 n6530 0.34375
r9975 n6414 n6531 0.66666666666666663
r9976 n6530 n6531 0.40625
r9977 n6415 n6532 0.33333333333333331
r9978 n6531 n6532 0.28125
r9979 n6416 n6533 1
r9980 n6532 n6533 0.25
r9981 n6417 n6534 2
r9982 n6533 n6534 0.09375
r9983 n6418 n6535 2
r9984 n6534 n6535 0.0625
r9985 n6419 n6536 0.33333333333333331
r9986 n6535 n6536 0.21875
r9987 n6420 n6537 0.40000000000000002
r9988 n6536 n6537 0.34375
r9989 n6421 n6538 2
r9990 n6537 n6538 0.1875
r9991 n6422 n6539 0.5
r9992 n6538 n6539 0.15625
r9993 n6423 n6540 0.40000000000000002
r9994 n6539 n6540 0.28125
r9995 n6424 n6541 0.66666666666666663
r9996 n6540 n6541 0.25
r9997 n6425 n6542 0.2857142857142857
r9998 n6541 n6542 0.3125
r9999 n6426 n6543 0.33333333333333331
r10000 n6542 n6543 0.40625
r10001 n6427 n6544 0.20000000000000001
r10002 n6543 n6544 0.5
r10003 n6428 n6545 0.5
r10004 n6544 n6545 0.4375
r10005 n6429 n6546 0.2857142857142857
r10006 n6545 n6546 0.34375
r10007 n6430 n6547 0.22222222222222221
r10008 n6546 n6547 0.5
r10009 n6431 n6548 0.5
r10010 n6547 n6548 0.40625
r10011 n6432 n6549 0.25
r10012 n6548 n6549 0.375
r10013 n6433 n6550 0.40000000000000002
r10014 n6549 n6550 0.40625
r10015 n6434 n6551 0.33333333333333331
r10016 n6550 n6551 0.34375
r10017 n6435 n6552 1
r10018 n6551 n6552 0.25
r10019 n6436 n6553 0.11764705882352941
r10020 n6552 n6553 0.59375
r10021 n6437 n6554 0.15384615384615385
r10022 n6553 n6554 0.9375
r10023 n6438 n6555 1
r10024 n6554 n6555 0.46875
r10025 n6439 n6556 1
r10026 n6555 n6556 0.125
r10027 n6440 n6557 0.5
r10028 n6556 n6557 0.1875
r10029 n6441 n6558 0.40000000000000002
r10030 n6557 n6558 0.28125
r10031 n6442 n6559 0.25
r10032 n6558 n6559 0.40625
r10033 n6443 n6560 0.5
r10034 n6559 n6560 0.375
r10035 n6444 n6561 0.15384615384615385
r10036 n6560 n6561 0.53125
r10037 n6445 n6562 0.2857142857142857
r10038 n6561 n6562 0.625
r10039 n6446 n6563 0.07407407407407407
r10040 n6562 n6563 1.0625
r10041 n6447 n6564 1
r10042 n6563 n6564 0.90625
r10043 n6448 n6565 0.40000000000000002
r10044 n6564 n6565 0.21875
r10045 n6449 n6566 0.07407407407407407
r10046 n6565 n6566 1
r10047 n6450 n6567 1
r10048 n6566 n6567 0.90625
r10049 n6451 n6568 0.0625
r10050 n6567 n6568 1.0625
r10051 n6452 n6569 0.058823529411764705
r10052 n6568 n6569 2.0625
r10053 n6453 n6570 0.058823529411764705
r10054 n6569 n6570 2.125
r10055 n6454 n6571 0.058823529411764705
r10056 n6570 n6571 2.125
r10057 n6455 n6572 0.058823529411764705
r10058 n6571 n6572 2.125
r10059 n6456 n6573 0.058823529411764705
r10060 n6572 n6573 2.125
r10061 n6457 n6574 0.058823529411764705
r10062 n6573 n6574 2.125
r10063 n6458 n6575 0.058823529411764705
r10064 n6574 n6575 2.125
r10065 n6459 n6576 0.058823529411764705
r10066 n6575 n6576 2.125
r10067 n6460 n6577 0.058823529411764705
r10068 n6576 n6577 2.125
r10069 n6461 n6578 0.058823529411764705
r10070 n6577 n6578 2.125
r10071 n6462 n6579 0.058823529411764705
r10072 n6578 n6579 2.125
r10073 n6463 n6580 0.058823529411764705
r10074 n6579 n6580 2.125
r10075 n6464 n6581 0.058823529411764705
r10076 n6580 n6581 2.125
r10077 n6465 n6582 0.058823529411764705
r10078 n6581 n6582 2.125
r10079 n6466 n6583 0.058823529411764705
r10080 n6582 n6583 2.125
r10081 n6467 n6584 0.058823529411764705
r10082 n6583 n6584 2.125
r10083 n6468 n6585 0.058823529411764705
r10084 n6584 n6585 2.125
r10085 n6469 n6586 0.058823529411764705
r10086 n6585 n6586 2.125
r10087 n6470 n6587 0.058823529411764705
r10088 n6586 n6587 2.125
r10089 n6471 n6588 0.058823529411764705
r10090 n6587 n6588 2.125
r10091 n6472 n6589 0.058823529411764705
r10092 n6588 n6589 2.125
r10093 n6473 n6590 0.058823529411764705
r10094 n6589 n6590 2.125
r10095 n6474 n6591 0.18181818181818182
r10096 n6590 n6591 1.40625
r10097 n6475 n6592 0.086956521739130432
r10098 n6591 n6592 1.0625
r10099 n6476 n6593 1
r10100 n6592 n6593 0.78125
r10101 n6477 n6594 0.066666666666666666
r10102 n6593 n6594 1
r10103 n6478 n6595 1
r10104 n6594 n6595 1
r10105 n6479 n6596 0.086956521739130432
r10106 n6595 n6596 0.78125
r10107 n6480 n6597 0.20000000000000001
r10108 n6481 n6598 0.080000000000000002
r10109 n6597 n6598 1.09375
r10110 n6482 n6599 2
r10111 n6598 n6599 0.8125
r10112 n6483 n6600 0.071428571428571425
r10113 n6599 n6600 0.90625
r10114 n6484 n6601 2
r10115 n6600 n6601 0.90625
r10116 n6485 n6602 0.080000000000000002
r10117 n6601 n6602 0.8125
r10118 n6486 n6603 0.20000000000000001
r10119 n6602 n6603 1.09375
r10120 n6487 n6604 0.02462121212121212
r10121 n6488 n6605 0.40625
r10122 n6604 n6605 0.19886363636363635
r10123 n6489 n6606 0.027083333333333334
r10124 n6605 n6606 0.18181818181818182
r10125 n6490 n6607 0.40625
r10126 n6606 n6607 0.18181818181818182
r10127 n6491 n6608 0.02462121212121212
r10128 n6607 n6608 0.19886363636363635
r10129 n6492 n6609 0.081250000000000003
r10130 n6608 n6609 0.24431818181818182
r10131 n6493 n6610 0.16250000000000001
r10132 n6609 n6610 0.085227272727272721
r10133 n6494 n6611 0.020621827411167512
r10134 n6610 n6611 0.25227272727272726
r10135 n6495 n6612 0.020727040816326529
r10136 n6611 n6612 0.44659090909090909
r10137 n6496 n6613 0.020621827411167512
r10138 n6612 n6613 0.44659090909090909
r10139 n6497 n6614 0.02389705882352941
r10140 n6613 n6614 0.41704545454545455
r10141 n6498 n6615 0.029653284671532845
r10142 n6614 n6615 0.34886363636363638
r10143 n6499 n6616 0.029438405797101448
r10144 n6615 n6616 0.3125
r10145 n6500 n6617 0.02389705882352941
r10146 n6616 n6617 0.34999999999999998
r10147 n6501 n6618 0.0625
r10148 n6617 n6618 0.26704545454545453
r10149 n6502 n6619 0.020312500000000001
r10150 n6618 n6619 0.30113636363636365
r10151 n6503 n6620 0.8125
r10152 n6619 n6620 0.23295454545454544
r10153 n6504 n6621 0.02462121212121212
r10154 n6620 n6621 0.19318181818181818
r10155 n6505 n6622 0.8125
r10156 n6621 n6622 0.19318181818181818
r10157 n6506 n6623 0.035326086956521736
r10158 n6622 n6623 0.13636363636363635
r10159 n6507 n6624 0.203125
r10160 n6623 n6624 0.15340909090909091
r10161 n6508 n6625 0.13541666666666666
r10162 n6624 n6625 0.056818181818181816
r10163 n6509 n6626 0.16250000000000001
r10164 n6625 n6626 0.0625
r10165 n6510 n6627 0.8125
r10166 n6626 n6627 0.034090909090909088
r10167 n6511 n6628 0.0625
r10168 n6627 n6628 0.079545454545454544
r10169 n6512 n6629 0.081250000000000003
r10170 n6628 n6629 0.13068181818181818
r10171 n6513 n6630 0.16250000000000001
r10172 n6629 n6630 0.085227272727272721
r10173 n6514 n6631 0.16250000000000001
r10174 n6630 n6631 0.056818181818181816
r10175 n6515 n6632 0.8125
r10176 n6631 n6632 0.034090909090909088
r10177 n6516 n6633 0.27083333333333331
r10178 n6632 n6633 0.022727272727272728
r10179 n6517 n6634 0.8125
r10180 n6633 n6634 0.022727272727272728
r10181 n6518 n6635 0.090277777777777776
r10182 n6634 n6635 0.056818181818181816
r10183 n6519 n6636 0.081250000000000003
r10184 n6635 n6636 0.10795454545454546
r10185 n6520 n6637 0.16250000000000001
r10186 n6636 n6637 0.085227272727272721
r10187 n6521 n6638 0.16250000000000001
r10188 n6637 n6638 0.056818181818181816
r10189 n6522 n6639 0.8125
r10190 n6638 n6639 0.034090909090909088
r10191 n6523 n6640 0.40625
r10192 n6639 n6640 0.017045454545454544
r10193 n6524 n6641 0.8125
r10194 n6640 n6641 0.017045454545454544
r10195 n6525 n6642 0.8125
r10196 n6641 n6642 0.011363636363636364
r10197 n6526 n6643 0.8125
r10198 n6642 n6643 0.011363636363636364
r10199 n6527 n6644 0.203125
r10200 n6643 n6644 0.028409090909090908
r10201 n6528 n6645 0.16250000000000001
r10202 n6644 n6645 0.05113636363636364
r10203 n6529 n6646 0.8125
r10204 n6645 n6646 0.034090909090909088
r10205 n6530 n6647 0.081250000000000003
r10206 n6646 n6647 0.0625
r10207 n6531 n6648 0.27083333333333331
r10208 n6647 n6648 0.073863636363636367
r10209 n6532 n6649 0.13541666666666666
r10210 n6648 n6649 0.05113636363636364
r10211 n6533 n6650 0.40625
r10212 n6649 n6650 0.045454545454545456
r10213 n6534 n6651 0.8125
r10214 n6650 n6651 0.017045454545454544
r10215 n6535 n6652 0.8125
r10216 n6651 n6652 0.011363636363636364
r10217 n6536 n6653 0.13541666666666666
r10218 n6652 n6653 0.039772727272727272
r10219 n6537 n6654 0.16250000000000001
r10220 n6653 n6654 0.0625
r10221 n6538 n6655 0.8125
r10222 n6654 n6655 0.034090909090909088
r10223 n6539 n6656 0.203125
r10224 n6655 n6656 0.028409090909090908
r10225 n6540 n6657 0.16250000000000001
r10226 n6656 n6657 0.05113636363636364
r10227 n6541 n6658 0.27083333333333331
r10228 n6657 n6658 0.045454545454545456
r10229 n6542 n6659 0.11607142857142858
r10230 n6658 n6659 0.056818181818181816
r10231 n6543 n6660 0.13541666666666666
r10232 n6659 n6660 0.073863636363636367
r10233 n6544 n6661 0.081250000000000003
r10234 n6660 n6661 0.090909090909090912
r10235 n6545 n6662 0.203125
r10236 n6661 n6662 0.079545454545454544
r10237 n6546 n6663 0.11607142857142858
r10238 n6662 n6663 0.0625
r10239 n6547 n6664 0.090277777777777776
r10240 n6663 n6664 0.090909090909090912
r10241 n6548 n6665 0.203125
r10242 n6664 n6665 0.073863636363636367
r10243 n6549 n6666 0.1015625
r10244 n6665 n6666 0.068181818181818177
r10245 n6550 n6667 0.16250000000000001
r10246 n6666 n6667 0.073863636363636367
r10247 n6551 n6668 0.13541666666666666
r10248 n6667 n6668 0.0625
r10249 n6552 n6669 0.40625
r10250 n6668 n6669 0.045454545454545456
r10251 n6553 n6670 0.04779411764705882
r10252 n6669 n6670 0.10795454545454546
r10253 n6554 n6671 0.0625
r10254 n6670 n6671 0.17045454545454544
r10255 n6555 n6672 0.40625
r10256 n6671 n6672 0.085227272727272721
r10257 n6556 n6673 0.40625
r10258 n6672 n6673 0.022727272727272728
r10259 n6557 n6674 0.203125
r10260 n6673 n6674 0.034090909090909088
r10261 n6558 n6675 0.16250000000000001
r10262 n6674 n6675 0.05113636363636364
r10263 n6559 n6676 0.1015625
r10264 n6675 n6676 0.073863636363636367
r10265 n6560 n6677 0.203125
r10266 n6676 n6677 0.068181818181818177
r10267 n6561 n6678 0.0625
r10268 n6677 n6678 0.096590909090909088
r10269 n6562 n6679 0.11607142857142858
r10270 n6678 n6679 0.11363636363636363
r10271 n6563 n6680 0.030092592592592591
r10272 n6679 n6680 0.19318181818181818
r10273 n6564 n6681 0.40625
r10274 n6680 n6681 0.16477272727272727
r10275 n6565 n6682 0.16250000000000001
r10276 n6681 n6682 0.039772727272727272
r10277 n6566 n6683 0.030092592592592591
r10278 n6682 n6683 0.18181818181818182
r10279 n6567 n6684 0.40625
r10280 n6683 n6684 0.16477272727272727
r10281 n6568 n6685 0.025390625
r10282 n6684 n6685 0.19318181818181818
r10283 n6569 n6686 0.02389705882352941
r10284 n6685 n6686 0.375
r10285 n6570 n6687 0.02389705882352941
r10286 n6686 n6687 0.38636363636363635
r10287 n6571 n6688 0.02389705882352941
r10288 n6687 n6688 0.38636363636363635
r10289 n6572 n6689 0.02389705882352941
r10290 n6688 n6689 0.38636363636363635
r10291 n6573 n6690 0.02389705882352941
r10292 n6689 n6690 0.38636363636363635
r10293 n6574 n6691 0.02389705882352941
r10294 n6690 n6691 0.38636363636363635
r10295 n6575 n6692 0.02389705882352941
r10296 n6691 n6692 0.38636363636363635
r10297 n6576 n6693 0.02389705882352941
r10298 n6692 n6693 0.38636363636363635
r10299 n6577 n6694 0.02389705882352941
r10300 n6693 n6694 0.38636363636363635
r10301 n6578 n6695 0.02389705882352941
r10302 n6694 n6695 0.38636363636363635
r10303 n6579 n6696 0.02389705882352941
r10304 n6695 n6696 0.38636363636363635
r10305 n6580 n6697 0.02389705882352941
r10306 n6696 n6697 0.38636363636363635
r10307 n6581 n6698 0.02389705882352941
r10308 n6697 n6698 0.38636363636363635
r10309 n6582 n6699 0.02389705882352941
r10310 n6698 n6699 0.38636363636363635
r10311 n6583 n6700 0.02389705882352941
r10312 n6699 n6700 0.38636363636363635
r10313 n6584 n6701 0.02389705882352941
r10314 n6700 n6701 0.38636363636363635
r10315 n6585 n6702 0.02389705882352941
r10316 n6701 n6702 0.38636363636363635
r10317 n6586 n6703 0.02389705882352941
r10318 n6702 n6703 0.38636363636363635
r10319 n6587 n6704 0.02389705882352941
r10320 n6703 n6704 0.38636363636363635
r10321 n6588 n6705 0.02389705882352941
r10322 n6704 n6705 0.38636363636363635
r10323 n6589 n6706 0.02389705882352941
r10324 n6705 n6706 0.38636363636363635
r10325 n6590 n6707 0.02389705882352941
r10326 n6706 n6707 0.38636363636363635
r10327 n6591 n6708 0.073863636363636367
r10328 n6707 n6708 0.25568181818181818
r10329 n6592 n6709 0.035326086956521736
r10330 n6708 n6709 0.19318181818181818
r10331 n6593 n6710 0.40625
r10332 n6709 n6710 0.14204545454545456
r10333 n6594 n6711 0.027083333333333334
r10334 n6710 n6711 0.18181818181818182
r10335 n6595 n6712 0.40625
r10336 n6711 n6712 0.18181818181818182
r10337 n6596 n6713 0.035326086956521736
r10338 n6712 n6713 0.14204545454545456
r10339 n6597 n6714 0.081250000000000003
r10340 n6598 n6715 0.032500000000000001
r10341 n6714 n6715 0.19886363636363635
r10342 n6599 n6716 0.8125
r10343 n6715 n6716 0.14772727272727273
r10344 n6600 n6717 0.029017857142857144
r10345 n6716 n6717 0.16477272727272727
r10346 n6601 n6718 0.8125
r10347 n6717 n6718 0.16477272727272727
r10348 n6602 n6719 0.032500000000000001
r10349 n6718 n6719 0.14772727272727273
r10350 n6603 n6720 0.081250000000000003
r10351 n6719 n6720 0.19886363636363635
r10352 n6604 n6721 0.02462121212121212
r10353 n6605 n6722 0.40625
r10354 n6721 n6722 1.09375
r10355 n6606 n6723 0.027083333333333334
r10356 n6722 n6723 1
r10357 n6607 n6724 0.40625
r10358 n6723 n6724 1
r10359 n6608 n6725 0.02462121212121212
r10360 n6724 n6725 1.09375
r10361 n6709 n6726 0.035326086956521736
r10362 n6710 n6727 0.40625
r10363 n6726 n6727 0.78125
r10364 n6711 n6728 0.027083333333333334
r10365 n6727 n6728 1
r10366 n6712 n6729 0.40625
r10367 n6728 n6729 1
r10368 n6713 n6730 0.035326086956521736
r10369 n6729 n6730 0.78125
r10370 n6714 n6731 0.081250000000000003
r10371 n6715 n6732 0.032500000000000001
r10372 n6731 n6732 1.09375
r10373 n6716 n6733 0.8125
r10374 n6732 n6733 0.8125
r10375 n6717 n6734 0.029017857142857144
r10376 n6733 n6734 0.90625
r10377 n6718 n6735 0.8125
r10378 n6734 n6735 0.90625
r10379 n6719 n6736 0.032500000000000001
r10380 n6735 n6736 0.8125
r10381 n6720 n6737 0.081250000000000003
r10382 n6736 n6737 1.09375
r10383 n6721 n6738 0.067424242424242428
r10384 n6722 n6739 1.1125
r10385 n6738 n6739 0.065104166666666671
r10386 n6723 n6740 0.074166666666666672
r10387 n6739 n6740 0.059523809523809521
r10388 n6724 n6741 1.1125
r10389 n6740 n6741 0.059523809523809521
r10390 n6725 n6742 0.067424242424242428
r10391 n6741 n6742 0.065104166666666671
r10392 n6731 n6743 0.2225
r10393 n6732 n6744 0.088999999999999996
r10394 n6743 n6744 0.065104166666666671
r10395 n6733 n6745 2.2250000000000001
r10396 n6744 n6745 0.04836309523809524
r10397 n6734 n6746 0.07946428571428571
r10398 n6745 n6746 0.053943452380952384
r10399 n6735 n6747 2.2250000000000001
r10400 n6746 n6747 0.053943452380952384
r10401 n6736 n6748 0.088999999999999996
r10402 n6747 n6748 0.04836309523809524
r10403 n6737 n6749 0.2225
r10404 n6748 n6749 0.065104166666666671
r10405 n6738 n6750 0.12689393939393939
r10406 n6739 n6751 2.09375
r10407 n6750 n6751 0.0654940119760479
r10408 n6740 n6752 0.13958333333333334
r10409 n6751 n6752 0.059880239520958084
r10410 n6741 n6753 2.09375
r10411 n6752 n6753 0.059880239520958084
r10412 n6742 n6754 0.12689393939393939
r10413 n6753 n6754 0.0654940119760479
r10414 n6743 n6755 0.41875000000000001
r10415 n6744 n6756 0.16750000000000001
r10416 n6755 n6756 0.0654940119760479
r10417 n6745 n6757 4.1875
r10418 n6756 n6757 0.048652694610778445
r10419 n6746 n6758 0.14955357142857142
r10420 n6757 n6758 0.054266467065868261
r10421 n6747 n6759 4.1875
r10422 n6758 n6759 0.054266467065868261
r10423 n6748 n6760 0.16750000000000001
r10424 n6759 n6760 0.048652694610778445
r10425 n6749 n6761 0.41875000000000001
r10426 n6760 n6761 0.0654940119760479
r10427 n6750 n6762 0.084090909090909091
r10428 n6751 n6763 1.3875
r10429 n6762 n6763 0.19886363636363635
r10430 n6752 n6764 0.092499999999999999
r10431 n6763 n6764 0.18181818181818182
r10432 n6753 n6765 1.3875
r10433 n6764 n6765 0.18181818181818182
r10434 n6754 n6766 0.084090909090909091
r10435 n6765 n6766 0.19886363636363635
r10436 n6755 n6767 0.27750000000000002
r10437 n6756 n6768 0.111
r10438 n6767 n6768 0.19886363636363635
r10439 n6757 n6769 2.7749999999999999
r10440 n6768 n6769 0.14772727272727273
r10441 n6758 n6770 0.099107142857142852
r10442 n6769 n6770 0.16477272727272727
r10443 n6759 n6771 2.7749999999999999
r10444 n6770 n6771 0.16477272727272727
r10445 n6760 n6772 0.111
r10446 n6771 n6772 0.14772727272727273
r10447 n6761 n6773 0.27750000000000002
r10448 n6772 n6773 0.19886363636363635
r10449 n6762 n6774 0.039772727272727272
r10450 n6763 n6775 0.65625
r10451 n6774 n6775 0.21875
r10452 n6764 n6776 0.043749999999999997
r10453 n6775 n6776 0.20000000000000001
r10454 n6765 n6777 0.65625
r10455 n6776 n6777 0.20000000000000001
r10456 n6766 n6778 0.039772727272727272
r10457 n6777 n6778 0.21875
r10458 n6779 n6780 0.0625
r10459 n6780 n6781 0.037499999999999999
r10460 n6781 n6782 0.018749999999999999
r10461 n6782 n6783 0.018749999999999999
r10462 n6783 n6784 0.012500000000000001
r10463 n6784 n6785 0.012500000000000001
r10464 n6785 n6786 0.03125
r10465 n6786 n6787 0.056250000000000001
r10466 n6787 n6788 0.037499999999999999
r10467 n6788 n6789 0.068750000000000006
r10468 n6789 n6790 0.081250000000000003
r10469 n6790 n6791 0.056250000000000001
r10470 n6791 n6792 0.050000000000000003
r10471 n6792 n6793 0.018749999999999999
r10472 n6793 n6794 0.012500000000000001
r10473 n6794 n6795 0.043749999999999997
r10474 n6795 n6796 0.068750000000000006
r10475 n6796 n6797 0.037499999999999999
r10476 n6797 n6798 0.03125
r10477 n6798 n6799 0.056250000000000001
r10478 n6799 n6800 0.050000000000000003
r10479 n6800 n6801 0.0625
r10480 n6767 n6802 0.13125000000000001
r10481 n6768 n6803 0.052499999999999998
r10482 n6802 n6803 0.21875
r10483 n6769 n6804 1.3125
r10484 n6803 n6804 0.16250000000000001
r10485 n6770 n6805 0.046875
r10486 n6804 n6805 0.18124999999999999
r10487 n6771 n6806 1.3125
r10488 n6805 n6806 0.18124999999999999
r10489 n6772 n6807 0.052499999999999998
r10490 n6806 n6807 0.16250000000000001
r10491 n6773 n6808 0.13125000000000001
r10492 n6807 n6808 0.21875
r10493 n6774 n6809 0.022727272727272728
r10494 n6775 n6810 0.375
r10495 n6809 n6810 1.09375
r10496 n6776 n6811 0.025000000000000001
r10497 n6810 n6811 1
r10498 n6777 n6812 0.375
r10499 n6811 n6812 1
r10500 n6778 n6813 0.022727272727272728
r10501 n6812 n6813 1.09375
r10502 n6779 n6814 0.14999999999999999
r10503 n6780 n6815 0.14999999999999999
r10504 n6814 n6815 0.3125
r10505 n6781 n6816 0.75
r10506 n6815 n6816 0.1875
r10507 n6782 n6817 0.375
r10508 n6816 n6817 0.09375
r10509 n6783 n6818 0.75
r10510 n6817 n6818 0.09375
r10511 n6784 n6819 0.75
r10512 n6818 n6819 0.0625
r10513 n6785 n6820 0.75
r10514 n6819 n6820 0.0625
r10515 n6786 n6821 0.1875
r10516 n6820 n6821 0.15625
r10517 n6787 n6822 0.14999999999999999
r10518 n6821 n6822 0.28125
r10519 n6788 n6823 0.75
r10520 n6822 n6823 0.1875
r10521 n6789 n6824 0.074999999999999997
r10522 n6823 n6824 0.34375
r10523 n6790 n6825 0.25
r10524 n6824 n6825 0.40625
r10525 n6791 n6826 0.125
r10526 n6825 n6826 0.28125
r10527 n6792 n6827 0.375
r10528 n6826 n6827 0.25
r10529 n6793 n6828 0.75
r10530 n6827 n6828 0.09375
r10531 n6794 n6829 0.75
r10532 n6828 n6829 0.0625
r10533 n6795 n6830 0.125
r10534 n6829 n6830 0.21875
r10535 n6796 n6831 0.14999999999999999
r10536 n6830 n6831 0.34375
r10537 n6797 n6832 0.75
r10538 n6831 n6832 0.1875
r10539 n6798 n6833 0.1875
r10540 n6832 n6833 0.15625
r10541 n6799 n6834 0.14999999999999999
r10542 n6833 n6834 0.28125
r10543 n6800 n6835 0.25
r10544 n6834 n6835 0.25
r10545 n6801 n6836 0.10714285714285714
r10546 n6835 n6836 0.3125
r10547 n6837 n6838 0.78125
r10548 n6838 n6839 1.0625
r10549 n6839 n6840 0.9375
r10550 n6840 n6841 1.0625
r10551 n6841 n6842 0.78125
r10552 n6802 n6843 0.074999999999999997
r10553 n6803 n6844 0.029999999999999999
r10554 n6843 n6844 1.09375
r10555 n6804 n6845 0.75
r10556 n6844 n6845 0.8125
r10557 n6805 n6846 0.026785714285714284
r10558 n6845 n6846 0.90625
r10559 n6806 n6847 0.75
r10560 n6846 n6847 0.90625
r10561 n6807 n6848 0.029999999999999999
r10562 n6847 n6848 0.8125
r10563 n6808 n6849 0.074999999999999997
r10564 n6848 n6849 1.09375
r10565 n6809 n6850 0.00946969696969697
r10566 n6810 n6851 0.15625
r10567 n6850 n6851 0.72916666666666663
r10568 n6811 n6852 0.010416666666666666
r10569 n6851 n6852 0.66666666666666663
r10570 n6812 n6853 0.15625
r10571 n6852 n6853 0.66666666666666663
r10572 n6813 n6854 0.00946969696969697
r10573 n6853 n6854 0.72916666666666663
r10574 n6814 n6855 0.0625
r10575 n6815 n6856 0.0625
r10576 n6855 n6856 0.20833333333333334
r10577 n6816 n6857 0.3125
r10578 n6856 n6857 0.125
r10579 n6817 n6858 0.15625
r10580 n6857 n6858 0.0625
r10581 n6818 n6859 0.3125
r10582 n6858 n6859 0.0625
r10583 n6819 n6860 0.3125
r10584 n6859 n6860 0.041666666666666664
r10585 n6820 n6861 0.3125
r10586 n6860 n6861 0.041666666666666664
r10587 n6821 n6862 0.078125
r10588 n6861 n6862 0.10416666666666667
r10589 n6822 n6863 0.0625
r10590 n6862 n6863 0.1875
r10591 n6823 n6864 0.3125
r10592 n6863 n6864 0.125
r10593 n6824 n6865 0.03125
r10594 n6864 n6865 0.22916666666666666
r10595 n6825 n6866 0.10416666666666667
r10596 n6865 n6866 0.27083333333333331
r10597 n6826 n6867 0.052083333333333336
r10598 n6866 n6867 0.1875
r10599 n6827 n6868 0.15625
r10600 n6867 n6868 0.16666666666666666
r10601 n6828 n6869 0.3125
r10602 n6868 n6869 0.0625
r10603 n6829 n6870 0.3125
r10604 n6869 n6870 0.041666666666666664
r10605 n6830 n6871 0.052083333333333336
r10606 n6870 n6871 0.14583333333333334
r10607 n6831 n6872 0.0625
r10608 n6871 n6872 0.22916666666666666
r10609 n6832 n6873 0.3125
r10610 n6872 n6873 0.125
r10611 n6833 n6874 0.078125
r10612 n6873 n6874 0.10416666666666667
r10613 n6834 n6875 0.0625
r10614 n6874 n6875 0.1875
r10615 n6835 n6876 0.10416666666666667
r10616 n6875 n6876 0.16666666666666666
r10617 n6836 n6877 0.044642857142857144
r10618 n6876 n6877 0.20833333333333334
r10619 n6837 n6878 0.044642857142857144
r10620 n6838 n6879 0.017361111111111112
r10621 n6878 n6879 0.52083333333333337
r10622 n6839 n6880 0.01953125
r10623 n6879 n6880 0.70833333333333337
r10624 n6840 n6881 0.022321428571428572
r10625 n6880 n6881 0.625
r10626 n6841 n6882 0.015625
r10627 n6881 n6882 0.70833333333333337
r10628 n6842 n6883 0.0625
r10629 n6882 n6883 0.52083333333333337
r10630 n6883 n6884 0.70833333333333337
r10631 n6884 n6885 1.3125
r10632 n6885 n6886 1.4166666666666667
r10633 n6886 n6887 1.4166666666666667
r10634 n6887 n6888 1.5416666666666667
r10635 n6888 n6889 1.5416666666666667
r10636 n6889 n6890 1.4166666666666667
r10637 n6890 n6891 1.4166666666666667
r10638 n6891 n6892 1.0625
r10639 n6892 n6893 0.70833333333333337
r10640 n6893 n6894 1.2083333333333333
r10641 n6894 n6895 1.7083333333333333
r10642 n6895 n6896 1.7083333333333333
r10643 n6896 n6897 1.0625
r10644 n6843 n6898 0.03125
r10645 n6897 n6898 0.41666666666666669
r10646 n6844 n6899 0.012500000000000001
r10647 n6898 n6899 0.72916666666666663
r10648 n6845 n6900 0.3125
r10649 n6899 n6900 0.54166666666666663
r10650 n6846 n6901 0.011160714285714286
r10651 n6900 n6901 0.60416666666666663
r10652 n6847 n6902 0.3125
r10653 n6901 n6902 0.60416666666666663
r10654 n6848 n6903 0.012500000000000001
r10655 n6902 n6903 0.54166666666666663
r10656 n6849 n6904 0.03125
r10657 n6903 n6904 0.72916666666666663
r10658 n6850 n6905 0.015151515151515152
r10659 n6851 n6906 0.25
r10660 n6905 n6906 0.4375
r10661 n6852 n6907 0.016666666666666666
r10662 n6906 n6907 0.40000000000000002
r10663 n6853 n6908 0.25
r10664 n6907 n6908 0.40000000000000002
r10665 n6854 n6909 0.015151515151515152
r10666 n6908 n6909 0.4375
r10667 n6855 n6910 0.10000000000000001
r10668 n6856 n6911 0.10000000000000001
r10669 n6910 n6911 0.125
r10670 n6857 n6912 0.5
r10671 n6911 n6912 0.074999999999999997
r10672 n6858 n6913 0.25
r10673 n6912 n6913 0.037499999999999999
r10674 n6859 n6914 0.5
r10675 n6913 n6914 0.037499999999999999
r10676 n6860 n6915 0.5
r10677 n6914 n6915 0.025000000000000001
r10678 n6861 n6916 0.5
r10679 n6915 n6916 0.025000000000000001
r10680 n6862 n6917 0.125
r10681 n6916 n6917 0.0625
r10682 n6863 n6918 0.10000000000000001
r10683 n6917 n6918 0.1125
r10684 n6864 n6919 0.5
r10685 n6918 n6919 0.074999999999999997
r10686 n6865 n6920 0.050000000000000003
r10687 n6919 n6920 0.13750000000000001
r10688 n6866 n6921 0.16666666666666666
r10689 n6920 n6921 0.16250000000000001
r10690 n6867 n6922 0.083333333333333329
r10691 n6921 n6922 0.1125
r10692 n6868 n6923 0.25
r10693 n6922 n6923 0.10000000000000001
r10694 n6869 n6924 0.5
r10695 n6923 n6924 0.037499999999999999
r10696 n6870 n6925 0.5
r10697 n6924 n6925 0.025000000000000001
r10698 n6871 n6926 0.083333333333333329
r10699 n6925 n6926 0.087499999999999994
r10700 n6872 n6927 0.10000000000000001
r10701 n6926 n6927 0.13750000000000001
r10702 n6873 n6928 0.5
r10703 n6927 n6928 0.074999999999999997
r10704 n6874 n6929 0.125
r10705 n6928 n6929 0.0625
r10706 n6875 n6930 0.10000000000000001
r10707 n6929 n6930 0.1125
r10708 n6876 n6931 0.16666666666666666
r10709 n6930 n6931 0.10000000000000001
r10710 n6877 n6932 0.071428571428571425
r10711 n6931 n6932 0.125
r10712 n6878 n6933 0.071428571428571425
r10713 n6879 n6934 0.027777777777777776
r10714 n6933 n6934 0.3125
r10715 n6880 n6935 0.03125
r10716 n6934 n6935 0.42499999999999999
r10717 n6881 n6936 0.035714285714285712
r10718 n6935 n6936 0.375
r10719 n6882 n6937 0.025000000000000001
r10720 n6936 n6937 0.42499999999999999
r10721 n6883 n6938 0.10000000000000001
r10722 n6937 n6938 0.3125
r10723 n6884 n6939 0.017241379310344827
r10724 n6938 n6939 0.42499999999999999
r10725 n6885 n6940 0.014705882352941176
r10726 n6939 n6940 0.78749999999999998
r10727 n6886 n6941 0.014705882352941176
r10728 n6940 n6941 0.84999999999999998
r10729 n6887 n6942 0.014705882352941176
r10730 n6941 n6942 0.84999999999999998
r10731 n6888 n6943 0.012500000000000001
r10732 n6942 n6943 0.92500000000000004
r10733 n6889 n6944 0.014705882352941176
r10734 n6943 n6944 0.92500000000000004
r10735 n6890 n6945 0.014705882352941176
r10736 n6944 n6945 0.84999999999999998
r10737 n6891 n6946 0.014705882352941176
r10738 n6945 n6946 0.84999999999999998
r10739 n6892 n6947 0.029411764705882353
r10740 n6946 n6947 0.63749999999999996
r10741 n6893 n6948 0.029411764705882353
r10742 n6947 n6948 0.42499999999999999
r10743 n6894 n6949 0.012195121951219513
r10744 n6948 n6949 0.72499999999999998
r10745 n6895 n6950 0.012195121951219513
r10746 n6949 n6950 1.0249999999999999
r10747 n6896 n6951 0.012195121951219513
r10748 n6950 n6951 1.0249999999999999
r10749 n6897 n6952 0.050000000000000003
r10750 n6951 n6952 0.63749999999999996
r10751 n6898 n6953 0.050000000000000003
r10752 n6952 n6953 0.25
r10753 n6899 n6954 0.02
r10754 n6953 n6954 0.4375
r10755 n6900 n6955 0.5
r10756 n6954 n6955 0.32500000000000001
r10757 n6901 n6956 0.017857142857142856
r10758 n6955 n6956 0.36249999999999999
r10759 n6902 n6957 0.5
r10760 n6956 n6957 0.36249999999999999
r10761 n6903 n6958 0.02
r10762 n6957 n6958 0.32500000000000001
r10763 n6904 n6959 0.050000000000000003
r10764 n6958 n6959 0.4375
r10765 n6905 n6960 0.015151515151515152
r10766 n6906 n6961 0.25
r10767 n6960 n6961 0.72916666666666663
r10768 n6907 n6962 0.016666666666666666
r10769 n6961 n6962 0.66666666666666663
r10770 n6908 n6963 0.25
r10771 n6962 n6963 0.66666666666666663
r10772 n6909 n6964 0.015151515151515152
r10773 n6963 n6964 0.72916666666666663
r10774 n6910 n6965 0.10000000000000001
r10775 n6911 n6966 0.10000000000000001
r10776 n6965 n6966 0.20833333333333334
r10777 n6912 n6967 0.5
r10778 n6966 n6967 0.125
r10779 n6913 n6968 0.25
r10780 n6967 n6968 0.0625
r10781 n6914 n6969 0.5
r10782 n6968 n6969 0.0625
r10783 n6915 n6970 0.5
r10784 n6969 n6970 0.041666666666666664
r10785 n6916 n6971 0.5
r10786 n6970 n6971 0.041666666666666664
r10787 n6917 n6972 0.125
r10788 n6971 n6972 0.10416666666666667
r10789 n6918 n6973 0.10000000000000001
r10790 n6972 n6973 0.1875
r10791 n6919 n6974 0.5
r10792 n6973 n6974 0.125
r10793 n6920 n6975 0.050000000000000003
r10794 n6974 n6975 0.22916666666666666
r10795 n6921 n6976 0.16666666666666666
r10796 n6975 n6976 0.27083333333333331
r10797 n6922 n6977 0.083333333333333329
r10798 n6976 n6977 0.1875
r10799 n6923 n6978 0.25
r10800 n6977 n6978 0.16666666666666666
r10801 n6924 n6979 0.5
r10802 n6978 n6979 0.0625
r10803 n6925 n6980 0.5
r10804 n6979 n6980 0.041666666666666664
r10805 n6926 n6981 0.083333333333333329
r10806 n6980 n6981 0.14583333333333334
r10807 n6927 n6982 0.10000000000000001
r10808 n6981 n6982 0.22916666666666666
r10809 n6928 n6983 0.5
r10810 n6982 n6983 0.125
r10811 n6929 n6984 0.125
r10812 n6983 n6984 0.10416666666666667
r10813 n6930 n6985 0.10000000000000001
r10814 n6984 n6985 0.1875
r10815 n6931 n6986 0.16666666666666666
r10816 n6985 n6986 0.16666666666666666
r10817 n6932 n6987 0.071428571428571425
r10818 n6986 n6987 0.20833333333333334
r10819 n6933 n6988 0.071428571428571425
r10820 n6934 n6989 0.027777777777777776
r10821 n6988 n6989 0.52083333333333337
r10822 n6935 n6990 0.03125
r10823 n6989 n6990 0.70833333333333337
r10824 n6936 n6991 0.035714285714285712
r10825 n6990 n6991 0.625
r10826 n6937 n6992 0.025000000000000001
r10827 n6991 n6992 0.70833333333333337
r10828 n6938 n6993 0.10000000000000001
r10829 n6992 n6993 0.52083333333333337
r10830 n6939 n6994 0.017241379310344827
r10831 n6993 n6994 0.70833333333333337
r10832 n6940 n6995 0.014705882352941176
r10833 n6994 n6995 1.3125
r10834 n6941 n6996 0.014705882352941176
r10835 n6995 n6996 1.4166666666666667
r10836 n6942 n6997 0.014705882352941176
r10837 n6996 n6997 1.4166666666666667
r10838 n6943 n6998 0.012500000000000001
r10839 n6997 n6998 1.5416666666666667
r10840 n6944 n6999 0.014705882352941176
r10841 n6998 n6999 1.5416666666666667
r10842 n6945 n7000 0.014705882352941176
r10843 n6999 n7000 1.4166666666666667
r10844 n6946 n7001 0.014705882352941176
r10845 n7000 n7001 1.4166666666666667
r10846 n6947 n7002 0.029411764705882353
r10847 n7001 n7002 1.0625
r10848 n6948 n7003 0.029411764705882353
r10849 n7002 n7003 0.70833333333333337
r10850 n6949 n7004 0.012195121951219513
r10851 n7003 n7004 1.2083333333333333
r10852 n6950 n7005 0.012195121951219513
r10853 n7004 n7005 1.7083333333333333
r10854 n6951 n7006 0.012195121951219513
r10855 n7005 n7006 1.7083333333333333
r10856 n6952 n7007 0.050000000000000003
r10857 n7006 n7007 1.0625
r10858 n6953 n7008 0.050000000000000003
r10859 n7007 n7008 0.41666666666666669
r10860 n6954 n7009 0.02
r10861 n7008 n7009 0.72916666666666663
r10862 n6955 n7010 0.5
r10863 n7009 n7010 0.54166666666666663
r10864 n6956 n7011 0.017857142857142856
r10865 n7010 n7011 0.60416666666666663
r10866 n6957 n7012 0.5
r10867 n7011 n7012 0.60416666666666663
r10868 n6958 n7013 0.02
r10869 n7012 n7013 0.54166666666666663
r10870 n6959 n7014 0.050000000000000003
r10871 n7013 n7014 0.72916666666666663
r10872 n6960 n7015 0.00946969696969697
r10873 n6961 n7016 0.15625
r10874 n7015 n7016 1.09375
r10875 n6962 n7017 0.010416666666666666
r10876 n7016 n7017 1
r10877 n6963 n7018 0.15625
r10878 n7017 n7018 1
r10879 n6964 n7019 0.00946969696969697
r10880 n7018 n7019 1.09375
r10881 n6965 n7020 0.0625
r10882 n6966 n7021 0.0625
r10883 n7020 n7021 0.3125
r10884 n6967 n7022 0.3125
r10885 n7021 n7022 0.1875
r10886 n6968 n7023 0.15625
r10887 n7022 n7023 0.09375
r10888 n6969 n7024 0.3125
r10889 n7023 n7024 0.09375
r10890 n6970 n7025 0.3125
r10891 n7024 n7025 0.0625
r10892 n6971 n7026 0.3125
r10893 n7025 n7026 0.0625
r10894 n6972 n7027 0.078125
r10895 n7026 n7027 0.15625
r10896 n6973 n7028 0.0625
r10897 n7027 n7028 0.28125
r10898 n6974 n7029 0.3125
r10899 n7028 n7029 0.1875
r10900 n6975 n7030 0.03125
r10901 n7029 n7030 0.34375
r10902 n6976 n7031 0.10416666666666667
r10903 n7030 n7031 0.40625
r10904 n6977 n7032 0.052083333333333336
r10905 n7031 n7032 0.28125
r10906 n6978 n7033 0.15625
r10907 n7032 n7033 0.25
r10908 n6979 n7034 0.3125
r10909 n7033 n7034 0.09375
r10910 n6980 n7035 0.3125
r10911 n7034 n7035 0.0625
r10912 n6981 n7036 0.052083333333333336
r10913 n7035 n7036 0.21875
r10914 n6982 n7037 0.0625
r10915 n7036 n7037 0.34375
r10916 n6983 n7038 0.3125
r10917 n7037 n7038 0.1875
r10918 n6984 n7039 0.078125
r10919 n7038 n7039 0.15625
r10920 n6985 n7040 0.0625
r10921 n7039 n7040 0.28125
r10922 n6986 n7041 0.10416666666666667
r10923 n7040 n7041 0.25
r10924 n6987 n7042 0.044642857142857144
r10925 n7041 n7042 0.3125
r10926 n6988 n7043 0.044642857142857144
r10927 n6989 n7044 0.017361111111111112
r10928 n7043 n7044 0.78125
r10929 n6990 n7045 0.01953125
r10930 n7044 n7045 1.0625
r10931 n6991 n7046 0.022321428571428572
r10932 n7045 n7046 0.9375
r10933 n6992 n7047 0.015625
r10934 n7046 n7047 1.0625
r10935 n6993 n7048 0.0625
r10936 n7047 n7048 0.78125
r10937 n6994 n7049 0.010775862068965518
r10938 n7048 n7049 1.0625
r10939 n6995 n7050 0.0091911764705882356
r10940 n7049 n7050 1.96875
r10941 n6996 n7051 0.0091911764705882356
r10942 n7050 n7051 2.125
r10943 n6997 n7052 0.0091911764705882356
r10944 n7051 n7052 2.125
r10945 n6998 n7053 0.0078125
r10946 n7052 n7053 2.3125
r10947 n6999 n7054 0.0091911764705882356
r10948 n7053 n7054 2.3125
r10949 n7000 n7055 0.0091911764705882356
r10950 n7054 n7055 2.125
r10951 n7001 n7056 0.0091911764705882356
r10952 n7055 n7056 2.125
r10953 n7002 n7057 0.018382352941176471
r10954 n7056 n7057 1.59375
r10955 n7003 n7058 0.018382352941176471
r10956 n7057 n7058 1.0625
r10957 n7004 n7059 0.007621951219512195
r10958 n7058 n7059 1.8125
r10959 n7005 n7060 0.007621951219512195
r10960 n7059 n7060 2.5625
r10961 n7006 n7061 0.007621951219512195
r10962 n7060 n7061 2.5625
r10963 n7007 n7062 0.03125
r10964 n7061 n7062 1.59375
r10965 n7008 n7063 0.03125
r10966 n7062 n7063 0.625
r10967 n7009 n7064 0.012500000000000001
r10968 n7063 n7064 1.09375
r10969 n7010 n7065 0.3125
r10970 n7064 n7065 0.8125
r10971 n7011 n7066 0.011160714285714286
r10972 n7065 n7066 0.90625
r10973 n7012 n7067 0.3125
r10974 n7066 n7067 0.90625
r10975 n7013 n7068 0.012500000000000001
r10976 n7067 n7068 0.8125
r10977 n7014 n7069 0.03125
r10978 n7068 n7069 1.09375
r10979 n7015 n7070 0.060606060606060608
r10980 n7016 n7071 1
r10981 n7070 n7071 0.072916666666666671
r10982 n7017 n7072 0.066666666666666666
r10983 n7071 n7072 0.066666666666666666
r10984 n7018 n7073 1
r10985 n7072 n7073 0.066666666666666666
r10986 n7019 n7074 0.060606060606060608
r10987 n7073 n7074 0.072916666666666671
r10988 n7020 n7075 0.40000000000000002
r10989 n7021 n7076 0.40000000000000002
r10990 n7075 n7076 0.020833333333333332
r10991 n7022 n7077 2
r10992 n7076 n7077 0.012500000000000001
r10993 n7023 n7078 1
r10994 n7077 n7078 0.0062500000000000003
r10995 n7024 n7079 2
r10996 n7078 n7079 0.0062500000000000003
r10997 n7025 n7080 2
r10998 n7079 n7080 0.0041666666666666666
r10999 n7026 n7081 2
r11000 n7080 n7081 0.0041666666666666666
r11001 n7027 n7082 0.5
r11002 n7081 n7082 0.010416666666666666
r11003 n7028 n7083 0.40000000000000002
r11004 n7082 n7083 0.018749999999999999
r11005 n7029 n7084 2
r11006 n7083 n7084 0.012500000000000001
r11007 n7030 n7085 0.20000000000000001
r11008 n7084 n7085 0.022916666666666665
r11009 n7031 n7086 0.66666666666666663
r11010 n7085 n7086 0.027083333333333334
r11011 n7032 n7087 0.33333333333333331
r11012 n7086 n7087 0.018749999999999999
r11013 n7033 n7088 1
r11014 n7087 n7088 0.016666666666666666
r11015 n7034 n7089 2
r11016 n7088 n7089 0.0062500000000000003
r11017 n7035 n7090 2
r11018 n7089 n7090 0.0041666666666666666
r11019 n7036 n7091 0.33333333333333331
r11020 n7090 n7091 0.014583333333333334
r11021 n7037 n7092 0.40000000000000002
r11022 n7091 n7092 0.022916666666666665
r11023 n7038 n7093 2
r11024 n7092 n7093 0.012500000000000001
r11025 n7039 n7094 0.5
r11026 n7093 n7094 0.010416666666666666
r11027 n7040 n7095 0.40000000000000002
r11028 n7094 n7095 0.018749999999999999
r11029 n7041 n7096 0.66666666666666663
r11030 n7095 n7096 0.016666666666666666
r11031 n7042 n7097 0.2857142857142857
r11032 n7096 n7097 0.020833333333333332
r11033 n7043 n7098 0.2857142857142857
r11034 n7044 n7099 0.1111111111111111
r11035 n7098 n7099 0.052083333333333336
r11036 n7045 n7100 0.125
r11037 n7099 n7100 0.070833333333333331
r11038 n7046 n7101 0.14285714285714285
r11039 n7100 n7101 0.0625
r11040 n7047 n7102 0.10000000000000001
r11041 n7101 n7102 0.070833333333333331
r11042 n7048 n7103 0.40000000000000002
r11043 n7102 n7103 0.052083333333333336
r11044 n7049 n7104 0.068965517241379309
r11045 n7103 n7104 0.070833333333333331
r11046 n7050 n7105 0.058823529411764705
r11047 n7104 n7105 0.13125000000000001
r11048 n7051 n7106 0.058823529411764705
r11049 n7105 n7106 0.14166666666666666
r11050 n7052 n7107 0.058823529411764705
r11051 n7106 n7107 0.14166666666666666
r11052 n7053 n7108 0.050000000000000003
r11053 n7107 n7108 0.15416666666666667
r11054 n7054 n7109 0.058823529411764705
r11055 n7108 n7109 0.15416666666666667
r11056 n7055 n7110 0.058823529411764705
r11057 n7109 n7110 0.14166666666666666
r11058 n7056 n7111 0.058823529411764705
r11059 n7110 n7111 0.14166666666666666
r11060 n7057 n7112 0.11764705882352941
r11061 n7111 n7112 0.10625
r11062 n7058 n7113 0.11764705882352941
r11063 n7112 n7113 0.070833333333333331
r11064 n7059 n7114 0.04878048780487805
r11065 n7113 n7114 0.12083333333333333
r11066 n7060 n7115 0.04878048780487805
r11067 n7114 n7115 0.17083333333333334
r11068 n7061 n7116 0.04878048780487805
r11069 n7115 n7116 0.17083333333333334
r11070 n7062 n7117 0.20000000000000001
r11071 n7116 n7117 0.10625
r11072 n7063 n7118 0.20000000000000001
r11073 n7117 n7118 0.041666666666666664
r11074 n7064 n7119 0.080000000000000002
r11075 n7118 n7119 0.072916666666666671
r11076 n7065 n7120 2
r11077 n7119 n7120 0.054166666666666669
r11078 n7066 n7121 0.071428571428571425
r11079 n7120 n7121 0.060416666666666667
r11080 n7067 n7122 2
r11081 n7121 n7122 0.060416666666666667
r11082 n7068 n7123 0.080000000000000002
r11083 n7122 n7123 0.054166666666666669
r11084 n7069 n7124 0.20000000000000001
r11085 n7123 n7124 0.072916666666666671
r11086 n7070 n7125 0.060606060606060608
r11087 n7071 n7126 1
r11088 n7125 n7126 1.09375
r11089 n7072 n7127 0.066666666666666666
r11090 n7126 n7127 1
r11091 n7073 n7128 1
r11092 n7127 n7128 1
r11093 n7074 n7129 0.060606060606060608
r11094 n7128 n7129 1.09375
r11095 n7075 n7130 0.40000000000000002
r11096 n7076 n7131 0.40000000000000002
r11097 n7130 n7131 0.3125
r11098 n7077 n7132 2
r11099 n7131 n7132 0.1875
r11100 n7078 n7133 1
r11101 n7132 n7133 0.09375
r11102 n7079 n7134 2
r11103 n7133 n7134 0.09375
r11104 n7080 n7135 2
r11105 n7134 n7135 0.0625
r11106 n7081 n7136 2
r11107 n7135 n7136 0.0625
r11108 n7082 n7137 0.5
r11109 n7136 n7137 0.15625
r11110 n7083 n7138 0.40000000000000002
r11111 n7137 n7138 0.28125
r11112 n7084 n7139 2
r11113 n7138 n7139 0.1875
r11114 n7085 n7140 0.20000000000000001
r11115 n7139 n7140 0.34375
r11116 n7086 n7141 0.66666666666666663
r11117 n7140 n7141 0.40625
r11118 n7087 n7142 0.33333333333333331
r11119 n7141 n7142 0.28125
r11120 n7088 n7143 1
r11121 n7142 n7143 0.25
r11122 n7089 n7144 2
r11123 n7143 n7144 0.09375
r11124 n7090 n7145 2
r11125 n7144 n7145 0.0625
r11126 n7091 n7146 0.33333333333333331
r11127 n7145 n7146 0.21875
r11128 n7092 n7147 0.40000000000000002
r11129 n7146 n7147 0.34375
r11130 n7093 n7148 2
r11131 n7147 n7148 0.1875
r11132 n7094 n7149 0.5
r11133 n7148 n7149 0.15625
r11134 n7095 n7150 0.40000000000000002
r11135 n7149 n7150 0.28125
r11136 n7096 n7151 0.66666666666666663
r11137 n7150 n7151 0.25
r11138 n7097 n7152 0.2857142857142857
r11139 n7151 n7152 0.3125
r11140 n7098 n7153 0.2857142857142857
r11141 n7099 n7154 0.1111111111111111
r11142 n7153 n7154 0.78125
r11143 n7100 n7155 0.125
r11144 n7154 n7155 1.0625
r11145 n7101 n7156 0.14285714285714285
r11146 n7155 n7156 0.9375
r11147 n7102 n7157 0.10000000000000001
r11148 n7156 n7157 1.0625
r11149 n7103 n7158 0.40000000000000002
r11150 n7157 n7158 0.78125
r11151 n7104 n7159 0.068965517241379309
r11152 n7158 n7159 1.0625
r11153 n7105 n7160 0.058823529411764705
r11154 n7159 n7160 1.96875
r11155 n7106 n7161 0.058823529411764705
r11156 n7160 n7161 2.125
r11157 n7107 n7162 0.058823529411764705
r11158 n7161 n7162 2.125
r11159 n7108 n7163 0.050000000000000003
r11160 n7162 n7163 2.3125
r11161 n7109 n7164 0.058823529411764705
r11162 n7163 n7164 2.3125
r11163 n7110 n7165 0.058823529411764705
r11164 n7164 n7165 2.125
r11165 n7111 n7166 0.058823529411764705
r11166 n7165 n7166 2.125
r11167 n7112 n7167 0.11764705882352941
r11168 n7166 n7167 1.59375
r11169 n7113 n7168 0.11764705882352941
r11170 n7167 n7168 1.0625
r11171 n7114 n7169 0.04878048780487805
r11172 n7168 n7169 1.8125
r11173 n7115 n7170 0.04878048780487805
r11174 n7169 n7170 2.5625
r11175 n7116 n7171 0.04878048780487805
r11176 n7170 n7171 2.5625
r11177 n7117 n7172 0.20000000000000001
r11178 n7171 n7172 1.59375
r11179 n7118 n7173 0.20000000000000001
r11180 n7172 n7173 0.625
r11181 n7119 n7174 0.080000000000000002
r11182 n7173 n7174 1.09375
r11183 n7120 n7175 2
r11184 n7174 n7175 0.8125
r11185 n7121 n7176 0.071428571428571425
r11186 n7175 n7176 0.90625
r11187 n7122 n7177 2
r11188 n7176 n7177 0.90625
r11189 n7123 n7178 0.080000000000000002
r11190 n7177 n7178 0.8125
r11191 n7124 n7179 0.20000000000000001
r11192 n7178 n7179 1.09375
r11193 n7125 n7180 0.00946969696969697
r11194 n7126 n7181 0.15625
r11195 n7180 n7181 0.72916666666666663
r11196 n7127 n7182 0.010416666666666666
r11197 n7181 n7182 0.66666666666666663
r11198 n7128 n7183 0.15625
r11199 n7182 n7183 0.66666666666666663
r11200 n7129 n7184 0.00946969696969697
r11201 n7183 n7184 0.72916666666666663
r11202 n7130 n7185 0.0625
r11203 n7131 n7186 0.0625
r11204 n7185 n7186 0.20833333333333334
r11205 n7132 n7187 0.3125
r11206 n7186 n7187 0.125
r11207 n7133 n7188 0.15625
r11208 n7187 n7188 0.0625
r11209 n7134 n7189 0.3125
r11210 n7188 n7189 0.0625
r11211 n7135 n7190 0.3125
r11212 n7189 n7190 0.041666666666666664
r11213 n7136 n7191 0.3125
r11214 n7190 n7191 0.041666666666666664
r11215 n7137 n7192 0.078125
r11216 n7191 n7192 0.10416666666666667
r11217 n7138 n7193 0.0625
r11218 n7192 n7193 0.1875
r11219 n7139 n7194 0.3125
r11220 n7193 n7194 0.125
r11221 n7140 n7195 0.03125
r11222 n7194 n7195 0.22916666666666666
r11223 n7141 n7196 0.10416666666666667
r11224 n7195 n7196 0.27083333333333331
r11225 n7142 n7197 0.052083333333333336
r11226 n7196 n7197 0.1875
r11227 n7143 n7198 0.15625
r11228 n7197 n7198 0.16666666666666666
r11229 n7144 n7199 0.3125
r11230 n7198 n7199 0.0625
r11231 n7145 n7200 0.3125
r11232 n7199 n7200 0.041666666666666664
r11233 n7146 n7201 0.052083333333333336
r11234 n7200 n7201 0.14583333333333334
r11235 n7147 n7202 0.0625
r11236 n7201 n7202 0.22916666666666666
r11237 n7148 n7203 0.3125
r11238 n7202 n7203 0.125
r11239 n7149 n7204 0.078125
r11240 n7203 n7204 0.10416666666666667
r11241 n7150 n7205 0.0625
r11242 n7204 n7205 0.1875
r11243 n7151 n7206 0.10416666666666667
r11244 n7205 n7206 0.16666666666666666
r11245 n7152 n7207 0.044642857142857144
r11246 n7206 n7207 0.20833333333333334
r11247 n7153 n7208 0.044642857142857144
r11248 n7154 n7209 0.017361111111111112
r11249 n7208 n7209 0.52083333333333337
r11250 n7155 n7210 0.01953125
r11251 n7209 n7210 0.70833333333333337
r11252 n7156 n7211 0.022321428571428572
r11253 n7210 n7211 0.625
r11254 n7157 n7212 0.015625
r11255 n7211 n7212 0.70833333333333337
r11256 n7158 n7213 0.0625
r11257 n7212 n7213 0.52083333333333337
r11258 n7159 n7214 0.010775862068965518
r11259 n7213 n7214 0.70833333333333337
r11260 n7160 n7215 0.0091911764705882356
r11261 n7214 n7215 1.3125
r11262 n7161 n7216 0.0091911764705882356
r11263 n7215 n7216 1.4166666666666667
r11264 n7162 n7217 0.0091911764705882356
r11265 n7216 n7217 1.4166666666666667
r11266 n7163 n7218 0.0078125
r11267 n7217 n7218 1.5416666666666667
r11268 n7164 n7219 0.0091911764705882356
r11269 n7218 n7219 1.5416666666666667
r11270 n7165 n7220 0.0091911764705882356
r11271 n7219 n7220 1.4166666666666667
r11272 n7166 n7221 0.0091911764705882356
r11273 n7220 n7221 1.4166666666666667
r11274 n7167 n7222 0.018382352941176471
r11275 n7221 n7222 1.0625
r11276 n7168 n7223 0.018382352941176471
r11277 n7222 n7223 0.70833333333333337
r11278 n7169 n7224 0.007621951219512195
r11279 n7223 n7224 1.2083333333333333
r11280 n7170 n7225 0.007621951219512195
r11281 n7224 n7225 1.7083333333333333
r11282 n7171 n7226 0.007621951219512195
r11283 n7225 n7226 1.7083333333333333
r11284 n7172 n7227 0.03125
r11285 n7226 n7227 1.0625
r11286 n7173 n7228 0.03125
r11287 n7227 n7228 0.41666666666666669
r11288 n7174 n7229 0.012500000000000001
r11289 n7228 n7229 0.72916666666666663
r11290 n7175 n7230 0.3125
r11291 n7229 n7230 0.54166666666666663
r11292 n7176 n7231 0.011160714285714286
r11293 n7230 n7231 0.60416666666666663
r11294 n7177 n7232 0.3125
r11295 n7231 n7232 0.60416666666666663
r11296 n7178 n7233 0.012500000000000001
r11297 n7232 n7233 0.54166666666666663
r11298 n7179 n7234 0.03125
r11299 n7233 n7234 0.72916666666666663
r11300 n7180 n7235 0.015151515151515152
r11301 n7181 n7236 0.25
r11302 n7235 n7236 0.4375
r11303 n7182 n7237 0.016666666666666666
r11304 n7236 n7237 0.40000000000000002
r11305 n7183 n7238 0.25
r11306 n7237 n7238 0.40000000000000002
r11307 n7184 n7239 0.015151515151515152
r11308 n7238 n7239 0.4375
r11309 n7185 n7240 0.10000000000000001
r11310 n7186 n7241 0.10000000000000001
r11311 n7240 n7241 0.125
r11312 n7187 n7242 0.5
r11313 n7241 n7242 0.074999999999999997
r11314 n7188 n7243 0.25
r11315 n7242 n7243 0.037499999999999999
r11316 n7189 n7244 0.5
r11317 n7243 n7244 0.037499999999999999
r11318 n7190 n7245 0.5
r11319 n7244 n7245 0.025000000000000001
r11320 n7191 n7246 0.5
r11321 n7245 n7246 0.025000000000000001
r11322 n7192 n7247 0.125
r11323 n7246 n7247 0.0625
r11324 n7193 n7248 0.10000000000000001
r11325 n7247 n7248 0.1125
r11326 n7194 n7249 0.5
r11327 n7248 n7249 0.074999999999999997
r11328 n7195 n7250 0.050000000000000003
r11329 n7249 n7250 0.13750000000000001
r11330 n7196 n7251 0.16666666666666666
r11331 n7250 n7251 0.16250000000000001
r11332 n7197 n7252 0.083333333333333329
r11333 n7251 n7252 0.1125
r11334 n7198 n7253 0.25
r11335 n7252 n7253 0.10000000000000001
r11336 n7199 n7254 0.5
r11337 n7253 n7254 0.037499999999999999
r11338 n7200 n7255 0.5
r11339 n7254 n7255 0.025000000000000001
r11340 n7201 n7256 0.083333333333333329
r11341 n7255 n7256 0.087499999999999994
r11342 n7202 n7257 0.10000000000000001
r11343 n7256 n7257 0.13750000000000001
r11344 n7203 n7258 0.5
r11345 n7257 n7258 0.074999999999999997
r11346 n7204 n7259 0.125
r11347 n7258 n7259 0.0625
r11348 n7205 n7260 0.10000000000000001
r11349 n7259 n7260 0.1125
r11350 n7206 n7261 0.16666666666666666
r11351 n7260 n7261 0.10000000000000001
r11352 n7207 n7262 0.071428571428571425
r11353 n7261 n7262 0.125
r11354 n7208 n7263 0.071428571428571425
r11355 n7209 n7264 0.027777777777777776
r11356 n7263 n7264 0.3125
r11357 n7210 n7265 0.03125
r11358 n7264 n7265 0.42499999999999999
r11359 n7211 n7266 0.035714285714285712
r11360 n7265 n7266 0.375
r11361 n7212 n7267 0.025000000000000001
r11362 n7266 n7267 0.42499999999999999
r11363 n7213 n7268 0.10000000000000001
r11364 n7267 n7268 0.3125
r11365 n7214 n7269 0.017241379310344827
r11366 n7268 n7269 0.42499999999999999
r11367 n7215 n7270 0.014705882352941176
r11368 n7269 n7270 0.78749999999999998
r11369 n7216 n7271 0.014705882352941176
r11370 n7270 n7271 0.84999999999999998
r11371 n7217 n7272 0.014705882352941176
r11372 n7271 n7272 0.84999999999999998
r11373 n7218 n7273 0.012500000000000001
r11374 n7272 n7273 0.92500000000000004
r11375 n7219 n7274 0.014705882352941176
r11376 n7273 n7274 0.92500000000000004
r11377 n7220 n7275 0.014705882352941176
r11378 n7274 n7275 0.84999999999999998
r11379 n7221 n7276 0.014705882352941176
r11380 n7275 n7276 0.84999999999999998
r11381 n7222 n7277 0.029411764705882353
r11382 n7276 n7277 0.63749999999999996
r11383 n7223 n7278 0.029411764705882353
r11384 n7277 n7278 0.42499999999999999
r11385 n7224 n7279 0.012195121951219513
r11386 n7278 n7279 0.72499999999999998
r11387 n7225 n7280 0.012195121951219513
r11388 n7279 n7280 1.0249999999999999
r11389 n7226 n7281 0.012195121951219513
r11390 n7280 n7281 1.0249999999999999
r11391 n7227 n7282 0.050000000000000003
r11392 n7281 n7282 0.63749999999999996
r11393 n7228 n7283 0.050000000000000003
r11394 n7282 n7283 0.25
r11395 n7229 n7284 0.02
r11396 n7283 n7284 0.4375
r11397 n7230 n7285 0.5
r11398 n7284 n7285 0.32500000000000001
r11399 n7231 n7286 0.017857142857142856
r11400 n7285 n7286 0.36249999999999999
r11401 n7232 n7287 0.5
r11402 n7286 n7287 0.36249999999999999
r11403 n7233 n7288 0.02
r11404 n7287 n7288 0.32500000000000001
r11405 n7234 n7289 0.050000000000000003
r11406 n7288 n7289 0.4375
r11407 n7235 n7290 0.015151515151515152
r11408 n7236 n7291 0.25
r11409 n7290 n7291 0.72916666666666663
r11410 n7237 n7292 0.016666666666666666
r11411 n7291 n7292 0.66666666666666663
r11412 n7238 n7293 0.25
r11413 n7292 n7293 0.66666666666666663
r11414 n7239 n7294 0.015151515151515152
r11415 n7293 n7294 0.72916666666666663
r11416 n7240 n7295 0.10000000000000001
r11417 n7241 n7296 0.10000000000000001
r11418 n7295 n7296 0.20833333333333334
r11419 n7242 n7297 0.5
r11420 n7296 n7297 0.125
r11421 n7243 n7298 0.25
r11422 n7297 n7298 0.0625
r11423 n7244 n7299 0.5
r11424 n7298 n7299 0.0625
r11425 n7245 n7300 0.5
r11426 n7299 n7300 0.041666666666666664
r11427 n7246 n7301 0.5
r11428 n7300 n7301 0.041666666666666664
r11429 n7247 n7302 0.125
r11430 n7301 n7302 0.10416666666666667
r11431 n7248 n7303 0.10000000000000001
r11432 n7302 n7303 0.1875
r11433 n7249 n7304 0.5
r11434 n7303 n7304 0.125
r11435 n7250 n7305 0.050000000000000003
r11436 n7304 n7305 0.22916666666666666
r11437 n7251 n7306 0.16666666666666666
r11438 n7305 n7306 0.27083333333333331
r11439 n7252 n7307 0.083333333333333329
r11440 n7306 n7307 0.1875
r11441 n7253 n7308 0.25
r11442 n7307 n7308 0.16666666666666666
r11443 n7254 n7309 0.5
r11444 n7308 n7309 0.0625
r11445 n7255 n7310 0.5
r11446 n7309 n7310 0.041666666666666664
r11447 n7256 n7311 0.083333333333333329
r11448 n7310 n7311 0.14583333333333334
r11449 n7257 n7312 0.10000000000000001
r11450 n7311 n7312 0.22916666666666666
r11451 n7258 n7313 0.5
r11452 n7312 n7313 0.125
r11453 n7259 n7314 0.125
r11454 n7313 n7314 0.10416666666666667
r11455 n7260 n7315 0.10000000000000001
r11456 n7314 n7315 0.1875
r11457 n7261 n7316 0.16666666666666666
r11458 n7315 n7316 0.16666666666666666
r11459 n7262 n7317 0.071428571428571425
r11460 n7316 n7317 0.20833333333333334
r11461 n7263 n7318 0.071428571428571425
r11462 n7264 n7319 0.027777777777777776
r11463 n7318 n7319 0.52083333333333337
r11464 n7265 n7320 0.03125
r11465 n7319 n7320 0.70833333333333337
r11466 n7266 n7321 0.035714285714285712
r11467 n7320 n7321 0.625
r11468 n7267 n7322 0.025000000000000001
r11469 n7321 n7322 0.70833333333333337
r11470 n7268 n7323 0.10000000000000001
r11471 n7322 n7323 0.52083333333333337
r11472 n7269 n7324 0.017241379310344827
r11473 n7323 n7324 0.70833333333333337
r11474 n7270 n7325 0.014705882352941176
r11475 n7324 n7325 1.3125
r11476 n7271 n7326 0.014705882352941176
r11477 n7325 n7326 1.4166666666666667
r11478 n7272 n7327 0.014705882352941176
r11479 n7326 n7327 1.4166666666666667
r11480 n7273 n7328 0.012500000000000001
r11481 n7327 n7328 1.5416666666666667
r11482 n7274 n7329 0.014705882352941176
r11483 n7328 n7329 1.5416666666666667
r11484 n7275 n7330 0.014705882352941176
r11485 n7329 n7330 1.4166666666666667
r11486 n7276 n7331 0.014705882352941176
r11487 n7330 n7331 1.4166666666666667
r11488 n7277 n7332 0.029411764705882353
r11489 n7331 n7332 1.0625
r11490 n7278 n7333 0.029411764705882353
r11491 n7332 n7333 0.70833333333333337
r11492 n7279 n7334 0.012195121951219513
r11493 n7333 n7334 1.2083333333333333
r11494 n7280 n7335 0.012195121951219513
r11495 n7334 n7335 1.7083333333333333
r11496 n7281 n7336 0.012195121951219513
r11497 n7335 n7336 1.7083333333333333
r11498 n7282 n7337 0.050000000000000003
r11499 n7336 n7337 1.0625
r11500 n7283 n7338 0.050000000000000003
r11501 n7337 n7338 0.41666666666666669
r11502 n7284 n7339 0.02
r11503 n7338 n7339 0.72916666666666663
r11504 n7285 n7340 0.5
r11505 n7339 n7340 0.54166666666666663
r11506 n7286 n7341 0.017857142857142856
r11507 n7340 n7341 0.60416666666666663
r11508 n7287 n7342 0.5
r11509 n7341 n7342 0.60416666666666663
r11510 n7288 n7343 0.02
r11511 n7342 n7343 0.54166666666666663
r11512 n7289 n7344 0.050000000000000003
r11513 n7343 n7344 0.72916666666666663
r11514 n7290 n7345 0.00946969696969697
r11515 n7291 n7346 0.15625
r11516 n7345 n7346 1.09375
r11517 n7292 n7347 0.010416666666666666
r11518 n7346 n7347 1
r11519 n7293 n7348 0.15625
r11520 n7347 n7348 1
r11521 n7294 n7349 0.00946969696969697
r11522 n7348 n7349 1.09375
r11523 n7295 n7350 0.0625
r11524 n7296 n7351 0.0625
r11525 n7350 n7351 0.3125
r11526 n7297 n7352 0.3125
r11527 n7351 n7352 0.1875
r11528 n7298 n7353 0.15625
r11529 n7352 n7353 0.09375
r11530 n7299 n7354 0.3125
r11531 n7353 n7354 0.09375
r11532 n7300 n7355 0.3125
r11533 n7354 n7355 0.0625
r11534 n7301 n7356 0.3125
r11535 n7355 n7356 0.0625
r11536 n7302 n7357 0.078125
r11537 n7356 n7357 0.15625
r11538 n7303 n7358 0.0625
r11539 n7357 n7358 0.28125
r11540 n7304 n7359 0.3125
r11541 n7358 n7359 0.1875
r11542 n7305 n7360 0.03125
r11543 n7359 n7360 0.34375
r11544 n7306 n7361 0.10416666666666667
r11545 n7360 n7361 0.40625
r11546 n7307 n7362 0.052083333333333336
r11547 n7361 n7362 0.28125
r11548 n7308 n7363 0.15625
r11549 n7362 n7363 0.25
r11550 n7309 n7364 0.3125
r11551 n7363 n7364 0.09375
r11552 n7310 n7365 0.3125
r11553 n7364 n7365 0.0625
r11554 n7311 n7366 0.052083333333333336
r11555 n7365 n7366 0.21875
r11556 n7312 n7367 0.0625
r11557 n7366 n7367 0.34375
r11558 n7313 n7368 0.3125
r11559 n7367 n7368 0.1875
r11560 n7314 n7369 0.078125
r11561 n7368 n7369 0.15625
r11562 n7315 n7370 0.0625
r11563 n7369 n7370 0.28125
r11564 n7316 n7371 0.10416666666666667
r11565 n7370 n7371 0.25
r11566 n7317 n7372 0.044642857142857144
r11567 n7371 n7372 0.3125
r11568 n7318 n7373 0.044642857142857144
r11569 n7319 n7374 0.017361111111111112
r11570 n7373 n7374 0.78125
r11571 n7320 n7375 0.01953125
r11572 n7374 n7375 1.0625
r11573 n7321 n7376 0.022321428571428572
r11574 n7375 n7376 0.9375
r11575 n7322 n7377 0.015625
r11576 n7376 n7377 1.0625
r11577 n7323 n7378 0.0625
r11578 n7377 n7378 0.78125
r11579 n7338 n7379 0.03125
r11580 n7339 n7380 0.012500000000000001
r11581 n7379 n7380 1.09375
r11582 n7340 n7381 0.3125
r11583 n7380 n7381 0.8125
r11584 n7341 n7382 0.011160714285714286
r11585 n7381 n7382 0.90625
r11586 n7342 n7383 0.3125
r11587 n7382 n7383 0.90625
r11588 n7343 n7384 0.012500000000000001
r11589 n7383 n7384 0.8125
r11590 n7344 n7385 0.03125
r11591 n7384 n7385 1.09375
r11592 n7345 n7386 0.022727272727272728
r11593 n7346 n7387 0.375
r11594 n7386 n7387 0.21875
r11595 n7347 n7388 0.025000000000000001
r11596 n7387 n7388 0.20000000000000001
r11597 n7348 n7389 0.375
r11598 n7388 n7389 0.20000000000000001
r11599 n7349 n7390 0.022727272727272728
r11600 n7389 n7390 0.21875
r11601 n7350 n7391 0.14999999999999999
r11602 n7351 n7392 0.14999999999999999
r11603 n7391 n7392 0.0625
r11604 n7352 n7393 0.75
r11605 n7392 n7393 0.037499999999999999
r11606 n7353 n7394 0.375
r11607 n7393 n7394 0.018749999999999999
r11608 n7354 n7395 0.75
r11609 n7394 n7395 0.018749999999999999
r11610 n7355 n7396 0.75
r11611 n7395 n7396 0.012500000000000001
r11612 n7356 n7397 0.75
r11613 n7396 n7397 0.012500000000000001
r11614 n7357 n7398 0.1875
r11615 n7397 n7398 0.03125
r11616 n7358 n7399 0.14999999999999999
r11617 n7398 n7399 0.056250000000000001
r11618 n7359 n7400 0.75
r11619 n7399 n7400 0.037499999999999999
r11620 n7360 n7401 0.074999999999999997
r11621 n7400 n7401 0.068750000000000006
r11622 n7361 n7402 0.25
r11623 n7401 n7402 0.081250000000000003
r11624 n7362 n7403 0.125
r11625 n7402 n7403 0.056250000000000001
r11626 n7363 n7404 0.375
r11627 n7403 n7404 0.050000000000000003
r11628 n7364 n7405 0.75
r11629 n7404 n7405 0.018749999999999999
r11630 n7365 n7406 0.75
r11631 n7405 n7406 0.012500000000000001
r11632 n7366 n7407 0.125
r11633 n7406 n7407 0.043749999999999997
r11634 n7367 n7408 0.14999999999999999
r11635 n7407 n7408 0.068750000000000006
r11636 n7368 n7409 0.75
r11637 n7408 n7409 0.037499999999999999
r11638 n7369 n7410 0.1875
r11639 n7409 n7410 0.03125
r11640 n7370 n7411 0.14999999999999999
r11641 n7410 n7411 0.056250000000000001
r11642 n7371 n7412 0.25
r11643 n7411 n7412 0.050000000000000003
r11644 n7372 n7413 0.10714285714285714
r11645 n7412 n7413 0.0625
r11646 n7379 n7414 0.074999999999999997
r11647 n7380 n7415 0.029999999999999999
r11648 n7414 n7415 0.21875
r11649 n7381 n7416 0.75
r11650 n7415 n7416 0.16250000000000001
r11651 n7382 n7417 0.026785714285714284
r11652 n7416 n7417 0.18124999999999999
r11653 n7383 n7418 0.75
r11654 n7417 n7418 0.18124999999999999
r11655 n7384 n7419 0.029999999999999999
r11656 n7418 n7419 0.16250000000000001
r11657 n7385 n7420 0.074999999999999997
r11658 n7419 n7420 0.21875
r11659 n7386 n7421 0.039772727272727272
r11660 n7387 n7422 0.65625
r11661 n7421 n7422 0.19886363636363635
r11662 n7388 n7423 0.043749999999999997
r11663 n7422 n7423 0.18181818181818182
r11664 n7389 n7424 0.65625
r11665 n7423 n7424 0.18181818181818182
r11666 n7390 n7425 0.039772727272727272
r11667 n7424 n7425 0.19886363636363635
r11668 n7414 n7426 0.13125000000000001
r11669 n7415 n7427 0.052499999999999998
r11670 n7426 n7427 0.19886363636363635
r11671 n7416 n7428 1.3125
r11672 n7427 n7428 0.14772727272727273
r11673 n7417 n7429 0.046875
r11674 n7428 n7429 0.16477272727272727
r11675 n7418 n7430 1.3125
r11676 n7429 n7430 0.16477272727272727
r11677 n7419 n7431 0.052499999999999998
r11678 n7430 n7431 0.14772727272727273
r11679 n7420 n7432 0.13125000000000001
r11680 n7431 n7432 0.19886363636363635
r11681 n7421 n7433 0.096590909090909088
r11682 n7422 n7434 1.59375
r11683 n7433 n7434 0.0546875
r11684 n7423 n7435 0.10625
r11685 n7434 n7435 0.050000000000000003
r11686 n7424 n7436 1.59375
r11687 n7435 n7436 0.050000000000000003
r11688 n7425 n7437 0.096590909090909088
r11689 n7436 n7437 0.0546875
r11690 n7426 n7438 0.31874999999999998
r11691 n7427 n7439 0.1275
r11692 n7438 n7439 0.0546875
r11693 n7428 n7440 3.1875
r11694 n7439 n7440 0.040625000000000001
r11695 n7429 n7441 0.11383928571428571
r11696 n7440 n7441 0.045312499999999999
r11697 n7430 n7442 3.1875
r11698 n7441 n7442 0.045312499999999999
r11699 n7431 n7443 0.1275
r11700 n7442 n7443 0.040625000000000001
r11701 n7432 n7444 0.31874999999999998
r11702 n7443 n7444 0.0546875
r11703 n7433 n7445 0.15151515151515152
r11704 n7434 n7446 2.5
r11705 n7445 n7446 0.0546875
r11706 n7435 n7447 0.16666666666666666
r11707 n7446 n7447 0.050000000000000003
r11708 n7436 n7448 2.5
r11709 n7447 n7448 0.050000000000000003
r11710 n7437 n7449 0.15151515151515152
r11711 n7448 n7449 0.0546875
r11712 n7438 n7450 0.5
r11713 n7439 n7451 0.20000000000000001
r11714 n7450 n7451 0.0546875
r11715 n7440 n7452 5
r11716 n7451 n7452 0.040625000000000001
r11717 n7441 n7453 0.17857142857142858
r11718 n7452 n7453 0.045312499999999999
r11719 n7442 n7454 5
r11720 n7453 n7454 0.045312499999999999
r11721 n7443 n7455 0.20000000000000001
r11722 n7454 n7455 0.040625000000000001
r11723 n7444 n7456 0.5
r11724 n7455 n7456 0.0546875
r11725 n7445 n7457 0.14015151515151514
r11726 n7446 n7458 2.3125
r11727 n7457 n7458 0.064338235294117641
r11728 n7447 n7459 0.15416666666666667
r11729 n7458 n7459 0.058823529411764705
r11730 n7448 n7460 2.3125
r11731 n7459 n7460 0.058823529411764705
r11732 n7449 n7461 0.14015151515151514
r11733 n7460 n7461 0.064338235294117641
r11734 n7450 n7462 0.46250000000000002
r11735 n7451 n7463 0.185
r11736 n7462 n7463 0.064338235294117641
r11737 n7452 n7464 4.625
r11738 n7463 n7464 0.04779411764705882
r11739 n7453 n7465 0.16517857142857142
r11740 n7464 n7465 0.053308823529411763
r11741 n7454 n7466 4.625
r11742 n7465 n7466 0.053308823529411763
r11743 n7455 n7467 0.185
r11744 n7466 n7467 0.04779411764705882
r11745 n7456 n7468 0.46250000000000002
r11746 n7467 n7468 0.064338235294117641
r11747 n7457 n7469 0.14734848484848484
r11748 n7458 n7470 2.4312499999999999
r11749 n7469 n7470 0.049942922374429224
r11750 n7459 n7471 0.16208333333333333
r11751 n7470 n7471 0.045662100456621002
r11752 n7460 n7472 2.4312499999999999
r11753 n7471 n7472 0.045662100456621002
r11754 n7461 n7473 0.14734848484848484
r11755 n7472 n7473 0.049942922374429224
r11756 n7462 n7474 0.48625000000000002
r11757 n7463 n7475 0.19450000000000001
r11758 n7474 n7475 0.049942922374429224
r11759 n7464 n7476 4.8624999999999998
r11760 n7475 n7476 0.037100456621004564
r11761 n7465 n7477 0.17366071428571428
r11762 n7476 n7477 0.041381278538812787
r11763 n7466 n7478 4.8624999999999998
r11764 n7477 n7478 0.041381278538812787
r11765 n7467 n7479 0.19450000000000001
r11766 n7478 n7479 0.037100456621004564
r11767 n7468 n7480 0.48625000000000002
r11768 n7479 n7480 0.049942922374429224
r11769 n7469 n7481 0.16553030303030303
r11770 n7470 n7482 2.7312500000000002
r11771 n7481 n7482 0.050172018348623851
r11772 n7471 n7483 0.18208333333333335
r11773 n7482 n7483 0.045871559633027525
r11774 n7472 n7484 2.7312500000000002
r11775 n7483 n7484 0.045871559633027525
r11776 n7473 n7485 0.16553030303030303
r11777 n7484 n7485 0.050172018348623851
r11778 n7474 n7486 0.54625000000000001
r11779 n7475 n7487 0.2185
r11780 n7486 n7487 0.050172018348623851
r11781 n7476 n7488 5.4625000000000004
r11782 n7487 n7488 0.037270642201834861
r11783 n7477 n7489 0.19508928571428572
r11784 n7488 n7489 0.041571100917431193
r11785 n7478 n7490 5.4625000000000004
r11786 n7489 n7490 0.041571100917431193
r11787 n7479 n7491 0.2185
r11788 n7490 n7491 0.037270642201834861
r11789 n7480 n7492 0.54625000000000001
r11790 n7491 n7492 0.050172018348623851
r11791 n7481 n7493 0.16553030303030303
r11792 n7482 n7494 2.7312500000000002
r11793 n7493 n7494 0.049942922374429224
r11794 n7483 n7495 0.18208333333333335
r11795 n7494 n7495 0.045662100456621002
r11796 n7484 n7496 2.7312500000000002
r11797 n7495 n7496 0.045662100456621002
r11798 n7485 n7497 0.16553030303030303
r11799 n7496 n7497 0.049942922374429224
r11800 n7486 n7498 0.54625000000000001
r11801 n7487 n7499 0.2185
r11802 n7498 n7499 0.049942922374429224
r11803 n7488 n7500 5.4625000000000004
r11804 n7499 n7500 0.037100456621004564
r11805 n7489 n7501 0.19508928571428572
r11806 n7500 n7501 0.041381278538812787
r11807 n7490 n7502 5.4625000000000004
r11808 n7501 n7502 0.041381278538812787
r11809 n7491 n7503 0.2185
r11810 n7502 n7503 0.037100456621004564
r11811 n7492 n7504 0.54625000000000001
r11812 n7503 n7504 0.049942922374429224
r11813 n7493 n7505 0.16590909090909092
r11814 n7494 n7506 2.7374999999999998
r11815 n7505 n7506 0.049942922374429224
r11816 n7495 n7507 0.1825
r11817 n7506 n7507 0.045662100456621002
r11818 n7496 n7508 2.7374999999999998
r11819 n7507 n7508 0.045662100456621002
r11820 n7497 n7509 0.16590909090909092
r11821 n7508 n7509 0.049942922374429224
r11822 n7498 n7510 0.54749999999999999
r11823 n7499 n7511 0.219
r11824 n7510 n7511 0.049942922374429224
r11825 n7500 n7512 5.4749999999999996
r11826 n7511 n7512 0.037100456621004564
r11827 n7501 n7513 0.19553571428571428
r11828 n7512 n7513 0.041381278538812787
r11829 n7502 n7514 5.4749999999999996
r11830 n7513 n7514 0.041381278538812787
r11831 n7503 n7515 0.219
r11832 n7514 n7515 0.037100456621004564
r11833 n7504 n7516 0.54749999999999999
r11834 n7515 n7516 0.049942922374429224
r11835 n7505 n7517 0.15227272727272728
r11836 n7506 n7518 2.5125000000000002
r11837 n7517 n7518 0.059767759562841527
r11838 n7507 n7519 0.16750000000000001
r11839 n7518 n7519 0.054644808743169397
r11840 n7508 n7520 2.5125000000000002
r11841 n7519 n7520 0.054644808743169397
r11842 n7509 n7521 0.15227272727272728
r11843 n7520 n7521 0.059767759562841527
r11844 n7510 n7522 0.50249999999999995
r11845 n7511 n7523 0.20100000000000001
r11846 n7522 n7523 0.059767759562841527
r11847 n7512 n7524 5.0250000000000004
r11848 n7523 n7524 0.044398907103825137
r11849 n7513 n7525 0.17946428571428572
r11850 n7524 n7525 0.049521857923497267
r11851 n7514 n7526 5.0250000000000004
r11852 n7525 n7526 0.049521857923497267
r11853 n7515 n7527 0.20100000000000001
r11854 n7526 n7527 0.044398907103825137
r11855 n7516 n7528 0.50249999999999995
r11856 n7527 n7528 0.059767759562841527
r11857 n7517 n7529 0.13901515151515151
r11858 n7518 n7530 2.2937500000000002
r11859 n7529 n7530 0.059442934782608696
r11860 n7519 n7531 0.15291666666666667
r11861 n7530 n7531 0.05434782608695652
r11862 n7520 n7532 2.2937500000000002
r11863 n7531 n7532 0.05434782608695652
r11864 n7521 n7533 0.13901515151515151
r11865 n7532 n7533 0.059442934782608696
r11866 n7522 n7534 0.45874999999999999
r11867 n7523 n7535 0.1835
r11868 n7534 n7535 0.059442934782608696
r11869 n7524 n7536 4.5875000000000004
r11870 n7535 n7536 0.044157608695652176
r11871 n7525 n7537 0.16383928571428572
r11872 n7536 n7537 0.049252717391304345
r11873 n7526 n7538 4.5875000000000004
r11874 n7537 n7538 0.049252717391304345
r11875 n7527 n7539 0.1835
r11876 n7538 n7539 0.044157608695652176
r11877 n7528 n7540 0.45874999999999999
r11878 n7539 n7540 0.059442934782608696
r11879 n7529 n7541 0.13901515151515151
r11880 n7530 n7542 2.2937500000000002
r11881 n7541 n7542 0.059767759562841527
r11882 n7531 n7543 0.15291666666666667
r11883 n7542 n7543 0.054644808743169397
r11884 n7532 n7544 2.2937500000000002
r11885 n7543 n7544 0.054644808743169397
r11886 n7533 n7545 0.13901515151515151
r11887 n7544 n7545 0.059767759562841527
r11888 n7534 n7546 0.45874999999999999
r11889 n7535 n7547 0.1835
r11890 n7546 n7547 0.059767759562841527
r11891 n7536 n7548 4.5875000000000004
r11892 n7547 n7548 0.044398907103825137
r11893 n7537 n7549 0.16383928571428572
r11894 n7548 n7549 0.049521857923497267
r11895 n7538 n7550 4.5875000000000004
r11896 n7549 n7550 0.049521857923497267
r11897 n7539 n7551 0.1835
r11898 n7550 n7551 0.044398907103825137
r11899 n7540 n7552 0.45874999999999999
r11900 n7551 n7552 0.059767759562841527
r11901 n7553 n7554 0.17624999999999999
r11902 n7554 n7555 0.11750000000000001
r11903 n7555 n7556 0.070499999999999993
r11904 n7556 n7557 0.047
r11905 n7557 n7558 0.047
r11906 n7558 n7559 0.11750000000000001
r11907 n7559 n7560 0.22325
r11908 n7560 n7561 0.17624999999999999
r11909 n7561 n7562 0.11750000000000001
r11910 n7562 n7563 0.070499999999999993
r11911 n7563 n7564 0.035249999999999997
r11912 n7564 n7565 0.035249999999999997
r11913 n7565 n7566 0.0235
r11914 n7566 n7567 0.0235
r11915 n7567 n7568 0.058750000000000004
r11916 n7568 n7569 0.10575000000000001
r11917 n7569 n7570 0.070499999999999993
r11918 n7570 n7571 0.12925
r11919 n7553 n7572 0.0093999999999999986
r11920 n7554 n7573 0.018799999999999997
r11921 n7572 n7573 0.17624999999999999
r11922 n7555 n7574 0.018799999999999997
r11923 n7573 n7574 0.11750000000000001
r11924 n7556 n7575 0.094
r11925 n7574 n7575 0.070499999999999993
r11926 n7557 n7576 0.031333333333333331
r11927 n7575 n7576 0.047
r11928 n7558 n7577 0.094
r11929 n7576 n7577 0.047
r11930 n7559 n7578 0.010444444444444444
r11931 n7577 n7578 0.11750000000000001
r11932 n7560 n7579 0.0093999999999999986
r11933 n7578 n7579 0.22325
r11934 n7561 n7580 0.018799999999999997
r11935 n7579 n7580 0.17624999999999999
r11936 n7562 n7581 0.018799999999999997
r11937 n7580 n7581 0.11750000000000001
r11938 n7563 n7582 0.094
r11939 n7581 n7582 0.070499999999999993
r11940 n7564 n7583 0.047
r11941 n7582 n7583 0.035249999999999997
r11942 n7565 n7584 0.094
r11943 n7583 n7584 0.035249999999999997
r11944 n7566 n7585 0.094
r11945 n7584 n7585 0.0235
r11946 n7567 n7586 0.094
r11947 n7585 n7586 0.0235
r11948 n7568 n7587 0.0235
r11949 n7586 n7587 0.058750000000000004
r11950 n7569 n7588 0.018799999999999997
r11951 n7587 n7588 0.10575000000000001
r11952 n7570 n7589 0.094
r11953 n7588 n7589 0.070499999999999993
r11954 n7571 n7590 0.0093999999999999986
r11955 n7589 n7590 0.12925
r11956 n7572 n7591 0.0093999999999999986
r11957 n7573 n7592 0.018799999999999997
r11958 n7591 n7592 0.17624999999999999
r11959 n7574 n7593 0.018799999999999997
r11960 n7592 n7593 0.11750000000000001
r11961 n7575 n7594 0.094
r11962 n7593 n7594 0.070499999999999993
r11963 n7576 n7595 0.031333333333333331
r11964 n7594 n7595 0.047
r11965 n7577 n7596 0.094
r11966 n7595 n7596 0.047
r11967 n7578 n7597 0.010444444444444444
r11968 n7596 n7597 0.11750000000000001
r11969 n7579 n7598 0.0093999999999999986
r11970 n7597 n7598 0.22325
r11971 n7580 n7599 0.018799999999999997
r11972 n7598 n7599 0.17624999999999999
r11973 n7581 n7600 0.018799999999999997
r11974 n7599 n7600 0.11750000000000001
r11975 n7582 n7601 0.094
r11976 n7600 n7601 0.070499999999999993
r11977 n7583 n7602 0.047
r11978 n7601 n7602 0.035249999999999997
r11979 n7584 n7603 0.094
r11980 n7602 n7603 0.035249999999999997
r11981 n7585 n7604 0.094
r11982 n7603 n7604 0.0235
r11983 n7586 n7605 0.094
r11984 n7604 n7605 0.0235
r11985 n7587 n7606 0.0235
r11986 n7605 n7606 0.058750000000000004
r11987 n7588 n7607 0.018799999999999997
r11988 n7606 n7607 0.10575000000000001
r11989 n7589 n7608 0.094
r11990 n7607 n7608 0.070499999999999993
r11991 n7590 n7609 0.0093999999999999986
r11992 n7608 n7609 0.12925
r11993 n7591 n7610 0.0141
r11994 n7592 n7611 0.028199999999999999
r11995 n7610 n7611 0.088124999999999995
r11996 n7593 n7612 0.028199999999999999
r11997 n7611 n7612 0.058750000000000004
r11998 n7594 n7613 0.14099999999999999
r11999 n7612 n7613 0.035249999999999997
r12000 n7595 n7614 0.047
r12001 n7613 n7614 0.0235
r12002 n7596 n7615 0.14099999999999999
r12003 n7614 n7615 0.0235
r12004 n7597 n7616 0.015666666666666666
r12005 n7615 n7616 0.058750000000000004
r12006 n7598 n7617 0.0141
r12007 n7616 n7617 0.111625
r12008 n7599 n7618 0.028199999999999999
r12009 n7617 n7618 0.088124999999999995
r12010 n7600 n7619 0.028199999999999999
r12011 n7618 n7619 0.058750000000000004
r12012 n7601 n7620 0.14099999999999999
r12013 n7619 n7620 0.035249999999999997
r12014 n7602 n7621 0.070499999999999993
r12015 n7620 n7621 0.017624999999999998
r12016 n7603 n7622 0.14099999999999999
r12017 n7621 n7622 0.017624999999999998
r12018 n7604 n7623 0.14099999999999999
r12019 n7622 n7623 0.01175
r12020 n7605 n7624 0.14099999999999999
r12021 n7623 n7624 0.01175
r12022 n7606 n7625 0.035249999999999997
r12023 n7624 n7625 0.029375000000000002
r12024 n7607 n7626 0.028199999999999999
r12025 n7625 n7626 0.052875000000000005
r12026 n7608 n7627 0.14099999999999999
r12027 n7626 n7627 0.035249999999999997
r12028 n7609 n7628 0.0141
r12029 n7627 n7628 0.064625000000000002
r12030 n7610 n7629 0.025849999999999998
r12031 n7611 n7630 0.051699999999999996
r12032 n7629 n7630 0.050357142857142857
r12033 n7612 n7631 0.051699999999999996
r12034 n7630 n7631 0.033571428571428572
r12035 n7613 n7632 0.25850000000000001
r12036 n7631 n7632 0.020142857142857143
r12037 n7614 n7633 0.086166666666666669
r12038 n7632 n7633 0.013428571428571429
r12039 n7615 n7634 0.25850000000000001
r12040 n7633 n7634 0.013428571428571429
r12041 n7616 n7635 0.028722222222222222
r12042 n7634 n7635 0.033571428571428572
r12043 n7617 n7636 0.025849999999999998
r12044 n7635 n7636 0.063785714285714279
r12045 n7618 n7637 0.051699999999999996
r12046 n7636 n7637 0.050357142857142857
r12047 n7619 n7638 0.051699999999999996
r12048 n7637 n7638 0.033571428571428572
r12049 n7620 n7639 0.25850000000000001
r12050 n7638 n7639 0.020142857142857143
r12051 n7621 n7640 0.12925
r12052 n7639 n7640 0.010071428571428571
r12053 n7622 n7641 0.25850000000000001
r12054 n7640 n7641 0.010071428571428571
r12055 n7623 n7642 0.25850000000000001
r12056 n7641 n7642 0.0067142857142857143
r12057 n7624 n7643 0.25850000000000001
r12058 n7642 n7643 0.0067142857142857143
r12059 n7625 n7644 0.064625000000000002
r12060 n7643 n7644 0.016785714285714286
r12061 n7626 n7645 0.051699999999999996
r12062 n7644 n7645 0.030214285714285718
r12063 n7627 n7646 0.25850000000000001
r12064 n7645 n7646 0.020142857142857143
r12065 n7628 n7647 0.025849999999999998
r12066 n7646 n7647 0.036928571428571429
r12067 n7629 n7648 0.0235
r12068 n7630 n7649 0.047
r12069 n7648 n7649 0.11749999999999999
r12070 n7631 n7650 0.047
r12071 n7649 n7650 0.078333333333333338
r12072 n7632 n7651 0.23500000000000001
r12073 n7650 n7651 0.047
r12074 n7633 n7652 0.078333333333333338
r12075 n7651 n7652 0.031333333333333331
r12076 n7634 n7653 0.23500000000000001
r12077 n7652 n7653 0.031333333333333331
r12078 n7635 n7654 0.026111111111111113
r12079 n7653 n7654 0.078333333333333338
r12080 n7636 n7655 0.0235
r12081 n7654 n7655 0.14883333333333332
r12082 n7637 n7656 0.047
r12083 n7655 n7656 0.11749999999999999
r12084 n7638 n7657 0.047
r12085 n7656 n7657 0.078333333333333338
r12086 n7639 n7658 0.23500000000000001
r12087 n7657 n7658 0.047
r12088 n7640 n7659 0.11750000000000001
r12089 n7658 n7659 0.0235
r12090 n7641 n7660 0.23500000000000001
r12091 n7659 n7660 0.0235
r12092 n7642 n7661 0.23500000000000001
r12093 n7660 n7661 0.015666666666666666
r12094 n7643 n7662 0.23500000000000001
r12095 n7661 n7662 0.015666666666666666
r12096 n7644 n7663 0.058750000000000004
r12097 n7662 n7663 0.039166666666666669
r12098 n7645 n7664 0.047
r12099 n7663 n7664 0.070500000000000007
r12100 n7646 n7665 0.23500000000000001
r12101 n7664 n7665 0.047
r12102 n7647 n7666 0.0235
r12103 n7665 n7666 0.086166666666666669
r12104 n7648 n7667 0.0141
r12105 n7649 n7668 0.028199999999999999
r12106 n7667 n7668 0.11749999999999999
r12107 n7650 n7669 0.028199999999999999
r12108 n7668 n7669 0.078333333333333338
r12109 n7651 n7670 0.14099999999999999
r12110 n7669 n7670 0.047
r12111 n7652 n7671 0.047
r12112 n7670 n7671 0.031333333333333331
r12113 n7653 n7672 0.14099999999999999
r12114 n7671 n7672 0.031333333333333331
r12115 n7654 n7673 0.015666666666666666
r12116 n7672 n7673 0.078333333333333338
r12117 n7655 n7674 0.0141
r12118 n7673 n7674 0.14883333333333332
r12119 n7656 n7675 0.028199999999999999
r12120 n7674 n7675 0.11749999999999999
r12121 n7657 n7676 0.028199999999999999
r12122 n7675 n7676 0.078333333333333338
r12123 n7658 n7677 0.14099999999999999
r12124 n7676 n7677 0.047
r12125 n7659 n7678 0.070499999999999993
r12126 n7677 n7678 0.0235
r12127 n7660 n7679 0.14099999999999999
r12128 n7678 n7679 0.0235
r12129 n7661 n7680 0.14099999999999999
r12130 n7679 n7680 0.015666666666666666
r12131 n7662 n7681 0.14099999999999999
r12132 n7680 n7681 0.015666666666666666
r12133 n7663 n7682 0.035249999999999997
r12134 n7681 n7682 0.039166666666666669
r12135 n7664 n7683 0.028199999999999999
r12136 n7682 n7683 0.070500000000000007
r12137 n7665 n7684 0.14099999999999999
r12138 n7683 n7684 0.047
r12139 n7666 n7685 0.0141
r12140 n7684 n7685 0.086166666666666669
r12141 n7667 n7686 0.01175
r12142 n7668 n7687 0.0235
r12143 n7686 n7687 0.17624999999999999
r12144 n7669 n7688 0.0235
r12145 n7687 n7688 0.11750000000000001
r12146 n7670 n7689 0.11750000000000001
r12147 n7688 n7689 0.070499999999999993
r12148 n7671 n7690 0.039166666666666669
r12149 n7689 n7690 0.047
r12150 n7672 n7691 0.11750000000000001
r12151 n7690 n7691 0.047
r12152 n7673 n7692 0.013055555555555556
r12153 n7691 n7692 0.11750000000000001
r12154 n7674 n7693 0.01175
r12155 n7692 n7693 0.22325
r12156 n7675 n7694 0.0235
r12157 n7693 n7694 0.17624999999999999
r12158 n7676 n7695 0.0235
r12159 n7694 n7695 0.11750000000000001
r12160 n7677 n7696 0.11750000000000001
r12161 n7695 n7696 0.070499999999999993
r12162 n7678 n7697 0.058750000000000004
r12163 n7696 n7697 0.035249999999999997
r12164 n7679 n7698 0.11750000000000001
r12165 n7697 n7698 0.035249999999999997
r12166 n7680 n7699 0.11750000000000001
r12167 n7698 n7699 0.0235
r12168 n7681 n7700 0.11750000000000001
r12169 n7699 n7700 0.0235
r12170 n7682 n7701 0.029375000000000002
r12171 n7700 n7701 0.058750000000000004
r12172 n7683 n7702 0.0235
r12173 n7701 n7702 0.10575000000000001
r12174 n7684 n7703 0.11750000000000001
r12175 n7702 n7703 0.070499999999999993
r12176 n7685 n7704 0.01175
r12177 n7703 n7704 0.12925
r12178 n7686 n7705 0.039949999999999999
r12179 n7687 n7706 0.079899999999999999
r12180 n7705 n7706 0.0235
r12181 n7688 n7707 0.079899999999999999
r12182 n7706 n7707 0.015666666666666666
r12183 n7689 n7708 0.39950000000000002
r12184 n7707 n7708 0.0093999999999999986
r12185 n7690 n7709 0.13316666666666668
r12186 n7708 n7709 0.006266666666666666
r12187 n7691 n7710 0.39950000000000002
r12188 n7709 n7710 0.006266666666666666
r12189 n7692 n7711 0.044388888888888887
r12190 n7710 n7711 0.015666666666666666
r12191 n7693 n7712 0.039949999999999999
r12192 n7711 n7712 0.029766666666666667
r12193 n7694 n7713 0.079899999999999999
r12194 n7712 n7713 0.0235
r12195 n7695 n7714 0.079899999999999999
r12196 n7713 n7714 0.015666666666666666
r12197 n7696 n7715 0.39950000000000002
r12198 n7714 n7715 0.0093999999999999986
r12199 n7697 n7716 0.19975000000000001
r12200 n7715 n7716 0.0046999999999999993
r12201 n7698 n7717 0.39950000000000002
r12202 n7716 n7717 0.0046999999999999993
r12203 n7699 n7718 0.39950000000000002
r12204 n7717 n7718 0.003133333333333333
r12205 n7700 n7719 0.39950000000000002
r12206 n7718 n7719 0.003133333333333333
r12207 n7701 n7720 0.099875000000000005
r12208 n7719 n7720 0.0078333333333333328
r12209 n7702 n7721 0.079899999999999999
r12210 n7720 n7721 0.014100000000000001
r12211 n7703 n7722 0.39950000000000002
r12212 n7721 n7722 0.0093999999999999986
r12213 n7704 n7723 0.039949999999999999
r12214 n7722 n7723 0.017233333333333333
r12215 n7705 n7724 0.070499999999999993
r12216 n7706 n7725 0.14099999999999999
r12217 n7724 n7725 0.0235
r12218 n7707 n7726 0.14099999999999999
r12219 n7725 n7726 0.015666666666666666
r12220 n7708 n7727 0.70499999999999996
r12221 n7726 n7727 0.0093999999999999986
r12222 n7709 n7728 0.23499999999999999
r12223 n7727 n7728 0.006266666666666666
r12224 n7710 n7729 0.70499999999999996
r12225 n7728 n7729 0.006266666666666666
r12226 n7711 n7730 0.078333333333333338
r12227 n7729 n7730 0.015666666666666666
r12228 n7712 n7731 0.070499999999999993
r12229 n7730 n7731 0.029766666666666667
r12230 n7713 n7732 0.14099999999999999
r12231 n7731 n7732 0.0235
r12232 n7714 n7733 0.14099999999999999
r12233 n7732 n7733 0.015666666666666666
r12234 n7715 n7734 0.70499999999999996
r12235 n7733 n7734 0.0093999999999999986
r12236 n7716 n7735 0.35249999999999998
r12237 n7734 n7735 0.0046999999999999993
r12238 n7717 n7736 0.70499999999999996
r12239 n7735 n7736 0.0046999999999999993
r12240 n7718 n7737 0.70499999999999996
r12241 n7736 n7737 0.003133333333333333
r12242 n7719 n7738 0.70499999999999996
r12243 n7737 n7738 0.003133333333333333
r12244 n7720 n7739 0.17624999999999999
r12245 n7738 n7739 0.0078333333333333328
r12246 n7721 n7740 0.14099999999999999
r12247 n7739 n7740 0.014100000000000001
r12248 n7722 n7741 0.70499999999999996
r12249 n7740 n7741 0.0093999999999999986
r12250 n7723 n7742 0.070499999999999993
r12251 n7741 n7742 0.017233333333333333
r12252 n7724 n7743 0.039949999999999999
r12253 n7725 n7744 0.079899999999999999
r12254 n7743 n7744 0.17624999999999999
r12255 n7726 n7745 0.079899999999999999
r12256 n7744 n7745 0.11750000000000001
r12257 n7727 n7746 0.39950000000000002
r12258 n7745 n7746 0.070499999999999993
r12259 n7728 n7747 0.13316666666666668
r12260 n7746 n7747 0.047
r12261 n7729 n7748 0.39950000000000002
r12262 n7747 n7748 0.047
r12263 n7730 n7749 0.044388888888888887
r12264 n7748 n7749 0.11750000000000001
r12265 n7731 n7750 0.039949999999999999
r12266 n7749 n7750 0.22325
r12267 n7732 n7751 0.079899999999999999
r12268 n7750 n7751 0.17624999999999999
r12269 n7733 n7752 0.079899999999999999
r12270 n7751 n7752 0.11750000000000001
r12271 n7734 n7753 0.39950000000000002
r12272 n7752 n7753 0.070499999999999993
r12273 n7735 n7754 0.19975000000000001
r12274 n7753 n7754 0.035249999999999997
r12275 n7736 n7755 0.39950000000000002
r12276 n7754 n7755 0.035249999999999997
r12277 n7737 n7756 0.39950000000000002
r12278 n7755 n7756 0.0235
r12279 n7738 n7757 0.39950000000000002
r12280 n7756 n7757 0.0235
r12281 n7739 n7758 0.099875000000000005
r12282 n7757 n7758 0.058750000000000004
r12283 n7740 n7759 0.079899999999999999
r12284 n7758 n7759 0.10575000000000001
r12285 n7741 n7760 0.39950000000000002
r12286 n7759 n7760 0.070499999999999993
r12287 n7742 n7761 0.039949999999999999
r12288 n7760 n7761 0.12925
r12289 n7743 n7762 0.01175
r12290 n7744 n7763 0.0235
r12291 n7762 n7763 0.11749999999999999
r12292 n7745 n7764 0.0235
r12293 n7763 n7764 0.078333333333333338
r12294 n7746 n7765 0.11750000000000001
r12295 n7764 n7765 0.047
r12296 n7747 n7766 0.039166666666666669
r12297 n7765 n7766 0.031333333333333331
r12298 n7748 n7767 0.11750000000000001
r12299 n7766 n7767 0.031333333333333331
r12300 n7749 n7768 0.013055555555555556
r12301 n7767 n7768 0.078333333333333338
r12302 n7750 n7769 0.01175
r12303 n7768 n7769 0.14883333333333332
r12304 n7751 n7770 0.0235
r12305 n7769 n7770 0.11749999999999999
r12306 n7752 n7771 0.0235
r12307 n7770 n7771 0.078333333333333338
r12308 n7753 n7772 0.11750000000000001
r12309 n7771 n7772 0.047
r12310 n7754 n7773 0.058750000000000004
r12311 n7772 n7773 0.0235
r12312 n7755 n7774 0.11750000000000001
r12313 n7773 n7774 0.0235
r12314 n7756 n7775 0.11750000000000001
r12315 n7774 n7775 0.015666666666666666
r12316 n7757 n7776 0.11750000000000001
r12317 n7775 n7776 0.015666666666666666
r12318 n7758 n7777 0.029375000000000002
r12319 n7776 n7777 0.039166666666666669
r12320 n7759 n7778 0.0235
r12321 n7777 n7778 0.070500000000000007
r12322 n7760 n7779 0.11750000000000001
r12323 n7778 n7779 0.047
r12324 n7761 n7780 0.01175
r12325 n7779 n7780 0.086166666666666669
r12326 n7762 n7781 0.0141
r12327 n7763 n7782 0.028199999999999999
r12328 n7781 n7782 0.11749999999999999
r12329 n7764 n7783 0.028199999999999999
r12330 n7782 n7783 0.078333333333333338
r12331 n7765 n7784 0.14099999999999999
r12332 n7783 n7784 0.047
r12333 n7766 n7785 0.047
r12334 n7784 n7785 0.031333333333333331
r12335 n7767 n7786 0.14099999999999999
r12336 n7785 n7786 0.031333333333333331
r12337 n7768 n7787 0.015666666666666666
r12338 n7786 n7787 0.078333333333333338
r12339 n7769 n7788 0.0141
r12340 n7787 n7788 0.14883333333333332
r12341 n7770 n7789 0.028199999999999999
r12342 n7788 n7789 0.11749999999999999
r12343 n7771 n7790 0.028199999999999999
r12344 n7789 n7790 0.078333333333333338
r12345 n7772 n7791 0.14099999999999999
r12346 n7790 n7791 0.047
r12347 n7773 n7792 0.070499999999999993
r12348 n7791 n7792 0.0235
r12349 n7774 n7793 0.14099999999999999
r12350 n7792 n7793 0.0235
r12351 n7775 n7794 0.14099999999999999
r12352 n7793 n7794 0.015666666666666666
r12353 n7776 n7795 0.14099999999999999
r12354 n7794 n7795 0.015666666666666666
r12355 n7777 n7796 0.035249999999999997
r12356 n7795 n7796 0.039166666666666669
r12357 n7778 n7797 0.028199999999999999
r12358 n7796 n7797 0.070500000000000007
r12359 n7779 n7798 0.14099999999999999
r12360 n7797 n7798 0.047
r12361 n7780 n7799 0.0141
r12362 n7798 n7799 0.086166666666666669
r12363 n7781 n7800 0.0235
r12364 n7782 n7801 0.047
r12365 n7800 n7801 0.050357142857142857
r12366 n7783 n7802 0.047
r12367 n7801 n7802 0.033571428571428572
r12368 n7784 n7803 0.23500000000000001
r12369 n7802 n7803 0.020142857142857143
r12370 n7785 n7804 0.078333333333333338
r12371 n7803 n7804 0.013428571428571429
r12372 n7786 n7805 0.23500000000000001
r12373 n7804 n7805 0.013428571428571429
r12374 n7787 n7806 0.026111111111111113
r12375 n7805 n7806 0.033571428571428572
r12376 n7788 n7807 0.0235
r12377 n7806 n7807 0.063785714285714279
r12378 n7789 n7808 0.047
r12379 n7807 n7808 0.050357142857142857
r12380 n7790 n7809 0.047
r12381 n7808 n7809 0.033571428571428572
r12382 n7791 n7810 0.23500000000000001
r12383 n7809 n7810 0.020142857142857143
r12384 n7792 n7811 0.11750000000000001
r12385 n7810 n7811 0.010071428571428571
r12386 n7793 n7812 0.23500000000000001
r12387 n7811 n7812 0.010071428571428571
r12388 n7794 n7813 0.23500000000000001
r12389 n7812 n7813 0.0067142857142857143
r12390 n7795 n7814 0.23500000000000001
r12391 n7813 n7814 0.0067142857142857143
r12392 n7796 n7815 0.058750000000000004
r12393 n7814 n7815 0.016785714285714286
r12394 n7797 n7816 0.047
r12395 n7815 n7816 0.030214285714285718
r12396 n7798 n7817 0.23500000000000001
r12397 n7816 n7817 0.020142857142857143
r12398 n7799 n7818 0.0235
r12399 n7817 n7818 0.036928571428571429
r12400 n7800 n7819 0.035249999999999997
r12401 n7801 n7820 0.070499999999999993
r12402 n7819 n7820 0.044062499999999998
r12403 n7802 n7821 0.070499999999999993
r12404 n7820 n7821 0.029375000000000002
r12405 n7803 n7822 0.35249999999999998
r12406 n7821 n7822 0.017624999999999998
r12407 n7804 n7823 0.11749999999999999
r12408 n7822 n7823 0.01175
r12409 n7805 n7824 0.35249999999999998
r12410 n7823 n7824 0.01175
r12411 n7806 n7825 0.039166666666666669
r12412 n7824 n7825 0.029375000000000002
r12413 n7807 n7826 0.035249999999999997
r12414 n7825 n7826 0.055812500000000001
r12415 n7808 n7827 0.070499999999999993
r12416 n7826 n7827 0.044062499999999998
r12417 n7809 n7828 0.070499999999999993
r12418 n7827 n7828 0.029375000000000002
r12419 n7810 n7829 0.35249999999999998
r12420 n7828 n7829 0.017624999999999998
r12421 n7811 n7830 0.17624999999999999
r12422 n7829 n7830 0.0088124999999999992
r12423 n7812 n7831 0.35249999999999998
r12424 n7830 n7831 0.0088124999999999992
r12425 n7813 n7832 0.35249999999999998
r12426 n7831 n7832 0.005875
r12427 n7814 n7833 0.35249999999999998
r12428 n7832 n7833 0.005875
r12429 n7815 n7834 0.088124999999999995
r12430 n7833 n7834 0.014687500000000001
r12431 n7816 n7835 0.070499999999999993
r12432 n7834 n7835 0.026437500000000003
r12433 n7817 n7836 0.35249999999999998
r12434 n7835 n7836 0.017624999999999998
r12435 n7818 n7837 0.035249999999999997
r12436 n7836 n7837 0.032312500000000001
r12437 n7819 n7838 0.0235
r12438 n7820 n7839 0.047
r12439 n7838 n7839 0.17624999999999999
r12440 n7821 n7840 0.047
r12441 n7839 n7840 0.11750000000000001
r12442 n7822 n7841 0.23500000000000001
r12443 n7840 n7841 0.070499999999999993
r12444 n7823 n7842 0.078333333333333338
r12445 n7841 n7842 0.047
r12446 n7824 n7843 0.23500000000000001
r12447 n7842 n7843 0.047
r12448 n7825 n7844 0.026111111111111113
r12449 n7843 n7844 0.11750000000000001
r12450 n7826 n7845 0.0235
r12451 n7844 n7845 0.22325
r12452 n7827 n7846 0.047
r12453 n7845 n7846 0.17624999999999999
r12454 n7828 n7847 0.047
r12455 n7846 n7847 0.11750000000000001
r12456 n7829 n7848 0.23500000000000001
r12457 n7847 n7848 0.070499999999999993
r12458 n7830 n7849 0.11750000000000001
r12459 n7848 n7849 0.035249999999999997
r12460 n7831 n7850 0.23500000000000001
r12461 n7849 n7850 0.035249999999999997
r12462 n7832 n7851 0.23500000000000001
r12463 n7850 n7851 0.0235
r12464 n7833 n7852 0.23500000000000001
r12465 n7851 n7852 0.0235
r12466 n7834 n7853 0.058750000000000004
r12467 n7852 n7853 0.058750000000000004
r12468 n7835 n7854 0.047
r12469 n7853 n7854 0.10575000000000001
r12470 n7836 n7855 0.23500000000000001
r12471 n7854 n7855 0.070499999999999993
r12472 n7837 n7856 0.0235
r12473 n7855 n7856 0.12925
r12474 n7839 n7857 0.1598
r12475 n7840 n7858 0.1598
r12476 n7857 n7858 0.0073437500000000005
r12477 n7841 n7859 0.79900000000000004
r12478 n7858 n7859 0.0044062499999999996
r12479 n7842 n7860 0.26633333333333337
r12480 n7859 n7860 0.0029375
r12481 n7843 n7861 0.79900000000000004
r12482 n7860 n7861 0.0029375
r12483 n7844 n7862 0.088777777777777775
r12484 n7861 n7862 0.0073437500000000005
r12485 n7845 n7863 0.079899999999999999
r12486 n7862 n7863 0.013953125
r12487 n7846 n7864 0.1598
r12488 n7863 n7864 0.011015624999999999
r12489 n7847 n7865 0.1598
r12490 n7864 n7865 0.0073437500000000005
r12491 n7848 n7866 0.79900000000000004
r12492 n7865 n7866 0.0044062499999999996
r12493 n7849 n7867 0.39950000000000002
r12494 n7866 n7867 0.0022031249999999998
r12495 n7850 n7868 0.79900000000000004
r12496 n7867 n7868 0.0022031249999999998
r12497 n7851 n7869 0.79900000000000004
r12498 n7868 n7869 0.00146875
r12499 n7852 n7870 0.79900000000000004
r12500 n7869 n7870 0.00146875
r12501 n7853 n7871 0.19975000000000001
r12502 n7870 n7871 0.0036718750000000002
r12503 n7854 n7872 0.1598
r12504 n7871 n7872 0.0066093750000000007
r12505 n7855 n7873 0.79900000000000004
r12506 n7872 n7873 0.0044062499999999996
r12507 n7857 n7874 0.37130000000000002
r12508 n7858 n7875 0.37130000000000002
r12509 n7874 n7875 0.0050000000000000001
r12510 n7859 n7876 1.8565
r12511 n7875 n7876 0.0029999999999999996
r12512 n7860 n7877 0.61883333333333335
r12513 n7876 n7877 0.002
r12514 n7861 n7878 1.8565
r12515 n7877 n7878 0.002
r12516 n7862 n7879 0.20627777777777778
r12517 n7878 n7879 0.0050000000000000001
r12518 n7863 n7880 0.18565000000000001
r12519 n7879 n7880 0.0094999999999999998
r12520 n7864 n7881 0.37130000000000002
r12521 n7880 n7881 0.0074999999999999997
r12522 n7865 n7882 0.37130000000000002
r12523 n7881 n7882 0.0050000000000000001
r12524 n7866 n7883 1.8565
r12525 n7882 n7883 0.0029999999999999996
r12526 n7867 n7884 0.92825000000000002
r12527 n7883 n7884 0.0014999999999999998
r12528 n7868 n7885 1.8565
r12529 n7884 n7885 0.0014999999999999998
r12530 n7869 n7886 1.8565
r12531 n7885 n7886 0.001
r12532 n7870 n7887 1.8565
r12533 n7886 n7887 0.001
r12534 n7871 n7888 0.46412500000000001
r12535 n7887 n7888 0.0025000000000000001
r12536 n7872 n7889 0.37130000000000002
r12537 n7888 n7889 0.0045000000000000005
r12538 n7873 n7890 1.8565
r12539 n7889 n7890 0.0029999999999999996
r12540 n7874 n7891 0.38069999999999998
r12541 n7875 n7892 0.38069999999999998
r12542 n7891 n7892 0.0069117647058823534
r12543 n7876 n7893 1.9035
r12544 n7892 n7893 0.0041470588235294117
r12545 n7877 n7894 0.63449999999999995
r12546 n7893 n7894 0.0027647058823529408
r12547 n7878 n7895 1.9035
r12548 n7894 n7895 0.0027647058823529408
r12549 n7879 n7896 0.21149999999999999
r12550 n7895 n7896 0.0069117647058823534
r12551 n7880 n7897 0.19034999999999999
r12552 n7896 n7897 0.01313235294117647
r12553 n7881 n7898 0.38069999999999998
r12554 n7897 n7898 0.010367647058823528
r12555 n7882 n7899 0.38069999999999998
r12556 n7898 n7899 0.0069117647058823534
r12557 n7883 n7900 1.9035
r12558 n7899 n7900 0.0041470588235294117
r12559 n7884 n7901 0.95174999999999998
r12560 n7900 n7901 0.0020735294117647058
r12561 n7885 n7902 1.9035
r12562 n7901 n7902 0.0020735294117647058
r12563 n7886 n7903 1.9035
r12564 n7902 n7903 0.0013823529411764704
r12565 n7887 n7904 1.9035
r12566 n7903 n7904 0.0013823529411764704
r12567 n7888 n7905 0.47587499999999999
r12568 n7904 n7905 0.0034558823529411767
r12569 n7889 n7906 0.38069999999999998
r12570 n7905 n7906 0.0062205882352941184
r12571 n7890 n7907 1.9035
r12572 n7906 n7907 0.0041470588235294117
r12573 n7891 n7908 0.38822000000000001
r12574 n7892 n7909 0.38822000000000001
r12575 n7908 n7909 0.0048353909465020575
r12576 n7893 n7910 1.9411
r12577 n7909 n7910 0.0029012345679012342
r12578 n7894 n7911 0.64703333333333335
r12579 n7910 n7911 0.001934156378600823
r12580 n7895 n7912 1.9411
r12581 n7911 n7912 0.001934156378600823
r12582 n7896 n7913 0.2156777777777778
r12583 n7912 n7913 0.0048353909465020575
r12584 n7897 n7914 0.19411
r12585 n7913 n7914 0.009187242798353909
r12586 n7898 n7915 0.38822000000000001
r12587 n7914 n7915 0.0072530864197530862
r12588 n7899 n7916 0.38822000000000001
r12589 n7915 n7916 0.0048353909465020575
r12590 n7900 n7917 1.9411
r12591 n7916 n7917 0.0029012345679012342
r12592 n7901 n7918 0.97055000000000002
r12593 n7917 n7918 0.0014506172839506171
r12594 n7902 n7919 1.9411
r12595 n7918 n7919 0.0014506172839506171
r12596 n7903 n7920 1.9411
r12597 n7919 n7920 0.00096707818930041151
r12598 n7904 n7921 1.9411
r12599 n7920 n7921 0.00096707818930041151
r12600 n7905 n7922 0.48527500000000001
r12601 n7921 n7922 0.0024176954732510287
r12602 n7906 n7923 0.38822000000000001
r12603 n7922 n7923 0.0043518518518518524
r12604 n7907 n7924 1.9411
r12605 n7923 n7924 0.0029012345679012342
r12606 n7908 n7925 0.45777999999999996
r12607 n7909 n7926 0.45777999999999996
r12608 n7925 n7926 0.0048155737704918032
r12609 n7910 n7927 2.2888999999999999
r12610 n7926 n7927 0.0028893442622950818
r12611 n7911 n7928 0.76296666666666668
r12612 n7927 n7928 0.0019262295081967213
r12613 n7912 n7929 2.2888999999999999
r12614 n7928 n7929 0.0019262295081967213
r12615 n7913 n7930 0.25432222222222223
r12616 n7929 n7930 0.0048155737704918032
r12617 n7914 n7931 0.22888999999999998
r12618 n7930 n7931 0.0091495901639344259
r12619 n7915 n7932 0.45777999999999996
r12620 n7931 n7932 0.0072233606557377044
r12621 n7916 n7933 0.45777999999999996
r12622 n7932 n7933 0.0048155737704918032
r12623 n7917 n7934 2.2888999999999999
r12624 n7933 n7934 0.0028893442622950818
r12625 n7918 n7935 1.14445
r12626 n7934 n7935 0.0014446721311475409
r12627 n7919 n7936 2.2888999999999999
r12628 n7935 n7936 0.0014446721311475409
r12629 n7920 n7937 2.2888999999999999
r12630 n7936 n7937 0.00096311475409836063
r12631 n7921 n7938 2.2888999999999999
r12632 n7937 n7938 0.00096311475409836063
r12633 n7922 n7939 0.57222499999999998
r12634 n7938 n7939 0.0024077868852459016
r12635 n7923 n7940 0.45777999999999996
r12636 n7939 n7940 0.0043340163934426235
r12637 n7924 n7941 2.2888999999999999
r12638 n7940 n7941 0.0028893442622950818
r12639 n7925 n7942 0.45777999999999996
r12640 n7926 n7943 0.45777999999999996
r12641 n7942 n7943 0.0048353909465020575
r12642 n7927 n7944 2.2888999999999999
r12643 n7943 n7944 0.0029012345679012342
r12644 n7928 n7945 0.76296666666666668
r12645 n7944 n7945 0.001934156378600823
r12646 n7929 n7946 2.2888999999999999
r12647 n7945 n7946 0.001934156378600823
r12648 n7930 n7947 0.25432222222222223
r12649 n7946 n7947 0.0048353909465020575
r12650 n7931 n7948 0.22888999999999998
r12651 n7947 n7948 0.009187242798353909
r12652 n7932 n7949 0.45777999999999996
r12653 n7948 n7949 0.0072530864197530862
r12654 n7933 n7950 0.45777999999999996
r12655 n7949 n7950 0.0048353909465020575
r12656 n7934 n7951 2.2888999999999999
r12657 n7950 n7951 0.0029012345679012342
r12658 n7935 n7952 1.14445
r12659 n7951 n7952 0.0014506172839506171
r12660 n7936 n7953 2.2888999999999999
r12661 n7952 n7953 0.0014506172839506171
r12662 n7937 n7954 2.2888999999999999
r12663 n7953 n7954 0.00096707818930041151
r12664 n7938 n7955 2.2888999999999999
r12665 n7954 n7955 0.00096707818930041151
r12666 n7939 n7956 0.57222499999999998
r12667 n7955 n7956 0.0024176954732510287
r12668 n7940 n7957 0.45777999999999996
r12669 n7956 n7957 0.0043518518518518524
r12670 n7941 n7958 2.2888999999999999
r12671 n7957 n7958 0.0029012345679012342
r12672 n7942 n7959 0.45683999999999997
r12673 n7943 n7960 0.45683999999999997
r12674 n7959 n7960 0.0048353909465020575
r12675 n7944 n7961 2.2841999999999998
r12676 n7960 n7961 0.0029012345679012342
r12677 n7945 n7962 0.76139999999999997
r12678 n7961 n7962 0.001934156378600823
r12679 n7946 n7963 2.2841999999999998
r12680 n7962 n7963 0.001934156378600823
r12681 n7947 n7964 0.25379999999999997
r12682 n7963 n7964 0.0048353909465020575
r12683 n7948 n7965 0.22841999999999998
r12684 n7964 n7965 0.009187242798353909
r12685 n7949 n7966 0.45683999999999997
r12686 n7965 n7966 0.0072530864197530862
r12687 n7950 n7967 0.45683999999999997
r12688 n7966 n7967 0.0048353909465020575
r12689 n7951 n7968 2.2841999999999998
r12690 n7967 n7968 0.0029012345679012342
r12691 n7952 n7969 1.1420999999999999
r12692 n7968 n7969 0.0014506172839506171
r12693 n7953 n7970 2.2841999999999998
r12694 n7969 n7970 0.0014506172839506171
r12695 n7954 n7971 2.2841999999999998
r12696 n7970 n7971 0.00096707818930041151
r12697 n7955 n7972 2.2841999999999998
r12698 n7971 n7972 0.00096707818930041151
r12699 n7956 n7973 0.57104999999999995
r12700 n7972 n7973 0.0024176954732510287
r12701 n7957 n7974 0.45683999999999997
r12702 n7973 n7974 0.0043518518518518524
r12703 n7958 n7975 2.2841999999999998
r12704 n7974 n7975 0.0029012345679012342
r12705 n7959 n7976 0.45777999999999996
r12706 n7960 n7977 0.45777999999999996
r12707 n7976 n7977 0.0048155737704918032
r12708 n7961 n7978 2.2888999999999999
r12709 n7977 n7978 0.0028893442622950818
r12710 n7962 n7979 0.76296666666666668
r12711 n7978 n7979 0.0019262295081967213
r12712 n7963 n7980 2.2888999999999999
r12713 n7979 n7980 0.0019262295081967213
r12714 n7964 n7981 0.25432222222222223
r12715 n7980 n7981 0.0048155737704918032
r12716 n7965 n7982 0.22888999999999998
r12717 n7981 n7982 0.0091495901639344259
r12718 n7966 n7983 0.45777999999999996
r12719 n7982 n7983 0.0072233606557377044
r12720 n7967 n7984 0.45777999999999996
r12721 n7983 n7984 0.0048155737704918032
r12722 n7968 n7985 2.2888999999999999
r12723 n7984 n7985 0.0028893442622950818
r12724 n7969 n7986 1.14445
r12725 n7985 n7986 0.0014446721311475409
r12726 n7970 n7987 2.2888999999999999
r12727 n7986 n7987 0.0014446721311475409
r12728 n7971 n7988 2.2888999999999999
r12729 n7987 n7988 0.00096311475409836063
r12730 n7972 n7989 2.2888999999999999
r12731 n7988 n7989 0.00096311475409836063
r12732 n7973 n7990 0.57222499999999998
r12733 n7989 n7990 0.0024077868852459016
r12734 n7974 n7991 0.45777999999999996
r12735 n7990 n7991 0.0043340163934426235
r12736 n7975 n7992 2.2888999999999999
r12737 n7991 n7992 0.0028893442622950818
r12738 n7976 n7993 0.45777999999999996
r12739 n7977 n7994 0.45777999999999996
r12740 n7993 n7994 0.0048353909465020575
r12741 n7978 n7995 2.2888999999999999
r12742 n7994 n7995 0.0029012345679012342
r12743 n7979 n7996 0.76296666666666668
r12744 n7995 n7996 0.001934156378600823
r12745 n7980 n7997 2.2888999999999999
r12746 n7996 n7997 0.001934156378600823
r12747 n7981 n7998 0.25432222222222223
r12748 n7997 n7998 0.0048353909465020575
r12749 n7982 n7999 0.22888999999999998
r12750 n7998 n7999 0.009187242798353909
r12751 n7983 n8000 0.45777999999999996
r12752 n7999 n8000 0.0072530864197530862
r12753 n7984 n8001 0.45777999999999996
r12754 n8000 n8001 0.0048353909465020575
r12755 n7985 n8002 2.2888999999999999
r12756 n8001 n8002 0.0029012345679012342
r12757 n7986 n8003 1.14445
r12758 n8002 n8003 0.0014506172839506171
r12759 n7987 n8004 2.2888999999999999
r12760 n8003 n8004 0.0014506172839506171
r12761 n7988 n8005 2.2888999999999999
r12762 n8004 n8005 0.00096707818930041151
r12763 n7989 n8006 2.2888999999999999
r12764 n8005 n8006 0.00096707818930041151
r12765 n7990 n8007 0.57222499999999998
r12766 n8006 n8007 0.0024176954732510287
r12767 n7991 n8008 0.45777999999999996
r12768 n8007 n8008 0.0043518518518518524
r12769 n7992 n8009 2.2888999999999999
r12770 n8008 n8009 0.0029012345679012342
r12771 n7993 n8010 0.23782
r12772 n7994 n8011 0.23782
r12773 n8010 n8011 0.11750000000000001
r12774 n7995 n8012 1.1891
r12775 n8011 n8012 0.070499999999999993
r12776 n7996 n8013 0.39636666666666664
r12777 n8012 n8013 0.047
r12778 n7997 n8014 1.1891
r12779 n8013 n8014 0.047
r12780 n7998 n8015 0.13212222222222222
r12781 n8014 n8015 0.11750000000000001
r12782 n7999 n8016 0.11891
r12783 n8015 n8016 0.22325
r12784 n8000 n8017 0.23782
r12785 n8016 n8017 0.17624999999999999
r12786 n8001 n8018 0.23782
r12787 n8017 n8018 0.11750000000000001
r12788 n8002 n8019 1.1891
r12789 n8018 n8019 0.070499999999999993
r12790 n8003 n8020 0.59455000000000002
r12791 n8019 n8020 0.035249999999999997
r12792 n8004 n8021 1.1891
r12793 n8020 n8021 0.035249999999999997
r12794 n8005 n8022 1.1891
r12795 n8021 n8022 0.0235
r12796 n8006 n8023 1.1891
r12797 n8022 n8023 0.0235
r12798 n8007 n8024 0.29727500000000001
r12799 n8023 n8024 0.058750000000000004
r12800 n8008 n8025 0.23782
r12801 n8024 n8025 0.10575000000000001
r12802 n8009 n8026 1.1891
r12803 n8025 n8026 0.070499999999999993
r12804 n8010 n8027 0.061100000000000002
r12805 n8011 n8028 0.061100000000000002
r12806 n8027 n8028 0.021363636363636366
r12807 n8012 n8029 0.30549999999999999
r12808 n8028 n8029 0.012818181818181817
r12809 n8013 n8030 0.10183333333333335
r12810 n8029 n8030 0.0085454545454545453
r12811 n8014 n8031 0.30549999999999999
r12812 n8030 n8031 0.0085454545454545453
r12813 n8015 n8032 0.033944444444444444
r12814 n8031 n8032 0.021363636363636366
r12815 n8016 n8033 0.030550000000000001
r12816 n8032 n8033 0.040590909090909087
r12817 n8017 n8034 0.061100000000000002
r12818 n8033 n8034 0.032045454545454544
r12819 n8018 n8035 0.061100000000000002
r12820 n8034 n8035 0.021363636363636366
r12821 n8019 n8036 0.30549999999999999
r12822 n8035 n8036 0.012818181818181817
r12823 n8020 n8037 0.15275
r12824 n8036 n8037 0.0064090909090909086
r12825 n8021 n8038 0.30549999999999999
r12826 n8037 n8038 0.0064090909090909086
r12827 n8022 n8039 0.30549999999999999
r12828 n8038 n8039 0.0042727272727272727
r12829 n8023 n8040 0.30549999999999999
r12830 n8039 n8040 0.0042727272727272727
r12831 n8024 n8041 0.076374999999999998
r12832 n8040 n8041 0.010681818181818183
r12833 n8025 n8042 0.061100000000000002
r12834 n8041 n8042 0.019227272727272728
r12835 n8026 n8043 0.30549999999999999
r12836 n8042 n8043 0.012818181818181817
r12837 n8027 n8044 0.061100000000000002
r12838 n8028 n8045 0.061100000000000002
r12839 n8044 n8045 0.11750000000000001
r12840 n8029 n8046 0.30549999999999999
r12841 n8045 n8046 0.070499999999999993
r12842 n8030 n8047 0.10183333333333335
r12843 n8046 n8047 0.047
r12844 n8031 n8048 0.30549999999999999
r12845 n8047 n8048 0.047
r12846 n8032 n8049 0.033944444444444444
r12847 n8048 n8049 0.11750000000000001
r12848 n8033 n8050 0.030550000000000001
r12849 n8049 n8050 0.22325
r12850 n8034 n8051 0.061100000000000002
r12851 n8050 n8051 0.17624999999999999
r12852 n8035 n8052 0.061100000000000002
r12853 n8051 n8052 0.11750000000000001
r12854 n8036 n8053 0.30549999999999999
r12855 n8052 n8053 0.070499999999999993
r12856 n8037 n8054 0.15275
r12857 n8053 n8054 0.035249999999999997
r12858 n8038 n8055 0.30549999999999999
r12859 n8054 n8055 0.035249999999999997
r12860 n8039 n8056 0.30549999999999999
r12861 n8055 n8056 0.0235
r12862 n8040 n8057 0.30549999999999999
r12863 n8056 n8057 0.0235
r12864 n8041 n8058 0.076374999999999998
r12865 n8057 n8058 0.058750000000000004
r12866 n8042 n8059 0.061100000000000002
r12867 n8058 n8059 0.10575000000000001
r12868 n8043 n8060 0.30549999999999999
r12869 n8059 n8060 0.070499999999999993
r12870 n8044 n8061 0.15039999999999998
r12871 n8045 n8062 0.15039999999999998
r12872 n8061 n8062 0.0078333333333333328
r12873 n8046 n8063 0.752
r12874 n8062 n8063 0.0046999999999999993
r12875 n8047 n8064 0.25066666666666665
r12876 n8063 n8064 0.003133333333333333
r12877 n8048 n8065 0.752
r12878 n8064 n8065 0.003133333333333333
r12879 n8049 n8066 0.08355555555555555
r12880 n8065 n8066 0.0078333333333333328
r12881 n8050 n8067 0.075199999999999989
r12882 n8066 n8067 0.014883333333333333
r12883 n8051 n8068 0.15039999999999998
r12884 n8067 n8068 0.01175
r12885 n8052 n8069 0.15039999999999998
r12886 n8068 n8069 0.0078333333333333328
r12887 n8053 n8070 0.752
r12888 n8069 n8070 0.0046999999999999993
r12889 n8054 n8071 0.376
r12890 n8070 n8071 0.0023499999999999997
r12891 n8055 n8072 0.752
r12892 n8071 n8072 0.0023499999999999997
r12893 n8056 n8073 0.752
r12894 n8072 n8073 0.0015666666666666665
r12895 n8057 n8074 0.752
r12896 n8073 n8074 0.0015666666666666665
r12897 n8058 n8075 0.188
r12898 n8074 n8075 0.0039166666666666664
r12899 n8059 n8076 0.15039999999999998
r12900 n8075 n8076 0.0070500000000000007
r12901 n8060 n8077 0.752
r12902 n8076 n8077 0.0046999999999999993
r12903 n8061 n8078 0.15039999999999998
r12904 n8062 n8079 0.15039999999999998
r12905 n8078 n8079 0.11750000000000001
r12906 n8063 n8080 0.752
r12907 n8079 n8080 0.070499999999999993
r12908 n8064 n8081 0.25066666666666665
r12909 n8080 n8081 0.047
r12910 n8065 n8082 0.752
r12911 n8081 n8082 0.047
r12912 n8066 n8083 0.08355555555555555
r12913 n8082 n8083 0.11750000000000001
r12914 n8067 n8084 0.075199999999999989
r12915 n8083 n8084 0.22325
r12916 n8068 n8085 0.15039999999999998
r12917 n8084 n8085 0.17624999999999999
r12918 n8069 n8086 0.15039999999999998
r12919 n8085 n8086 0.11750000000000001
r12920 n8070 n8087 0.752
r12921 n8086 n8087 0.070499999999999993
r12922 n8071 n8088 0.376
r12923 n8087 n8088 0.035249999999999997
r12924 n8072 n8089 0.752
r12925 n8088 n8089 0.035249999999999997
r12926 n8073 n8090 0.752
r12927 n8089 n8090 0.0235
r12928 n8074 n8091 0.752
r12929 n8090 n8091 0.0235
r12930 n8075 n8092 0.188
r12931 n8091 n8092 0.058750000000000004
r12932 n8076 n8093 0.15039999999999998
r12933 n8092 n8093 0.10575000000000001
r12934 n8077 n8094 0.752
r12935 n8093 n8094 0.070499999999999993
r12936 n8078 n8095 0.061100000000000002
r12937 n8079 n8096 0.061100000000000002
r12938 n8095 n8096 0.021363636363636366
r12939 n8080 n8097 0.30549999999999999
r12940 n8096 n8097 0.012818181818181817
r12941 n8081 n8098 0.10183333333333335
r12942 n8097 n8098 0.0085454545454545453
r12943 n8082 n8099 0.30549999999999999
r12944 n8098 n8099 0.0085454545454545453
r12945 n8083 n8100 0.033944444444444444
r12946 n8099 n8100 0.021363636363636366
r12947 n8084 n8101 0.030550000000000001
r12948 n8100 n8101 0.040590909090909087
r12949 n8085 n8102 0.061100000000000002
r12950 n8101 n8102 0.032045454545454544
r12951 n8086 n8103 0.061100000000000002
r12952 n8102 n8103 0.021363636363636366
r12953 n8087 n8104 0.30549999999999999
r12954 n8103 n8104 0.012818181818181817
r12955 n8088 n8105 0.15275
r12956 n8104 n8105 0.0064090909090909086
r12957 n8089 n8106 0.30549999999999999
r12958 n8105 n8106 0.0064090909090909086
r12959 n8090 n8107 0.30549999999999999
r12960 n8106 n8107 0.0042727272727272727
r12961 n8091 n8108 0.30549999999999999
r12962 n8107 n8108 0.0042727272727272727
r12963 n8092 n8109 0.076374999999999998
r12964 n8108 n8109 0.010681818181818183
r12965 n8093 n8110 0.061100000000000002
r12966 n8109 n8110 0.019227272727272728
r12967 n8094 n8111 0.30549999999999999
r12968 n8110 n8111 0.012818181818181817
r12969 n8095 n8112 0.061100000000000002
r12970 n8096 n8113 0.061100000000000002
r12971 n8112 n8113 0.11750000000000001
r12972 n8097 n8114 0.30549999999999999
r12973 n8113 n8114 0.070499999999999993
r12974 n8098 n8115 0.10183333333333335
r12975 n8114 n8115 0.047
r12976 n8099 n8116 0.30549999999999999
r12977 n8115 n8116 0.047
r12978 n8100 n8117 0.033944444444444444
r12979 n8116 n8117 0.11750000000000001
r12980 n8101 n8118 0.030550000000000001
r12981 n8117 n8118 0.22325
r12982 n8102 n8119 0.061100000000000002
r12983 n8118 n8119 0.17624999999999999
r12984 n8103 n8120 0.061100000000000002
r12985 n8119 n8120 0.11750000000000001
r12986 n8104 n8121 0.30549999999999999
r12987 n8120 n8121 0.070499999999999993
r12988 n8105 n8122 0.15275
r12989 n8121 n8122 0.035249999999999997
r12990 n8106 n8123 0.30549999999999999
r12991 n8122 n8123 0.035249999999999997
r12992 n8107 n8124 0.30549999999999999
r12993 n8123 n8124 0.0235
r12994 n8108 n8125 0.30549999999999999
r12995 n8124 n8125 0.0235
r12996 n8109 n8126 0.076374999999999998
r12997 n8125 n8126 0.058750000000000004
r12998 n8110 n8127 0.061100000000000002
r12999 n8126 n8127 0.10575000000000001
r13000 n8111 n8128 0.30549999999999999
r13001 n8127 n8128 0.070499999999999993
r13002 n8112 n8129 0.16732
r13003 n8113 n8130 0.16732
r13004 n8129 n8130 0.0069940476190476194
r13005 n8114 n8131 0.83660000000000001
r13006 n8130 n8131 0.0041964285714285714
r13007 n8115 n8132 0.27886666666666665
r13008 n8131 n8132 0.0027976190476190475
r13009 n8116 n8133 0.83660000000000001
r13010 n8132 n8133 0.0027976190476190475
r13011 n8117 n8134 0.092955555555555555
r13012 n8133 n8134 0.0069940476190476194
r13013 n8118 n8135 0.083659999999999998
r13014 n8134 n8135 0.013288690476190477
r13015 n8119 n8136 0.16732
r13016 n8135 n8136 0.010491071428571428
r13017 n8120 n8137 0.16732
r13018 n8136 n8137 0.0069940476190476194
r13019 n8121 n8138 0.83660000000000001
r13020 n8137 n8138 0.0041964285714285714
r13021 n8122 n8139 0.41830000000000001
r13022 n8138 n8139 0.0020982142857142857
r13023 n8123 n8140 0.83660000000000001
r13024 n8139 n8140 0.0020982142857142857
r13025 n8124 n8141 0.83660000000000001
r13026 n8140 n8141 0.0013988095238095237
r13027 n8125 n8142 0.83660000000000001
r13028 n8141 n8142 0.0013988095238095237
r13029 n8126 n8143 0.20915
r13030 n8142 n8143 0.0034970238095238097
r13031 n8127 n8144 0.16732
r13032 n8143 n8144 0.006294642857142858
r13033 n8128 n8145 0.83660000000000001
r13034 n8144 n8145 0.0041964285714285714
r13035 n8129 n8146 0.31489999999999996
r13036 n8130 n8147 0.31489999999999996
r13037 n8146 n8147 0.0070359281437125751
r13038 n8131 n8148 1.5745
r13039 n8147 n8148 0.0042215568862275449
r13040 n8132 n8149 0.52483333333333326
r13041 n8148 n8149 0.0028143712574850298
r13042 n8133 n8150 1.5745
r13043 n8149 n8150 0.0028143712574850298
r13044 n8134 n8151 0.17494444444444443
r13045 n8150 n8151 0.0070359281437125751
r13046 n8135 n8152 0.15744999999999998
r13047 n8151 n8152 0.013368263473053891
r13048 n8136 n8153 0.31489999999999996
r13049 n8152 n8153 0.010553892215568862
r13050 n8137 n8154 0.31489999999999996
r13051 n8153 n8154 0.0070359281437125751
r13052 n8138 n8155 1.5745
r13053 n8154 n8155 0.0042215568862275449
r13054 n8139 n8156 0.78725000000000001
r13055 n8155 n8156 0.0021107784431137725
r13056 n8140 n8157 1.5745
r13057 n8156 n8157 0.0021107784431137725
r13058 n8141 n8158 1.5745
r13059 n8157 n8158 0.0014071856287425149
r13060 n8142 n8159 1.5745
r13061 n8158 n8159 0.0014071856287425149
r13062 n8143 n8160 0.393625
r13063 n8159 n8160 0.0035179640718562876
r13064 n8144 n8161 0.31489999999999996
r13065 n8160 n8161 0.0063323353293413178
r13066 n8145 n8162 1.5745
r13067 n8161 n8162 0.0042215568862275449
r13068 n8146 n8163 0.20867999999999998
r13069 n8147 n8164 0.20867999999999998
r13070 n8163 n8164 0.021363636363636366
r13071 n8148 n8165 1.0433999999999999
r13072 n8164 n8165 0.012818181818181817
r13073 n8149 n8166 0.3478
r13074 n8165 n8166 0.0085454545454545453
r13075 n8150 n8167 1.0433999999999999
r13076 n8166 n8167 0.0085454545454545453
r13077 n8151 n8168 0.11593333333333332
r13078 n8167 n8168 0.021363636363636366
r13079 n8152 n8169 0.10433999999999999
r13080 n8168 n8169 0.040590909090909087
r13081 n8153 n8170 0.20867999999999998
r13082 n8169 n8170 0.032045454545454544
r13083 n8154 n8171 0.20867999999999998
r13084 n8170 n8171 0.021363636363636366
r13085 n8155 n8172 1.0433999999999999
r13086 n8171 n8172 0.012818181818181817
r13087 n8156 n8173 0.52169999999999994
r13088 n8172 n8173 0.0064090909090909086
r13089 n8157 n8174 1.0433999999999999
r13090 n8173 n8174 0.0064090909090909086
r13091 n8158 n8175 1.0433999999999999
r13092 n8174 n8175 0.0042727272727272727
r13093 n8159 n8176 1.0433999999999999
r13094 n8175 n8176 0.0042727272727272727
r13095 n8160 n8177 0.26084999999999997
r13096 n8176 n8177 0.010681818181818183
r13097 n8161 n8178 0.20867999999999998
r13098 n8177 n8178 0.019227272727272728
r13099 n8162 n8179 1.0433999999999999
r13100 n8178 n8179 0.012818181818181817
r13101 n8163 n8180 0.098699999999999996
r13102 n8164 n8181 0.098699999999999996
r13103 n8180 n8181 0.0235
r13104 n8165 n8182 0.49349999999999994
r13105 n8181 n8182 0.0141
r13106 n8166 n8183 0.16449999999999998
r13107 n8182 n8183 0.0093999999999999986
r13108 n8167 n8184 0.49349999999999994
r13109 n8183 n8184 0.0093999999999999986
r13110 n8168 n8185 0.054833333333333331
r13111 n8184 n8185 0.0235
r13112 n8169 n8186 0.049349999999999998
r13113 n8185 n8186 0.044649999999999995
r13114 n8170 n8187 0.098699999999999996
r13115 n8186 n8187 0.035249999999999997
r13116 n8171 n8188 0.098699999999999996
r13117 n8187 n8188 0.0235
r13118 n8172 n8189 0.49349999999999994
r13119 n8188 n8189 0.0141
r13120 n8173 n8190 0.24674999999999997
r13121 n8189 n8190 0.0070499999999999998
r13122 n8174 n8191 0.49349999999999994
r13123 n8190 n8191 0.0070499999999999998
r13124 n8175 n8192 0.49349999999999994
r13125 n8191 n8192 0.0046999999999999993
r13126 n8176 n8193 0.49349999999999994
r13127 n8192 n8193 0.0046999999999999993
r13128 n8177 n8194 0.12337499999999998
r13129 n8193 n8194 0.01175
r13130 n8178 n8195 0.098699999999999996
r13131 n8194 n8195 0.021150000000000002
r13132 n8179 n8196 0.49349999999999994
r13133 n8195 n8196 0.0141
r13134 n8196 n8197 0.025849999999999998
r13135 n8197 n8198 0.030550000000000001
r13136 n8198 n8199 0.021150000000000002
r13137 n8199 n8200 0.018799999999999997
r13138 n8200 n8201 0.0070499999999999998
r13139 n8201 n8202 0.0046999999999999993
r13140 n8202 n8203 0.016449999999999999
r13141 n8203 n8204 0.025849999999999998
r13142 n8204 n8205 0.0141
r13143 n8205 n8206 0.01175
r13144 n8206 n8207 0.021150000000000002
r13145 n8207 n8208 0.018799999999999997
r13146 n8208 n8209 0.0235
r13147 n8180 n8210 0.056399999999999999
r13148 n8181 n8211 0.056399999999999999
r13149 n8210 n8211 0.11750000000000001
r13150 n8182 n8212 0.28199999999999997
r13151 n8211 n8212 0.070499999999999993
r13152 n8183 n8213 0.094
r13153 n8212 n8213 0.047
r13154 n8184 n8214 0.28199999999999997
r13155 n8213 n8214 0.047
r13156 n8185 n8215 0.031333333333333331
r13157 n8214 n8215 0.11750000000000001
r13158 n8186 n8216 0.028199999999999999
r13159 n8215 n8216 0.22325
r13160 n8187 n8217 0.056399999999999999
r13161 n8216 n8217 0.17624999999999999
r13162 n8188 n8218 0.056399999999999999
r13163 n8217 n8218 0.11750000000000001
r13164 n8189 n8219 0.28199999999999997
r13165 n8218 n8219 0.070499999999999993
r13166 n8190 n8220 0.14099999999999999
r13167 n8219 n8220 0.035249999999999997
r13168 n8191 n8221 0.28199999999999997
r13169 n8220 n8221 0.035249999999999997
r13170 n8192 n8222 0.28199999999999997
r13171 n8221 n8222 0.0235
r13172 n8193 n8223 0.28199999999999997
r13173 n8222 n8223 0.0235
r13174 n8194 n8224 0.070499999999999993
r13175 n8223 n8224 0.058750000000000004
r13176 n8195 n8225 0.056399999999999999
r13177 n8224 n8225 0.10575000000000001
r13178 n8196 n8226 0.28199999999999997
r13179 n8225 n8226 0.070499999999999993
r13180 n8197 n8227 0.028199999999999999
r13181 n8226 n8227 0.12925
r13182 n8198 n8228 0.094
r13183 n8227 n8228 0.15275
r13184 n8199 n8229 0.047
r13185 n8228 n8229 0.10575000000000001
r13186 n8200 n8230 0.14099999999999999
r13187 n8229 n8230 0.094
r13188 n8201 n8231 0.28199999999999997
r13189 n8230 n8231 0.035249999999999997
r13190 n8202 n8232 0.28199999999999997
r13191 n8231 n8232 0.0235
r13192 n8203 n8233 0.047
r13193 n8232 n8233 0.082250000000000004
r13194 n8204 n8234 0.056399999999999999
r13195 n8233 n8234 0.12925
r13196 n8205 n8235 0.28199999999999997
r13197 n8234 n8235 0.070499999999999993
r13198 n8206 n8236 0.070499999999999993
r13199 n8235 n8236 0.058750000000000004
r13200 n8207 n8237 0.056399999999999999
r13201 n8236 n8237 0.10575000000000001
r13202 n8208 n8238 0.094
r13203 n8237 n8238 0.094
r13204 n8209 n8239 0.040285714285714286
r13205 n8238 n8239 0.11750000000000001
r13206 n8210 n8240 0.0235
r13207 n8211 n8241 0.0235
r13208 n8240 n8241 0.078333333333333338
r13209 n8212 n8242 0.11750000000000001
r13210 n8241 n8242 0.047
r13211 n8213 n8243 0.039166666666666669
r13212 n8242 n8243 0.031333333333333331
r13213 n8214 n8244 0.11750000000000001
r13214 n8243 n8244 0.031333333333333331
r13215 n8215 n8245 0.013055555555555556
r13216 n8244 n8245 0.078333333333333338
r13217 n8216 n8246 0.01175
r13218 n8245 n8246 0.14883333333333332
r13219 n8217 n8247 0.0235
r13220 n8246 n8247 0.11749999999999999
r13221 n8218 n8248 0.0235
r13222 n8247 n8248 0.078333333333333338
r13223 n8219 n8249 0.11750000000000001
r13224 n8248 n8249 0.047
r13225 n8220 n8250 0.058750000000000004
r13226 n8249 n8250 0.0235
r13227 n8221 n8251 0.11750000000000001
r13228 n8250 n8251 0.0235
r13229 n8222 n8252 0.11750000000000001
r13230 n8251 n8252 0.015666666666666666
r13231 n8223 n8253 0.11750000000000001
r13232 n8252 n8253 0.015666666666666666
r13233 n8224 n8254 0.029375000000000002
r13234 n8253 n8254 0.039166666666666669
r13235 n8225 n8255 0.0235
r13236 n8254 n8255 0.070500000000000007
r13237 n8226 n8256 0.11750000000000001
r13238 n8255 n8256 0.047
r13239 n8227 n8257 0.01175
r13240 n8256 n8257 0.086166666666666669
r13241 n8228 n8258 0.039166666666666669
r13242 n8257 n8258 0.10183333333333335
r13243 n8229 n8259 0.019583333333333335
r13244 n8258 n8259 0.070500000000000007
r13245 n8230 n8260 0.058750000000000004
r13246 n8259 n8260 0.062666666666666662
r13247 n8231 n8261 0.11750000000000001
r13248 n8260 n8261 0.0235
r13249 n8232 n8262 0.11750000000000001
r13250 n8261 n8262 0.015666666666666666
r13251 n8233 n8263 0.019583333333333335
r13252 n8262 n8263 0.054833333333333331
r13253 n8234 n8264 0.0235
r13254 n8263 n8264 0.086166666666666669
r13255 n8235 n8265 0.11750000000000001
r13256 n8264 n8265 0.047
r13257 n8236 n8266 0.029375000000000002
r13258 n8265 n8266 0.039166666666666669
r13259 n8237 n8267 0.0235
r13260 n8266 n8267 0.070500000000000007
r13261 n8238 n8268 0.039166666666666669
r13262 n8267 n8268 0.062666666666666662
r13263 n8239 n8269 0.016785714285714286
r13264 n8268 n8269 0.078333333333333338
r13265 n8240 n8270 0.037599999999999995
r13266 n8241 n8271 0.037599999999999995
r13267 n8270 n8271 0.047
r13268 n8242 n8272 0.188
r13269 n8271 n8272 0.028199999999999999
r13270 n8243 n8273 0.062666666666666662
r13271 n8272 n8273 0.018799999999999997
r13272 n8244 n8274 0.188
r13273 n8273 n8274 0.018799999999999997
r13274 n8245 n8275 0.020888888888888887
r13275 n8274 n8275 0.047
r13276 n8246 n8276 0.018799999999999997
r13277 n8275 n8276 0.08929999999999999
r13278 n8247 n8277 0.037599999999999995
r13279 n8276 n8277 0.070499999999999993
r13280 n8248 n8278 0.037599999999999995
r13281 n8277 n8278 0.047
r13282 n8249 n8279 0.188
r13283 n8278 n8279 0.028199999999999999
r13284 n8250 n8280 0.094
r13285 n8279 n8280 0.0141
r13286 n8251 n8281 0.188
r13287 n8280 n8281 0.0141
r13288 n8252 n8282 0.188
r13289 n8281 n8282 0.0093999999999999986
r13290 n8253 n8283 0.188
r13291 n8282 n8283 0.0093999999999999986
r13292 n8254 n8284 0.047
r13293 n8283 n8284 0.0235
r13294 n8255 n8285 0.037599999999999995
r13295 n8284 n8285 0.042300000000000004
r13296 n8256 n8286 0.188
r13297 n8285 n8286 0.028199999999999999
r13298 n8257 n8287 0.018799999999999997
r13299 n8286 n8287 0.051699999999999996
r13300 n8258 n8288 0.062666666666666662
r13301 n8287 n8288 0.061100000000000002
r13302 n8259 n8289 0.031333333333333331
r13303 n8288 n8289 0.042300000000000004
r13304 n8260 n8290 0.094
r13305 n8289 n8290 0.037599999999999995
r13306 n8261 n8291 0.188
r13307 n8290 n8291 0.0141
r13308 n8262 n8292 0.188
r13309 n8291 n8292 0.0093999999999999986
r13310 n8263 n8293 0.031333333333333331
r13311 n8292 n8293 0.032899999999999999
r13312 n8264 n8294 0.037599999999999995
r13313 n8293 n8294 0.051699999999999996
r13314 n8265 n8295 0.188
r13315 n8294 n8295 0.028199999999999999
r13316 n8266 n8296 0.047
r13317 n8295 n8296 0.0235
r13318 n8267 n8297 0.037599999999999995
r13319 n8296 n8297 0.042300000000000004
r13320 n8268 n8298 0.062666666666666662
r13321 n8297 n8298 0.037599999999999995
r13322 n8269 n8299 0.026857142857142857
r13323 n8298 n8299 0.047
r13324 n8270 n8300 0.037599999999999995
r13325 n8271 n8301 0.037599999999999995
r13326 n8300 n8301 0.078333333333333338
r13327 n8272 n8302 0.188
r13328 n8301 n8302 0.047
r13329 n8273 n8303 0.062666666666666662
r13330 n8302 n8303 0.031333333333333331
r13331 n8274 n8304 0.188
r13332 n8303 n8304 0.031333333333333331
r13333 n8275 n8305 0.020888888888888887
r13334 n8304 n8305 0.078333333333333338
r13335 n8276 n8306 0.018799999999999997
r13336 n8305 n8306 0.14883333333333332
r13337 n8277 n8307 0.037599999999999995
r13338 n8306 n8307 0.11749999999999999
r13339 n8278 n8308 0.037599999999999995
r13340 n8307 n8308 0.078333333333333338
r13341 n8279 n8309 0.188
r13342 n8308 n8309 0.047
r13343 n8280 n8310 0.094
r13344 n8309 n8310 0.0235
r13345 n8281 n8311 0.188
r13346 n8310 n8311 0.0235
r13347 n8282 n8312 0.188
r13348 n8311 n8312 0.015666666666666666
r13349 n8283 n8313 0.188
r13350 n8312 n8313 0.015666666666666666
r13351 n8284 n8314 0.047
r13352 n8313 n8314 0.039166666666666669
r13353 n8285 n8315 0.037599999999999995
r13354 n8314 n8315 0.070500000000000007
r13355 n8286 n8316 0.188
r13356 n8315 n8316 0.047
r13357 n8287 n8317 0.018799999999999997
r13358 n8316 n8317 0.086166666666666669
r13359 n8288 n8318 0.062666666666666662
r13360 n8317 n8318 0.10183333333333335
r13361 n8289 n8319 0.031333333333333331
r13362 n8318 n8319 0.070500000000000007
r13363 n8290 n8320 0.094
r13364 n8319 n8320 0.062666666666666662
r13365 n8291 n8321 0.188
r13366 n8320 n8321 0.0235
r13367 n8292 n8322 0.188
r13368 n8321 n8322 0.015666666666666666
r13369 n8293 n8323 0.031333333333333331
r13370 n8322 n8323 0.054833333333333331
r13371 n8294 n8324 0.037599999999999995
r13372 n8323 n8324 0.086166666666666669
r13373 n8295 n8325 0.188
r13374 n8324 n8325 0.047
r13375 n8296 n8326 0.047
r13376 n8325 n8326 0.039166666666666669
r13377 n8297 n8327 0.037599999999999995
r13378 n8326 n8327 0.070500000000000007
r13379 n8298 n8328 0.062666666666666662
r13380 n8327 n8328 0.062666666666666662
r13381 n8299 n8329 0.026857142857142857
r13382 n8328 n8329 0.078333333333333338
r13383 n8300 n8330 0.0235
r13384 n8301 n8331 0.0235
r13385 n8330 n8331 0.11750000000000001
r13386 n8302 n8332 0.11750000000000001
r13387 n8331 n8332 0.070499999999999993
r13388 n8303 n8333 0.039166666666666669
r13389 n8332 n8333 0.047
r13390 n8304 n8334 0.11750000000000001
r13391 n8333 n8334 0.047
r13392 n8305 n8335 0.013055555555555556
r13393 n8334 n8335 0.11750000000000001
r13394 n8306 n8336 0.01175
r13395 n8335 n8336 0.22325
r13396 n8307 n8337 0.0235
r13397 n8336 n8337 0.17624999999999999
r13398 n8308 n8338 0.0235
r13399 n8337 n8338 0.11750000000000001
r13400 n8309 n8339 0.11750000000000001
r13401 n8338 n8339 0.070499999999999993
r13402 n8310 n8340 0.058750000000000004
r13403 n8339 n8340 0.035249999999999997
r13404 n8311 n8341 0.11750000000000001
r13405 n8340 n8341 0.035249999999999997
r13406 n8312 n8342 0.11750000000000001
r13407 n8341 n8342 0.0235
r13408 n8313 n8343 0.11750000000000001
r13409 n8342 n8343 0.0235
r13410 n8314 n8344 0.029375000000000002
r13411 n8343 n8344 0.058750000000000004
r13412 n8315 n8345 0.0235
r13413 n8344 n8345 0.10575000000000001
r13414 n8316 n8346 0.11750000000000001
r13415 n8345 n8346 0.070499999999999993
r13416 n8317 n8347 0.01175
r13417 n8346 n8347 0.12925
r13418 n8318 n8348 0.039166666666666669
r13419 n8347 n8348 0.15275
r13420 n8319 n8349 0.019583333333333335
r13421 n8348 n8349 0.10575000000000001
r13422 n8320 n8350 0.058750000000000004
r13423 n8349 n8350 0.094
r13424 n8321 n8351 0.11750000000000001
r13425 n8350 n8351 0.035249999999999997
r13426 n8322 n8352 0.11750000000000001
r13427 n8351 n8352 0.0235
r13428 n8323 n8353 0.019583333333333335
r13429 n8352 n8353 0.082250000000000004
r13430 n8324 n8354 0.0235
r13431 n8353 n8354 0.12925
r13432 n8325 n8355 0.11750000000000001
r13433 n8354 n8355 0.070499999999999993
r13434 n8326 n8356 0.029375000000000002
r13435 n8355 n8356 0.058750000000000004
r13436 n8327 n8357 0.0235
r13437 n8356 n8357 0.10575000000000001
r13438 n8328 n8358 0.039166666666666669
r13439 n8357 n8358 0.094
r13440 n8329 n8359 0.016785714285714286
r13441 n8358 n8359 0.11750000000000001
r13442 n8330 n8360 0.15039999999999998
r13443 n8331 n8361 0.15039999999999998
r13444 n8360 n8361 0.0078333333333333328
r13445 n8332 n8362 0.752
r13446 n8361 n8362 0.0046999999999999993
r13447 n8333 n8363 0.25066666666666665
r13448 n8362 n8363 0.003133333333333333
r13449 n8334 n8364 0.752
r13450 n8363 n8364 0.003133333333333333
r13451 n8335 n8365 0.08355555555555555
r13452 n8364 n8365 0.0078333333333333328
r13453 n8336 n8366 0.075199999999999989
r13454 n8365 n8366 0.014883333333333333
r13455 n8337 n8367 0.15039999999999998
r13456 n8366 n8367 0.01175
r13457 n8338 n8368 0.15039999999999998
r13458 n8367 n8368 0.0078333333333333328
r13459 n8339 n8369 0.752
r13460 n8368 n8369 0.0046999999999999993
r13461 n8340 n8370 0.376
r13462 n8369 n8370 0.0023499999999999997
r13463 n8341 n8371 0.752
r13464 n8370 n8371 0.0023499999999999997
r13465 n8342 n8372 0.752
r13466 n8371 n8372 0.0015666666666666665
r13467 n8343 n8373 0.752
r13468 n8372 n8373 0.0015666666666666665
r13469 n8344 n8374 0.188
r13470 n8373 n8374 0.0039166666666666664
r13471 n8345 n8375 0.15039999999999998
r13472 n8374 n8375 0.0070500000000000007
r13473 n8346 n8376 0.752
r13474 n8375 n8376 0.0046999999999999993
r13475 n8347 n8377 0.075199999999999989
r13476 n8376 n8377 0.0086166666666666666
r13477 n8348 n8378 0.25066666666666665
r13478 n8377 n8378 0.010183333333333334
r13479 n8349 n8379 0.12533333333333332
r13480 n8378 n8379 0.0070500000000000007
r13481 n8350 n8380 0.376
r13482 n8379 n8380 0.006266666666666666
r13483 n8351 n8381 0.752
r13484 n8380 n8381 0.0023499999999999997
r13485 n8352 n8382 0.752
r13486 n8381 n8382 0.0015666666666666665
r13487 n8353 n8383 0.12533333333333332
r13488 n8382 n8383 0.0054833333333333331
r13489 n8354 n8384 0.15039999999999998
r13490 n8383 n8384 0.0086166666666666666
r13491 n8355 n8385 0.752
r13492 n8384 n8385 0.0046999999999999993
r13493 n8356 n8386 0.188
r13494 n8385 n8386 0.0039166666666666664
r13495 n8357 n8387 0.15039999999999998
r13496 n8386 n8387 0.0070500000000000007
r13497 n8358 n8388 0.25066666666666665
r13498 n8387 n8388 0.006266666666666666
r13499 n8359 n8389 0.10742857142857143
r13500 n8388 n8389 0.0078333333333333328
r13501 n8360 n8390 0.15039999999999998
r13502 n8361 n8391 0.15039999999999998
r13503 n8390 n8391 0.11750000000000001
r13504 n8362 n8392 0.752
r13505 n8391 n8392 0.070499999999999993
r13506 n8363 n8393 0.25066666666666665
r13507 n8392 n8393 0.047
r13508 n8364 n8394 0.752
r13509 n8393 n8394 0.047
r13510 n8365 n8395 0.08355555555555555
r13511 n8394 n8395 0.11750000000000001
r13512 n8366 n8396 0.075199999999999989
r13513 n8395 n8396 0.22325
r13514 n8367 n8397 0.15039999999999998
r13515 n8396 n8397 0.17624999999999999
r13516 n8368 n8398 0.15039999999999998
r13517 n8397 n8398 0.11750000000000001
r13518 n8369 n8399 0.752
r13519 n8398 n8399 0.070499999999999993
r13520 n8370 n8400 0.376
r13521 n8399 n8400 0.035249999999999997
r13522 n8371 n8401 0.752
r13523 n8400 n8401 0.035249999999999997
r13524 n8372 n8402 0.752
r13525 n8401 n8402 0.0235
r13526 n8373 n8403 0.752
r13527 n8402 n8403 0.0235
r13528 n8374 n8404 0.188
r13529 n8403 n8404 0.058750000000000004
r13530 n8375 n8405 0.15039999999999998
r13531 n8404 n8405 0.10575000000000001
r13532 n8376 n8406 0.752
r13533 n8405 n8406 0.070499999999999993
r13534 n8377 n8407 0.075199999999999989
r13535 n8406 n8407 0.12925
r13536 n8378 n8408 0.25066666666666665
r13537 n8407 n8408 0.15275
r13538 n8379 n8409 0.12533333333333332
r13539 n8408 n8409 0.10575000000000001
r13540 n8380 n8410 0.376
r13541 n8409 n8410 0.094
r13542 n8381 n8411 0.752
r13543 n8410 n8411 0.035249999999999997
r13544 n8382 n8412 0.752
r13545 n8411 n8412 0.0235
r13546 n8383 n8413 0.12533333333333332
r13547 n8412 n8413 0.082250000000000004
r13548 n8384 n8414 0.15039999999999998
r13549 n8413 n8414 0.12925
r13550 n8385 n8415 0.752
r13551 n8414 n8415 0.070499999999999993
r13552 n8386 n8416 0.188
r13553 n8415 n8416 0.058750000000000004
r13554 n8387 n8417 0.15039999999999998
r13555 n8416 n8417 0.10575000000000001
r13556 n8388 n8418 0.25066666666666665
r13557 n8417 n8418 0.094
r13558 n8389 n8419 0.10742857142857143
r13559 n8418 n8419 0.11750000000000001
r13560 n8390 n8420 0.0235
r13561 n8391 n8421 0.0235
r13562 n8420 n8421 0.078333333333333338
r13563 n8392 n8422 0.11750000000000001
r13564 n8421 n8422 0.047
r13565 n8393 n8423 0.039166666666666669
r13566 n8422 n8423 0.031333333333333331
r13567 n8394 n8424 0.11750000000000001
r13568 n8423 n8424 0.031333333333333331
r13569 n8395 n8425 0.013055555555555556
r13570 n8424 n8425 0.078333333333333338
r13571 n8396 n8426 0.01175
r13572 n8425 n8426 0.14883333333333332
r13573 n8397 n8427 0.0235
r13574 n8426 n8427 0.11749999999999999
r13575 n8398 n8428 0.0235
r13576 n8427 n8428 0.078333333333333338
r13577 n8399 n8429 0.11750000000000001
r13578 n8428 n8429 0.047
r13579 n8400 n8430 0.058750000000000004
r13580 n8429 n8430 0.0235
r13581 n8401 n8431 0.11750000000000001
r13582 n8430 n8431 0.0235
r13583 n8402 n8432 0.11750000000000001
r13584 n8431 n8432 0.015666666666666666
r13585 n8403 n8433 0.11750000000000001
r13586 n8432 n8433 0.015666666666666666
r13587 n8404 n8434 0.029375000000000002
r13588 n8433 n8434 0.039166666666666669
r13589 n8405 n8435 0.0235
r13590 n8434 n8435 0.070500000000000007
r13591 n8406 n8436 0.11750000000000001
r13592 n8435 n8436 0.047
r13593 n8407 n8437 0.01175
r13594 n8436 n8437 0.086166666666666669
r13595 n8408 n8438 0.039166666666666669
r13596 n8437 n8438 0.10183333333333335
r13597 n8409 n8439 0.019583333333333335
r13598 n8438 n8439 0.070500000000000007
r13599 n8410 n8440 0.058750000000000004
r13600 n8439 n8440 0.062666666666666662
r13601 n8411 n8441 0.11750000000000001
r13602 n8440 n8441 0.0235
r13603 n8412 n8442 0.11750000000000001
r13604 n8441 n8442 0.015666666666666666
r13605 n8413 n8443 0.019583333333333335
r13606 n8442 n8443 0.054833333333333331
r13607 n8414 n8444 0.0235
r13608 n8443 n8444 0.086166666666666669
r13609 n8415 n8445 0.11750000000000001
r13610 n8444 n8445 0.047
r13611 n8416 n8446 0.029375000000000002
r13612 n8445 n8446 0.039166666666666669
r13613 n8417 n8447 0.0235
r13614 n8446 n8447 0.070500000000000007
r13615 n8418 n8448 0.039166666666666669
r13616 n8447 n8448 0.062666666666666662
r13617 n8419 n8449 0.016785714285714286
r13618 n8448 n8449 0.078333333333333338
r13619 n8420 n8450 0.037599999999999995
r13620 n8421 n8451 0.037599999999999995
r13621 n8450 n8451 0.047
r13622 n8422 n8452 0.188
r13623 n8451 n8452 0.028199999999999999
r13624 n8423 n8453 0.062666666666666662
r13625 n8452 n8453 0.018799999999999997
r13626 n8424 n8454 0.188
r13627 n8453 n8454 0.018799999999999997
r13628 n8425 n8455 0.020888888888888887
r13629 n8454 n8455 0.047
r13630 n8426 n8456 0.018799999999999997
r13631 n8455 n8456 0.08929999999999999
r13632 n8427 n8457 0.037599999999999995
r13633 n8456 n8457 0.070499999999999993
r13634 n8428 n8458 0.037599999999999995
r13635 n8457 n8458 0.047
r13636 n8429 n8459 0.188
r13637 n8458 n8459 0.028199999999999999
r13638 n8430 n8460 0.094
r13639 n8459 n8460 0.0141
r13640 n8431 n8461 0.188
r13641 n8460 n8461 0.0141
r13642 n8432 n8462 0.188
r13643 n8461 n8462 0.0093999999999999986
r13644 n8433 n8463 0.188
r13645 n8462 n8463 0.0093999999999999986
r13646 n8434 n8464 0.047
r13647 n8463 n8464 0.0235
r13648 n8435 n8465 0.037599999999999995
r13649 n8464 n8465 0.042300000000000004
r13650 n8436 n8466 0.188
r13651 n8465 n8466 0.028199999999999999
r13652 n8437 n8467 0.018799999999999997
r13653 n8466 n8467 0.051699999999999996
r13654 n8438 n8468 0.062666666666666662
r13655 n8467 n8468 0.061100000000000002
r13656 n8439 n8469 0.031333333333333331
r13657 n8468 n8469 0.042300000000000004
r13658 n8440 n8470 0.094
r13659 n8469 n8470 0.037599999999999995
r13660 n8441 n8471 0.188
r13661 n8470 n8471 0.0141
r13662 n8442 n8472 0.188
r13663 n8471 n8472 0.0093999999999999986
r13664 n8443 n8473 0.031333333333333331
r13665 n8472 n8473 0.032899999999999999
r13666 n8444 n8474 0.037599999999999995
r13667 n8473 n8474 0.051699999999999996
r13668 n8445 n8475 0.188
r13669 n8474 n8475 0.028199999999999999
r13670 n8446 n8476 0.047
r13671 n8475 n8476 0.0235
r13672 n8447 n8477 0.037599999999999995
r13673 n8476 n8477 0.042300000000000004
r13674 n8448 n8478 0.062666666666666662
r13675 n8477 n8478 0.037599999999999995
r13676 n8449 n8479 0.026857142857142857
r13677 n8478 n8479 0.047
r13678 n8450 n8480 0.037599999999999995
r13679 n8451 n8481 0.037599999999999995
r13680 n8480 n8481 0.078333333333333338
r13681 n8452 n8482 0.188
r13682 n8481 n8482 0.047
r13683 n8453 n8483 0.062666666666666662
r13684 n8482 n8483 0.031333333333333331
r13685 n8454 n8484 0.188
r13686 n8483 n8484 0.031333333333333331
r13687 n8455 n8485 0.020888888888888887
r13688 n8484 n8485 0.078333333333333338
r13689 n8456 n8486 0.018799999999999997
r13690 n8485 n8486 0.14883333333333332
r13691 n8457 n8487 0.037599999999999995
r13692 n8486 n8487 0.11749999999999999
r13693 n8458 n8488 0.037599999999999995
r13694 n8487 n8488 0.078333333333333338
r13695 n8459 n8489 0.188
r13696 n8488 n8489 0.047
r13697 n8460 n8490 0.094
r13698 n8489 n8490 0.0235
r13699 n8461 n8491 0.188
r13700 n8490 n8491 0.0235
r13701 n8462 n8492 0.188
r13702 n8491 n8492 0.015666666666666666
r13703 n8463 n8493 0.188
r13704 n8492 n8493 0.015666666666666666
r13705 n8464 n8494 0.047
r13706 n8493 n8494 0.039166666666666669
r13707 n8465 n8495 0.037599999999999995
r13708 n8494 n8495 0.070500000000000007
r13709 n8466 n8496 0.188
r13710 n8495 n8496 0.047
r13711 n8467 n8497 0.018799999999999997
r13712 n8496 n8497 0.086166666666666669
r13713 n8468 n8498 0.062666666666666662
r13714 n8497 n8498 0.10183333333333335
r13715 n8469 n8499 0.031333333333333331
r13716 n8498 n8499 0.070500000000000007
r13717 n8470 n8500 0.094
r13718 n8499 n8500 0.062666666666666662
r13719 n8471 n8501 0.188
r13720 n8500 n8501 0.0235
r13721 n8472 n8502 0.188
r13722 n8501 n8502 0.015666666666666666
r13723 n8473 n8503 0.031333333333333331
r13724 n8502 n8503 0.054833333333333331
r13725 n8474 n8504 0.037599999999999995
r13726 n8503 n8504 0.086166666666666669
r13727 n8475 n8505 0.188
r13728 n8504 n8505 0.047
r13729 n8476 n8506 0.047
r13730 n8505 n8506 0.039166666666666669
r13731 n8477 n8507 0.037599999999999995
r13732 n8506 n8507 0.070500000000000007
r13733 n8478 n8508 0.062666666666666662
r13734 n8507 n8508 0.062666666666666662
r13735 n8479 n8509 0.026857142857142857
r13736 n8508 n8509 0.078333333333333338
r13737 n8480 n8510 0.0235
r13738 n8481 n8511 0.0235
r13739 n8510 n8511 0.11750000000000001
r13740 n8482 n8512 0.11750000000000001
r13741 n8511 n8512 0.070499999999999993
r13742 n8483 n8513 0.039166666666666669
r13743 n8512 n8513 0.047
r13744 n8484 n8514 0.11750000000000001
r13745 n8513 n8514 0.047
r13746 n8485 n8515 0.013055555555555556
r13747 n8514 n8515 0.11750000000000001
r13748 n8486 n8516 0.01175
r13749 n8515 n8516 0.22325
r13750 n8487 n8517 0.0235
r13751 n8516 n8517 0.17624999999999999
r13752 n8488 n8518 0.0235
r13753 n8517 n8518 0.11750000000000001
r13754 n8489 n8519 0.11750000000000001
r13755 n8518 n8519 0.070499999999999993
r13756 n8490 n8520 0.058750000000000004
r13757 n8519 n8520 0.035249999999999997
r13758 n8491 n8521 0.11750000000000001
r13759 n8520 n8521 0.035249999999999997
r13760 n8492 n8522 0.11750000000000001
r13761 n8521 n8522 0.0235
r13762 n8493 n8523 0.11750000000000001
r13763 n8522 n8523 0.0235
r13764 n8494 n8524 0.029375000000000002
r13765 n8523 n8524 0.058750000000000004
r13766 n8495 n8525 0.0235
r13767 n8524 n8525 0.10575000000000001
r13768 n8496 n8526 0.11750000000000001
r13769 n8525 n8526 0.070499999999999993
r13770 n8497 n8527 0.01175
r13771 n8526 n8527 0.12925
r13772 n8498 n8528 0.039166666666666669
r13773 n8527 n8528 0.15275
r13774 n8499 n8529 0.019583333333333335
r13775 n8528 n8529 0.10575000000000001
r13776 n8500 n8530 0.058750000000000004
r13777 n8529 n8530 0.094
r13778 n8501 n8531 0.11750000000000001
r13779 n8530 n8531 0.035249999999999997
r13780 n8502 n8532 0.11750000000000001
r13781 n8531 n8532 0.0235
r13782 n8503 n8533 0.019583333333333335
r13783 n8532 n8533 0.082250000000000004
r13784 n8504 n8534 0.0235
r13785 n8533 n8534 0.12925
r13786 n8505 n8535 0.11750000000000001
r13787 n8534 n8535 0.070499999999999993
r13788 n8506 n8536 0.029375000000000002
r13789 n8535 n8536 0.058750000000000004
r13790 n8507 n8537 0.0235
r13791 n8536 n8537 0.10575000000000001
r13792 n8508 n8538 0.039166666666666669
r13793 n8537 n8538 0.094
r13794 n8509 n8539 0.016785714285714286
r13795 n8538 n8539 0.11750000000000001
r13796 n8517 n8540 0.056399999999999999
r13797 n8518 n8541 0.056399999999999999
r13798 n8540 n8541 0.0235
r13799 n8519 n8542 0.28199999999999997
r13800 n8541 n8542 0.0141
r13801 n8520 n8543 0.14099999999999999
r13802 n8542 n8543 0.0070499999999999998
r13803 n8521 n8544 0.28199999999999997
r13804 n8543 n8544 0.0070499999999999998
r13805 n8522 n8545 0.28199999999999997
r13806 n8544 n8545 0.0046999999999999993
r13807 n8523 n8546 0.28199999999999997
r13808 n8545 n8546 0.0046999999999999993
r13809 n8524 n8547 0.070499999999999993
r13810 n8546 n8547 0.01175
r13811 n8525 n8548 0.056399999999999999
r13812 n8547 n8548 0.021150000000000002
r13813 n8526 n8549 0.28199999999999997
r13814 n8548 n8549 0.0141
r13815 n8527 n8550 0.028199999999999999
r13816 n8549 n8550 0.025849999999999998
r13817 n8528 n8551 0.094
r13818 n8550 n8551 0.030550000000000001
r13819 n8529 n8552 0.047
r13820 n8551 n8552 0.021150000000000002
r13821 n8530 n8553 0.14099999999999999
r13822 n8552 n8553 0.018799999999999997
r13823 n8531 n8554 0.28199999999999997
r13824 n8553 n8554 0.0070499999999999998
r13825 n8532 n8555 0.28199999999999997
r13826 n8554 n8555 0.0046999999999999993
r13827 n8533 n8556 0.047
r13828 n8555 n8556 0.016449999999999999
r13829 n8534 n8557 0.056399999999999999
r13830 n8556 n8557 0.025849999999999998
r13831 n8535 n8558 0.28199999999999997
r13832 n8557 n8558 0.0141
r13833 n8536 n8559 0.070499999999999993
r13834 n8558 n8559 0.01175
r13835 n8537 n8560 0.056399999999999999
r13836 n8559 n8560 0.021150000000000002
r13837 n8538 n8561 0.094
r13838 n8560 n8561 0.018799999999999997
r13839 n8539 n8562 0.040285714285714286
r13840 n8561 n8562 0.0235
r13841 n8542 n8563 0.49349999999999994
r13842 n8543 n8564 0.24674999999999997
r13843 n8563 n8564 0.0064090909090909086
r13844 n8544 n8565 0.49349999999999994
r13845 n8564 n8565 0.0064090909090909086
r13846 n8545 n8566 0.49349999999999994
r13847 n8565 n8566 0.0042727272727272727
r13848 n8546 n8567 0.49349999999999994
r13849 n8566 n8567 0.0042727272727272727
r13850 n8547 n8568 0.12337499999999998
r13851 n8567 n8568 0.010681818181818183
r13852 n8548 n8569 0.098699999999999996
r13853 n8568 n8569 0.019227272727272728
r13854 n8549 n8570 0.49349999999999994
r13855 n8569 n8570 0.012818181818181817
r13856 n8550 n8571 0.049349999999999998
r13857 n8570 n8571 0.0235
r13858 n8551 n8572 0.16449999999999998
r13859 n8571 n8572 0.027772727272727275
r13860 n8552 n8573 0.08224999999999999
r13861 n8572 n8573 0.019227272727272728
r13862 n8553 n8574 0.24674999999999997
r13863 n8573 n8574 0.017090909090909091
r13864 n8554 n8575 0.49349999999999994
r13865 n8574 n8575 0.0064090909090909086
r13866 n8555 n8576 0.49349999999999994
r13867 n8575 n8576 0.0042727272727272727
r13868 n8556 n8577 0.08224999999999999
r13869 n8576 n8577 0.014954545454545455
r13870 n8557 n8578 0.098699999999999996
r13871 n8577 n8578 0.0235
r13872 n8558 n8579 0.49349999999999994
r13873 n8578 n8579 0.012818181818181817
r13874 n8559 n8580 0.12337499999999998
r13875 n8579 n8580 0.010681818181818183
r13876 n8560 n8581 0.098699999999999996
r13877 n8580 n8581 0.019227272727272728
r13878 n8563 n8582 1.1984999999999999
r13879 n8564 n8583 0.59924999999999995
r13880 n8582 n8583 0.0017625
r13881 n8565 n8584 1.1984999999999999
r13882 n8583 n8584 0.0017625
r13883 n8566 n8585 1.1984999999999999
r13884 n8584 n8585 0.0011749999999999998
r13885 n8567 n8586 1.1984999999999999
r13886 n8585 n8586 0.0011749999999999998
r13887 n8568 n8587 0.29962499999999997
r13888 n8586 n8587 0.0029375
r13889 n8569 n8588 0.2397
r13890 n8587 n8588 0.0052875000000000005
r13891 n8570 n8589 1.1984999999999999
r13892 n8588 n8589 0.0035249999999999999
r13893 n8571 n8590 0.11985
r13894 n8589 n8590 0.0064624999999999995
r13895 n8572 n8591 0.39949999999999997
r13896 n8590 n8591 0.0076375000000000002
r13897 n8573 n8592 0.19974999999999998
r13898 n8591 n8592 0.0052875000000000005
r13899 n8574 n8593 0.59924999999999995
r13900 n8592 n8593 0.0046999999999999993
r13901 n8575 n8594 1.1984999999999999
r13902 n8593 n8594 0.0017625
r13903 n8576 n8595 1.1984999999999999
r13904 n8594 n8595 0.0011749999999999998
r13905 n8577 n8596 0.19974999999999998
r13906 n8595 n8596 0.0041124999999999998
r13907 n8578 n8597 0.2397
r13908 n8596 n8597 0.0064624999999999995
r13909 n8579 n8598 1.1984999999999999
r13910 n8597 n8598 0.0035249999999999999
r13911 n8580 n8599 0.29962499999999997
r13912 n8598 n8599 0.0029375
r13913 n8581 n8600 0.2397
r13914 n8599 n8600 0.0052875000000000005
r13915 n8582 n8601 1.8800000000000001
r13916 n8583 n8602 0.94000000000000006
r13917 n8601 n8602 0.0017625
r13918 n8584 n8603 1.8800000000000001
r13919 n8602 n8603 0.0017625
r13920 n8585 n8604 1.8800000000000001
r13921 n8603 n8604 0.0011749999999999998
r13922 n8586 n8605 1.8800000000000001
r13923 n8604 n8605 0.0011749999999999998
r13924 n8587 n8606 0.47000000000000003
r13925 n8605 n8606 0.0029375
r13926 n8588 n8607 0.376
r13927 n8606 n8607 0.0052875000000000005
r13928 n8589 n8608 1.8800000000000001
r13929 n8607 n8608 0.0035249999999999999
r13930 n8590 n8609 0.188
r13931 n8608 n8609 0.0064624999999999995
r13932 n8591 n8610 0.62666666666666671
r13933 n8609 n8610 0.0076375000000000002
r13934 n8592 n8611 0.31333333333333335
r13935 n8610 n8611 0.0052875000000000005
r13936 n8593 n8612 0.94000000000000006
r13937 n8611 n8612 0.0046999999999999993
r13938 n8594 n8613 1.8800000000000001
r13939 n8612 n8613 0.0017625
r13940 n8595 n8614 1.8800000000000001
r13941 n8613 n8614 0.0011749999999999998
r13942 n8596 n8615 0.31333333333333335
r13943 n8614 n8615 0.0041124999999999998
r13944 n8597 n8616 0.376
r13945 n8615 n8616 0.0064624999999999995
r13946 n8598 n8617 1.8800000000000001
r13947 n8616 n8617 0.0035249999999999999
r13948 n8599 n8618 0.47000000000000003
r13949 n8617 n8618 0.0029375
r13950 n8600 n8619 0.376
r13951 n8618 n8619 0.0052875000000000005
r13952 n8601 n8620 1.7390000000000001
r13953 n8602 n8621 0.86950000000000005
r13954 n8620 n8621 0.0020735294117647058
r13955 n8603 n8622 1.7390000000000001
r13956 n8621 n8622 0.0020735294117647058
r13957 n8604 n8623 1.7390000000000001
r13958 n8622 n8623 0.0013823529411764704
r13959 n8605 n8624 1.7390000000000001
r13960 n8623 n8624 0.0013823529411764704
r13961 n8606 n8625 0.43475000000000003
r13962 n8624 n8625 0.0034558823529411767
r13963 n8607 n8626 0.3478
r13964 n8625 n8626 0.0062205882352941184
r13965 n8608 n8627 1.7390000000000001
r13966 n8626 n8627 0.0041470588235294117
r13967 n8609 n8628 0.1739
r13968 n8627 n8628 0.0076029411764705884
r13969 n8610 n8629 0.57966666666666666
r13970 n8628 n8629 0.0089852941176470601
r13971 n8611 n8630 0.28983333333333333
r13972 n8629 n8630 0.0062205882352941184
r13973 n8612 n8631 0.86950000000000005
r13974 n8630 n8631 0.0055294117647058817
r13975 n8613 n8632 1.7390000000000001
r13976 n8631 n8632 0.0020735294117647058
r13977 n8614 n8633 1.7390000000000001
r13978 n8632 n8633 0.0013823529411764704
r13979 n8615 n8634 0.28983333333333333
r13980 n8633 n8634 0.0048382352941176475
r13981 n8616 n8635 0.3478
r13982 n8634 n8635 0.0076029411764705884
r13983 n8617 n8636 1.7390000000000001
r13984 n8635 n8636 0.0041470588235294117
r13985 n8618 n8637 0.43475000000000003
r13986 n8636 n8637 0.0034558823529411767
r13987 n8619 n8638 0.3478
r13988 n8637 n8638 0.0062205882352941184
r13989 n8620 n8639 1.8283
r13990 n8621 n8640 0.91415000000000002
r13991 n8639 n8640 0.0016095890410958904
r13992 n8622 n8641 1.8283
r13993 n8640 n8641 0.0016095890410958904
r13994 n8623 n8642 1.8283
r13995 n8641 n8642 0.0010730593607305935
r13996 n8624 n8643 1.8283
r13997 n8642 n8643 0.0010730593607305935
r13998 n8625 n8644 0.45707500000000001
r13999 n8643 n8644 0.0026826484018264841
r14000 n8626 n8645 0.36566000000000004
r14001 n8644 n8645 0.004828767123287672
r14002 n8627 n8646 1.8283
r14003 n8645 n8646 0.0032191780821917808
r14004 n8628 n8647 0.18283000000000002
r14005 n8646 n8647 0.0059018264840182645
r14006 n8629 n8648 0.60943333333333338
r14007 n8647 n8648 0.0069748858447488587
r14008 n8630 n8649 0.30471666666666669
r14009 n8648 n8649 0.004828767123287672
r14010 n8631 n8650 0.91415000000000002
r14011 n8649 n8650 0.0042922374429223741
r14012 n8632 n8651 1.8283
r14013 n8650 n8651 0.0016095890410958904
r14014 n8633 n8652 1.8283
r14015 n8651 n8652 0.0010730593607305935
r14016 n8634 n8653 0.30471666666666669
r14017 n8652 n8653 0.0037557077625570779
r14018 n8635 n8654 0.36566000000000004
r14019 n8653 n8654 0.0059018264840182645
r14020 n8636 n8655 1.8283
r14021 n8654 n8655 0.0032191780821917808
r14022 n8637 n8656 0.45707500000000001
r14023 n8655 n8656 0.0026826484018264841
r14024 n8638 n8657 0.36566000000000004
r14025 n8656 n8657 0.004828767123287672
r14026 n8639 n8658 2.0539000000000001
r14027 n8640 n8659 1.02695
r14028 n8658 n8659 0.0016169724770642201
r14029 n8641 n8660 2.0539000000000001
r14030 n8659 n8660 0.0016169724770642201
r14031 n8642 n8661 2.0539000000000001
r14032 n8660 n8661 0.0010779816513761468
r14033 n8643 n8662 2.0539000000000001
r14034 n8661 n8662 0.0010779816513761468
r14035 n8644 n8663 0.51347500000000001
r14036 n8662 n8663 0.0026949541284403671
r14037 n8645 n8664 0.41078000000000003
r14038 n8663 n8664 0.0048509174311926612
r14039 n8646 n8665 2.0539000000000001
r14040 n8664 n8665 0.0032339449541284402
r14041 n8647 n8666 0.20539000000000002
r14042 n8665 n8666 0.0059288990825688073
r14043 n8648 n8667 0.68463333333333343
r14044 n8666 n8667 0.0070068807339449543
r14045 n8649 n8668 0.34231666666666671
r14046 n8667 n8668 0.0048509174311926612
r14047 n8650 n8669 1.02695
r14048 n8668 n8669 0.0043119266055045872
r14049 n8651 n8670 2.0539000000000001
r14050 n8669 n8670 0.0016169724770642201
r14051 n8652 n8671 2.0539000000000001
r14052 n8670 n8671 0.0010779816513761468
r14053 n8653 n8672 0.34231666666666671
r14054 n8671 n8672 0.0037729357798165137
r14055 n8654 n8673 0.41078000000000003
r14056 n8672 n8673 0.0059288990825688073
r14057 n8655 n8674 2.0539000000000001
r14058 n8673 n8674 0.0032339449541284402
r14059 n8656 n8675 0.51347500000000001
r14060 n8674 n8675 0.0026949541284403671
r14061 n8657 n8676 0.41078000000000003
r14062 n8675 n8676 0.0048509174311926612
r14063 n8658 n8677 2.0539000000000001
r14064 n8659 n8678 1.02695
r14065 n8677 n8678 0.0016095890410958904
r14066 n8660 n8679 2.0539000000000001
r14067 n8678 n8679 0.0016095890410958904
r14068 n8661 n8680 2.0539000000000001
r14069 n8679 n8680 0.0010730593607305935
r14070 n8662 n8681 2.0539000000000001
r14071 n8680 n8681 0.0010730593607305935
r14072 n8663 n8682 0.51347500000000001
r14073 n8681 n8682 0.0026826484018264841
r14074 n8664 n8683 0.41078000000000003
r14075 n8682 n8683 0.004828767123287672
r14076 n8665 n8684 2.0539000000000001
r14077 n8683 n8684 0.0032191780821917808
r14078 n8666 n8685 0.20539000000000002
r14079 n8684 n8685 0.0059018264840182645
r14080 n8667 n8686 0.68463333333333343
r14081 n8685 n8686 0.0069748858447488587
r14082 n8668 n8687 0.34231666666666671
r14083 n8686 n8687 0.004828767123287672
r14084 n8669 n8688 1.02695
r14085 n8687 n8688 0.0042922374429223741
r14086 n8670 n8689 2.0539000000000001
r14087 n8688 n8689 0.0016095890410958904
r14088 n8671 n8690 2.0539000000000001
r14089 n8689 n8690 0.0010730593607305935
r14090 n8672 n8691 0.34231666666666671
r14091 n8690 n8691 0.0037557077625570779
r14092 n8673 n8692 0.41078000000000003
r14093 n8691 n8692 0.0059018264840182645
r14094 n8674 n8693 2.0539000000000001
r14095 n8692 n8693 0.0032191780821917808
r14096 n8675 n8694 0.51347500000000001
r14097 n8693 n8694 0.0026826484018264841
r14098 n8676 n8695 0.41078000000000003
r14099 n8694 n8695 0.004828767123287672
r14100 n8677 n8696 2.0585999999999998
r14101 n8678 n8697 1.0292999999999999
r14102 n8696 n8697 0.0016095890410958904
r14103 n8679 n8698 2.0585999999999998
r14104 n8697 n8698 0.0016095890410958904
r14105 n8680 n8699 2.0585999999999998
r14106 n8698 n8699 0.0010730593607305935
r14107 n8681 n8700 2.0585999999999998
r14108 n8699 n8700 0.0010730593607305935
r14109 n8682 n8701 0.51464999999999994
r14110 n8700 n8701 0.0026826484018264841
r14111 n8683 n8702 0.41171999999999997
r14112 n8701 n8702 0.004828767123287672
r14113 n8684 n8703 2.0585999999999998
r14114 n8702 n8703 0.0032191780821917808
r14115 n8685 n8704 0.20585999999999999
r14116 n8703 n8704 0.0059018264840182645
r14117 n8686 n8705 0.68619999999999992
r14118 n8704 n8705 0.0069748858447488587
r14119 n8687 n8706 0.34309999999999996
r14120 n8705 n8706 0.004828767123287672
r14121 n8688 n8707 1.0292999999999999
r14122 n8706 n8707 0.0042922374429223741
r14123 n8689 n8708 2.0585999999999998
r14124 n8707 n8708 0.0016095890410958904
r14125 n8690 n8709 2.0585999999999998
r14126 n8708 n8709 0.0010730593607305935
r14127 n8691 n8710 0.34309999999999996
r14128 n8709 n8710 0.0037557077625570779
r14129 n8692 n8711 0.41171999999999997
r14130 n8710 n8711 0.0059018264840182645
r14131 n8693 n8712 2.0585999999999998
r14132 n8711 n8712 0.0032191780821917808
r14133 n8694 n8713 0.51464999999999994
r14134 n8712 n8713 0.0026826484018264841
r14135 n8695 n8714 0.41171999999999997
r14136 n8713 n8714 0.004828767123287672
r14137 n8696 out 1.8893999999999997
r14138 n8697 out 0.94469999999999987
r14139 n8698 out 1.8893999999999997
r14140 n8699 out 1.8893999999999997
r14141 n8700 out 1.8893999999999997
r14142 n8701 out 0.47234999999999994
r14143 n8702 out 0.37787999999999999
r14144 n8703 out 1.8893999999999997
r14145 n8704 out 0.18894
r14146 n8705 out 0.62979999999999992
r14147 n8706 out 0.31489999999999996
r14148 n8707 out 0.94469999999999987
r14149 n8708 out 1.8893999999999997
r14150 n8709 out 1.8893999999999997
r14151 n8710 out 0.31489999999999996
r14152 n8711 out 0.37787999999999999
r14153 n8712 out 1.8893999999999997
r14154 n8713 out 0.47234999999999994
r14155 n8714 out 0.37787999999999999
r14156 n9 0 158.10000000000002
r14157 n10 0 10.540000000000001
r14158 n11 0 158.10000000000002
r14159 n481 n2161 2687.7000000000003
r14160 n482 n2162 179.18000000000004
r14161 n483 n2163 2687.7000000000003
r14162 n488 n2173 179.18000000000004
r14163 n489 n2174 11.945333333333334
r14164 n490 n2175 179.18000000000004
r14165 n495 n2185 2687.7000000000003
r14166 n496 n2186 179.18000000000004
r14167 n497 n2187 2687.7000000000003
r14168 n755 n2440 413.49230769230769
r14169 n756 n2441 537.53999999999996
r14170 n757 n2442 1075.0799999999999
r14171 n758 n2443 1075.0799999999999
r14172 n759 n2444 5375.4000000000005
r14173 n792 n2471 51.686538461538461
r14174 n793 n2472 67.192499999999995
r14175 n794 n2473 134.38499999999999
r14176 n795 n2474 134.38499999999999
r14177 n796 n2475 671.92500000000007
r14178 n829 n2502 59.070329670329677
r14179 n830 n2503 76.791428571428582
r14180 n831 n2504 153.58285714285716
r14181 n832 n2505 153.58285714285716
r14182 n833 n2506 767.91428571428582
r14183 n866 n2533 413.49230769230769
r14184 n867 n2534 537.53999999999996
r14185 n868 n2535 1075.0799999999999
r14186 n869 n2536 1075.0799999999999
r14187 n870 n2537 5375.4000000000005
r14188 n1023 n2942 413.49230769230769
r14189 n1024 n2943 537.53999999999996
r14190 n1025 n2944 1075.0799999999999
r14191 n1026 n2945 1075.0799999999999
r14192 n1027 n2946 5375.4000000000005
r14193 n1060 n2973 55.132307692307698
r14194 n1061 n2974 71.672000000000011
r14195 n1062 n2975 143.34400000000002
r14196 n1063 n2976 143.34400000000002
r14197 n1064 n2977 716.72000000000014
r14198 n1097 n3004 55.132307692307698
r14199 n1098 n3005 71.672000000000011
r14200 n1099 n3006 143.34400000000002
r14201 n1100 n3007 143.34400000000002
r14202 n1101 n3008 716.72000000000014
r14203 n1134 n3035 413.49230769230769
r14204 n1135 n3036 537.53999999999996
r14205 n1136 n3037 1075.0799999999999
r14206 n1137 n3038 1075.0799999999999
r14207 n1138 n3039 5375.4000000000005
r14208 n538 n2263 5375.4000000000005
r14209 n539 n2264 5375.4000000000005
r14210 n540 n2265 5375.4000000000005
r14211 n541 n2266 1343.8500000000001
r14212 n542 n2267 1075.0799999999999
r14213 n543 n2268 5375.4000000000005
r14214 n544 n2269 537.53999999999996
r14215 n545 n2270 1791.8000000000002
r14216 n546 n2271 895.90000000000009
r14217 n547 n2272 2687.7000000000003
r14218 n606 n2285 358.36000000000007
r14219 n607 n2286 358.36000000000007
r14220 n608 n2287 358.36000000000007
r14221 n609 n2288 89.590000000000018
r14222 n610 n2289 71.672000000000011
r14223 n611 n2290 358.36000000000007
r14224 n612 n2291 35.836000000000006
r14225 n613 n2292 119.45333333333335
r14226 n614 n2293 59.726666666666674
r14227 n615 n2294 179.18000000000004
r14228 n674 n2307 5375.4000000000005
r14229 n675 n2308 5375.4000000000005
r14230 n676 n2309 5375.4000000000005
r14231 n677 n2310 1343.8500000000001
r14232 n678 n2311 1075.0799999999999
r14233 n679 n2312 5375.4000000000005
r14234 n680 n2313 537.53999999999996
r14235 n681 n2314 1791.8000000000002
r14236 n682 n2315 895.90000000000009
r14237 n683 n2316 2687.7000000000003
r14238 n770 n2455 5375.4000000000005
r14239 n771 n2456 1343.8500000000001
r14240 n772 n2457 1075.0799999999999
r14241 n773 n2458 5375.4000000000005
r14242 n774 n2459 537.53999999999996
r14243 n775 n2460 1791.8000000000002
r14244 n776 n2461 895.90000000000009
r14245 n777 n2462 2687.7000000000003
r14246 n778 n2463 5375.4000000000005
r14247 n779 n2464 5375.4000000000005
r14248 n807 n2486 671.92500000000007
r14249 n808 n2487 167.98125000000002
r14250 n809 n2488 134.38499999999999
r14251 n810 n2489 671.92500000000007
r14252 n811 n2490 67.192499999999995
r14253 n812 n2491 223.97500000000002
r14254 n813 n2492 111.98750000000001
r14255 n814 n2493 335.96250000000003
r14256 n815 n2494 671.92500000000007
r14257 n816 n2495 671.92500000000007
r14258 n844 n2517 767.91428571428582
r14259 n845 n2518 191.97857142857146
r14260 n846 n2519 153.58285714285716
r14261 n847 n2520 767.91428571428582
r14262 n848 n2521 76.791428571428582
r14263 n849 n2522 255.97142857142859
r14264 n850 n2523 127.98571428571429
r14265 n851 n2524 383.95714285714291
r14266 n852 n2525 767.91428571428582
r14267 n853 n2526 767.91428571428582
r14268 n881 n2548 5375.4000000000005
r14269 n882 n2549 1343.8500000000001
r14270 n883 n2550 1075.0799999999999
r14271 n884 n2551 5375.4000000000005
r14272 n885 n2552 537.53999999999996
r14273 n886 n2553 1791.8000000000002
r14274 n887 n2554 895.90000000000009
r14275 n888 n2555 2687.7000000000003
r14276 n889 n2556 5375.4000000000005
r14277 n890 n2557 5375.4000000000005
r14278 n1038 n2957 5375.4000000000005
r14279 n1039 n2958 1343.8500000000001
r14280 n1040 n2959 1075.0799999999999
r14281 n1041 n2960 5375.4000000000005
r14282 n1042 n2961 537.53999999999996
r14283 n1043 n2962 1791.8000000000002
r14284 n1044 n2963 895.90000000000009
r14285 n1045 n2964 2687.7000000000003
r14286 n1046 n2965 5375.4000000000005
r14287 n1047 n2966 5375.4000000000005
r14288 n1075 n2988 716.72000000000014
r14289 n1076 n2989 179.18000000000004
r14290 n1077 n2990 143.34400000000002
r14291 n1078 n2991 716.72000000000014
r14292 n1079 n2992 71.672000000000011
r14293 n1080 n2993 238.90666666666669
r14294 n1081 n2994 119.45333333333335
r14295 n1082 n2995 358.36000000000007
r14296 n1083 n2996 716.72000000000014
r14297 n1084 n2997 716.72000000000014
r14298 n1112 n3019 716.72000000000014
r14299 n1113 n3020 179.18000000000004
r14300 n1114 n3021 143.34400000000002
r14301 n1115 n3022 716.72000000000014
r14302 n1116 n3023 71.672000000000011
r14303 n1117 n3024 238.90666666666669
r14304 n1118 n3025 119.45333333333335
r14305 n1119 n3026 358.36000000000007
r14306 n1120 n3027 716.72000000000014
r14307 n1121 n3028 716.72000000000014
r14308 n1149 n3050 5375.4000000000005
r14309 n1150 n3051 1343.8500000000001
r14310 n1151 n3052 1075.0799999999999
r14311 n1152 n3053 5375.4000000000005
r14312 n1153 n3054 537.53999999999996
r14313 n1154 n3055 1791.8000000000002
r14314 n1155 n3056 895.90000000000009
r14315 n1156 n3057 2687.7000000000003
r14316 n1157 n3058 5375.4000000000005
r14317 n1158 n3059 5375.4000000000005
r14318 n951 n2757 2687.7000000000003
r14319 n952 n2758 316.20000000000005
r14320 n953 n2759 413.49230769230769
r14321 n954 n2760 2687.7000000000003
r14322 n959 n2770 191.97857142857146
r14323 n960 n2771 22.585714285714289
r14324 n961 n2772 29.535164835164839
r14325 n962 n2773 191.97857142857146
r14326 n967 n2783 2687.7000000000003
r14327 n968 n2784 316.20000000000005
r14328 n969 n2785 413.49230769230769
r14329 n970 n2786 2687.7000000000003
r14330 n975 n2796 2687.7000000000003
r14331 n976 n2797 316.20000000000005
r14332 n977 n2798 413.49230769230769
r14333 n978 n2799 2687.7000000000003
r14334 n1358 n3155 2687.7000000000003
r14335 n1359 n3156 179.18000000000004
r14336 n1360 n3157 2687.7000000000003
r14337 n1505 n3160 179.18000000000004
r14338 n1506 n3161 11.945333333333334
r14339 n1507 n3162 179.18000000000004
r14340 n1652 n3165 2687.7000000000003
r14341 n1653 n3166 179.18000000000004
r14342 n1654 n3167 2687.7000000000003
r14343 n2174 n3967 4.5
r14344 n2478 n4913 28.125
r14345 n2479 n4914 25.3125
r14346 n2480 n4915 50.625
r14347 n2481 n4916 50.625
r14348 n2482 n4917 253.125
r14349 n2509 n4973 32.142857142857139
r14350 n2510 n4974 28.928571428571427
r14351 n2511 n4975 57.857142857142854
r14352 n2512 n4976 57.857142857142854
r14353 n2513 n4977 289.28571428571428
r14354 n2980 n5774 30
r14355 n2981 n5775 27
r14356 n2982 n5776 54
r14357 n2983 n5777 54
r14358 n2984 n5778 270
r14359 n3011 n5805 30
r14360 n3012 n5806 27
r14361 n3013 n5807 54
r14362 n3014 n5808 54
r14363 n3015 n5809 270
r14364 n2287 n4385 135
r14365 n2288 n4386 33.75
r14366 n2289 n4387 27
r14367 n2290 n4388 135
r14368 n2291 n4389 13.5
r14369 n2292 n4390 45
r14370 n2293 n4391 22.5
r14371 t_r1_a n7084 135
r14372 t_r1_a n7085 13.5
r14373 t_r1_a n7086 45
r14374 t_r1_a n7087 22.5
r14375 t_r1_a n7088 67.5
r14376 t_r1_a n7089 135
r14377 t_r1_a n7090 135
r14378 t_r1_a n7091 22.5
r14379 n2771 n5435 8.5084033613445378
r14380 n2772 n5436 11.126373626373626
r14381 n2784 n5479 119.11764705882352
r14382 n2785 n5480 155.76923076923077
r14383 n3161 n6477 4.5
r14384 t_r1_b n7100 8.4375
r14385 t_r1_b n7101 9.6428571428571423
r14386 n2179 n3992 135
r14387 n2180 n3993 4.8214285714285712
r14388 n2181 n3994 135
r14389 n5709 n7670 1818.6666666666667
r14390 n5710 n7671 606.22222222222229
r14391 n5711 n7672 1818.6666666666667
r14392 n5712 n7673 202.07407407407408
r14393 n5713 n7674 181.86666666666667
r14394 n5714 n7675 363.73333333333335
r14395 n5715 n7676 363.73333333333335
r14396 n5716 n7677 1818.6666666666667
r14397 n5717 n7678 909.33333333333337
r14398 n5718 n7679 1818.6666666666667
r14399 n5719 n7680 1818.6666666666667
r14400 n5720 n7681 1818.6666666666667
r14401 n5740 n7689 2728
r14402 n5741 n7690 909.33333333333337
r14403 n5742 n7691 2728
r14404 n5743 n7692 303.11111111111114
r14405 n5744 n7693 272.80000000000001
r14406 n5745 n7694 545.60000000000002
r14407 n5746 n7695 545.60000000000002
r14408 n5747 n7696 2728
r14409 n5748 n7697 1364
r14410 n5749 n7698 2728
r14411 n5750 n7699 2728
r14412 n5751 n7700 2728
r14413 n5771 n7708 363.73333333333335
r14414 n5772 n7709 121.24444444444444
r14415 n5773 n7710 363.73333333333335
r14416 n5774 n7711 40.414814814814811
r14417 n5775 n7712 36.373333333333335
r14418 n5776 n7713 72.74666666666667
r14419 n5777 n7714 72.74666666666667
r14420 n5778 n7715 363.73333333333335
r14421 n5779 n7716 181.86666666666667
r14422 n5780 n7717 363.73333333333335
r14423 n5781 n7718 363.73333333333335
r14424 n5782 n7719 363.73333333333335
r14425 n5802 n7727 363.73333333333335
r14426 n5803 n7728 121.24444444444444
r14427 n5804 n7729 363.73333333333335
r14428 n5805 n7730 40.414814814814811
r14429 n5806 n7731 36.373333333333335
r14430 n5807 n7732 72.74666666666667
r14431 n5808 n7733 72.74666666666667
r14432 n5809 n7734 363.73333333333335
r14433 n5810 n7735 181.86666666666667
r14434 n5811 n7736 363.73333333333335
r14435 n5812 n7737 363.73333333333335
r14436 n5813 n7738 363.73333333333335
r14437 n5833 n7746 2728
r14438 n5834 n7747 909.33333333333337
r14439 n5835 n7748 2728
r14440 n5836 n7749 303.11111111111114
r14441 n5837 n7750 272.80000000000001
r14442 n5838 n7751 545.60000000000002
r14443 n5839 n7752 545.60000000000002
r14444 n5840 n7753 2728
r14445 n5841 n7754 1364
r14446 n5842 n7755 2728
r14447 n5843 n7756 2728
r14448 n5844 n7757 2728
r14449 n5864 n7765 1818.6666666666667
r14450 n5865 n7766 606.22222222222229
r14451 n5866 n7767 1818.6666666666667
r14452 n5867 n7768 202.07407407407408
r14453 n5868 n7769 181.86666666666667
r14454 n5869 n7770 363.73333333333335
r14455 n5870 n7771 363.73333333333335
r14456 n5871 n7772 1818.6666666666667
r14457 n5872 n7773 909.33333333333337
r14458 n5873 n7774 1818.6666666666667
r14459 n5874 n7775 1818.6666666666667
r14460 n5875 n7776 1818.6666666666667
r14461 n6973 n8315 363.73333333333335
r14462 n6974 n8316 1818.6666666666667
r14463 n6975 n8317 181.86666666666667
r14464 n6976 n8318 606.22222222222229
r14465 n6977 n8319 303.11111111111114
r14466 n6978 n8320 909.33333333333337
r14467 n6979 n8321 1818.6666666666667
r14468 n6980 n8322 1818.6666666666667
r14469 n6981 n8323 303.11111111111114
r14470 n6982 n8324 363.73333333333335
r14471 n7028 n8345 545.60000000000002
r14472 n7029 n8346 2728
r14473 n7030 n8347 272.80000000000001
r14474 n7031 n8348 909.33333333333337
r14475 n7032 n8349 454.66666666666669
r14476 n7033 n8350 1364
r14477 n7034 n8351 2728
r14478 n7035 n8352 2728
r14479 n7036 n8353 454.66666666666669
r14480 n7037 n8354 545.60000000000002
r14481 n7083 n8375 36.373333333333335
r14482 n7084 n8376 181.86666666666667
r14483 n7085 n8377 18.186666666666667
r14484 n7086 n8378 60.62222222222222
r14485 n7087 n8379 30.31111111111111
r14486 n7088 n8380 90.933333333333337
r14487 n7089 n8381 181.86666666666667
r14488 n7090 n8382 181.86666666666667
r14489 n7091 n8383 30.31111111111111
r14490 n7092 n8384 36.373333333333335
r14491 n7138 n8405 545.60000000000002
r14492 n7139 n8406 2728
r14493 n7140 n8407 272.80000000000001
r14494 n7141 n8408 909.33333333333337
r14495 n7142 n8409 454.66666666666669
r14496 n7143 n8410 1364
r14497 n7144 n8411 2728
r14498 n7145 n8412 2728
r14499 n7146 n8413 454.66666666666669
r14500 n7147 n8414 545.60000000000002
r14501 n7193 n8435 363.73333333333335
r14502 n7194 n8436 1818.6666666666667
r14503 n7195 n8437 181.86666666666667
r14504 n7196 n8438 606.22222222222229
r14505 n7197 n8439 303.11111111111114
r14506 n7198 n8440 909.33333333333337
r14507 n7199 n8441 1818.6666666666667
r14508 n7200 n8442 1818.6666666666667
r14509 n7201 n8443 303.11111111111114
r14510 n7202 n8444 363.73333333333335
r14511 n730 t_m1_b 585
r14512 n824 t_m1_b 1420.7142857142858
r14513 n861 t_m1_b 9945
r14514 n898 t_m1_b 4972.5
r14515 n902 t_m1_b 9945
r14516 n910 t_m1_b 19890
r14517 n918 t_m1_b 4972.5
r14518 n926 t_m1_b 9945
r14519 n934 t_m1_b 3978
r14520 n990 t_m1_b 4972.5
r14521 n998 t_m1_b 2841.4285714285716
r14522 n1006 t_m1_b 6630
r14523 n1014 t_m1_b 6630
r14524 n1018 t_m1_b 9945
r14525 n1055 t_m1_b 1326
r14526 n1182 t_m1_b 9945
r14527 n1186 t_m1_b 621.5625
r14528 n518 t_m1_b 10246.363636363636
r14529 n519 t_m1_b 338130
r14530 n586 t_m1_b 683.09090909090912
r14531 n587 t_m1_b 22542
r14532 n654 t_m1_b 10246.363636363636
r14533 n655 t_m1_b 338130
r14534 n1198 t_m1_b 602.72727272727275
r14535 n1199 t_m1_b 19890
r14536 n524 t_m1_b 338130
r14537 n525 t_m1_b 26010
r14538 n526 t_m1_b 33813
r14539 n527 t_m1_b 67626
r14540 n528 t_m1_b 67626
r14541 n592 t_m1_b 22542
r14542 n593 t_m1_b 1734
r14543 n594 t_m1_b 2254.2000000000003
r14544 n595 t_m1_b 4508.4000000000005
r14545 n596 t_m1_b 4508.4000000000005
r14546 n660 t_m1_b 338130
r14547 n661 t_m1_b 26010
r14548 n662 t_m1_b 33813
r14549 n663 t_m1_b 67626
r14550 n664 t_m1_b 67626
r14551 n1204 t_m1_b 19890
r14552 n1205 t_m1_b 1530
r14553 n1206 t_m1_b 1989
r14554 n1207 t_m1_b 3978
r14555 n1208 t_m1_b 3978
r14556 n755 t_m1_s 8225.3846153846152
r14557 n756 t_m1_s 10693
r14558 n757 t_m1_s 21386
r14559 n758 t_m1_s 21386
r14560 n759 t_m1_s 106930
r14561 n792 t_m1_s 1028.1730769230769
r14562 n793 t_m1_s 1336.625
r14563 n794 t_m1_s 2673.25
r14564 n795 t_m1_s 2673.25
r14565 n796 t_m1_s 13366.25
r14566 n829 t_m1_s 1175.0549450549452
r14567 n830 t_m1_s 1527.5714285714287
r14568 n831 t_m1_s 3055.1428571428573
r14569 n832 t_m1_s 3055.1428571428573
r14570 n833 t_m1_s 15275.714285714286
r14571 n866 t_m1_s 8225.3846153846152
r14572 n867 t_m1_s 10693
r14573 n868 t_m1_s 21386
r14574 n869 t_m1_s 21386
r14575 n870 t_m1_s 106930
r14576 n1023 t_m1_d 8225.3846153846152
r14577 n1024 t_m1_d 10693
r14578 n1025 t_m1_d 21386
r14579 n1026 t_m1_d 21386
r14580 n1027 t_m1_d 106930
r14581 n1060 t_m1_d 1096.7179487179487
r14582 n1061 t_m1_d 1425.7333333333333
r14583 n1062 t_m1_d 2851.4666666666667
r14584 n1063 t_m1_d 2851.4666666666667
r14585 n1064 t_m1_d 14257.333333333334
r14586 n1097 t_m1_d 1096.7179487179487
r14587 n1098 t_m1_d 1425.7333333333333
r14588 n1099 t_m1_d 2851.4666666666667
r14589 n1100 t_m1_d 2851.4666666666667
r14590 n1101 t_m1_d 14257.333333333334
r14591 n1134 t_m1_d 8225.3846153846152
r14592 n1135 t_m1_d 10693
r14593 n1136 t_m1_d 21386
r14594 n1137 t_m1_d 21386
r14595 n1138 t_m1_d 106930
r14596 n539 t_m1_b 338130
r14597 n540 t_m1_b 338130
r14598 n541 t_m1_b 84532.5
r14599 n542 t_m1_b 67626
r14600 n543 t_m1_b 338130
r14601 n544 t_m1_b 33813
r14602 n545 t_m1_b 112710
r14603 n546 t_m1_b 56355
r14604 n547 t_m1_b 169065
r14605 n548 t_m1_b 338130
r14606 n607 t_m1_b 22542
r14607 n608 t_m1_b 22542
r14608 n609 t_m1_b 5635.5
r14609 n610 t_m1_b 4508.4000000000005
r14610 n611 t_m1_b 22542
r14611 n612 t_m1_b 2254.2000000000003
r14612 n613 t_m1_b 7514
r14613 n614 t_m1_b 3757
r14614 n615 t_m1_b 11271
r14615 n616 t_m1_b 22542
r14616 n675 t_m1_b 338130
r14617 n676 t_m1_b 338130
r14618 n677 t_m1_b 84532.5
r14619 n678 t_m1_b 67626
r14620 n679 t_m1_b 338130
r14621 n680 t_m1_b 33813
r14622 n681 t_m1_b 112710
r14623 n682 t_m1_b 56355
r14624 n683 t_m1_b 169065
r14625 n684 t_m1_b 338130
r14626 n1219 t_m1_b 19890
r14627 n1220 t_m1_b 19890
r14628 n1221 t_m1_b 4972.5
r14629 n1222 t_m1_b 3978
r14630 n1223 t_m1_b 19890
r14631 n1224 t_m1_b 1989
r14632 n1225 t_m1_b 6630
r14633 n1226 t_m1_b 3315
r14634 n1227 t_m1_b 9945
r14635 n1228 t_m1_b 19890
r14636 n770 t_m1_s 106930
r14637 n771 t_m1_s 26732.5
r14638 n772 t_m1_s 21386
r14639 n773 t_m1_s 106930
r14640 n774 t_m1_s 10693
r14641 n775 t_m1_s 35643.333333333336
r14642 n776 t_m1_s 17821.666666666668
r14643 n777 t_m1_s 53465
r14644 n778 t_m1_s 106930
r14645 n779 t_m1_s 106930
r14646 n807 t_m1_s 13366.25
r14647 n808 t_m1_s 3341.5625
r14648 n809 t_m1_s 2673.25
r14649 n810 t_m1_s 13366.25
r14650 n811 t_m1_s 1336.625
r14651 n812 t_m1_s 4455.416666666667
r14652 n813 t_m1_s 2227.7083333333335
r14653 n814 t_m1_s 6683.125
r14654 n815 t_m1_s 13366.25
r14655 n816 t_m1_s 13366.25
r14656 n844 t_m1_s 15275.714285714286
r14657 n845 t_m1_s 3818.9285714285716
r14658 n846 t_m1_s 3055.1428571428573
r14659 n847 t_m1_s 15275.714285714286
r14660 n848 t_m1_s 1527.5714285714287
r14661 n849 t_m1_s 5091.9047619047615
r14662 n850 t_m1_s 2545.9523809523807
r14663 n851 t_m1_s 7637.8571428571431
r14664 n852 t_m1_s 15275.714285714286
r14665 n853 t_m1_s 15275.714285714286
r14666 n881 t_m1_s 106930
r14667 n882 t_m1_s 26732.5
r14668 n883 t_m1_s 21386
r14669 n884 t_m1_s 106930
r14670 n885 t_m1_s 10693
r14671 n886 t_m1_s 35643.333333333336
r14672 n887 t_m1_s 17821.666666666668
r14673 n888 t_m1_s 53465
r14674 n889 t_m1_s 106930
r14675 n890 t_m1_s 106930
r14676 n1038 t_m1_d 106930
r14677 n1039 t_m1_d 26732.5
r14678 n1040 t_m1_d 21386
r14679 n1041 t_m1_d 106930
r14680 n1042 t_m1_d 10693
r14681 n1043 t_m1_d 35643.333333333336
r14682 n1044 t_m1_d 17821.666666666668
r14683 n1045 t_m1_d 53465
r14684 n1046 t_m1_d 106930
r14685 n1047 t_m1_d 106930
r14686 n1075 t_m1_d 14257.333333333334
r14687 n1076 t_m1_d 3564.3333333333335
r14688 n1077 t_m1_d 2851.4666666666667
r14689 n1078 t_m1_d 14257.333333333334
r14690 n1079 t_m1_d 1425.7333333333333
r14691 n1080 t_m1_d 4752.4444444444443
r14692 n1081 t_m1_d 2376.2222222222222
r14693 n1082 t_m1_d 7128.666666666667
r14694 n1083 t_m1_d 14257.333333333334
r14695 n1084 t_m1_d 14257.333333333334
r14696 n1112 t_m1_d 14257.333333333334
r14697 n1113 t_m1_d 3564.3333333333335
r14698 n1114 t_m1_d 2851.4666666666667
r14699 n1115 t_m1_d 14257.333333333334
r14700 n1116 t_m1_d 1425.7333333333333
r14701 n1117 t_m1_d 4752.4444444444443
r14702 n1118 t_m1_d 2376.2222222222222
r14703 n1119 t_m1_d 7128.666666666667
r14704 n1120 t_m1_d 14257.333333333334
r14705 n1121 t_m1_d 14257.333333333334
r14706 n1149 t_m1_d 106930
r14707 n1150 t_m1_d 26732.5
r14708 n1151 t_m1_d 21386
r14709 n1152 t_m1_d 106930
r14710 n1153 t_m1_d 10693
r14711 n1154 t_m1_d 35643.333333333336
r14712 n1155 t_m1_d 17821.666666666668
r14713 n1156 t_m1_d 53465
r14714 n1157 t_m1_d 106930
r14715 n1158 t_m1_d 106930
r14716 n558 t_m1_b 33813
r14717 n559 t_m1_b 84532.5
r14718 n560 t_m1_b 48304.285714285717
r14719 n561 t_m1_b 37570
r14720 n562 t_m1_b 84532.5
r14721 n626 t_m1_b 2254.2000000000003
r14722 n627 t_m1_b 5635.5
r14723 n628 t_m1_b 3220.2857142857142
r14724 n629 t_m1_b 2504.6666666666665
r14725 n630 t_m1_b 5635.5
r14726 n694 t_m1_b 33813
r14727 n695 t_m1_b 84532.5
r14728 n696 t_m1_b 48304.285714285717
r14729 n697 t_m1_b 37570
r14730 n698 t_m1_b 84532.5
r14731 n1238 t_m1_b 1989
r14732 n1239 t_m1_b 4972.5
r14733 n1240 t_m1_b 2841.4285714285716
r14734 n1241 t_m1_b 2210
r14735 n1242 t_m1_b 4972.5
r14736 n951 t_m1_g 43928
r14737 n952 t_m1_g 5168
r14738 n953 t_m1_g 6758.1538461538457
r14739 n954 t_m1_g 43928
r14740 n959 t_m1_g 3137.7142857142858
r14741 n960 t_m1_g 369.14285714285717
r14742 n961 t_m1_g 482.72527472527474
r14743 n962 t_m1_g 3137.7142857142858
r14744 n967 t_m1_g 43928
r14745 n968 t_m1_g 5168
r14746 n969 t_m1_g 6758.1538461538457
r14747 n970 t_m1_g 43928
r14748 n975 t_m1_g 43928
r14749 n976 t_m1_g 5168
r14750 n977 t_m1_g 6758.1538461538457
r14751 n978 t_m1_g 43928
r14752 n568 t_m1_b 26010
r14753 n569 t_m1_b 169065
r14754 n570 t_m1_b 169065
r14755 n571 t_m1_b 84532.5
r14756 n572 t_m1_b 67626
r14757 n573 t_m1_b 42266.25
r14758 n636 t_m1_b 1734
r14759 n637 t_m1_b 11271
r14760 n638 t_m1_b 11271
r14761 n639 t_m1_b 5635.5
r14762 n640 t_m1_b 4508.4000000000005
r14763 n641 t_m1_b 2817.75
r14764 n704 t_m1_b 26010
r14765 n705 t_m1_b 169065
r14766 n706 t_m1_b 169065
r14767 n707 t_m1_b 84532.5
r14768 n708 t_m1_b 67626
r14769 n709 t_m1_b 42266.25
r14770 n1248 t_m1_b 1530
r14771 n1249 t_m1_b 9945
r14772 n1250 t_m1_b 9945
r14773 n1251 t_m1_b 4972.5
r14774 n1252 t_m1_b 3978
r14775 n1253 t_m1_b 2486.25
r14776 n731 t_m1_b 3978
r14777 n732 t_m1_b 736.66666666666674
r14778 n733 t_m1_b 9945
r14779 n858 t_m1_b 9660.8571428571431
r14780 n859 t_m1_b 1789.047619047619
r14781 n860 t_m1_b 24152.142857142859
r14782 n895 t_m1_b 67626
r14783 n896 t_m1_b 12523.333333333334
r14784 n897 t_m1_b 169065
r14785 n899 t_m1_b 33813
r14786 n900 t_m1_b 6261.666666666667
r14787 n901 t_m1_b 84532.5
r14788 n907 t_m1_b 67626
r14789 n908 t_m1_b 12523.333333333334
r14790 n909 t_m1_b 169065
r14791 n915 t_m1_b 135252
r14792 n916 t_m1_b 25046.666666666668
r14793 n917 t_m1_b 338130
r14794 n923 t_m1_b 33813
r14795 n924 t_m1_b 6261.666666666667
r14796 n925 t_m1_b 84532.5
r14797 n931 t_m1_b 67626
r14798 n932 t_m1_b 12523.333333333334
r14799 n933 t_m1_b 169065
r14800 n939 t_m1_b 27050.400000000001
r14801 n940 t_m1_b 5009.333333333333
r14802 n941 t_m1_b 67626
r14803 n995 t_m1_b 33813
r14804 n996 t_m1_b 6261.666666666667
r14805 n997 t_m1_b 84532.5
r14806 n1003 t_m1_b 19321.714285714286
r14807 n1004 t_m1_b 3578.0952380952381
r14808 n1005 t_m1_b 48304.285714285717
r14809 n1011 t_m1_b 45084
r14810 n1012 t_m1_b 8348.8888888888887
r14811 n1013 t_m1_b 112710
r14812 n1015 t_m1_b 45084
r14813 n1016 t_m1_b 8348.8888888888887
r14814 n1017 t_m1_b 112710
r14815 n1052 t_m1_b 67626
r14816 n1053 t_m1_b 12523.333333333334
r14817 n1054 t_m1_b 169065
r14818 n1089 t_m1_b 9016.8000000000011
r14819 n1090 t_m1_b 1669.7777777777778
r14820 n1091 t_m1_b 22542
r14821 n1183 t_m1_b 67626
r14822 n1184 t_m1_b 12523.333333333334
r14823 n1185 t_m1_b 169065
r14824 n1187 t_m1_b 4226.625
r14825 n1188 t_m1_b 782.70833333333337
r14826 n1189 t_m1_b 10566.5625
r14827 n1715 t_r1_w 1808.181818181818
r14828 n1718 t_r1_w 1989
r14829 n1721 t_r1_w 9945
r14830 n1724 t_r1_w 6630
r14831 n1727 t_r1_w 3978
r14832 n1730 t_r1_w 6630
r14833 n1742 t_r1_w 6630
r14834 n1745 t_r1_w 3978
r14835 n1748 t_r1_w 6630
r14836 n1751 t_r1_w 9945
r14837 n1754 t_r1_w 1989
r14838 n1757 t_r1_w 1808.181818181818
r14839 n1268 t_r1_w 338130
r14840 n1269 t_r1_w 10246.363636363636
r14841 n1415 t_r1_w 22542
r14842 n1416 t_r1_w 683.09090909090912
r14843 n1562 t_r1_w 338130
r14844 n1563 t_r1_w 10246.363636363636
r14845 n1772 t_r1_w 19890
r14846 n1773 t_r1_w 602.72727272727275
r14847 n1274 t_r1_w 67626
r14848 n1275 t_r1_w 338130
r14849 n1276 t_r1_w 26010
r14850 n1277 t_r1_w 33813
r14851 n1278 t_r1_w 67626
r14852 n1421 t_r1_w 4508.4000000000005
r14853 n1422 t_r1_w 22542
r14854 n1423 t_r1_w 1734
r14855 n1424 t_r1_w 2254.2000000000003
r14856 n1425 t_r1_w 4508.4000000000005
r14857 n1568 t_r1_w 67626
r14858 n1569 t_r1_w 338130
r14859 n1570 t_r1_w 26010
r14860 n1571 t_r1_w 33813
r14861 n1572 t_r1_w 67626
r14862 n1778 t_r1_w 3978
r14863 n1779 t_r1_w 19890
r14864 n1780 t_r1_w 1530
r14865 n1781 t_r1_w 1989
r14866 n1782 t_r1_w 3978
r14867 n1286 t_r1_w 67626
r14868 n1287 t_r1_w 338130
r14869 n1288 t_r1_w 169065
r14870 n1289 t_r1_w 338130
r14871 n1290 t_r1_w 338130
r14872 n1291 t_r1_w 338130
r14873 n1292 t_r1_w 84532.5
r14874 n1293 t_r1_w 67626
r14875 n1294 t_r1_w 338130
r14876 n1295 t_r1_w 33813
r14877 n1296 t_r1_w 112710
r14878 n1433 t_r1_w 4508.4000000000005
r14879 n1434 t_r1_w 22542
r14880 n1435 t_r1_w 11271
r14881 n1436 t_r1_w 22542
r14882 n1437 t_r1_w 22542
r14883 n1438 t_r1_w 22542
r14884 n1439 t_r1_w 5635.5
r14885 n1440 t_r1_w 4508.4000000000005
r14886 n1441 t_r1_w 22542
r14887 n1442 t_r1_w 2254.2000000000003
r14888 n1443 t_r1_w 7514
r14889 n1580 t_r1_w 67626
r14890 n1581 t_r1_w 338130
r14891 n1582 t_r1_w 169065
r14892 n1583 t_r1_w 338130
r14893 n1584 t_r1_w 338130
r14894 n1585 t_r1_w 338130
r14895 n1586 t_r1_w 84532.5
r14896 n1587 t_r1_w 67626
r14897 n1588 t_r1_w 338130
r14898 n1589 t_r1_w 33813
r14899 n1590 t_r1_w 112710
r14900 n1790 t_r1_w 3978
r14901 n1791 t_r1_w 19890
r14902 n1792 t_r1_w 9945
r14903 n1793 t_r1_w 19890
r14904 n1794 t_r1_w 19890
r14905 n1795 t_r1_w 19890
r14906 n1796 t_r1_w 4972.5
r14907 n1797 t_r1_w 3978
r14908 n1798 t_r1_w 19890
r14909 n1799 t_r1_w 1989
r14910 n1800 t_r1_w 6630
r14911 n1307 t_r1_w 48304.285714285717
r14912 n1308 t_r1_w 56355
r14913 n1309 t_r1_w 33813
r14914 n1310 t_r1_w 84532.5
r14915 n1311 t_r1_w 48304.285714285717
r14916 n1454 t_r1_w 3220.2857142857142
r14917 n1455 t_r1_w 3757
r14918 n1456 t_r1_w 2254.2000000000003
r14919 n1457 t_r1_w 5635.5
r14920 n1458 t_r1_w 3220.2857142857142
r14921 n1601 t_r1_w 48304.285714285717
r14922 n1602 t_r1_w 56355
r14923 n1603 t_r1_w 33813
r14924 n1604 t_r1_w 84532.5
r14925 n1605 t_r1_w 48304.285714285717
r14926 n1811 t_r1_w 2841.4285714285716
r14927 n1812 t_r1_w 3315
r14928 n1813 t_r1_w 1989
r14929 n1814 t_r1_w 4972.5
r14930 n1815 t_r1_w 2841.4285714285716
r14931 n1318 t_r1_w 19890
r14932 n1319 t_r1_w 26010
r14933 n1320 t_r1_w 169065
r14934 n1321 t_r1_w 169065
r14935 n1465 t_r1_w 1326
r14936 n1466 t_r1_w 1734
r14937 n1467 t_r1_w 11271
r14938 n1468 t_r1_w 11271
r14939 n1612 t_r1_w 19890
r14940 n1613 t_r1_w 26010
r14941 n1614 t_r1_w 169065
r14942 n1615 t_r1_w 169065
r14943 n1822 t_r1_w 1170
r14944 n1823 t_r1_w 1530
r14945 n1824 t_r1_w 9945
r14946 n1825 t_r1_w 9945
r14947 n1327 t_r1_w 48304.285714285717
r14948 n1328 t_r1_w 12523.333333333334
r14949 n1474 t_r1_w 3220.2857142857142
r14950 n1475 t_r1_w 834.88888888888891
r14951 n1621 t_r1_w 48304.285714285717
r14952 n1622 t_r1_w 12523.333333333334
r14953 n1831 t_r1_w 2841.4285714285716
r14954 n1832 t_r1_w 736.66666666666674
r14955 n1332 t_r1_w 169065
r14956 n1333 t_r1_w 10566.5625
r14957 n1479 t_r1_w 11271
r14958 n1480 t_r1_w 704.4375
r14959 n1626 t_r1_w 169065
r14960 n1627 t_r1_w 10566.5625
r14961 n1836 t_r1_w 9945
r14962 n1837 t_r1_w 621.5625
r14963 n1335 t_r1_w 9945
r14964 n1482 t_r1_w 663
r14965 n1629 t_r1_w 9945
r14966 n1839 t_r1_w 585
r14967 n1337 t_r1_w 9945
r14968 n1484 t_r1_w 663
r14969 n1631 t_r1_w 9945
r14970 n1841 t_r1_w 585
r14971 n1339 t_r1_w 9945
r14972 n1486 t_r1_w 663
r14973 n1633 t_r1_w 9945
r14974 n1843 t_r1_w 585
r14975 n1341 t_r1_w 9945
r14976 n1488 t_r1_w 663
r14977 n1635 t_r1_w 9945
r14978 n1845 t_r1_w 585
r14979 n1343 t_r1_w 9945
r14980 n1490 t_r1_w 663
r14981 n1637 t_r1_w 9945
r14982 n1847 t_r1_w 585
r14983 n1345 t_r1_w 9945
r14984 n1492 t_r1_w 663
r14985 n1639 t_r1_w 9945
r14986 n1849 t_r1_w 585
r14987 n1347 t_r1_w 9945
r14988 n1494 t_r1_w 663
r14989 n1641 t_r1_w 9945
r14990 n1851 t_r1_w 585
r14991 n1349 t_r1_w 9945
r14992 n1496 t_r1_w 663
r14993 n1643 t_r1_w 9945
r14994 n1853 t_r1_w 585
r14995 n1351 t_r1_w 9945
r14996 n1498 t_r1_w 663
r14997 n1645 t_r1_w 9945
r14998 n1855 t_r1_w 585
r14999 n1353 t_r1_w 9945
r15000 n1500 t_r1_w 663
r15001 n1647 t_r1_w 9945
r15002 n1857 t_r1_w 585
r15003 n1355 t_r1_w 9945
r15004 n1502 t_r1_w 663
r15005 n1649 t_r1_w 9945
r15006 n1859 t_r1_w 585
r15007 n1358 t_r1_w 169065
r15008 n1359 t_r1_w 11271
r15009 n1360 t_r1_w 169065
r15010 n1505 t_r1_w 11271
r15011 n1506 t_r1_w 751.39999999999998
r15012 n1507 t_r1_w 11271
r15013 n1652 t_r1_w 169065
r15014 n1653 t_r1_w 11271
r15015 n1654 t_r1_w 169065
r15016 n1862 t_r1_w 9945
r15017 n1863 t_r1_w 663
r15018 n1864 t_r1_w 9945
r15019 n1363 t_r1_w 9945
r15020 n1510 t_r1_w 663
r15021 n1657 t_r1_w 9945
r15022 n1867 t_r1_w 585
r15023 n1365 t_r1_w 9945
r15024 n1512 t_r1_w 663
r15025 n1659 t_r1_w 9945
r15026 n1869 t_r1_w 585
r15027 n1367 t_r1_w 9945
r15028 n1514 t_r1_w 663
r15029 n1661 t_r1_w 9945
r15030 n1871 t_r1_w 585
r15031 n1369 t_r1_w 9945
r15032 n1516 t_r1_w 663
r15033 n1663 t_r1_w 9945
r15034 n1873 t_r1_w 585
r15035 n1371 t_r1_w 9945
r15036 n1518 t_r1_w 663
r15037 n1665 t_r1_w 9945
r15038 n1875 t_r1_w 585
r15039 n1373 t_r1_w 9945
r15040 n1520 t_r1_w 663
r15041 n1667 t_r1_w 9945
r15042 n1877 t_r1_w 585
r15043 n1375 t_r1_w 9945
r15044 n1522 t_r1_w 663
r15045 n1669 t_r1_w 9945
r15046 n1879 t_r1_w 585
r15047 n1377 t_r1_w 9945
r15048 n1524 t_r1_w 663
r15049 n1671 t_r1_w 9945
r15050 n1881 t_r1_w 585
r15051 n1379 t_r1_w 9945
r15052 n1526 t_r1_w 663
r15053 n1673 t_r1_w 9945
r15054 n1883 t_r1_w 585
r15055 n1381 t_r1_w 9945
r15056 n1528 t_r1_w 663
r15057 n1675 t_r1_w 9945
r15058 n1885 t_r1_w 585
r15059 n1383 t_r1_w 9945
r15060 n1530 t_r1_w 663
r15061 n1677 t_r1_w 9945
r15062 n1887 t_r1_w 585
r15063 n1385 t_r1_w 9945
r15064 n1532 t_r1_w 663
r15065 n1679 t_r1_w 9945
r15066 n1889 t_r1_w 585
r15067 n1388 t_r1_w 9945
r15068 n1535 t_r1_w 663
r15069 n1682 t_r1_w 9945
r15070 n1892 t_r1_w 585
r15071 n1390 t_r1_w 9945
r15072 n1537 t_r1_w 663
r15073 n1684 t_r1_w 9945
r15074 n1894 t_r1_w 585
r15075 n1392 t_r1_w 12523.333333333334
r15076 n1393 t_r1_w 48304.285714285717
r15077 n1539 t_r1_w 834.88888888888891
r15078 n1540 t_r1_w 3220.2857142857142
r15079 n1686 t_r1_w 12523.333333333334
r15080 n1687 t_r1_w 48304.285714285717
r15081 n1896 t_r1_w 736.66666666666674
r15082 n1897 t_r1_w 2841.4285714285716
r15083 n1396 t_r1_w 24152.142857142859
r15084 n1397 t_r1_w 16906.5
r15085 n1543 t_r1_w 1610.1428571428571
r15086 n1544 t_r1_w 1127.1000000000001
r15087 n1690 t_r1_w 24152.142857142859
r15088 n1691 t_r1_w 16906.5
r15089 n1900 t_r1_w 1420.7142857142858
r15090 n1901 t_r1_w 994.5
r15091 n1400 t_r1_w 9945
r15092 n1547 t_r1_w 663
r15093 n1694 t_r1_w 9945
r15094 n1904 t_r1_w 585
r15095 n1402 t_r1_w 9945
r15096 n1549 t_r1_w 663
r15097 n1696 t_r1_w 9945
r15098 n1906 t_r1_w 585
r15099 n1716 t_r1_w 3616.363636363636
r15100 n1717 t_r1_w 3616.363636363636
r15101 n1719 t_r1_w 3978
r15102 n1720 t_r1_w 3978
r15103 n1722 t_r1_w 19890
r15104 n1723 t_r1_w 19890
r15105 n1725 t_r1_w 13260
r15106 n1726 t_r1_w 13260
r15107 n1728 t_r1_w 7956
r15108 n1729 t_r1_w 7956
r15109 n1731 t_r1_w 13260
r15110 n1732 t_r1_w 13260
r15111 n1743 t_r1_w 13260
r15112 n1744 t_r1_w 13260
r15113 n1746 t_r1_w 7956
r15114 n1747 t_r1_w 7956
r15115 n1749 t_r1_w 13260
r15116 n1750 t_r1_w 13260
r15117 n1752 t_r1_w 19890
r15118 n1753 t_r1_w 19890
r15119 n1755 t_r1_w 3978
r15120 n1756 t_r1_w 3978
r15121 n1758 t_r1_w 3616.363636363636
r15122 n1759 t_r1_w 3616.363636363636
