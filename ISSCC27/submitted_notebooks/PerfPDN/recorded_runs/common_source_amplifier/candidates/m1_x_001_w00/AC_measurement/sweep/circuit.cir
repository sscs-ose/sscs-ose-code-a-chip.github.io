PerfPDN frequency sweep
.lib /home/gokalp/.local/share/perfpdn/pdks/sky130A/libs.tech/ngspice/sky130.lib.spice tt
.option scale=1e-6 reltol=1e-8 abstol=1e-14
.temp 27
.option klu reltol=1e-8 abstol=1e-14 vntol=1e-10
vin in 0 DC 0 AC 1 0
vdd vdd 0 DC 0 AC 0 0
C1 out 0 9.9999999999999998e-13
v_r1_a t_r1_a r1_a 0
v_r1_b t_r1_b r1_b -1.2
v_r1_w t_r1_w r1_w -0
XR1 r1_a r1_b r1_w sky130_fd_pr__res_high_po_0p35 L=8.67 mult=1 m=1
v_m1_d t_m1_d m1_d 0
v_m1_g t_m1_g m1_g -0.95472500000000005
v_m1_s t_m1_s m1_s -0
v_m1_b t_m1_b m1_b -0
XM1 m1_d m1_g m1_s m1_b sky130_fd_pr__nfet_01v8_lvt L=0.235 W=0.865 nf=1 ad='int(( 1 + 1 ) / 2 ) * 0.865 / 1 * 0.29' as='int(( 1 + 2 ) / 2 ) * 0.865 / 1 * 0.29' pd='2 * int(( 1 + 1 ) / 2 ) * ( 0.865 / 1 + 0.29 )' ps='2 * int(( 1 + 2 ) / 2 ) * ( 0.865 / 1 + 0.29 )' nrd='0.29 / 0.865 ' nrs='0.29 / 0.865 ' sa=0 sb=0 sd=0 mult=1 m=1
r0 n0 n1 6.4000000000000004
r1 n1 n2 5.2093023255813957
r2 n2 n3 4.7627906976744185
r3 n3 n4 4.7627906976744185
r4 n4 n5 5.2093023255813957
r5 n5 n6 6.4000000000000004
r6 n0 n7 49.280000000000001
r7 n1 n8 14.933333333333334
r8 n7 n8 8.0941176470588232
r9 n2 n9 246.40000000000001
r10 n8 n9 6.5882352941176467
r11 n3 n10 16.426666666666666
r12 n9 n10 6.0235294117647058
r13 n4 n11 246.40000000000001
r14 n10 n11 6.0235294117647058
r15 n5 n12 14.933333333333334
r16 n11 n12 6.5882352941176467
r17 n6 n13 49.280000000000001
r18 n12 n13 8.0941176470588232
r19 n7 n14 49.280000000000001
r20 n8 n15 14.933333333333334
r21 n14 n15 6.4000000000000004
r22 n9 n16 246.40000000000001
r23 n15 n16 5.2093023255813957
r24 n10 n17 16.426666666666666
r25 n16 n17 4.7627906976744185
r26 n11 n18 246.40000000000001
r27 n17 n18 4.7627906976744185
r28 n12 n19 14.933333333333334
r29 n18 n19 5.2093023255813957
r30 n13 n20 49.280000000000001
r31 n19 n20 6.4000000000000004
r32 n16 n21 297.60000000000002
r33 n17 n22 19.84
r34 n21 n22 4.0960000000000001
r35 n18 n23 297.60000000000002
r36 n22 n23 4.0960000000000001
r37 n21 n24 320
r38 n22 n25 21.333333333333332
r39 n24 n25 4.0960000000000001
r40 n23 n26 320
r41 n25 n26 4.0960000000000001
r42 n24 n27 320
r43 n25 n28 21.333333333333332
r44 n27 n28 4.0960000000000001
r45 n26 n29 320
r46 n28 n29 4.0960000000000001
r47 n27 n30 320
r48 n28 n31 21.333333333333332
r49 n30 n31 4.0960000000000001
r50 n29 n32 320
r51 n31 n32 4.0960000000000001
r52 n30 n33 320
r53 n31 n34 21.333333333333332
r54 n33 n34 4.0960000000000001
r55 n32 n35 320
r56 n34 n35 4.0960000000000001
r57 n33 n36 320
r58 n34 n37 21.333333333333332
r59 n36 n37 4.0960000000000001
r60 n35 n38 320
r61 n37 n38 4.0960000000000001
r62 n36 n39 320
r63 n37 n40 21.333333333333332
r64 n39 n40 4.0960000000000001
r65 n38 n41 320
r66 n40 n41 4.0960000000000001
r67 n39 n42 320
r68 n40 n43 21.333333333333332
r69 n42 n43 4.0960000000000001
r70 n41 n44 320
r71 n43 n44 4.0960000000000001
r72 n42 n45 320
r73 n43 n46 21.333333333333332
r74 n45 n46 4.0960000000000001
r75 n44 n47 320
r76 n46 n47 4.0960000000000001
r77 n45 n48 320
r78 n46 n49 21.333333333333332
r79 n48 n49 4.0960000000000001
r80 n47 n50 320
r81 n49 n50 4.0960000000000001
r82 n48 n51 320
r83 n49 n52 21.333333333333332
r84 n51 n52 4.0960000000000001
r85 n50 n53 320
r86 n52 n53 4.0960000000000001
r87 n51 n54 320
r88 n52 n55 21.333333333333332
r89 n54 n55 4.0960000000000001
r90 n53 n56 320
r91 n55 n56 4.0960000000000001
r92 n54 n57 320
r93 n55 n58 21.333333333333332
r94 n57 n58 4.0960000000000001
r95 n56 n59 320
r96 n58 n59 4.0960000000000001
r97 n57 n60 320
r98 n58 n61 21.333333333333332
r99 n60 n61 4.0960000000000001
r100 n59 n62 320
r101 n61 n62 4.0960000000000001
r102 n60 n63 320
r103 n61 n64 21.333333333333332
r104 n63 n64 4.0960000000000001
r105 n62 n65 320
r106 n64 n65 4.0960000000000001
r107 n63 n66 320
r108 n64 n67 21.333333333333332
r109 n66 n67 4.0960000000000001
r110 n65 n68 320
r111 n67 n68 4.0960000000000001
r112 n66 n69 320
r113 n67 n70 21.333333333333332
r114 n69 n70 4.0960000000000001
r115 n68 n71 320
r116 n70 n71 4.0960000000000001
r117 n69 n72 320
r118 n70 n73 21.333333333333332
r119 n72 n73 4.0960000000000001
r120 n71 n74 320
r121 n73 n74 4.0960000000000001
r122 n72 n75 320
r123 n73 n76 21.333333333333332
r124 n75 n76 4.0960000000000001
r125 n74 n77 320
r126 n76 n77 4.0960000000000001
r127 n75 n78 320
r128 n76 n79 21.333333333333332
r129 n78 n79 4.0960000000000001
r130 n77 n80 320
r131 n79 n80 4.0960000000000001
r132 n78 n81 320
r133 n79 n82 21.333333333333332
r134 n81 n82 4.0960000000000001
r135 n80 n83 320
r136 n82 n83 4.0960000000000001
r137 n81 n84 320
r138 n82 n85 21.333333333333332
r139 n84 n85 4.0960000000000001
r140 n83 n86 320
r141 n85 n86 4.0960000000000001
r142 n84 n87 320
r143 n85 n88 21.333333333333332
r144 n87 n88 4.0960000000000001
r145 n86 n89 320
r146 n88 n89 4.0960000000000001
r147 n87 n90 320
r148 n88 n91 21.333333333333332
r149 n90 n91 4.0960000000000001
r150 n89 n92 320
r151 n91 n92 4.0960000000000001
r152 n90 n93 320
r153 n91 n94 21.333333333333332
r154 n93 n94 4.0960000000000001
r155 n92 n95 320
r156 n94 n95 4.0960000000000001
r157 n93 n96 320
r158 n94 n97 21.333333333333332
r159 n96 n97 4.0960000000000001
r160 n95 n98 320
r161 n97 n98 4.0960000000000001
r162 n96 n99 320
r163 n97 n100 21.333333333333332
r164 n99 n100 4.0960000000000001
r165 n98 n101 320
r166 n100 n101 4.0960000000000001
r167 n99 n102 320
r168 n100 n103 21.333333333333332
r169 n102 n103 4.0960000000000001
r170 n101 n104 320
r171 n103 n104 4.0960000000000001
r172 n102 n105 320
r173 n103 n106 21.333333333333332
r174 n105 n106 4.0960000000000001
r175 n104 n107 320
r176 n106 n107 4.0960000000000001
r177 n105 n108 320
r178 n106 n109 21.333333333333332
r179 n108 n109 4.0960000000000001
r180 n107 n110 320
r181 n109 n110 4.0960000000000001
r182 n108 n111 320
r183 n109 n112 21.333333333333332
r184 n111 n112 4.0960000000000001
r185 n110 n113 320
r186 n112 n113 4.0960000000000001
r187 n111 n114 320
r188 n112 n115 21.333333333333332
r189 n114 n115 4.0960000000000001
r190 n113 n116 320
r191 n115 n116 4.0960000000000001
r192 n114 n117 320
r193 n115 n118 21.333333333333332
r194 n117 n118 4.0960000000000001
r195 n116 n119 320
r196 n118 n119 4.0960000000000001
r197 n117 n120 320
r198 n118 n121 21.333333333333332
r199 n120 n121 4.0960000000000001
r200 n119 n122 320
r201 n121 n122 4.0960000000000001
r202 n120 n123 320
r203 n121 n124 21.333333333333332
r204 n123 n124 4.0960000000000001
r205 n122 n125 320
r206 n124 n125 4.0960000000000001
r207 n123 n126 320
r208 n124 n127 21.333333333333332
r209 n126 n127 4.0960000000000001
r210 n125 n128 320
r211 n127 n128 4.0960000000000001
r212 n126 n129 320
r213 n127 n130 21.333333333333332
r214 n129 n130 4.0960000000000001
r215 n128 n131 320
r216 n130 n131 4.0960000000000001
r217 n129 n132 320
r218 n130 n133 21.333333333333332
r219 n132 n133 4.0960000000000001
r220 n131 n134 320
r221 n133 n134 4.0960000000000001
r222 n132 n135 320
r223 n133 n136 21.333333333333332
r224 n135 n136 4.0960000000000001
r225 n134 n137 320
r226 n136 n137 4.0960000000000001
r227 n135 n138 320
r228 n136 n139 21.333333333333332
r229 n138 n139 4.0960000000000001
r230 n137 n140 320
r231 n139 n140 4.0960000000000001
r232 n138 n141 320
r233 n139 n142 21.333333333333332
r234 n141 n142 4.0960000000000001
r235 n140 n143 320
r236 n142 n143 4.0960000000000001
r237 n141 n144 320
r238 n142 n145 21.333333333333332
r239 n144 n145 4.0960000000000001
r240 n143 n146 320
r241 n145 n146 4.0960000000000001
r242 n144 n147 320
r243 n145 n148 21.333333333333332
r244 n147 n148 4.0960000000000001
r245 n146 n149 320
r246 n148 n149 4.0960000000000001
r247 n147 n150 320
r248 n148 n151 21.333333333333332
r249 n150 n151 4.0960000000000001
r250 n149 n152 320
r251 n151 n152 4.0960000000000001
r252 n150 n153 320
r253 n151 n154 21.333333333333332
r254 n153 n154 4.0960000000000001
r255 n152 n155 320
r256 n154 n155 4.0960000000000001
r257 n153 n156 320
r258 n154 n157 21.333333333333332
r259 n156 n157 4.0960000000000001
r260 n155 n158 320
r261 n157 n158 4.0960000000000001
r262 n156 n159 320
r263 n157 n160 21.333333333333332
r264 n159 n160 4.0960000000000001
r265 n158 n161 320
r266 n160 n161 4.0960000000000001
r267 n159 n162 320
r268 n160 n163 21.333333333333332
r269 n162 n163 4.0960000000000001
r270 n161 n164 320
r271 n163 n164 4.0960000000000001
r272 n162 n165 320
r273 n163 n166 21.333333333333332
r274 n165 n166 4.0960000000000001
r275 n164 n167 320
r276 n166 n167 4.0960000000000001
r277 n165 n168 320
r278 n166 n169 21.333333333333332
r279 n168 n169 4.0960000000000001
r280 n167 n170 320
r281 n169 n170 4.0960000000000001
r282 n168 n171 288
r283 n169 n172 19.199999999999999
r284 n171 n172 5.1200000000000001
r285 n170 n173 288
r286 n172 n173 5.1200000000000001
r287 n171 n174 256
r288 n172 n175 17.066666666666666
r289 n174 n175 5.1200000000000001
r290 n173 n176 256
r291 n175 n176 5.1200000000000001
r292 n177 n178 13.76
r293 n174 n179 192
r294 n178 n179 11.199999999999999
r295 n175 n180 12.800000000000001
r296 n179 n180 10.24
r297 n176 n181 192
r298 n180 n181 10.24
r299 n181 n182 11.199999999999999
r300 n182 n183 13.76
r301 n177 n184 27.52
r302 n178 n185 8.3393939393939398
r303 n184 n185 11.965217391304348
r304 n179 n186 137.59999999999999
r305 n185 n186 9.7391304347826093
r306 n180 n187 9.1733333333333338
r307 n186 n187 8.9043478260869566
r308 n181 n188 137.59999999999999
r309 n187 n188 8.9043478260869566
r310 n182 n189 8.3393939393939398
r311 n188 n189 9.7391304347826093
r312 n183 n190 27.52
r313 n189 n190 11.965217391304348
r314 n184 n191 16
r315 n185 n192 4.8484848484848486
r316 n191 n192 137.59999999999999
r317 n186 n193 80
r318 n192 n193 112
r319 n187 n194 5.333333333333333
r320 n193 n194 102.40000000000001
r321 n188 n195 80
r322 n194 n195 102.40000000000001
r323 n189 n196 4.8484848484848486
r324 n195 n196 112
r325 n190 n197 16
r326 n196 n197 137.59999999999999
r327 n191 n198 20.48
r328 n192 n199 6.2060606060606061
r329 n198 n199 9.1733333333333338
r330 n193 n200 102.40000000000001
r331 n199 n200 7.4666666666666668
r332 n194 n201 6.8266666666666671
r333 n200 n201 6.8266666666666671
r334 n195 n202 102.40000000000001
r335 n201 n202 6.8266666666666671
r336 n196 n203 6.2060606060606061
r337 n202 n203 7.4666666666666668
r338 n197 n204 20.48
r339 n203 n204 9.1733333333333338
r340 n198 n205 20.48
r341 n199 n206 6.2060606060606061
r342 n205 n206 137.59999999999999
r343 n200 n207 102.40000000000001
r344 n206 n207 112
r345 n201 n208 6.8266666666666671
r346 n207 n208 102.40000000000001
r347 n202 n209 102.40000000000001
r348 n208 n209 102.40000000000001
r349 n203 n210 6.2060606060606061
r350 n209 n210 112
r351 n204 n211 20.48
r352 n210 n211 137.59999999999999
r353 n205 n212 16
r354 n206 n213 4.8484848484848486
r355 n212 n213 11.965217391304348
r356 n207 n214 80
r357 n213 n214 9.7391304347826093
r358 n208 n215 5.333333333333333
r359 n214 n215 8.9043478260869566
r360 n209 n216 80
r361 n215 n216 8.9043478260869566
r362 n210 n217 4.8484848484848486
r363 n216 n217 9.7391304347826093
r364 n211 n218 16
r365 n217 n218 11.965217391304348
r366 n212 n219 27.52
r367 n213 n220 8.3393939393939398
r368 n219 n220 13.76
r369 n214 n221 137.59999999999999
r370 n220 n221 11.199999999999999
r371 n215 n222 9.1733333333333338
r372 n221 n222 10.24
r373 n216 n223 137.59999999999999
r374 n222 n223 10.24
r375 n217 n224 8.3393939393939398
r376 n223 n224 11.199999999999999
r377 n218 n225 27.52
r378 n224 n225 13.76
r379 n226 n227 150.40000000000001
r380 n227 n228 169.59999999999999
r381 n228 n229 131.19999999999999
r382 n229 n230 108.8
r383 n230 n231 108.8
r384 n231 n232 76.799999999999997
r385 n232 n233 86.400000000000006
r386 n233 n234 32
r387 n234 n235 35.200000000000003
r388 n235 n236 19.199999999999999
r389 n236 n237 44.799999999999997
r390 n237 n238 73.599999999999994
r391 n238 n239 48
r392 n239 n240 32
r393 n240 n241 19.199999999999999
r394 n241 n242 12.800000000000001
r395 n242 n243 12.800000000000001
r396 n243 n244 32
r397 n244 n245 60.799999999999997
r398 n245 n246 48
r399 n246 n247 32
r400 n247 n248 19.199999999999999
r401 n248 n249 9.5999999999999996
r402 n249 n250 9.5999999999999996
r403 n250 n251 6.4000000000000004
r404 n251 n252 6.4000000000000004
r405 n252 n253 16
r406 n253 n254 28.800000000000001
r407 n254 n255 19.199999999999999
r408 n255 n256 35.200000000000003
r409 n256 n257 41.600000000000001
r410 n257 n258 28.800000000000001
r411 n258 n259 25.600000000000001
r412 n259 n260 9.5999999999999996
r413 n260 n261 6.4000000000000004
r414 n261 n262 22.399999999999999
r415 n262 n263 35.200000000000003
r416 n263 n264 19.199999999999999
r417 n264 n265 16
r418 n265 n266 28.800000000000001
r419 n266 n267 25.600000000000001
r420 n267 n268 32
r421 n268 n269 41.600000000000001
r422 n269 n270 51.200000000000003
r423 n270 n271 44.799999999999997
r424 n271 n272 35.200000000000003
r425 n272 n273 51.200000000000003
r426 n273 n274 41.600000000000001
r427 n274 n275 38.399999999999999
r428 n275 n276 41.600000000000001
r429 n276 n277 35.200000000000003
r430 n277 n278 25.600000000000001
r431 n278 n279 60.799999999999997
r432 n279 n280 96
r433 n280 n281 48
r434 n281 n282 12.800000000000001
r435 n282 n283 19.199999999999999
r436 n283 n284 28.800000000000001
r437 n284 n285 41.600000000000001
r438 n285 n286 38.399999999999999
r439 n286 n287 54.399999999999999
r440 n287 n288 64
r441 n288 n289 108.8
r442 n289 n290 92.799999999999997
r443 n290 n291 22.399999999999999
r444 n291 n292 102.40000000000001
r445 n292 n293 92.799999999999997
r446 n226 n294 6.0235294117647058
r447 n227 n295 15.753846153846155
r448 n294 n295 10.026666666666667
r449 n228 n296 5.1200000000000001
r450 n295 n296 11.306666666666667
r451 n229 n297 204.80000000000001
r452 n296 n297 8.7466666666666661
r453 n230 n298 6.2060606060606061
r454 n297 n298 7.253333333333333
r455 n231 n299 204.80000000000001
r456 n298 n299 7.253333333333333
r457 n232 n300 8.9043478260869566
r458 n299 n300 5.1200000000000001
r459 n233 n301 51.200000000000003
r460 n300 n301 5.7599999999999998
r461 n234 n302 34.133333333333333
r462 n301 n302 2.1333333333333333
r463 n235 n303 40.960000000000001
r464 n302 n303 2.3466666666666667
r465 n236 n304 204.80000000000001
r466 n303 n304 1.28
r467 n237 n305 15.753846153846155
r468 n304 n305 2.9866666666666668
r469 n238 n306 20.48
r470 n305 n306 4.9066666666666663
r471 n239 n307 40.960000000000001
r472 n306 n307 3.2000000000000002
r473 n240 n308 40.960000000000001
r474 n307 n308 2.1333333333333333
r475 n241 n309 204.80000000000001
r476 n308 n309 1.28
r477 n242 n310 68.266666666666666
r478 n309 n310 0.85333333333333339
r479 n243 n311 204.80000000000001
r480 n310 n311 0.85333333333333339
r481 n244 n312 22.755555555555556
r482 n311 n312 2.1333333333333333
r483 n245 n313 20.48
r484 n312 n313 4.0533333333333337
r485 n246 n314 40.960000000000001
r486 n313 n314 3.2000000000000002
r487 n247 n315 40.960000000000001
r488 n314 n315 2.1333333333333333
r489 n248 n316 204.80000000000001
r490 n315 n316 1.28
r491 n249 n317 102.40000000000001
r492 n316 n317 0.64000000000000001
r493 n250 n318 204.80000000000001
r494 n317 n318 0.64000000000000001
r495 n251 n319 204.80000000000001
r496 n318 n319 0.42666666666666669
r497 n252 n320 204.80000000000001
r498 n319 n320 0.42666666666666669
r499 n253 n321 51.200000000000003
r500 n320 n321 1.0666666666666667
r501 n254 n322 40.960000000000001
r502 n321 n322 1.9199999999999999
r503 n255 n323 204.80000000000001
r504 n322 n323 1.28
r505 n256 n324 20.48
r506 n323 n324 2.3466666666666667
r507 n257 n325 68.266666666666666
r508 n324 n325 2.7733333333333334
r509 n258 n326 34.133333333333333
r510 n325 n326 1.9199999999999999
r511 n259 n327 102.40000000000001
r512 n326 n327 1.7066666666666668
r513 n260 n328 204.80000000000001
r514 n327 n328 0.64000000000000001
r515 n261 n329 204.80000000000001
r516 n328 n329 0.42666666666666669
r517 n262 n330 34.133333333333333
r518 n329 n330 1.4933333333333334
r519 n263 n331 40.960000000000001
r520 n330 n331 2.3466666666666667
r521 n264 n332 204.80000000000001
r522 n331 n332 1.28
r523 n265 n333 51.200000000000003
r524 n332 n333 1.0666666666666667
r525 n266 n334 40.960000000000001
r526 n333 n334 1.9199999999999999
r527 n267 n335 68.266666666666666
r528 n334 n335 1.7066666666666668
r529 n268 n336 29.257142857142856
r530 n335 n336 2.1333333333333333
r531 n269 n337 34.133333333333333
r532 n336 n337 2.7733333333333334
r533 n270 n338 20.48
r534 n337 n338 3.4133333333333336
r535 n271 n339 51.200000000000003
r536 n338 n339 2.9866666666666668
r537 n272 n340 29.257142857142856
r538 n339 n340 2.3466666666666667
r539 n273 n341 22.755555555555556
r540 n340 n341 3.4133333333333336
r541 n274 n342 51.200000000000003
r542 n341 n342 2.7733333333333334
r543 n275 n343 25.600000000000001
r544 n342 n343 2.5600000000000001
r545 n276 n344 40.960000000000001
r546 n343 n344 2.7733333333333334
r547 n277 n345 34.133333333333333
r548 n344 n345 2.3466666666666667
r549 n278 n346 102.40000000000001
r550 n345 n346 1.7066666666666668
r551 n279 n347 12.047058823529412
r552 n346 n347 4.0533333333333337
r553 n280 n348 15.753846153846155
r554 n347 n348 6.4000000000000004
r555 n281 n349 102.40000000000001
r556 n348 n349 3.2000000000000002
r557 n282 n350 102.40000000000001
r558 n349 n350 0.85333333333333339
r559 n283 n351 51.200000000000003
r560 n350 n351 1.28
r561 n284 n352 40.960000000000001
r562 n351 n352 1.9199999999999999
r563 n285 n353 25.600000000000001
r564 n352 n353 2.7733333333333334
r565 n286 n354 51.200000000000003
r566 n353 n354 2.5600000000000001
r567 n287 n355 15.753846153846155
r568 n354 n355 3.6266666666666665
r569 n288 n356 29.257142857142856
r570 n355 n356 4.2666666666666666
r571 n289 n357 7.5851851851851855
r572 n356 n357 7.253333333333333
r573 n290 n358 102.40000000000001
r574 n357 n358 6.1866666666666665
r575 n291 n359 40.960000000000001
r576 n358 n359 1.4933333333333334
r577 n292 n360 7.5851851851851855
r578 n359 n360 6.8266666666666671
r579 n293 n361 102.40000000000001
r580 n360 n361 6.1866666666666665
r581 n294 n362 6.0235294117647058
r582 n295 n363 15.753846153846155
r583 n362 n363 150.40000000000001
r584 n296 n364 5.1200000000000001
r585 n363 n364 169.59999999999999
r586 n297 n365 204.80000000000001
r587 n364 n365 131.19999999999999
r588 n298 n366 6.2060606060606061
r589 n365 n366 108.8
r590 n299 n367 204.80000000000001
r591 n366 n367 108.8
r592 n300 n368 8.9043478260869566
r593 n367 n368 76.799999999999997
r594 n301 n369 51.200000000000003
r595 n368 n369 86.400000000000006
r596 n302 n370 34.133333333333333
r597 n369 n370 32
r598 n303 n371 40.960000000000001
r599 n370 n371 35.200000000000003
r600 n304 n372 204.80000000000001
r601 n371 n372 19.199999999999999
r602 n305 n373 15.753846153846155
r603 n372 n373 44.799999999999997
r604 n306 n374 20.48
r605 n373 n374 73.599999999999994
r606 n307 n375 40.960000000000001
r607 n374 n375 48
r608 n308 n376 40.960000000000001
r609 n375 n376 32
r610 n309 n377 204.80000000000001
r611 n376 n377 19.199999999999999
r612 n310 n378 68.266666666666666
r613 n377 n378 12.800000000000001
r614 n311 n379 204.80000000000001
r615 n378 n379 12.800000000000001
r616 n312 n380 22.755555555555556
r617 n379 n380 32
r618 n313 n381 20.48
r619 n380 n381 60.799999999999997
r620 n314 n382 40.960000000000001
r621 n381 n382 48
r622 n315 n383 40.960000000000001
r623 n382 n383 32
r624 n316 n384 204.80000000000001
r625 n383 n384 19.199999999999999
r626 n317 n385 102.40000000000001
r627 n384 n385 9.5999999999999996
r628 n318 n386 204.80000000000001
r629 n385 n386 9.5999999999999996
r630 n319 n387 204.80000000000001
r631 n386 n387 6.4000000000000004
r632 n320 n388 204.80000000000001
r633 n387 n388 6.4000000000000004
r634 n321 n389 51.200000000000003
r635 n388 n389 16
r636 n322 n390 40.960000000000001
r637 n389 n390 28.800000000000001
r638 n323 n391 204.80000000000001
r639 n390 n391 19.199999999999999
r640 n324 n392 20.48
r641 n391 n392 35.200000000000003
r642 n325 n393 68.266666666666666
r643 n392 n393 41.600000000000001
r644 n326 n394 34.133333333333333
r645 n393 n394 28.800000000000001
r646 n327 n395 102.40000000000001
r647 n394 n395 25.600000000000001
r648 n328 n396 204.80000000000001
r649 n395 n396 9.5999999999999996
r650 n329 n397 204.80000000000001
r651 n396 n397 6.4000000000000004
r652 n330 n398 34.133333333333333
r653 n397 n398 22.399999999999999
r654 n331 n399 40.960000000000001
r655 n398 n399 35.200000000000003
r656 n332 n400 204.80000000000001
r657 n399 n400 19.199999999999999
r658 n333 n401 51.200000000000003
r659 n400 n401 16
r660 n334 n402 40.960000000000001
r661 n401 n402 28.800000000000001
r662 n335 n403 68.266666666666666
r663 n402 n403 25.600000000000001
r664 n336 n404 29.257142857142856
r665 n403 n404 32
r666 n337 n405 34.133333333333333
r667 n404 n405 41.600000000000001
r668 n338 n406 20.48
r669 n405 n406 51.200000000000003
r670 n339 n407 51.200000000000003
r671 n406 n407 44.799999999999997
r672 n340 n408 29.257142857142856
r673 n407 n408 35.200000000000003
r674 n341 n409 22.755555555555556
r675 n408 n409 51.200000000000003
r676 n342 n410 51.200000000000003
r677 n409 n410 41.600000000000001
r678 n343 n411 25.600000000000001
r679 n410 n411 38.399999999999999
r680 n344 n412 40.960000000000001
r681 n411 n412 41.600000000000001
r682 n345 n413 34.133333333333333
r683 n412 n413 35.200000000000003
r684 n346 n414 102.40000000000001
r685 n413 n414 25.600000000000001
r686 n347 n415 12.047058823529412
r687 n414 n415 60.799999999999997
r688 n348 n416 15.753846153846155
r689 n415 n416 96
r690 n349 n417 102.40000000000001
r691 n416 n417 48
r692 n350 n418 102.40000000000001
r693 n417 n418 12.800000000000001
r694 n351 n419 51.200000000000003
r695 n418 n419 19.199999999999999
r696 n352 n420 40.960000000000001
r697 n419 n420 28.800000000000001
r698 n353 n421 25.600000000000001
r699 n420 n421 41.600000000000001
r700 n354 n422 51.200000000000003
r701 n421 n422 38.399999999999999
r702 n355 n423 15.753846153846155
r703 n422 n423 54.399999999999999
r704 n356 n424 29.257142857142856
r705 n423 n424 64
r706 n357 n425 7.5851851851851855
r707 n424 n425 108.8
r708 n358 n426 102.40000000000001
r709 n425 n426 92.799999999999997
r710 n359 n427 40.960000000000001
r711 n426 n427 22.399999999999999
r712 n360 n428 7.5851851851851855
r713 n427 n428 102.40000000000001
r714 n361 n429 102.40000000000001
r715 n428 n429 92.799999999999997
r716 n362 n430 2.447058823529412
r717 n427 n431 16.640000000000001
r718 n428 n432 3.0814814814814815
r719 n431 n432 18.618181818181817
r720 n429 n433 41.600000000000001
r721 n432 n433 16.872727272727271
r722 n430 n434 2.447058823529412
r723 n431 n435 16.640000000000001
r724 n432 n436 3.0814814814814815
r725 n435 n436 102.40000000000001
r726 n433 n437 41.600000000000001
r727 n436 n437 92.799999999999997
r728 n434 n438 6.9647058823529413
r729 n435 n439 47.359999999999999
r730 n436 n440 8.7703703703703706
r731 n439 n440 5.8514285714285714
r732 n437 n441 118.40000000000001
r733 n440 n441 5.3028571428571425
r734 n438 n442 12.988235294117647
r735 n439 n443 88.319999999999993
r736 n440 n444 16.355555555555554
r737 n443 n444 6.0235294117647058
r738 n441 n445 220.80000000000001
r739 n444 n445 5.4588235294117649
r740 n442 n446 7.7176470588235295
r741 n443 n447 52.479999999999997
r742 n444 n448 9.7185185185185183
r743 n447 n448 29.257142857142856
r744 n445 n449 131.19999999999999
r745 n448 n449 26.514285714285716
r746 n446 n450 1.6941176470588235
r747 n447 n451 11.52
r748 n448 n452 2.1333333333333333
r749 n451 n452 102.40000000000001
r750 n449 n453 28.800000000000001
r751 n452 n453 92.799999999999997
r752 n450 n454 1.3176470588235294
r753 n451 n455 8.9600000000000009
r754 n452 n456 1.6592592592592592
r755 n455 n456 40.960000000000001
r756 n453 n457 22.399999999999999
r757 n456 n457 37.119999999999997
r758 n454 n458 2.0705882352941178
r759 n455 n459 14.08
r760 n456 n460 2.6074074074074076
r761 n459 n460 34.133333333333333
r762 n457 n461 35.200000000000003
r763 n460 n461 30.933333333333334
r764 n458 n462 1.5058823529411764
r765 n463 n464 32
r766 n464 n465 35.200000000000003
r767 n465 n466 19.199999999999999
r768 n466 n467 44.799999999999997
r769 n467 n468 73.599999999999994
r770 n468 n469 48
r771 n469 n470 32
r772 n470 n471 19.199999999999999
r773 n471 n472 12.800000000000001
r774 n472 n473 12.800000000000001
r775 n473 n474 32
r776 n474 n475 60.799999999999997
r777 n475 n476 48
r778 n476 n477 32
r779 n477 n478 19.199999999999999
r780 n478 n479 9.5999999999999996
r781 n479 n480 9.5999999999999996
r782 n480 n481 6.4000000000000004
r783 n481 n482 6.4000000000000004
r784 n482 n483 16
r785 n483 n484 28.800000000000001
r786 n484 n485 19.199999999999999
r787 n485 n486 35.200000000000003
r788 n486 n487 41.600000000000001
r789 n487 n488 28.800000000000001
r790 n488 n489 25.600000000000001
r791 n489 n490 9.5999999999999996
r792 n490 n491 6.4000000000000004
r793 n491 n492 22.399999999999999
r794 n492 n493 35.200000000000003
r795 n493 n494 19.199999999999999
r796 n494 n495 16
r797 n459 n496 10.24
r798 n460 n497 1.8962962962962964
r799 n496 n497 102.40000000000001
r800 n461 n498 25.600000000000001
r801 n497 n498 92.799999999999997
r802 n462 n499 3.388235294117647
r803 n463 n500 28.800000000000001
r804 n464 n501 19.199999999999999
r805 n500 n501 4
r806 n465 n502 23.039999999999999
r807 n501 n502 4.4000000000000004
r808 n466 n503 115.2
r809 n502 n503 2.3999999999999999
r810 n467 n504 8.861538461538462
r811 n503 n504 5.5999999999999996
r812 n468 n505 11.52
r813 n504 n505 9.1999999999999993
r814 n469 n506 23.039999999999999
r815 n505 n506 6
r816 n470 n507 23.039999999999999
r817 n506 n507 4
r818 n471 n508 115.2
r819 n507 n508 2.3999999999999999
r820 n472 n509 38.399999999999999
r821 n508 n509 1.6000000000000001
r822 n473 n510 115.2
r823 n509 n510 1.6000000000000001
r824 n474 n511 12.800000000000001
r825 n510 n511 4
r826 n475 n512 11.52
r827 n511 n512 7.5999999999999996
r828 n476 n513 23.039999999999999
r829 n512 n513 6
r830 n477 n514 23.039999999999999
r831 n513 n514 4
r832 n478 n515 115.2
r833 n514 n515 2.3999999999999999
r834 n479 n516 57.600000000000001
r835 n515 n516 1.2
r836 n480 n517 115.2
r837 n516 n517 1.2
r838 n481 n518 115.2
r839 n517 n518 0.80000000000000004
r840 n482 n519 115.2
r841 n518 n519 0.80000000000000004
r842 n483 n520 28.800000000000001
r843 n519 n520 2
r844 n484 n521 23.039999999999999
r845 n520 n521 3.6000000000000001
r846 n485 n522 115.2
r847 n521 n522 2.3999999999999999
r848 n486 n523 11.52
r849 n522 n523 4.4000000000000004
r850 n487 n524 38.399999999999999
r851 n523 n524 5.2000000000000002
r852 n488 n525 19.199999999999999
r853 n524 n525 3.6000000000000001
r854 n489 n526 57.600000000000001
r855 n525 n526 3.2000000000000002
r856 n490 n527 115.2
r857 n526 n527 1.2
r858 n491 n528 115.2
r859 n527 n528 0.80000000000000004
r860 n492 n529 19.199999999999999
r861 n528 n529 2.7999999999999998
r862 n493 n530 23.039999999999999
r863 n529 n530 4.4000000000000004
r864 n494 n531 115.2
r865 n530 n531 2.3999999999999999
r866 n495 n532 28.800000000000001
r867 n531 n532 2
r868 n496 n533 23.039999999999999
r869 n497 n534 4.2666666666666666
r870 n533 n534 12.800000000000001
r871 n498 n535 57.600000000000001
r872 n534 n535 11.6
r873 n499 n536 5.6470588235294121
r874 n500 n537 48
r875 n501 n538 32
r876 n537 n538 4.5714285714285712
r877 n502 n539 38.399999999999999
r878 n538 n539 5.0285714285714285
r879 n503 n540 192
r880 n539 n540 2.7428571428571429
r881 n504 n541 14.76923076923077
r882 n540 n541 6.4000000000000004
r883 n505 n542 19.199999999999999
r884 n541 n542 10.514285714285714
r885 n506 n543 38.399999999999999
r886 n542 n543 6.8571428571428568
r887 n507 n544 38.399999999999999
r888 n543 n544 4.5714285714285712
r889 n508 n545 192
r890 n544 n545 2.7428571428571429
r891 n509 n546 64
r892 n545 n546 1.8285714285714285
r893 n510 n547 192
r894 n546 n547 1.8285714285714285
r895 n511 n548 21.333333333333332
r896 n547 n548 4.5714285714285712
r897 n512 n549 19.199999999999999
r898 n548 n549 8.6857142857142851
r899 n513 n550 38.399999999999999
r900 n549 n550 6.8571428571428568
r901 n514 n551 38.399999999999999
r902 n550 n551 4.5714285714285712
r903 n515 n552 192
r904 n551 n552 2.7428571428571429
r905 n516 n553 96
r906 n552 n553 1.3714285714285714
r907 n517 n554 192
r908 n553 n554 1.3714285714285714
r909 n518 n555 192
r910 n554 n555 0.91428571428571426
r911 n519 n556 192
r912 n555 n556 0.91428571428571426
r913 n520 n557 48
r914 n556 n557 2.2857142857142856
r915 n521 n558 38.399999999999999
r916 n557 n558 4.1142857142857139
r917 n522 n559 192
r918 n558 n559 2.7428571428571429
r919 n523 n560 19.199999999999999
r920 n559 n560 5.0285714285714285
r921 n524 n561 64
r922 n560 n561 5.9428571428571431
r923 n525 n562 32
r924 n561 n562 4.1142857142857139
r925 n526 n563 96
r926 n562 n563 3.657142857142857
r927 n527 n564 192
r928 n563 n564 1.3714285714285714
r929 n528 n565 192
r930 n564 n565 0.91428571428571426
r931 n529 n566 32
r932 n565 n566 3.2000000000000002
r933 n530 n567 38.399999999999999
r934 n566 n567 5.0285714285714285
r935 n531 n568 192
r936 n567 n568 2.7428571428571429
r937 n532 n569 48
r938 n568 n569 2.2857142857142856
r939 n533 n570 38.399999999999999
r940 n534 n571 7.1111111111111107
r941 n570 n571 14.628571428571428
r942 n535 n572 96
r943 n571 n572 13.257142857142858
r944 n536 n573 3.0117647058823529
r945 n537 n574 25.600000000000001
r946 n538 n575 17.066666666666666
r947 n574 n575 32
r948 n539 n576 20.48
r949 n575 n576 35.200000000000003
r950 n540 n577 102.40000000000001
r951 n576 n577 19.199999999999999
r952 n541 n578 7.8769230769230774
r953 n577 n578 44.799999999999997
r954 n542 n579 10.24
r955 n578 n579 73.599999999999994
r956 n543 n580 20.48
r957 n579 n580 48
r958 n544 n581 20.48
r959 n580 n581 32
r960 n545 n582 102.40000000000001
r961 n581 n582 19.199999999999999
r962 n546 n583 34.133333333333333
r963 n582 n583 12.800000000000001
r964 n547 n584 102.40000000000001
r965 n583 n584 12.800000000000001
r966 n548 n585 11.377777777777778
r967 n584 n585 32
r968 n549 n586 10.24
r969 n585 n586 60.799999999999997
r970 n550 n587 20.48
r971 n586 n587 48
r972 n551 n588 20.48
r973 n587 n588 32
r974 n552 n589 102.40000000000001
r975 n588 n589 19.199999999999999
r976 n553 n590 51.200000000000003
r977 n589 n590 9.5999999999999996
r978 n554 n591 102.40000000000001
r979 n590 n591 9.5999999999999996
r980 n555 n592 102.40000000000001
r981 n591 n592 6.4000000000000004
r982 n556 n593 102.40000000000001
r983 n592 n593 6.4000000000000004
r984 n557 n594 25.600000000000001
r985 n593 n594 16
r986 n558 n595 20.48
r987 n594 n595 28.800000000000001
r988 n559 n596 102.40000000000001
r989 n595 n596 19.199999999999999
r990 n560 n597 10.24
r991 n596 n597 35.200000000000003
r992 n561 n598 34.133333333333333
r993 n597 n598 41.600000000000001
r994 n562 n599 17.066666666666666
r995 n598 n599 28.800000000000001
r996 n563 n600 51.200000000000003
r997 n599 n600 25.600000000000001
r998 n564 n601 102.40000000000001
r999 n600 n601 9.5999999999999996
r1000 n565 n602 102.40000000000001
r1001 n601 n602 6.4000000000000004
r1002 n566 n603 17.066666666666666
r1003 n602 n603 22.399999999999999
r1004 n567 n604 20.48
r1005 n603 n604 35.200000000000003
r1006 n568 n605 102.40000000000001
r1007 n604 n605 19.199999999999999
r1008 n569 n606 25.600000000000001
r1009 n605 n606 16
r1010 n570 n607 20.48
r1011 n571 n608 3.7925925925925927
r1012 n607 n608 102.40000000000001
r1013 n572 n609 51.200000000000003
r1014 n608 n609 92.799999999999997
r1015 n573 n610 1.1294117647058823
r1016 n607 n611 7.6799999999999997
r1017 n608 n612 1.4222222222222223
r1018 n611 n612 51.200000000000003
r1019 n609 n613 19.199999999999999
r1020 n612 n613 46.399999999999999
r1021 n610 n614 1.1294117647058823
r1022 n615 n616 60.799999999999997
r1023 n616 n617 96
r1024 n617 n618 48
r1025 n611 n619 7.6799999999999997
r1026 n612 n620 1.4222222222222223
r1027 n619 n620 102.40000000000001
r1028 n613 n621 19.199999999999999
r1029 n620 n621 92.799999999999997
r1030 n614 n622 0.56470588235294117
r1031 n615 n623 9.5999999999999996
r1032 n616 n624 1.1294117647058823
r1033 n623 n624 121.59999999999999
r1034 n617 n625 1.476923076923077
r1035 n624 n625 192
r1036 n618 n626 9.5999999999999996
r1037 n625 n626 96
r1038 n619 n627 3.8399999999999999
r1039 n620 n628 0.71111111111111114
r1040 n627 n628 204.80000000000001
r1041 n621 n629 9.5999999999999996
r1042 n628 n629 185.59999999999999
r1043 n622 n630 0.94117647058823528
r1044 n623 n631 16
r1045 n624 n632 1.8823529411764706
r1046 n631 n632 30.399999999999999
r1047 n625 n633 2.4615384615384617
r1048 n632 n633 48
r1049 n626 n634 16
r1050 n633 n634 24
r1051 n627 n635 6.4000000000000004
r1052 n628 n636 1.1851851851851851
r1053 n635 n636 51.200000000000003
r1054 n629 n637 16
r1055 n636 n637 46.399999999999999
r1056 n630 n638 1.1294117647058823
r1057 n631 n639 19.199999999999999
r1058 n632 n640 2.2588235294117647
r1059 n639 n640 60.799999999999997
r1060 n633 n641 2.953846153846154
r1061 n640 n641 96
r1062 n634 n642 19.199999999999999
r1063 n641 n642 48
r1064 n635 n643 7.6799999999999997
r1065 n636 n644 1.4222222222222223
r1066 n643 n644 102.40000000000001
r1067 n637 n645 19.199999999999999
r1068 n644 n645 92.799999999999997
r1069 n638 n646 1.3176470588235294
r1070 n639 n647 22.399999999999999
r1071 n640 n648 2.6352941176470588
r1072 n647 n648 24.32
r1073 n641 n649 3.4461538461538463
r1074 n648 n649 38.399999999999999
r1075 n642 n650 22.399999999999999
r1076 n649 n650 19.199999999999999
r1077 n643 n651 8.9600000000000009
r1078 n644 n652 1.6592592592592592
r1079 n651 n652 40.960000000000001
r1080 n645 n653 22.399999999999999
r1081 n652 n653 37.119999999999997
r1082 n646 n654 1.3176470588235294
r1083 n647 n655 22.399999999999999
r1084 n648 n656 2.6352941176470588
r1085 n655 n656 60.799999999999997
r1086 n649 n657 3.4461538461538463
r1087 n656 n657 96
r1088 n650 n658 22.399999999999999
r1089 n657 n658 48
r1090 n651 n659 8.9600000000000009
r1091 n652 n660 1.6592592592592592
r1092 n659 n660 102.40000000000001
r1093 n653 n661 22.399999999999999
r1094 n660 n661 92.799999999999997
r1095 n654 n662 0.75294117647058822
r1096 n655 n663 12.800000000000001
r1097 n656 n664 1.5058823529411764
r1098 n663 n664 60.799999999999997
r1099 n657 n665 1.9692307692307693
r1100 n664 n665 96
r1101 n658 n666 12.800000000000001
r1102 n665 n666 48
r1103 n659 n667 5.1200000000000001
r1104 n660 n668 0.94814814814814818
r1105 n667 n668 102.40000000000001
r1106 n661 n669 12.800000000000001
r1107 n668 n669 92.799999999999997
r1108 n662 n670 5.6470588235294121
r1109 n663 n671 96
r1110 n664 n672 11.294117647058824
r1111 n671 n672 4.3428571428571425
r1112 n665 n673 14.76923076923077
r1113 n672 n673 6.8571428571428568
r1114 n666 n674 96
r1115 n673 n674 3.4285714285714284
r1116 n667 n675 38.399999999999999
r1117 n668 n676 7.1111111111111107
r1118 n675 n676 7.3142857142857141
r1119 n669 n677 96
r1120 n676 n677 6.628571428571429
r1121 n670 n678 5.6470588235294121
r1122 n671 n679 96
r1123 n672 n680 11.294117647058824
r1124 n679 n680 60.799999999999997
r1125 n673 n681 14.76923076923077
r1126 n680 n681 96
r1127 n674 n682 96
r1128 n681 n682 48
r1129 n675 n683 38.399999999999999
r1130 n676 n684 7.1111111111111107
r1131 n683 n684 102.40000000000001
r1132 n677 n685 96
r1133 n684 n685 92.799999999999997
r1134 n678 n686 0.75294117647058822
r1135 n679 n687 12.800000000000001
r1136 n680 n688 1.5058823529411764
r1137 n687 n688 60.799999999999997
r1138 n681 n689 1.9692307692307693
r1139 n688 n689 96
r1140 n682 n690 12.800000000000001
r1141 n689 n690 48
r1142 n683 n691 5.1200000000000001
r1143 n684 n692 0.94814814814814818
r1144 n691 n692 102.40000000000001
r1145 n685 n693 12.800000000000001
r1146 n692 n693 92.799999999999997
r1147 n686 n694 0.75294117647058822
r1148 n687 n695 12.800000000000001
r1149 n688 n696 1.5058823529411764
r1150 n695 n696 60.799999999999997
r1151 n689 n697 1.9692307692307693
r1152 n696 n697 96
r1153 n690 n698 12.800000000000001
r1154 n697 n698 48
r1155 n691 n699 5.1200000000000001
r1156 n692 n700 0.94814814814814818
r1157 n699 n700 102.40000000000001
r1158 n693 n701 12.800000000000001
r1159 n700 n701 92.799999999999997
r1160 n694 n702 1.1294117647058823
r1161 n695 n703 19.199999999999999
r1162 n696 n704 2.2588235294117647
r1163 n703 n704 30.399999999999999
r1164 n697 n705 2.953846153846154
r1165 n704 n705 48
r1166 n698 n706 19.199999999999999
r1167 n705 n706 24
r1168 n699 n707 7.6799999999999997
r1169 n700 n708 1.4222222222222223
r1170 n707 n708 51.200000000000003
r1171 n701 n709 19.199999999999999
r1172 n708 n709 46.399999999999999
r1173 n702 n710 2.0705882352941178
r1174 n703 n711 35.200000000000003
r1175 n704 n712 4.1411764705882357
r1176 n711 n712 17.37142857142857
r1177 n705 n713 5.4153846153846157
r1178 n712 n713 27.428571428571427
r1179 n706 n714 35.200000000000003
r1180 n713 n714 13.714285714285714
r1181 n707 n715 14.08
r1182 n708 n716 2.6074074074074076
r1183 n715 n716 29.257142857142856
r1184 n709 n717 35.200000000000003
r1185 n716 n717 26.514285714285716
r1186 n710 n718 1.8823529411764706
r1187 n711 n719 32
r1188 n712 n720 3.7647058823529411
r1189 n719 n720 40.533333333333331
r1190 n713 n721 4.9230769230769234
r1191 n720 n721 64
r1192 n714 n722 32
r1193 n721 n722 32
r1194 n715 n723 12.800000000000001
r1195 n716 n724 2.3703703703703702
r1196 n723 n724 68.266666666666666
r1197 n717 n725 32
r1198 n724 n725 61.866666666666667
r1199 n718 n726 1.1294117647058823
r1200 n723 n727 7.6799999999999997
r1201 n724 n728 1.4222222222222223
r1202 n727 n728 68.266666666666666
r1203 n725 n729 19.199999999999999
r1204 n728 n729 61.866666666666667
r1205 n726 n730 0.94117647058823528
r1206 n731 n732 32
r1207 n732 n733 35.200000000000003
r1208 n733 n734 19.199999999999999
r1209 n734 n735 44.799999999999997
r1210 n735 n736 73.599999999999994
r1211 n736 n737 48
r1212 n737 n738 32
r1213 n738 n739 19.199999999999999
r1214 n739 n740 12.800000000000001
r1215 n740 n741 12.800000000000001
r1216 n741 n742 32
r1217 n742 n743 60.799999999999997
r1218 n743 n744 48
r1219 n744 n745 32
r1220 n745 n746 19.199999999999999
r1221 n746 n747 9.5999999999999996
r1222 n747 n748 9.5999999999999996
r1223 n748 n749 6.4000000000000004
r1224 n749 n750 6.4000000000000004
r1225 n750 n751 16
r1226 n751 n752 28.800000000000001
r1227 n752 n753 19.199999999999999
r1228 n753 n754 35.200000000000003
r1229 n754 n755 41.600000000000001
r1230 n755 n756 28.800000000000001
r1231 n756 n757 25.600000000000001
r1232 n757 n758 9.5999999999999996
r1233 n758 n759 6.4000000000000004
r1234 n759 n760 22.399999999999999
r1235 n760 n761 35.200000000000003
r1236 n761 n762 19.199999999999999
r1237 n762 n763 16
r1238 n727 n764 6.4000000000000004
r1239 n728 n765 1.1851851851851851
r1240 n764 n765 102.40000000000001
r1241 n729 n766 16
r1242 n765 n766 92.799999999999997
r1243 n730 n767 3.2000000000000002
r1244 n731 n768 27.199999999999999
r1245 n732 n769 18.133333333333333
r1246 n768 n769 4.2666666666666666
r1247 n733 n770 21.760000000000002
r1248 n769 n770 4.6933333333333334
r1249 n734 n771 108.8
r1250 n770 n771 2.5600000000000001
r1251 n735 n772 8.3692307692307697
r1252 n771 n772 5.9733333333333336
r1253 n736 n773 10.880000000000001
r1254 n772 n773 9.8133333333333326
r1255 n737 n774 21.760000000000002
r1256 n773 n774 6.4000000000000004
r1257 n738 n775 21.760000000000002
r1258 n774 n775 4.2666666666666666
r1259 n739 n776 108.8
r1260 n775 n776 2.5600000000000001
r1261 n740 n777 36.266666666666666
r1262 n776 n777 1.7066666666666668
r1263 n741 n778 108.8
r1264 n777 n778 1.7066666666666668
r1265 n742 n779 12.088888888888889
r1266 n778 n779 4.2666666666666666
r1267 n743 n780 10.880000000000001
r1268 n779 n780 8.1066666666666674
r1269 n744 n781 21.760000000000002
r1270 n780 n781 6.4000000000000004
r1271 n745 n782 21.760000000000002
r1272 n781 n782 4.2666666666666666
r1273 n746 n783 108.8
r1274 n782 n783 2.5600000000000001
r1275 n747 n784 54.399999999999999
r1276 n783 n784 1.28
r1277 n748 n785 108.8
r1278 n784 n785 1.28
r1279 n749 n786 108.8
r1280 n785 n786 0.85333333333333339
r1281 n750 n787 108.8
r1282 n786 n787 0.85333333333333339
r1283 n751 n788 27.199999999999999
r1284 n787 n788 2.1333333333333333
r1285 n752 n789 21.760000000000002
r1286 n788 n789 3.8399999999999999
r1287 n753 n790 108.8
r1288 n789 n790 2.5600000000000001
r1289 n754 n791 10.880000000000001
r1290 n790 n791 4.6933333333333334
r1291 n755 n792 36.266666666666666
r1292 n791 n792 5.5466666666666669
r1293 n756 n793 18.133333333333333
r1294 n792 n793 3.8399999999999999
r1295 n757 n794 54.399999999999999
r1296 n793 n794 3.4133333333333336
r1297 n758 n795 108.8
r1298 n794 n795 1.28
r1299 n759 n796 108.8
r1300 n795 n796 0.85333333333333339
r1301 n760 n797 18.133333333333333
r1302 n796 n797 2.9866666666666668
r1303 n761 n798 21.760000000000002
r1304 n797 n798 4.6933333333333334
r1305 n762 n799 108.8
r1306 n798 n799 2.5600000000000001
r1307 n763 n800 27.199999999999999
r1308 n799 n800 2.1333333333333333
r1309 n764 n801 21.760000000000002
r1310 n765 n802 4.0296296296296292
r1311 n801 n802 13.653333333333334
r1312 n766 n803 54.399999999999999
r1313 n802 n803 12.373333333333333
r1314 n767 n804 5.6470588235294121
r1315 n768 n805 48
r1316 n769 n806 32
r1317 n805 n806 4.2666666666666666
r1318 n770 n807 38.399999999999999
r1319 n806 n807 4.6933333333333334
r1320 n771 n808 192
r1321 n807 n808 2.5600000000000001
r1322 n772 n809 14.76923076923077
r1323 n808 n809 5.9733333333333336
r1324 n773 n810 19.199999999999999
r1325 n809 n810 9.8133333333333326
r1326 n774 n811 38.399999999999999
r1327 n810 n811 6.4000000000000004
r1328 n775 n812 38.399999999999999
r1329 n811 n812 4.2666666666666666
r1330 n776 n813 192
r1331 n812 n813 2.5600000000000001
r1332 n777 n814 64
r1333 n813 n814 1.7066666666666668
r1334 n778 n815 192
r1335 n814 n815 1.7066666666666668
r1336 n779 n816 21.333333333333332
r1337 n815 n816 4.2666666666666666
r1338 n780 n817 19.199999999999999
r1339 n816 n817 8.1066666666666674
r1340 n781 n818 38.399999999999999
r1341 n817 n818 6.4000000000000004
r1342 n782 n819 38.399999999999999
r1343 n818 n819 4.2666666666666666
r1344 n783 n820 192
r1345 n819 n820 2.5600000000000001
r1346 n784 n821 96
r1347 n820 n821 1.28
r1348 n785 n822 192
r1349 n821 n822 1.28
r1350 n786 n823 192
r1351 n822 n823 0.85333333333333339
r1352 n787 n824 192
r1353 n823 n824 0.85333333333333339
r1354 n788 n825 48
r1355 n824 n825 2.1333333333333333
r1356 n789 n826 38.399999999999999
r1357 n825 n826 3.8399999999999999
r1358 n790 n827 192
r1359 n826 n827 2.5600000000000001
r1360 n791 n828 19.199999999999999
r1361 n827 n828 4.6933333333333334
r1362 n792 n829 64
r1363 n828 n829 5.5466666666666669
r1364 n793 n830 32
r1365 n829 n830 3.8399999999999999
r1366 n794 n831 96
r1367 n830 n831 3.4133333333333336
r1368 n795 n832 192
r1369 n831 n832 1.28
r1370 n796 n833 192
r1371 n832 n833 0.85333333333333339
r1372 n797 n834 32
r1373 n833 n834 2.9866666666666668
r1374 n798 n835 38.399999999999999
r1375 n834 n835 4.6933333333333334
r1376 n799 n836 192
r1377 n835 n836 2.5600000000000001
r1378 n800 n837 48
r1379 n836 n837 2.1333333333333333
r1380 n801 n838 38.399999999999999
r1381 n802 n839 7.1111111111111107
r1382 n838 n839 13.653333333333334
r1383 n803 n840 96
r1384 n839 n840 12.373333333333333
r1385 n804 n841 3.2000000000000002
r1386 n805 n842 27.199999999999999
r1387 n806 n843 18.133333333333333
r1388 n842 n843 32
r1389 n807 n844 21.760000000000002
r1390 n843 n844 35.200000000000003
r1391 n808 n845 108.8
r1392 n844 n845 19.199999999999999
r1393 n809 n846 8.3692307692307697
r1394 n845 n846 44.799999999999997
r1395 n810 n847 10.880000000000001
r1396 n846 n847 73.599999999999994
r1397 n811 n848 21.760000000000002
r1398 n847 n848 48
r1399 n812 n849 21.760000000000002
r1400 n848 n849 32
r1401 n813 n850 108.8
r1402 n849 n850 19.199999999999999
r1403 n814 n851 36.266666666666666
r1404 n850 n851 12.800000000000001
r1405 n815 n852 108.8
r1406 n851 n852 12.800000000000001
r1407 n816 n853 12.088888888888889
r1408 n852 n853 32
r1409 n817 n854 10.880000000000001
r1410 n853 n854 60.799999999999997
r1411 n818 n855 21.760000000000002
r1412 n854 n855 48
r1413 n819 n856 21.760000000000002
r1414 n855 n856 32
r1415 n820 n857 108.8
r1416 n856 n857 19.199999999999999
r1417 n821 n858 54.399999999999999
r1418 n857 n858 9.5999999999999996
r1419 n822 n859 108.8
r1420 n858 n859 9.5999999999999996
r1421 n823 n860 108.8
r1422 n859 n860 6.4000000000000004
r1423 n824 n861 108.8
r1424 n860 n861 6.4000000000000004
r1425 n825 n862 27.199999999999999
r1426 n861 n862 16
r1427 n826 n863 21.760000000000002
r1428 n862 n863 28.800000000000001
r1429 n827 n864 108.8
r1430 n863 n864 19.199999999999999
r1431 n828 n865 10.880000000000001
r1432 n864 n865 35.200000000000003
r1433 n829 n866 36.266666666666666
r1434 n865 n866 41.600000000000001
r1435 n830 n867 18.133333333333333
r1436 n866 n867 28.800000000000001
r1437 n831 n868 54.399999999999999
r1438 n867 n868 25.600000000000001
r1439 n832 n869 108.8
r1440 n868 n869 9.5999999999999996
r1441 n833 n870 108.8
r1442 n869 n870 6.4000000000000004
r1443 n834 n871 18.133333333333333
r1444 n870 n871 22.399999999999999
r1445 n835 n872 21.760000000000002
r1446 n871 n872 35.200000000000003
r1447 n836 n873 108.8
r1448 n872 n873 19.199999999999999
r1449 n837 n874 27.199999999999999
r1450 n873 n874 16
r1451 n838 n875 21.760000000000002
r1452 n839 n876 4.0296296296296292
r1453 n875 n876 102.40000000000001
r1454 n840 n877 54.399999999999999
r1455 n876 n877 92.799999999999997
r1456 n841 n878 0.94117647058823528
r1457 n875 n879 6.4000000000000004
r1458 n876 n880 1.1851851851851851
r1459 n879 n880 68.266666666666666
r1460 n877 n881 16
r1461 n880 n881 61.866666666666667
r1462 n878 n882 1.1294117647058823
r1463 n879 n883 7.6799999999999997
r1464 n880 n884 1.4222222222222223
r1465 n883 n884 68.266666666666666
r1466 n881 n885 19.199999999999999
r1467 n884 n885 61.866666666666667
r1468 n882 n886 1.8823529411764706
r1469 n883 n887 12.800000000000001
r1470 n884 n888 2.3703703703703702
r1471 n887 n888 29.257142857142856
r1472 n885 n889 32
r1473 n888 n889 26.514285714285716
r1474 n886 n890 2.8235294117647061
r1475 n887 n891 19.199999999999999
r1476 n888 n892 3.5555555555555554
r1477 n891 n892 25.600000000000001
r1478 n889 n893 48
r1479 n892 n893 23.199999999999999
r1480 n890 n894 1.8823529411764706
r1481 n891 n895 12.800000000000001
r1482 n892 n896 2.3703703703703702
r1483 n895 n896 102.40000000000001
r1484 n893 n897 32
r1485 n896 n897 92.799999999999997
r1486 n894 n898 6.4000000000000004
r1487 n895 n899 43.520000000000003
r1488 n896 n900 8.0592592592592585
r1489 n899 n900 6.4000000000000004
r1490 n897 n901 108.8
r1491 n900 n901 5.7999999999999998
r1492 n898 n902 14.870588235294118
r1493 n899 n903 101.12
r1494 n900 n904 18.725925925925925
r1495 n903 n904 4.3574468085106384
r1496 n901 n905 252.80000000000001
r1497 n904 n905 3.9489361702127659
r1498 n902 n906 15.247058823529411
r1499 n906 n907 8.8470588235294123
r1500 n907 n908 9.9764705882352942
r1501 n908 n909 7.7176470588235295
r1502 n909 n910 6.4000000000000004
r1503 n910 n911 6.4000000000000004
r1504 n911 n912 4.5176470588235293
r1505 n912 n913 5.0823529411764703
r1506 n913 n914 1.8823529411764706
r1507 n914 n915 2.0705882352941178
r1508 n915 n916 1.1294117647058823
r1509 n916 n917 2.6352941176470588
r1510 n917 n918 4.3294117647058821
r1511 n918 n919 2.8235294117647061
r1512 n919 n920 1.8823529411764706
r1513 n920 n921 1.1294117647058823
r1514 n921 n922 0.75294117647058822
r1515 n922 n923 0.75294117647058822
r1516 n923 n924 1.8823529411764706
r1517 n924 n925 3.5764705882352943
r1518 n925 n926 2.8235294117647061
r1519 n926 n927 1.8823529411764706
r1520 n927 n928 1.1294117647058823
r1521 n928 n929 0.56470588235294117
r1522 n929 n930 0.56470588235294117
r1523 n930 n931 0.37647058823529411
r1524 n931 n932 0.37647058823529411
r1525 n932 n933 0.94117647058823528
r1526 n933 n934 1.6941176470588235
r1527 n934 n935 1.1294117647058823
r1528 n935 n936 2.0705882352941178
r1529 n936 n937 2.447058823529412
r1530 n937 n938 1.6941176470588235
r1531 n938 n939 1.5058823529411764
r1532 n939 n940 0.56470588235294117
r1533 n940 n941 0.37647058823529411
r1534 n941 n942 1.3176470588235294
r1535 n942 n943 2.0705882352941178
r1536 n943 n944 1.1294117647058823
r1537 n944 n945 0.94117647058823528
r1538 n945 n946 1.6941176470588235
r1539 n946 n947 1.5058823529411764
r1540 n947 n948 1.8823529411764706
r1541 n948 n949 2.447058823529412
r1542 n949 n950 3.0117647058823529
r1543 n950 n951 2.6352941176470588
r1544 n951 n952 2.0705882352941178
r1545 n952 n953 3.0117647058823529
r1546 n953 n954 2.447058823529412
r1547 n954 n955 2.2588235294117647
r1548 n955 n956 2.447058823529412
r1549 n956 n957 2.0705882352941178
r1550 n957 n958 1.5058823529411764
r1551 n958 n959 3.5764705882352943
r1552 n959 n960 5.6470588235294121
r1553 n960 n961 2.8235294117647061
r1554 n961 n962 0.75294117647058822
r1555 n962 n963 1.1294117647058823
r1556 n963 n964 1.6941176470588235
r1557 n964 n965 2.447058823529412
r1558 n965 n966 2.2588235294117647
r1559 n966 n967 3.2000000000000002
r1560 n967 n968 3.7647058823529411
r1561 n968 n969 6.4000000000000004
r1562 n969 n970 5.4588235294117649
r1563 n903 n971 103.68000000000001
r1564 n970 n971 1.3176470588235294
r1565 n904 n972 19.199999999999999
r1566 n971 n972 6.0235294117647058
r1567 n905 n973 259.19999999999999
r1568 n972 n973 5.4588235294117649
r1569 n974 n975 196.48000000000002
r1570 n975 n976 176
r1571 n976 n977 197.12
r1572 n977 n978 150.40000000000001
r1573 n978 n979 169.59999999999999
r1574 n979 n980 131.19999999999999
r1575 n980 n981 108.8
r1576 n981 n982 108.8
r1577 n982 n983 76.799999999999997
r1578 n983 n984 86.400000000000006
r1579 n984 n985 32
r1580 n985 n986 35.200000000000003
r1581 n986 n987 19.199999999999999
r1582 n987 n988 44.799999999999997
r1583 n988 n989 73.599999999999994
r1584 n989 n990 48
r1585 n990 n991 32
r1586 n991 n992 19.199999999999999
r1587 n992 n993 12.800000000000001
r1588 n993 n994 12.800000000000001
r1589 n994 n995 32
r1590 n995 n996 60.799999999999997
r1591 n996 n997 48
r1592 n997 n998 32
r1593 n998 n999 19.199999999999999
r1594 n999 n1000 9.5999999999999996
r1595 n1000 n1001 9.5999999999999996
r1596 n1001 n1002 6.4000000000000004
r1597 n1002 n1003 6.4000000000000004
r1598 n1003 n1004 16
r1599 n1004 n1005 28.800000000000001
r1600 n1005 n1006 19.199999999999999
r1601 n1006 n1007 35.200000000000003
r1602 n1007 n1008 41.600000000000001
r1603 n1008 n1009 28.800000000000001
r1604 n1009 n1010 25.600000000000001
r1605 n1010 n1011 9.5999999999999996
r1606 n1011 n1012 6.4000000000000004
r1607 n1012 n1013 22.399999999999999
r1608 n1013 n1014 35.200000000000003
r1609 n1014 n1015 19.199999999999999
r1610 n1015 n1016 16
r1611 n1016 n1017 28.800000000000001
r1612 n1017 n1018 25.600000000000001
r1613 n1018 n1019 32
r1614 n1019 n1020 41.600000000000001
r1615 n1020 n1021 51.200000000000003
r1616 n1021 n1022 44.799999999999997
r1617 n1022 n1023 35.200000000000003
r1618 n1023 n1024 51.200000000000003
r1619 n1024 n1025 41.600000000000001
r1620 n1025 n1026 38.399999999999999
r1621 n1026 n1027 41.600000000000001
r1622 n1027 n1028 35.200000000000003
r1623 n1028 n1029 25.600000000000001
r1624 n1029 n1030 60.799999999999997
r1625 n1030 n1031 96
r1626 n1031 n1032 48
r1627 n1032 n1033 12.800000000000001
r1628 n1033 n1034 19.199999999999999
r1629 n1034 n1035 28.800000000000001
r1630 n1035 n1036 41.600000000000001
r1631 n1036 n1037 38.399999999999999
r1632 n1037 n1038 54.399999999999999
r1633 n1038 n1039 64
r1634 n1039 n1040 108.8
r1635 n1040 n1041 92.799999999999997
r1636 n1041 n1042 22.399999999999999
r1637 n1042 n1043 102.40000000000001
r1638 n1043 n1044 92.799999999999997
r1639 n1044 n1045 108.8
r1640 n1045 n1046 211.19999999999999
r1641 n1046 n1047 217.59999999999999
r1642 n1047 n1048 217.59999999999999
r1643 n1048 n1049 217.59999999999999
r1644 n1049 n1050 217.59999999999999
r1645 n1050 n1051 217.59999999999999
r1646 n1051 n1052 217.59999999999999
r1647 n1052 n1053 217.59999999999999
r1648 n1053 n1054 217.59999999999999
r1649 n1054 n1055 217.59999999999999
r1650 n1055 n1056 217.59999999999999
r1651 n1056 n1057 217.59999999999999
r1652 n1057 n1058 217.59999999999999
r1653 n1058 n1059 217.59999999999999
r1654 n1059 n1060 217.59999999999999
r1655 n1060 n1061 217.59999999999999
r1656 n1061 n1062 217.59999999999999
r1657 n1062 n1063 217.59999999999999
r1658 n1063 n1064 217.59999999999999
r1659 n1064 n1065 217.59999999999999
r1660 n1065 n1066 217.59999999999999
r1661 n1066 n1067 217.59999999999999
r1662 n1067 n1068 144
r1663 n1068 n1069 108.8
r1664 n1069 n1070 80
r1665 n1070 n1071 102.40000000000001
r1666 n1071 n1072 102.40000000000001
r1667 n1072 n1073 80
r1668 n1073 n1074 108.8
r1669 n1074 n1075 144
r1670 n1075 n1076 217.59999999999999
r1671 n1076 n1077 217.59999999999999
r1672 n1077 n1078 217.59999999999999
r1673 n1078 n1079 217.59999999999999
r1674 n1079 n1080 217.59999999999999
r1675 n1080 n1081 217.59999999999999
r1676 n1081 n1082 217.59999999999999
r1677 n1082 n1083 217.59999999999999
r1678 n1083 n1084 217.59999999999999
r1679 n1084 n1085 217.59999999999999
r1680 n1085 n1086 217.59999999999999
r1681 n1086 n1087 217.59999999999999
r1682 n1087 n1088 217.59999999999999
r1683 n1088 n1089 217.59999999999999
r1684 n1089 n1090 217.59999999999999
r1685 n1090 n1091 217.59999999999999
r1686 n1091 n1092 217.59999999999999
r1687 n1092 n1093 217.59999999999999
r1688 n1093 n1094 217.59999999999999
r1689 n1094 n1095 217.59999999999999
r1690 n1095 n1096 217.59999999999999
r1691 n1096 n1097 217.59999999999999
r1692 n1097 n1098 195.19999999999999
r1693 n1098 n1099 108.8
r1694 n1099 n1100 131.19999999999999
r1695 n1100 n1101 217.59999999999999
r1696 n1101 n1102 217.59999999999999
r1697 n1102 n1103 217.59999999999999
r1698 n1103 n1104 195.19999999999999
r1699 n1104 n1105 108.8
r1700 n1105 n1106 80
r1701 n1106 n1107 108.8
r1702 n1107 n1108 96
r1703 n1108 n1109 108.8
r1704 n1109 n1110 80
r1705 n1110 n1111 108.8
r1706 n1111 n1112 201.59999999999999
r1707 n1112 n1113 217.59999999999999
r1708 n1113 n1114 217.59999999999999
r1709 n1114 n1115 236.80000000000001
r1710 n1115 n1116 236.80000000000001
r1711 n1116 n1117 217.59999999999999
r1712 n1117 n1118 217.59999999999999
r1713 n1118 n1119 163.19999999999999
r1714 n1119 n1120 108.8
r1715 n974 n1121 6.0235294117647058
r1716 n975 n1122 7.4744525547445253
r1717 n1121 n1122 13.098666666666668
r1718 n976 n1123 7.4202898550724639
r1719 n1122 n1123 11.733333333333333
r1720 n977 n1124 6.0235294117647058
r1721 n1123 n1124 13.141333333333334
r1722 n978 n1125 15.753846153846155
r1723 n1124 n1125 10.026666666666667
r1724 n979 n1126 5.1200000000000001
r1725 n1125 n1126 11.306666666666667
r1726 n980 n1127 204.80000000000001
r1727 n1126 n1127 8.7466666666666661
r1728 n981 n1128 6.2060606060606061
r1729 n1127 n1128 7.253333333333333
r1730 n982 n1129 204.80000000000001
r1731 n1128 n1129 7.253333333333333
r1732 n983 n1130 8.9043478260869566
r1733 n1129 n1130 5.1200000000000001
r1734 n984 n1131 51.200000000000003
r1735 n1130 n1131 5.7599999999999998
r1736 n985 n1132 34.133333333333333
r1737 n1131 n1132 2.1333333333333333
r1738 n986 n1133 40.960000000000001
r1739 n1132 n1133 2.3466666666666667
r1740 n987 n1134 204.80000000000001
r1741 n1133 n1134 1.28
r1742 n988 n1135 15.753846153846155
r1743 n1134 n1135 2.9866666666666668
r1744 n989 n1136 20.48
r1745 n1135 n1136 4.9066666666666663
r1746 n990 n1137 40.960000000000001
r1747 n1136 n1137 3.2000000000000002
r1748 n991 n1138 40.960000000000001
r1749 n1137 n1138 2.1333333333333333
r1750 n992 n1139 204.80000000000001
r1751 n1138 n1139 1.28
r1752 n993 n1140 68.266666666666666
r1753 n1139 n1140 0.85333333333333339
r1754 n994 n1141 204.80000000000001
r1755 n1140 n1141 0.85333333333333339
r1756 n995 n1142 22.755555555555556
r1757 n1141 n1142 2.1333333333333333
r1758 n996 n1143 20.48
r1759 n1142 n1143 4.0533333333333337
r1760 n997 n1144 40.960000000000001
r1761 n1143 n1144 3.2000000000000002
r1762 n998 n1145 40.960000000000001
r1763 n1144 n1145 2.1333333333333333
r1764 n999 n1146 204.80000000000001
r1765 n1145 n1146 1.28
r1766 n1000 n1147 102.40000000000001
r1767 n1146 n1147 0.64000000000000001
r1768 n1001 n1148 204.80000000000001
r1769 n1147 n1148 0.64000000000000001
r1770 n1002 n1149 204.80000000000001
r1771 n1148 n1149 0.42666666666666669
r1772 n1003 n1150 204.80000000000001
r1773 n1149 n1150 0.42666666666666669
r1774 n1004 n1151 51.200000000000003
r1775 n1150 n1151 1.0666666666666667
r1776 n1005 n1152 40.960000000000001
r1777 n1151 n1152 1.9199999999999999
r1778 n1006 n1153 204.80000000000001
r1779 n1152 n1153 1.28
r1780 n1007 n1154 20.48
r1781 n1153 n1154 2.3466666666666667
r1782 n1008 n1155 68.266666666666666
r1783 n1154 n1155 2.7733333333333334
r1784 n1009 n1156 34.133333333333333
r1785 n1155 n1156 1.9199999999999999
r1786 n1010 n1157 102.40000000000001
r1787 n1156 n1157 1.7066666666666668
r1788 n1011 n1158 204.80000000000001
r1789 n1157 n1158 0.64000000000000001
r1790 n1012 n1159 204.80000000000001
r1791 n1158 n1159 0.42666666666666669
r1792 n1013 n1160 34.133333333333333
r1793 n1159 n1160 1.4933333333333334
r1794 n1014 n1161 40.960000000000001
r1795 n1160 n1161 2.3466666666666667
r1796 n1015 n1162 204.80000000000001
r1797 n1161 n1162 1.28
r1798 n1016 n1163 51.200000000000003
r1799 n1162 n1163 1.0666666666666667
r1800 n1017 n1164 40.960000000000001
r1801 n1163 n1164 1.9199999999999999
r1802 n1018 n1165 68.266666666666666
r1803 n1164 n1165 1.7066666666666668
r1804 n1019 n1166 29.257142857142856
r1805 n1165 n1166 2.1333333333333333
r1806 n1020 n1167 34.133333333333333
r1807 n1166 n1167 2.7733333333333334
r1808 n1021 n1168 20.48
r1809 n1167 n1168 3.4133333333333336
r1810 n1022 n1169 51.200000000000003
r1811 n1168 n1169 2.9866666666666668
r1812 n1023 n1170 29.257142857142856
r1813 n1169 n1170 2.3466666666666667
r1814 n1024 n1171 22.755555555555556
r1815 n1170 n1171 3.4133333333333336
r1816 n1025 n1172 51.200000000000003
r1817 n1171 n1172 2.7733333333333334
r1818 n1026 n1173 25.600000000000001
r1819 n1172 n1173 2.5600000000000001
r1820 n1027 n1174 40.960000000000001
r1821 n1173 n1174 2.7733333333333334
r1822 n1028 n1175 34.133333333333333
r1823 n1174 n1175 2.3466666666666667
r1824 n1029 n1176 102.40000000000001
r1825 n1175 n1176 1.7066666666666668
r1826 n1030 n1177 12.047058823529412
r1827 n1176 n1177 4.0533333333333337
r1828 n1031 n1178 15.753846153846155
r1829 n1177 n1178 6.4000000000000004
r1830 n1032 n1179 102.40000000000001
r1831 n1178 n1179 3.2000000000000002
r1832 n1033 n1180 102.40000000000001
r1833 n1179 n1180 0.85333333333333339
r1834 n1034 n1181 51.200000000000003
r1835 n1180 n1181 1.28
r1836 n1035 n1182 40.960000000000001
r1837 n1181 n1182 1.9199999999999999
r1838 n1036 n1183 25.600000000000001
r1839 n1182 n1183 2.7733333333333334
r1840 n1037 n1184 51.200000000000003
r1841 n1183 n1184 2.5600000000000001
r1842 n1038 n1185 15.753846153846155
r1843 n1184 n1185 3.6266666666666665
r1844 n1039 n1186 29.257142857142856
r1845 n1185 n1186 4.2666666666666666
r1846 n1040 n1187 7.5851851851851855
r1847 n1186 n1187 7.253333333333333
r1848 n1041 n1188 102.40000000000001
r1849 n1187 n1188 6.1866666666666665
r1850 n1042 n1189 40.960000000000001
r1851 n1188 n1189 1.4933333333333334
r1852 n1043 n1190 7.5851851851851855
r1853 n1189 n1190 6.8266666666666671
r1854 n1044 n1191 102.40000000000001
r1855 n1190 n1191 6.1866666666666665
r1856 n1045 n1192 6.4000000000000004
r1857 n1191 n1192 7.253333333333333
r1858 n1046 n1193 6.0235294117647058
r1859 n1192 n1193 14.08
r1860 n1047 n1194 6.0235294117647058
r1861 n1193 n1194 14.506666666666666
r1862 n1048 n1195 6.0235294117647058
r1863 n1194 n1195 14.506666666666666
r1864 n1049 n1196 6.0235294117647058
r1865 n1195 n1196 14.506666666666666
r1866 n1050 n1197 6.0235294117647058
r1867 n1196 n1197 14.506666666666666
r1868 n1051 n1198 6.0235294117647058
r1869 n1197 n1198 14.506666666666666
r1870 n1052 n1199 6.0235294117647058
r1871 n1198 n1199 14.506666666666666
r1872 n1053 n1200 6.0235294117647058
r1873 n1199 n1200 14.506666666666666
r1874 n1054 n1201 6.0235294117647058
r1875 n1200 n1201 14.506666666666666
r1876 n1055 n1202 6.0235294117647058
r1877 n1201 n1202 14.506666666666666
r1878 n1056 n1203 6.0235294117647058
r1879 n1202 n1203 14.506666666666666
r1880 n1057 n1204 6.0235294117647058
r1881 n1203 n1204 14.506666666666666
r1882 n1058 n1205 6.0235294117647058
r1883 n1204 n1205 14.506666666666666
r1884 n1059 n1206 6.0235294117647058
r1885 n1205 n1206 14.506666666666666
r1886 n1060 n1207 6.0235294117647058
r1887 n1206 n1207 14.506666666666666
r1888 n1061 n1208 6.0235294117647058
r1889 n1207 n1208 14.506666666666666
r1890 n1062 n1209 6.0235294117647058
r1891 n1208 n1209 14.506666666666666
r1892 n1063 n1210 6.0235294117647058
r1893 n1209 n1210 14.506666666666666
r1894 n1064 n1211 6.0235294117647058
r1895 n1210 n1211 14.506666666666666
r1896 n1065 n1212 6.0235294117647058
r1897 n1211 n1212 14.506666666666666
r1898 n1066 n1213 6.0235294117647058
r1899 n1212 n1213 14.506666666666666
r1900 n1067 n1214 6.0235294117647058
r1901 n1213 n1214 14.506666666666666
r1902 n1068 n1215 18.618181818181817
r1903 n1214 n1215 9.5999999999999996
r1904 n1069 n1216 8.9043478260869566
r1905 n1215 n1216 7.253333333333333
r1906 n1070 n1217 102.40000000000001
r1907 n1216 n1217 5.333333333333333
r1908 n1071 n1218 6.8266666666666671
r1909 n1217 n1218 6.8266666666666671
r1910 n1072 n1219 102.40000000000001
r1911 n1218 n1219 6.8266666666666671
r1912 n1073 n1220 8.9043478260869566
r1913 n1219 n1220 5.333333333333333
r1914 n1074 n1221 18.618181818181817
r1915 n1220 n1221 7.253333333333333
r1916 n1075 n1222 6.0235294117647058
r1917 n1221 n1222 9.5999999999999996
r1918 n1076 n1223 6.0235294117647058
r1919 n1222 n1223 14.506666666666666
r1920 n1077 n1224 6.0235294117647058
r1921 n1223 n1224 14.506666666666666
r1922 n1078 n1225 6.0235294117647058
r1923 n1224 n1225 14.506666666666666
r1924 n1079 n1226 6.0235294117647058
r1925 n1225 n1226 14.506666666666666
r1926 n1080 n1227 6.0235294117647058
r1927 n1226 n1227 14.506666666666666
r1928 n1081 n1228 6.0235294117647058
r1929 n1227 n1228 14.506666666666666
r1930 n1082 n1229 6.0235294117647058
r1931 n1228 n1229 14.506666666666666
r1932 n1083 n1230 6.0235294117647058
r1933 n1229 n1230 14.506666666666666
r1934 n1084 n1231 6.0235294117647058
r1935 n1230 n1231 14.506666666666666
r1936 n1085 n1232 6.0235294117647058
r1937 n1231 n1232 14.506666666666666
r1938 n1086 n1233 6.0235294117647058
r1939 n1232 n1233 14.506666666666666
r1940 n1087 n1234 6.0235294117647058
r1941 n1233 n1234 14.506666666666666
r1942 n1088 n1235 6.0235294117647058
r1943 n1234 n1235 14.506666666666666
r1944 n1089 n1236 6.0235294117647058
r1945 n1235 n1236 14.506666666666666
r1946 n1090 n1237 6.0235294117647058
r1947 n1236 n1237 14.506666666666666
r1948 n1091 n1238 6.0235294117647058
r1949 n1237 n1238 14.506666666666666
r1950 n1092 n1239 6.0235294117647058
r1951 n1238 n1239 14.506666666666666
r1952 n1093 n1240 6.0235294117647058
r1953 n1239 n1240 14.506666666666666
r1954 n1094 n1241 6.0235294117647058
r1955 n1240 n1241 14.506666666666666
r1956 n1095 n1242 6.0235294117647058
r1957 n1241 n1242 14.506666666666666
r1958 n1096 n1243 6.0235294117647058
r1959 n1242 n1243 14.506666666666666
r1960 n1097 n1244 6.0235294117647058
r1961 n1243 n1244 14.506666666666666
r1962 n1098 n1245 7.5851851851851855
r1963 n1244 n1245 13.013333333333334
r1964 n1099 n1246 29.257142857142856
r1965 n1245 n1246 7.253333333333333
r1966 n1100 n1247 6.0235294117647058
r1967 n1246 n1247 8.7466666666666661
r1968 n1101 n1248 6.0235294117647058
r1969 n1247 n1248 14.506666666666666
r1970 n1102 n1249 6.0235294117647058
r1971 n1248 n1249 14.506666666666666
r1972 n1103 n1250 6.0235294117647058
r1973 n1249 n1250 14.506666666666666
r1974 n1104 n1251 7.5851851851851855
r1975 n1250 n1251 13.013333333333334
r1976 n1105 n1252 29.257142857142856
r1977 n1251 n1252 7.253333333333333
r1978 n1106 n1253 11.377777777777778
r1979 n1252 n1253 5.333333333333333
r1980 n1107 n1254 12.800000000000001
r1981 n1253 n1254 7.253333333333333
r1982 n1108 n1255 14.628571428571428
r1983 n1254 n1255 6.4000000000000004
r1984 n1109 n1256 10.24
r1985 n1255 n1256 7.253333333333333
r1986 n1110 n1257 40.960000000000001
r1987 n1256 n1257 5.333333333333333
r1988 n1111 n1258 7.0620689655172413
r1989 n1257 n1258 7.253333333333333
r1990 n1112 n1259 6.0235294117647058
r1991 n1258 n1259 13.44
r1992 n1113 n1260 6.0235294117647058
r1993 n1259 n1260 14.506666666666666
r1994 n1114 n1261 6.0235294117647058
r1995 n1260 n1261 14.506666666666666
r1996 n1115 n1262 5.1200000000000001
r1997 n1261 n1262 15.786666666666667
r1998 n1116 n1263 6.0235294117647058
r1999 n1262 n1263 15.786666666666667
r2000 n1117 n1264 6.0235294117647058
r2001 n1263 n1264 14.506666666666666
r2002 n1118 n1265 6.0235294117647058
r2003 n1264 n1265 14.506666666666666
r2004 n1119 n1266 12.047058823529412
r2005 n1265 n1266 10.880000000000001
r2006 n1120 n1267 12.047058823529412
r2007 n1266 n1267 7.253333333333333
r2008 n1121 n1268 6.0235294117647058
r2009 n1122 n1269 7.4744525547445253
r2010 n1268 n1269 196.48000000000002
r2011 n1123 n1270 7.4202898550724639
r2012 n1269 n1270 176
r2013 n1124 n1271 6.0235294117647058
r2014 n1270 n1271 197.12
r2015 n1125 n1272 15.753846153846155
r2016 n1271 n1272 150.40000000000001
r2017 n1126 n1273 5.1200000000000001
r2018 n1272 n1273 169.59999999999999
r2019 n1127 n1274 204.80000000000001
r2020 n1273 n1274 131.19999999999999
r2021 n1128 n1275 6.2060606060606061
r2022 n1274 n1275 108.8
r2023 n1129 n1276 204.80000000000001
r2024 n1275 n1276 108.8
r2025 n1130 n1277 8.9043478260869566
r2026 n1276 n1277 76.799999999999997
r2027 n1131 n1278 51.200000000000003
r2028 n1277 n1278 86.400000000000006
r2029 n1132 n1279 34.133333333333333
r2030 n1278 n1279 32
r2031 n1133 n1280 40.960000000000001
r2032 n1279 n1280 35.200000000000003
r2033 n1134 n1281 204.80000000000001
r2034 n1280 n1281 19.199999999999999
r2035 n1135 n1282 15.753846153846155
r2036 n1281 n1282 44.799999999999997
r2037 n1136 n1283 20.48
r2038 n1282 n1283 73.599999999999994
r2039 n1137 n1284 40.960000000000001
r2040 n1283 n1284 48
r2041 n1138 n1285 40.960000000000001
r2042 n1284 n1285 32
r2043 n1139 n1286 204.80000000000001
r2044 n1285 n1286 19.199999999999999
r2045 n1140 n1287 68.266666666666666
r2046 n1286 n1287 12.800000000000001
r2047 n1141 n1288 204.80000000000001
r2048 n1287 n1288 12.800000000000001
r2049 n1142 n1289 22.755555555555556
r2050 n1288 n1289 32
r2051 n1143 n1290 20.48
r2052 n1289 n1290 60.799999999999997
r2053 n1144 n1291 40.960000000000001
r2054 n1290 n1291 48
r2055 n1145 n1292 40.960000000000001
r2056 n1291 n1292 32
r2057 n1146 n1293 204.80000000000001
r2058 n1292 n1293 19.199999999999999
r2059 n1147 n1294 102.40000000000001
r2060 n1293 n1294 9.5999999999999996
r2061 n1148 n1295 204.80000000000001
r2062 n1294 n1295 9.5999999999999996
r2063 n1149 n1296 204.80000000000001
r2064 n1295 n1296 6.4000000000000004
r2065 n1150 n1297 204.80000000000001
r2066 n1296 n1297 6.4000000000000004
r2067 n1151 n1298 51.200000000000003
r2068 n1297 n1298 16
r2069 n1152 n1299 40.960000000000001
r2070 n1298 n1299 28.800000000000001
r2071 n1153 n1300 204.80000000000001
r2072 n1299 n1300 19.199999999999999
r2073 n1154 n1301 20.48
r2074 n1300 n1301 35.200000000000003
r2075 n1155 n1302 68.266666666666666
r2076 n1301 n1302 41.600000000000001
r2077 n1156 n1303 34.133333333333333
r2078 n1302 n1303 28.800000000000001
r2079 n1157 n1304 102.40000000000001
r2080 n1303 n1304 25.600000000000001
r2081 n1158 n1305 204.80000000000001
r2082 n1304 n1305 9.5999999999999996
r2083 n1159 n1306 204.80000000000001
r2084 n1305 n1306 6.4000000000000004
r2085 n1160 n1307 34.133333333333333
r2086 n1306 n1307 22.399999999999999
r2087 n1161 n1308 40.960000000000001
r2088 n1307 n1308 35.200000000000003
r2089 n1162 n1309 204.80000000000001
r2090 n1308 n1309 19.199999999999999
r2091 n1163 n1310 51.200000000000003
r2092 n1309 n1310 16
r2093 n1164 n1311 40.960000000000001
r2094 n1310 n1311 28.800000000000001
r2095 n1165 n1312 68.266666666666666
r2096 n1311 n1312 25.600000000000001
r2097 n1166 n1313 29.257142857142856
r2098 n1312 n1313 32
r2099 n1167 n1314 34.133333333333333
r2100 n1313 n1314 41.600000000000001
r2101 n1168 n1315 20.48
r2102 n1314 n1315 51.200000000000003
r2103 n1169 n1316 51.200000000000003
r2104 n1315 n1316 44.799999999999997
r2105 n1170 n1317 29.257142857142856
r2106 n1316 n1317 35.200000000000003
r2107 n1171 n1318 22.755555555555556
r2108 n1317 n1318 51.200000000000003
r2109 n1172 n1319 51.200000000000003
r2110 n1318 n1319 41.600000000000001
r2111 n1173 n1320 25.600000000000001
r2112 n1319 n1320 38.399999999999999
r2113 n1174 n1321 40.960000000000001
r2114 n1320 n1321 41.600000000000001
r2115 n1175 n1322 34.133333333333333
r2116 n1321 n1322 35.200000000000003
r2117 n1176 n1323 102.40000000000001
r2118 n1322 n1323 25.600000000000001
r2119 n1177 n1324 12.047058823529412
r2120 n1323 n1324 60.799999999999997
r2121 n1178 n1325 15.753846153846155
r2122 n1324 n1325 96
r2123 n1179 n1326 102.40000000000001
r2124 n1325 n1326 48
r2125 n1180 n1327 102.40000000000001
r2126 n1326 n1327 12.800000000000001
r2127 n1181 n1328 51.200000000000003
r2128 n1327 n1328 19.199999999999999
r2129 n1182 n1329 40.960000000000001
r2130 n1328 n1329 28.800000000000001
r2131 n1183 n1330 25.600000000000001
r2132 n1329 n1330 41.600000000000001
r2133 n1184 n1331 51.200000000000003
r2134 n1330 n1331 38.399999999999999
r2135 n1185 n1332 15.753846153846155
r2136 n1331 n1332 54.399999999999999
r2137 n1186 n1333 29.257142857142856
r2138 n1332 n1333 64
r2139 n1187 n1334 7.5851851851851855
r2140 n1333 n1334 108.8
r2141 n1188 n1335 102.40000000000001
r2142 n1334 n1335 92.799999999999997
r2143 n1189 n1336 40.960000000000001
r2144 n1335 n1336 22.399999999999999
r2145 n1190 n1337 7.5851851851851855
r2146 n1336 n1337 102.40000000000001
r2147 n1191 n1338 102.40000000000001
r2148 n1337 n1338 92.799999999999997
r2149 n1192 n1339 6.4000000000000004
r2150 n1338 n1339 108.8
r2151 n1193 n1340 6.0235294117647058
r2152 n1339 n1340 211.19999999999999
r2153 n1194 n1341 6.0235294117647058
r2154 n1340 n1341 217.59999999999999
r2155 n1195 n1342 6.0235294117647058
r2156 n1341 n1342 217.59999999999999
r2157 n1196 n1343 6.0235294117647058
r2158 n1342 n1343 217.59999999999999
r2159 n1197 n1344 6.0235294117647058
r2160 n1343 n1344 217.59999999999999
r2161 n1198 n1345 6.0235294117647058
r2162 n1344 n1345 217.59999999999999
r2163 n1199 n1346 6.0235294117647058
r2164 n1345 n1346 217.59999999999999
r2165 n1200 n1347 6.0235294117647058
r2166 n1346 n1347 217.59999999999999
r2167 n1201 n1348 6.0235294117647058
r2168 n1347 n1348 217.59999999999999
r2169 n1202 n1349 6.0235294117647058
r2170 n1348 n1349 217.59999999999999
r2171 n1203 n1350 6.0235294117647058
r2172 n1349 n1350 217.59999999999999
r2173 n1204 n1351 6.0235294117647058
r2174 n1350 n1351 217.59999999999999
r2175 n1205 n1352 6.0235294117647058
r2176 n1351 n1352 217.59999999999999
r2177 n1206 n1353 6.0235294117647058
r2178 n1352 n1353 217.59999999999999
r2179 n1207 n1354 6.0235294117647058
r2180 n1353 n1354 217.59999999999999
r2181 n1208 n1355 6.0235294117647058
r2182 n1354 n1355 217.59999999999999
r2183 n1209 n1356 6.0235294117647058
r2184 n1355 n1356 217.59999999999999
r2185 n1210 n1357 6.0235294117647058
r2186 n1356 n1357 217.59999999999999
r2187 n1211 n1358 6.0235294117647058
r2188 n1357 n1358 217.59999999999999
r2189 n1212 n1359 6.0235294117647058
r2190 n1358 n1359 217.59999999999999
r2191 n1213 n1360 6.0235294117647058
r2192 n1359 n1360 217.59999999999999
r2193 n1214 n1361 6.0235294117647058
r2194 n1360 n1361 217.59999999999999
r2195 n1215 n1362 18.618181818181817
r2196 n1361 n1362 144
r2197 n1216 n1363 8.9043478260869566
r2198 n1362 n1363 108.8
r2199 n1217 n1364 102.40000000000001
r2200 n1363 n1364 80
r2201 n1218 n1365 6.8266666666666671
r2202 n1364 n1365 102.40000000000001
r2203 n1219 n1366 102.40000000000001
r2204 n1365 n1366 102.40000000000001
r2205 n1220 n1367 8.9043478260869566
r2206 n1366 n1367 80
r2207 n1221 n1368 18.618181818181817
r2208 n1367 n1368 108.8
r2209 n1222 n1369 6.0235294117647058
r2210 n1368 n1369 144
r2211 n1223 n1370 6.0235294117647058
r2212 n1369 n1370 217.59999999999999
r2213 n1224 n1371 6.0235294117647058
r2214 n1370 n1371 217.59999999999999
r2215 n1225 n1372 6.0235294117647058
r2216 n1371 n1372 217.59999999999999
r2217 n1226 n1373 6.0235294117647058
r2218 n1372 n1373 217.59999999999999
r2219 n1227 n1374 6.0235294117647058
r2220 n1373 n1374 217.59999999999999
r2221 n1228 n1375 6.0235294117647058
r2222 n1374 n1375 217.59999999999999
r2223 n1229 n1376 6.0235294117647058
r2224 n1375 n1376 217.59999999999999
r2225 n1230 n1377 6.0235294117647058
r2226 n1376 n1377 217.59999999999999
r2227 n1231 n1378 6.0235294117647058
r2228 n1377 n1378 217.59999999999999
r2229 n1232 n1379 6.0235294117647058
r2230 n1378 n1379 217.59999999999999
r2231 n1233 n1380 6.0235294117647058
r2232 n1379 n1380 217.59999999999999
r2233 n1234 n1381 6.0235294117647058
r2234 n1380 n1381 217.59999999999999
r2235 n1235 n1382 6.0235294117647058
r2236 n1381 n1382 217.59999999999999
r2237 n1236 n1383 6.0235294117647058
r2238 n1382 n1383 217.59999999999999
r2239 n1237 n1384 6.0235294117647058
r2240 n1383 n1384 217.59999999999999
r2241 n1238 n1385 6.0235294117647058
r2242 n1384 n1385 217.59999999999999
r2243 n1239 n1386 6.0235294117647058
r2244 n1385 n1386 217.59999999999999
r2245 n1240 n1387 6.0235294117647058
r2246 n1386 n1387 217.59999999999999
r2247 n1241 n1388 6.0235294117647058
r2248 n1387 n1388 217.59999999999999
r2249 n1242 n1389 6.0235294117647058
r2250 n1388 n1389 217.59999999999999
r2251 n1243 n1390 6.0235294117647058
r2252 n1389 n1390 217.59999999999999
r2253 n1244 n1391 6.0235294117647058
r2254 n1390 n1391 217.59999999999999
r2255 n1245 n1392 7.5851851851851855
r2256 n1391 n1392 195.19999999999999
r2257 n1246 n1393 29.257142857142856
r2258 n1392 n1393 108.8
r2259 n1247 n1394 6.0235294117647058
r2260 n1393 n1394 131.19999999999999
r2261 n1248 n1395 6.0235294117647058
r2262 n1394 n1395 217.59999999999999
r2263 n1249 n1396 6.0235294117647058
r2264 n1395 n1396 217.59999999999999
r2265 n1250 n1397 6.0235294117647058
r2266 n1396 n1397 217.59999999999999
r2267 n1251 n1398 7.5851851851851855
r2268 n1397 n1398 195.19999999999999
r2269 n1252 n1399 29.257142857142856
r2270 n1398 n1399 108.8
r2271 n1253 n1400 11.377777777777778
r2272 n1399 n1400 80
r2273 n1254 n1401 12.800000000000001
r2274 n1400 n1401 108.8
r2275 n1255 n1402 14.628571428571428
r2276 n1401 n1402 96
r2277 n1256 n1403 10.24
r2278 n1402 n1403 108.8
r2279 n1257 n1404 40.960000000000001
r2280 n1403 n1404 80
r2281 n1258 n1405 7.0620689655172413
r2282 n1404 n1405 108.8
r2283 n1259 n1406 6.0235294117647058
r2284 n1405 n1406 201.59999999999999
r2285 n1260 n1407 6.0235294117647058
r2286 n1406 n1407 217.59999999999999
r2287 n1261 n1408 6.0235294117647058
r2288 n1407 n1408 217.59999999999999
r2289 n1262 n1409 5.1200000000000001
r2290 n1408 n1409 236.80000000000001
r2291 n1263 n1410 6.0235294117647058
r2292 n1409 n1410 236.80000000000001
r2293 n1264 n1411 6.0235294117647058
r2294 n1410 n1411 217.59999999999999
r2295 n1265 n1412 6.0235294117647058
r2296 n1411 n1412 217.59999999999999
r2297 n1266 n1413 12.047058823529412
r2298 n1412 n1413 163.19999999999999
r2299 n1267 n1414 12.047058823529412
r2300 n1413 n1414 108.8
r2301 n1268 n1415 2.447058823529412
r2302 n1413 n1416 4.8941176470588239
r2303 n1414 n1417 4.8941176470588239
r2304 n1416 n1417 19.781818181818181
r2305 n1415 n1418 2.447058823529412
r2306 n1416 n1419 4.8941176470588239
r2307 n1417 n1420 4.8941176470588239
r2308 n1419 n1420 108.8
r2309 n1418 n1421 6.7011764705882353
r2310 n1419 n1422 13.402352941176471
r2311 n1420 n1423 13.402352941176471
r2312 n1422 n1423 6.4761904761904763
r2313 n1421 n1424 12.611764705882353
r2314 n1422 n1425 25.223529411764705
r2315 n1423 n1426 25.223529411764705
r2316 n1425 n1426 6.5149700598802394
r2317 n1424 n1427 8.357647058823531
r2318 n1425 n1428 16.715294117647062
r2319 n1426 n1429 16.715294117647062
r2320 n1428 n1429 19.781818181818181
r2321 n1427 n1430 3.9529411764705884
r2322 n1428 n1431 7.9058823529411768
r2323 n1429 n1432 7.9058823529411768
r2324 n1431 n1432 21.760000000000002
r2325 n1430 n1433 2.2588235294117647
r2326 n1431 n1434 4.5176470588235293
r2327 n1432 n1435 4.5176470588235293
r2328 n1434 n1435 108.8
r2329 n1433 n1436 0.94117647058823528
r2330 n1434 n1437 1.8823529411764706
r2331 n1435 n1438 1.8823529411764706
r2332 n1437 n1438 72.533333333333331
r2333 n1436 n1439 1.5058823529411764
r2334 n1437 n1440 3.0117647058823529
r2335 n1438 n1441 3.0117647058823529
r2336 n1440 n1441 43.520000000000003
r2337 n1439 n1442 1.5058823529411764
r2338 n1440 n1443 3.0117647058823529
r2339 n1441 n1444 3.0117647058823529
r2340 n1443 n1444 72.533333333333331
r2341 n1442 n1445 0.94117647058823528
r2342 n1443 n1446 1.8823529411764706
r2343 n1444 n1447 1.8823529411764706
r2344 n1446 n1447 108.8
r2345 n1445 n1448 6.0235294117647058
r2346 n1446 n1449 12.047058823529412
r2347 n1447 n1450 12.047058823529412
r2348 n1449 n1450 7.253333333333333
r2349 n1448 n1451 6.0235294117647058
r2350 n1449 n1452 12.047058823529412
r2351 n1450 n1453 12.047058823529412
r2352 n1452 n1453 108.8
r2353 n1451 n1454 0.94117647058823528
r2354 n1452 n1455 1.8823529411764706
r2355 n1453 n1456 1.8823529411764706
r2356 n1455 n1456 72.533333333333331
r2357 n1454 n1457 1.5058823529411764
r2358 n1455 n1458 3.0117647058823529
r2359 n1456 n1459 3.0117647058823529
r2360 n1458 n1459 43.520000000000003
r2361 n1457 n1460 1.5058823529411764
r2362 n1458 n1461 3.0117647058823529
r2363 n1459 n1462 3.0117647058823529
r2364 n1461 n1462 72.533333333333331
r2365 n1460 n1463 0.94117647058823528
r2366 n1461 n1464 1.8823529411764706
r2367 n1462 n1465 1.8823529411764706
r2368 n1464 n1465 108.8
r2369 n1463 n1466 2.2588235294117647
r2370 n1464 n1467 4.5176470588235293
r2371 n1465 n1468 4.5176470588235293
r2372 n1467 n1468 21.760000000000002
r2373 n1466 n1469 3.9529411764705884
r2374 n1467 n1470 7.9058823529411768
r2375 n1468 n1471 7.9058823529411768
r2376 n1470 n1471 19.781818181818181
r2377 n1469 n1472 9.5999999999999996
r2378 n1470 n1473 19.199999999999999
r2379 n1471 n1474 19.199999999999999
r2380 n1473 n1474 5.4400000000000004
r2381 n1472 n1475 15.058823529411764
r2382 n1473 n1476 30.117647058823529
r2383 n1474 n1477 30.117647058823529
r2384 n1476 n1477 5.4400000000000004
r2385 n1475 n1478 13.929411764705883
r2386 n1478 n1479 11.55764705882353
r2387 n1479 n1480 10.352941176470589
r2388 n1480 n1481 11.595294117647059
r2389 n1481 n1482 8.8470588235294123
r2390 n1482 n1483 9.9764705882352942
r2391 n1483 n1484 7.7176470588235295
r2392 n1484 n1485 6.4000000000000004
r2393 n1485 n1486 6.4000000000000004
r2394 n1486 n1487 4.5176470588235293
r2395 n1487 n1488 5.0823529411764703
r2396 n1488 n1489 1.8823529411764706
r2397 n1489 n1490 2.0705882352941178
r2398 n1490 n1491 1.1294117647058823
r2399 n1491 n1492 2.6352941176470588
r2400 n1492 n1493 4.3294117647058821
r2401 n1493 n1494 2.8235294117647061
r2402 n1494 n1495 1.8823529411764706
r2403 n1495 n1496 1.1294117647058823
r2404 n1496 n1497 0.75294117647058822
r2405 n1497 n1498 0.75294117647058822
r2406 n1498 n1499 1.8823529411764706
r2407 n1499 n1500 3.5764705882352943
r2408 n1500 n1501 2.8235294117647061
r2409 n1501 n1502 1.8823529411764706
r2410 n1502 n1503 1.1294117647058823
r2411 n1503 n1504 0.56470588235294117
r2412 n1504 n1505 0.56470588235294117
r2413 n1505 n1506 0.37647058823529411
r2414 n1506 n1507 0.37647058823529411
r2415 n1507 n1508 0.94117647058823528
r2416 n1508 n1509 1.6941176470588235
r2417 n1509 n1510 1.1294117647058823
r2418 n1510 n1511 2.0705882352941178
r2419 n1511 n1512 2.447058823529412
r2420 n1512 n1513 1.6941176470588235
r2421 n1513 n1514 1.5058823529411764
r2422 n1514 n1515 0.56470588235294117
r2423 n1515 n1516 0.37647058823529411
r2424 n1516 n1517 1.3176470588235294
r2425 n1517 n1518 2.0705882352941178
r2426 n1518 n1519 1.1294117647058823
r2427 n1519 n1520 0.94117647058823528
r2428 n1520 n1521 1.6941176470588235
r2429 n1521 n1522 1.5058823529411764
r2430 n1522 n1523 1.8823529411764706
r2431 n1523 n1524 2.447058823529412
r2432 n1524 n1525 3.0117647058823529
r2433 n1525 n1526 2.6352941176470588
r2434 n1526 n1527 2.0705882352941178
r2435 n1527 n1528 3.0117647058823529
r2436 n1528 n1529 2.447058823529412
r2437 n1529 n1530 2.2588235294117647
r2438 n1530 n1531 2.447058823529412
r2439 n1531 n1532 2.0705882352941178
r2440 n1532 n1533 1.5058823529411764
r2441 n1533 n1534 3.5764705882352943
r2442 n1534 n1535 5.6470588235294121
r2443 n1535 n1536 2.8235294117647061
r2444 n1536 n1537 0.75294117647058822
r2445 n1537 n1538 1.1294117647058823
r2446 n1538 n1539 1.6941176470588235
r2447 n1539 n1540 2.447058823529412
r2448 n1540 n1541 2.2588235294117647
r2449 n1541 n1542 3.2000000000000002
r2450 n1542 n1543 3.7647058823529411
r2451 n1543 n1544 6.4000000000000004
r2452 n1544 n1545 5.4588235294117649
r2453 n1545 n1546 1.3176470588235294
r2454 n1546 n1547 6.0235294117647058
r2455 n1547 n1548 5.4588235294117649
r2456 n1548 n1549 6.4000000000000004
r2457 n1549 n1550 12.423529411764706
r2458 n1550 n1551 12.800000000000001
r2459 n1551 n1552 12.800000000000001
r2460 n1552 n1553 12.800000000000001
r2461 n1553 n1554 12.800000000000001
r2462 n1554 n1555 12.800000000000001
r2463 n1555 n1556 12.800000000000001
r2464 n1556 n1557 12.800000000000001
r2465 n1557 n1558 12.800000000000001
r2466 n1558 n1559 12.800000000000001
r2467 n1559 n1560 12.800000000000001
r2468 n1560 n1561 12.800000000000001
r2469 n1561 n1562 12.800000000000001
r2470 n1562 n1563 12.800000000000001
r2471 n1563 n1564 12.800000000000001
r2472 n1564 n1565 12.800000000000001
r2473 n1565 n1566 12.800000000000001
r2474 n1566 n1567 12.800000000000001
r2475 n1567 n1568 12.800000000000001
r2476 n1568 n1569 12.800000000000001
r2477 n1569 n1570 12.800000000000001
r2478 n1570 n1571 12.800000000000001
r2479 n1571 n1572 8.4705882352941178
r2480 n1572 n1573 6.4000000000000004
r2481 n1573 n1574 4.7058823529411766
r2482 n1574 n1575 6.0235294117647058
r2483 n1575 n1576 6.0235294117647058
r2484 n1576 n1577 4.7058823529411766
r2485 n1577 n1578 6.4000000000000004
r2486 n1578 n1579 8.4705882352941178
r2487 n1579 n1580 12.800000000000001
r2488 n1580 n1581 12.800000000000001
r2489 n1581 n1582 12.800000000000001
r2490 n1582 n1583 12.800000000000001
r2491 n1583 n1584 12.800000000000001
r2492 n1584 n1585 12.800000000000001
r2493 n1585 n1586 12.800000000000001
r2494 n1586 n1587 12.800000000000001
r2495 n1587 n1588 12.800000000000001
r2496 n1588 n1589 12.800000000000001
r2497 n1589 n1590 12.800000000000001
r2498 n1590 n1591 12.800000000000001
r2499 n1591 n1592 12.800000000000001
r2500 n1592 n1593 12.800000000000001
r2501 n1593 n1594 12.800000000000001
r2502 n1594 n1595 12.800000000000001
r2503 n1595 n1596 12.800000000000001
r2504 n1596 n1597 12.800000000000001
r2505 n1597 n1598 12.800000000000001
r2506 n1598 n1599 12.800000000000001
r2507 n1599 n1600 12.800000000000001
r2508 n1600 n1601 12.800000000000001
r2509 n1601 n1602 11.482352941176471
r2510 n1602 n1603 6.4000000000000004
r2511 n1603 n1604 7.7176470588235295
r2512 n1604 n1605 12.800000000000001
r2513 n1605 n1606 12.800000000000001
r2514 n1606 n1607 12.800000000000001
r2515 n1607 n1608 11.482352941176471
r2516 n1608 n1609 6.4000000000000004
r2517 n1609 n1610 4.7058823529411766
r2518 n1610 n1611 6.4000000000000004
r2519 n1611 n1612 5.6470588235294121
r2520 n1612 n1613 6.4000000000000004
r2521 n1613 n1614 4.7058823529411766
r2522 n1614 n1615 6.4000000000000004
r2523 n1615 n1616 11.858823529411765
r2524 n1616 n1617 12.800000000000001
r2525 n1617 n1618 12.800000000000001
r2526 n1618 n1619 13.929411764705883
r2527 n1619 n1620 13.929411764705883
r2528 n1620 n1621 12.800000000000001
r2529 n1621 n1622 12.800000000000001
r2530 n1476 n1623 27.858823529411765
r2531 n1622 n1623 9.5999999999999996
r2532 n1477 n1624 27.858823529411765
r2533 n1623 n1624 6.4000000000000004
r2534 vdd n1753 0.22321428571428573
r2535 n1753 n1754 0.22321428571428573
r2536 n1754 n1756 0.22321428571428573
r2537 n1755 n1756 0.036249999999999998
r2538 n1756 n1757 0.036249999999999998
r2539 n1755 n1758 616.6875
r2540 n1756 n1759 22.024553571428573
r2541 n1758 n1759 0.00018462870530712029
r2542 n1757 n1760 616.6875
r2543 n1759 n1760 0.00018462870530712029
r2544 n1758 n1761 1230.25
r2545 n1759 n1762 43.9375
r2546 n1761 n1762 0.00018369311847572716
r2547 n1760 n1763 1230.25
r2548 n1762 n1763 0.00018369311847572716
r2549 n1761 n1764 1233.375
r2550 n1762 n1765 44.049107142857146
r2551 n1764 n1765 0.00018369311847572716
r2552 n1763 n1766 1233.375
r2553 n1765 n1766 0.00018369311847572716
r2554 n1764 n1767 1233.375
r2555 n1765 n1768 44.049107142857146
r2556 n1767 n1768 0.00018369311847572716
r2557 n1766 n1769 1233.375
r2558 n1768 n1769 0.00018369311847572716
r2559 n1767 n1770 1233.375
r2560 n1768 n1771 44.049107142857146
r2561 n1770 n1771 0.00018369311847572716
r2562 n1769 n1772 1233.375
r2563 n1771 n1772 0.00018369311847572716
r2564 n1770 n1773 1233.375
r2565 n1771 n1774 44.049107142857146
r2566 n1773 n1774 0.00018369311847572716
r2567 n1772 n1775 1233.375
r2568 n1774 n1775 0.00018369311847572716
r2569 n1773 n1776 1233.375
r2570 n1774 n1777 44.049107142857146
r2571 n1776 n1777 0.00018369311847572716
r2572 n1775 n1778 1233.375
r2573 n1777 n1778 0.00018369311847572716
r2574 n1776 n1779 1233.375
r2575 n1777 n1780 44.049107142857146
r2576 n1779 n1780 0.00018369311847572716
r2577 n1778 n1781 1233.375
r2578 n1780 n1781 0.00018369311847572716
r2579 n1779 n1782 1233.375
r2580 n1780 n1783 44.049107142857146
r2581 n1782 n1783 0.00018369311847572716
r2582 n1781 n1784 1233.375
r2583 n1783 n1784 0.00018369311847572716
r2584 n1782 n1785 1233.375
r2585 n1783 n1786 44.049107142857146
r2586 n1785 n1786 0.00018369311847572716
r2587 n1784 n1787 1233.375
r2588 n1786 n1787 0.00018369311847572716
r2589 n1785 n1788 1233.375
r2590 n1786 n1789 44.049107142857146
r2591 n1788 n1789 0.00018369311847572716
r2592 n1787 n1790 1233.375
r2593 n1789 n1790 0.00018369311847572716
r2594 n1788 n1791 1233.375
r2595 n1789 n1792 44.049107142857146
r2596 n1791 n1792 0.00018369311847572716
r2597 n1790 n1793 1233.375
r2598 n1792 n1793 0.00018369311847572716
r2599 n1791 n1794 1233.375
r2600 n1792 n1795 44.049107142857146
r2601 n1794 n1795 0.00018369311847572716
r2602 n1793 n1796 1233.375
r2603 n1795 n1796 0.00018369311847572716
r2604 n1794 n1797 1233.375
r2605 n1795 n1798 44.049107142857146
r2606 n1797 n1798 0.00018369311847572716
r2607 n1796 n1799 1233.375
r2608 n1798 n1799 0.00018369311847572716
r2609 n1797 n1800 1233.375
r2610 n1798 n1801 44.049107142857146
r2611 n1800 n1801 0.00018369311847572716
r2612 n1799 n1802 1233.375
r2613 n1801 n1802 0.00018369311847572716
r2614 n1800 n1803 1233.375
r2615 n1801 n1804 44.049107142857146
r2616 n1803 n1804 0.00018369311847572716
r2617 n1802 n1805 1233.375
r2618 n1804 n1805 0.00018369311847572716
r2619 n1803 n1806 1233.375
r2620 n1804 n1807 44.049107142857146
r2621 n1806 n1807 0.00018369311847572716
r2622 n1805 n1808 1233.375
r2623 n1807 n1808 0.00018369311847572716
r2624 n1806 n1809 1233.375
r2625 n1807 n1810 44.049107142857146
r2626 n1809 n1810 0.00018369311847572716
r2627 n1808 n1811 1233.375
r2628 n1810 n1811 0.00018369311847572716
r2629 n1809 n1812 1233.375
r2630 n1810 n1813 44.049107142857146
r2631 n1812 n1813 0.00018369311847572716
r2632 n1811 n1814 1233.375
r2633 n1813 n1814 0.00018369311847572716
r2634 n1812 n1815 1230.25
r2635 n1813 n1816 43.9375
r2636 n1815 n1816 0.00018462870530712029
r2637 n1814 n1817 1230.25
r2638 n1816 n1817 0.00018462870530712029
r2639 n1815 n1818 616.6875
r2640 n1816 n1819 22.024553571428573
r2641 n1818 n1819 0.036249999999999998
r2642 n1817 n1820 616.6875
r2643 n1819 n1820 0.036249999999999998
r2644 n1818 n1828 5.8125
r2645 n1819 n1829 0.20758928571428573
r2646 n1828 n1829 0.042151162790697673
r2647 n1820 n1830 5.8125
r2648 n1829 n1830 0.042151162790697673
r2649 n1828 n1838 4.8125
r2650 n1829 n1839 0.171875
r2651 n1838 n1839 0.053308823529411763
r2652 n1830 n1840 4.8125
r2653 n1839 n1840 0.053308823529411763
r2654 n1838 n1848 4.8125
r2655 n1839 n1849 0.171875
r2656 n1848 n1849 0.042151162790697673
r2657 n1840 n1850 4.8125
r2658 n1849 n1850 0.042151162790697673
r2659 n1848 n1851 5.8125
r2660 n1849 n1852 0.20758928571428573
r2661 n1851 n1852 0.036249999999999998
r2662 n1850 n1853 5.8125
r2663 n1852 n1853 0.036249999999999998
r2664 n1851 n1854 6.25
r2665 n1852 n1855 0.22321428571428573
r2666 n1854 n1855 0.036249999999999998
r2667 n1853 n1856 6.25
r2668 n1855 n1856 0.036249999999999998
r2669 n1854 n1857 6.25
r2670 n1855 n1858 0.22321428571428573
r2671 n1857 n1858 0.036249999999999998
r2672 n1856 n1859 6.25
r2673 n1858 n1859 0.036249999999999998
r2674 n1857 n1860 6.25
r2675 n1858 n1861 0.22321428571428573
r2676 n1860 n1861 0.036249999999999998
r2677 n1859 n1862 6.25
r2678 n1861 n1862 0.036249999999999998
r2679 n1860 n1863 6.25
r2680 n1861 n1864 0.22321428571428573
r2681 n1863 n1864 0.036249999999999998
r2682 n1862 n1865 6.25
r2683 n1864 n1865 0.036249999999999998
r2684 n1863 n1866 6.25
r2685 n1864 n1867 0.22321428571428573
r2686 n1866 n1867 0.036249999999999998
r2687 n1865 n1868 6.25
r2688 n1867 n1868 0.036249999999999998
r2689 n1866 n1869 6.25
r2690 n1867 n1870 0.22321428571428573
r2691 n1869 n1870 0.036249999999999998
r2692 n1868 n1871 6.25
r2693 n1870 n1871 0.036249999999999998
r2694 n1869 n1872 6.25
r2695 n1870 n1873 0.22321428571428573
r2696 n1872 n1873 0.036249999999999998
r2697 n1871 n1874 6.25
r2698 n1873 n1874 0.036249999999999998
r2699 n1872 n1875 6.25
r2700 n1873 n1876 0.22321428571428573
r2701 n1875 n1876 0.036249999999999998
r2702 n1874 n1877 6.25
r2703 n1876 n1877 0.036249999999999998
r2704 n1875 n1878 6.25
r2705 n1876 n1879 0.22321428571428573
r2706 n1878 n1879 0.036249999999999998
r2707 n1877 n1880 6.25
r2708 n1879 n1880 0.036249999999999998
r2709 n1878 n1881 6.25
r2710 n1879 n1882 0.22321428571428573
r2711 n1881 n1882 0.036249999999999998
r2712 n1880 n1883 6.25
r2713 n1882 n1883 0.036249999999999998
r2714 n1881 n1884 6.25
r2715 n1882 n1885 0.22321428571428573
r2716 n1884 n1885 0.036249999999999998
r2717 n1883 n1886 6.25
r2718 n1885 n1886 0.036249999999999998
r2719 n1884 n1887 6.25
r2720 n1885 n1888 0.22321428571428573
r2721 n1887 n1888 0.036249999999999998
r2722 n1886 n1889 6.25
r2723 n1888 n1889 0.036249999999999998
r2724 n1887 n1890 6.25
r2725 n1888 n1891 0.22321428571428573
r2726 n1890 n1891 0.036249999999999998
r2727 n1889 n1892 6.25
r2728 n1891 n1892 0.036249999999999998
r2729 n1890 n1893 6.25
r2730 n1891 n1894 0.22321428571428573
r2731 n1893 n1894 0.036249999999999998
r2732 n1892 n1895 6.25
r2733 n1894 n1895 0.036249999999999998
r2734 n1893 n1896 6.25
r2735 n1894 n1897 0.22321428571428573
r2736 n1896 n1897 0.036249999999999998
r2737 n1895 n1898 6.25
r2738 n1897 n1898 0.036249999999999998
r2739 n1896 n1899 6.25
r2740 n1897 n1900 0.22321428571428573
r2741 n1899 n1900 0.036249999999999998
r2742 n1898 n1901 6.25
r2743 n1900 n1901 0.036249999999999998
r2744 n1899 n1902 6.25
r2745 n1900 n1903 0.22321428571428573
r2746 n1902 n1903 0.036249999999999998
r2747 n1901 n1904 6.25
r2748 n1903 n1904 0.036249999999999998
r2749 n1902 n1905 6.25
r2750 n1903 n1906 0.22321428571428573
r2751 n1905 n1906 0.036249999999999998
r2752 n1904 n1907 6.25
r2753 n1906 n1907 0.036249999999999998
r2754 n1905 n1908 6.25
r2755 n1906 n1909 0.22321428571428573
r2756 n1908 n1909 0.036249999999999998
r2757 n1907 n1910 6.25
r2758 n1909 n1910 0.036249999999999998
r2759 n1908 n1911 6.25
r2760 n1909 n1912 0.22321428571428573
r2761 n1911 n1912 0.036249999999999998
r2762 n1910 n1913 6.25
r2763 n1912 n1913 0.036249999999999998
r2764 n1911 n1914 6.25
r2765 n1912 n1915 0.22321428571428573
r2766 n1914 n1915 0.036249999999999998
r2767 n1913 n1916 6.25
r2768 n1915 n1916 0.036249999999999998
r2769 n1914 n1917 6.25
r2770 n1915 n1918 0.22321428571428573
r2771 n1917 n1918 0.036249999999999998
r2772 n1916 n1919 6.25
r2773 n1918 n1919 0.036249999999999998
r2774 n1917 n1920 6.25
r2775 n1918 n1921 0.22321428571428573
r2776 n1920 n1921 0.036249999999999998
r2777 n1919 n1922 6.25
r2778 n1921 n1922 0.036249999999999998
r2779 n1920 n1923 6.25
r2780 n1921 n1924 0.22321428571428573
r2781 n1923 n1924 0.036249999999999998
r2782 n1922 n1925 6.25
r2783 n1924 n1925 0.036249999999999998
r2784 n1923 n1926 6.25
r2785 n1924 n1927 0.22321428571428573
r2786 n1926 n1927 0.036249999999999998
r2787 n1925 n1928 6.25
r2788 n1927 n1928 0.036249999999999998
r2789 n1926 n1929 6.25
r2790 n1927 n1930 0.22321428571428573
r2791 n1929 n1930 0.036249999999999998
r2792 n1928 n1931 6.25
r2793 n1930 n1931 0.036249999999999998
r2794 n1929 n1932 6.25
r2795 n1930 n1933 0.22321428571428573
r2796 n1932 n1933 0.036249999999999998
r2797 n1931 n1934 6.25
r2798 n1933 n1934 0.036249999999999998
r2799 n1932 n1935 6.25
r2800 n1933 n1936 0.22321428571428573
r2801 n1935 n1936 0.036249999999999998
r2802 n1934 n1937 6.25
r2803 n1936 n1937 0.036249999999999998
r2804 n1935 n1938 6.25
r2805 n1936 n1939 0.22321428571428573
r2806 n1938 n1939 0.036249999999999998
r2807 n1937 n1940 6.25
r2808 n1939 n1940 0.036249999999999998
r2809 n1938 n1941 6.25
r2810 n1939 n1942 0.22321428571428573
r2811 n1941 n1942 0.036249999999999998
r2812 n1940 n1943 6.25
r2813 n1942 n1943 0.036249999999999998
r2814 n1941 n1944 6.25
r2815 n1942 n1945 0.22321428571428573
r2816 n1944 n1945 0.036249999999999998
r2817 n1943 n1946 6.25
r2818 n1945 n1946 0.036249999999999998
r2819 n1944 n1947 6.25
r2820 n1945 n1948 0.22321428571428573
r2821 n1947 n1948 0.036249999999999998
r2822 n1946 n1949 6.25
r2823 n1948 n1949 0.036249999999999998
r2824 n1947 n1950 6.25
r2825 n1948 n1951 0.22321428571428573
r2826 n1950 n1951 0.036249999999999998
r2827 n1949 n1952 6.25
r2828 n1951 n1952 0.036249999999999998
r2829 n1950 n1953 6.25
r2830 n1951 n1954 0.22321428571428573
r2831 n1953 n1954 0.036249999999999998
r2832 n1952 n1955 6.25
r2833 n1954 n1955 0.036249999999999998
r2834 n1953 n1956 6.25
r2835 n1954 n1957 0.22321428571428573
r2836 n1956 n1957 0.036249999999999998
r2837 n1955 n1958 6.25
r2838 n1957 n1958 0.036249999999999998
r2839 n1956 n1959 6.25
r2840 n1957 n1960 0.22321428571428573
r2841 n1959 n1960 0.036249999999999998
r2842 n1958 n1961 6.25
r2843 n1960 n1961 0.036249999999999998
r2844 n1959 n1962 6.25
r2845 n1960 n1963 0.22321428571428573
r2846 n1962 n1963 0.036249999999999998
r2847 n1961 n1964 6.25
r2848 n1963 n1964 0.036249999999999998
r2849 n1962 n1965 6.25
r2850 n1963 n1966 0.22321428571428573
r2851 n1965 n1966 0.036249999999999998
r2852 n1964 n1967 6.25
r2853 n1966 n1967 0.036249999999999998
r2854 n1965 n1968 6.25
r2855 n1966 n1969 0.22321428571428573
r2856 n1968 n1969 0.036249999999999998
r2857 n1967 n1970 6.25
r2858 n1969 n1970 0.036249999999999998
r2859 n1968 n1971 6.25
r2860 n1969 n1972 0.22321428571428573
r2861 n1971 n1972 0.036249999999999998
r2862 n1970 n1973 6.25
r2863 n1972 n1973 0.036249999999999998
r2864 n1971 n1974 6.25
r2865 n1972 n1975 0.22321428571428573
r2866 n1974 n1975 0.036249999999999998
r2867 n1973 n1976 6.25
r2868 n1975 n1976 0.036249999999999998
r2869 n1974 n1977 6.25
r2870 n1975 n1978 0.22321428571428573
r2871 n1977 n1978 0.036249999999999998
r2872 n1976 n1979 6.25
r2873 n1978 n1979 0.036249999999999998
r2874 n1977 n1980 6.25
r2875 n1978 n1981 0.22321428571428573
r2876 n1980 n1981 0.036249999999999998
r2877 n1979 n1982 6.25
r2878 n1981 n1982 0.036249999999999998
r2879 n1980 n1983 6.25
r2880 n1981 n1984 0.22321428571428573
r2881 n1983 n1984 0.036249999999999998
r2882 n1982 n1985 6.25
r2883 n1984 n1985 0.036249999999999998
r2884 n1983 n1986 6.25
r2885 n1984 n1987 0.22321428571428573
r2886 n1986 n1987 0.036249999999999998
r2887 n1985 n1988 6.25
r2888 n1987 n1988 0.036249999999999998
r2889 n1986 n1989 6.25
r2890 n1987 n1990 0.22321428571428573
r2891 n1989 n1990 0.036249999999999998
r2892 n1988 n1991 6.25
r2893 n1990 n1991 0.036249999999999998
r2894 n1989 n1992 6.25
r2895 n1990 n1993 0.22321428571428573
r2896 n1992 n1993 0.036249999999999998
r2897 n1991 n1994 6.25
r2898 n1993 n1994 0.036249999999999998
r2899 n1992 n1995 6.25
r2900 n1993 n1996 0.22321428571428573
r2901 n1995 n1996 0.036249999999999998
r2902 n1994 n1997 6.25
r2903 n1996 n1997 0.036249999999999998
r2904 n1995 n1998 6.25
r2905 n1996 n1999 0.22321428571428573
r2906 n1998 n1999 0.036249999999999998
r2907 n1997 n2000 6.25
r2908 n1999 n2000 0.036249999999999998
r2909 n1999 n2001 0.20089285714285715
r2910 n2001 n2002 0.17857142857142858
r2911 n2003 n2004 0.13437499999999999
r2912 n2004 n2005 0.109375
r2913 n2005 n2006 0.10000000000000001
r2914 n2006 n2007 0.10000000000000001
r2915 n2007 n2008 0.109375
r2916 n2008 n2009 0.13437499999999999
r2917 n2002 n2010 0.13392857142857142
r2918 n2003 n2011 0.26874999999999999
r2919 n2004 n2012 0.081439393939393936
r2920 n2011 n2012 0.11684782608695653
r2921 n2005 n2013 1.34375
r2922 n2012 n2013 0.095108695652173919
r2923 n2006 n2014 0.089583333333333334
r2924 n2013 n2014 0.086956521739130432
r2925 n2007 n2015 1.34375
r2926 n2014 n2015 0.086956521739130432
r2927 n2008 n2016 0.081439393939393936
r2928 n2015 n2016 0.095108695652173919
r2929 n2009 n2017 0.26874999999999999
r2930 n2016 n2017 0.11684782608695653
r2931 n2018 n2019 0.070652173913043473
r2932 n2010 n2020 0.095982142857142863
r2933 n2019 n2020 0.07880434782608696
r2934 n2020 n2021 0.07880434782608696
r2935 n2021 n2022 0.070652173913043473
r2936 n2011 n2023 0.15625
r2937 n2012 n2024 0.047348484848484848
r2938 n2023 n2024 1.34375
r2939 n2013 n2025 0.78125
r2940 n2024 n2025 1.09375
r2941 n2014 n2026 0.052083333333333336
r2942 n2025 n2026 1
r2943 n2015 n2027 0.78125
r2944 n2026 n2027 1
r2945 n2016 n2028 0.047348484848484848
r2946 n2027 n2028 1.09375
r2947 n2017 n2029 0.15625
r2948 n2028 n2029 1.34375
r2949 n2018 n2030 0.0625
r2950 n2019 n2031 1.5625
r2951 n2030 n2031 0.8125
r2952 n2020 n2032 0.055803571428571432
r2953 n2031 n2032 0.90625
r2954 n2021 n2033 1.5625
r2955 n2032 n2033 0.90625
r2956 n2022 n2034 0.0625
r2957 n2033 n2034 0.8125
r2958 n2023 n2035 0.20000000000000001
r2959 n2024 n2036 0.060606060606060608
r2960 n2035 n2036 0.089583333333333334
r2961 n2025 n2037 1
r2962 n2036 n2037 0.072916666666666671
r2963 n2026 n2038 0.066666666666666666
r2964 n2037 n2038 0.066666666666666666
r2965 n2027 n2039 1
r2966 n2038 n2039 0.066666666666666666
r2967 n2028 n2040 0.060606060606060608
r2968 n2039 n2040 0.072916666666666671
r2969 n2029 n2041 0.20000000000000001
r2970 n2040 n2041 0.089583333333333334
r2971 n2030 n2042 0.080000000000000002
r2972 n2031 n2043 2
r2973 n2042 n2043 0.054166666666666669
r2974 n2032 n2044 0.071428571428571425
r2975 n2043 n2044 0.060416666666666667
r2976 n2033 n2045 2
r2977 n2044 n2045 0.060416666666666667
r2978 n2034 n2046 0.080000000000000002
r2979 n2045 n2046 0.054166666666666669
r2980 n2035 n2047 0.20000000000000001
r2981 n2036 n2048 0.060606060606060608
r2982 n2047 n2048 1.34375
r2983 n2037 n2049 1
r2984 n2048 n2049 1.09375
r2985 n2038 n2050 0.066666666666666666
r2986 n2049 n2050 1
r2987 n2039 n2051 1
r2988 n2050 n2051 1
r2989 n2040 n2052 0.060606060606060608
r2990 n2051 n2052 1.09375
r2991 n2041 n2053 0.20000000000000001
r2992 n2052 n2053 1.34375
r2993 n2042 n2054 0.080000000000000002
r2994 n2043 n2055 2
r2995 n2054 n2055 0.8125
r2996 n2044 n2056 0.071428571428571425
r2997 n2055 n2056 0.90625
r2998 n2045 n2057 2
r2999 n2056 n2057 0.90625
r3000 n2046 n2058 0.080000000000000002
r3001 n2057 n2058 0.8125
r3002 n2047 n2059 0.15625
r3003 n2048 n2060 0.047348484848484848
r3004 n2059 n2060 0.11684782608695653
r3005 n2049 n2061 0.78125
r3006 n2060 n2061 0.095108695652173919
r3007 n2050 n2062 0.052083333333333336
r3008 n2061 n2062 0.086956521739130432
r3009 n2051 n2063 0.78125
r3010 n2062 n2063 0.086956521739130432
r3011 n2052 n2064 0.047348484848484848
r3012 n2063 n2064 0.095108695652173919
r3013 n2053 n2065 0.15625
r3014 n2064 n2065 0.11684782608695653
r3015 n2054 n2066 0.0625
r3016 n2055 n2067 1.5625
r3017 n2066 n2067 0.070652173913043473
r3018 n2056 n2068 0.055803571428571432
r3019 n2067 n2068 0.07880434782608696
r3020 n2057 n2069 1.5625
r3021 n2068 n2069 0.07880434782608696
r3022 n2058 n2070 0.0625
r3023 n2069 n2070 0.070652173913043473
r3024 n2059 n2071 0.26874999999999999
r3025 n2060 n2072 0.081439393939393936
r3026 n2071 n2072 0.13437499999999999
r3027 n2061 n2073 1.34375
r3028 n2072 n2073 0.109375
r3029 n2062 n2074 0.089583333333333334
r3030 n2073 n2074 0.10000000000000001
r3031 n2063 n2075 1.34375
r3032 n2074 n2075 0.10000000000000001
r3033 n2064 n2076 0.081439393939393936
r3034 n2075 n2076 0.109375
r3035 n2065 n2077 0.26874999999999999
r3036 n2076 n2077 0.13437499999999999
r3037 n2078 n2079 0.46875
r3038 n2079 n2080 0.3125
r3039 n2080 n2081 0.1875
r3040 n2081 n2082 0.09375
r3041 n2082 n2083 0.09375
r3042 n2083 n2084 0.0625
r3043 n2084 n2085 0.0625
r3044 n2085 n2086 0.15625
r3045 n2086 n2087 0.28125
r3046 n2087 n2088 0.1875
r3047 n2088 n2089 0.34375
r3048 n2089 n2090 0.40625
r3049 n2090 n2091 0.28125
r3050 n2091 n2092 0.25
r3051 n2092 n2093 0.09375
r3052 n2093 n2094 0.0625
r3053 n2094 n2095 0.21875
r3054 n2095 n2096 0.34375
r3055 n2096 n2097 0.1875
r3056 n2097 n2098 0.15625
r3057 n2098 n2099 0.28125
r3058 n2078 n2100 0.081250000000000003
r3059 n2079 n2101 0.16250000000000001
r3060 n2100 n2101 0.085227272727272721
r3061 n2080 n2102 0.16250000000000001
r3062 n2101 n2102 0.056818181818181816
r3063 n2081 n2103 0.8125
r3064 n2102 n2103 0.034090909090909088
r3065 n2082 n2104 0.40625
r3066 n2103 n2104 0.017045454545454544
r3067 n2083 n2105 0.8125
r3068 n2104 n2105 0.017045454545454544
r3069 n2084 n2106 0.8125
r3070 n2105 n2106 0.011363636363636364
r3071 n2085 n2107 0.8125
r3072 n2106 n2107 0.011363636363636364
r3073 n2086 n2108 0.203125
r3074 n2107 n2108 0.028409090909090908
r3075 n2087 n2109 0.16250000000000001
r3076 n2108 n2109 0.05113636363636364
r3077 n2088 n2110 0.8125
r3078 n2109 n2110 0.034090909090909088
r3079 n2089 n2111 0.081250000000000003
r3080 n2110 n2111 0.0625
r3081 n2090 n2112 0.27083333333333331
r3082 n2111 n2112 0.073863636363636367
r3083 n2091 n2113 0.13541666666666666
r3084 n2112 n2113 0.05113636363636364
r3085 n2092 n2114 0.40625
r3086 n2113 n2114 0.045454545454545456
r3087 n2093 n2115 0.8125
r3088 n2114 n2115 0.017045454545454544
r3089 n2094 n2116 0.8125
r3090 n2115 n2116 0.011363636363636364
r3091 n2095 n2117 0.13541666666666666
r3092 n2116 n2117 0.039772727272727272
r3093 n2096 n2118 0.16250000000000001
r3094 n2117 n2118 0.0625
r3095 n2097 n2119 0.8125
r3096 n2118 n2119 0.034090909090909088
r3097 n2098 n2120 0.203125
r3098 n2119 n2120 0.028409090909090908
r3099 n2099 n2121 0.16250000000000001
r3100 n2120 n2121 0.05113636363636364
r3101 n2100 n2122 0.081250000000000003
r3102 n2101 n2123 0.16250000000000001
r3103 n2122 n2123 0.46875
r3104 n2102 n2124 0.16250000000000001
r3105 n2123 n2124 0.3125
r3106 n2103 n2125 0.8125
r3107 n2124 n2125 0.1875
r3108 n2104 n2126 0.40625
r3109 n2125 n2126 0.09375
r3110 n2105 n2127 0.8125
r3111 n2126 n2127 0.09375
r3112 n2106 n2128 0.8125
r3113 n2127 n2128 0.0625
r3114 n2107 n2129 0.8125
r3115 n2128 n2129 0.0625
r3116 n2108 n2130 0.203125
r3117 n2129 n2130 0.15625
r3118 n2109 n2131 0.16250000000000001
r3119 n2130 n2131 0.28125
r3120 n2110 n2132 0.8125
r3121 n2131 n2132 0.1875
r3122 n2111 n2133 0.081250000000000003
r3123 n2132 n2133 0.34375
r3124 n2112 n2134 0.27083333333333331
r3125 n2133 n2134 0.40625
r3126 n2113 n2135 0.13541666666666666
r3127 n2134 n2135 0.28125
r3128 n2114 n2136 0.40625
r3129 n2135 n2136 0.25
r3130 n2115 n2137 0.8125
r3131 n2136 n2137 0.09375
r3132 n2116 n2138 0.8125
r3133 n2137 n2138 0.0625
r3134 n2117 n2139 0.13541666666666666
r3135 n2138 n2139 0.21875
r3136 n2118 n2140 0.16250000000000001
r3137 n2139 n2140 0.34375
r3138 n2119 n2141 0.8125
r3139 n2140 n2141 0.1875
r3140 n2120 n2142 0.203125
r3141 n2141 n2142 0.15625
r3142 n2121 n2143 0.16250000000000001
r3143 n2142 n2143 0.28125
r3144 n2122 n2144 0.20000000000000001
r3145 n2123 n2145 0.40000000000000002
r3146 n2144 n2145 0.03125
r3147 n2124 n2146 0.40000000000000002
r3148 n2145 n2146 0.020833333333333332
r3149 n2125 n2147 2
r3150 n2146 n2147 0.012500000000000001
r3151 n2126 n2148 1
r3152 n2147 n2148 0.0062500000000000003
r3153 n2127 n2149 2
r3154 n2148 n2149 0.0062500000000000003
r3155 n2128 n2150 2
r3156 n2149 n2150 0.0041666666666666666
r3157 n2129 n2151 2
r3158 n2150 n2151 0.0041666666666666666
r3159 n2130 n2152 0.5
r3160 n2151 n2152 0.010416666666666666
r3161 n2131 n2153 0.40000000000000002
r3162 n2152 n2153 0.018749999999999999
r3163 n2132 n2154 2
r3164 n2153 n2154 0.012500000000000001
r3165 n2133 n2155 0.20000000000000001
r3166 n2154 n2155 0.022916666666666665
r3167 n2134 n2156 0.66666666666666663
r3168 n2155 n2156 0.027083333333333334
r3169 n2135 n2157 0.33333333333333331
r3170 n2156 n2157 0.018749999999999999
r3171 n2136 n2158 1
r3172 n2157 n2158 0.016666666666666666
r3173 n2137 n2159 2
r3174 n2158 n2159 0.0062500000000000003
r3175 n2138 n2160 2
r3176 n2159 n2160 0.0041666666666666666
r3177 n2139 n2161 0.33333333333333331
r3178 n2160 n2161 0.014583333333333334
r3179 n2140 n2162 0.40000000000000002
r3180 n2161 n2162 0.022916666666666665
r3181 n2141 n2163 2
r3182 n2162 n2163 0.012500000000000001
r3183 n2142 n2164 0.5
r3184 n2163 n2164 0.010416666666666666
r3185 n2143 n2165 0.40000000000000002
r3186 n2164 n2165 0.018749999999999999
r3187 n2144 n2166 0.20000000000000001
r3188 n2145 n2167 0.40000000000000002
r3189 n2166 n2167 0.46875
r3190 n2146 n2168 0.40000000000000002
r3191 n2167 n2168 0.3125
r3192 n2147 n2169 2
r3193 n2168 n2169 0.1875
r3194 n2148 n2170 1
r3195 n2169 n2170 0.09375
r3196 n2149 n2171 2
r3197 n2170 n2171 0.09375
r3198 n2150 n2172 2
r3199 n2171 n2172 0.0625
r3200 n2151 n2173 2
r3201 n2172 n2173 0.0625
r3202 n2152 n2174 0.5
r3203 n2173 n2174 0.15625
r3204 n2153 n2175 0.40000000000000002
r3205 n2174 n2175 0.28125
r3206 n2154 n2176 2
r3207 n2175 n2176 0.1875
r3208 n2155 n2177 0.20000000000000001
r3209 n2176 n2177 0.34375
r3210 n2156 n2178 0.66666666666666663
r3211 n2177 n2178 0.40625
r3212 n2157 n2179 0.33333333333333331
r3213 n2178 n2179 0.28125
r3214 n2158 n2180 1
r3215 n2179 n2180 0.25
r3216 n2159 n2181 2
r3217 n2180 n2181 0.09375
r3218 n2160 n2182 2
r3219 n2181 n2182 0.0625
r3220 n2161 n2183 0.33333333333333331
r3221 n2182 n2183 0.21875
r3222 n2162 n2184 0.40000000000000002
r3223 n2183 n2184 0.34375
r3224 n2163 n2185 2
r3225 n2184 n2185 0.1875
r3226 n2164 n2186 0.5
r3227 n2185 n2186 0.15625
r3228 n2165 n2187 0.40000000000000002
r3229 n2186 n2187 0.28125
r3230 n2166 n2188 0.081250000000000003
r3231 n2167 n2189 0.16250000000000001
r3232 n2188 n2189 0.085227272727272721
r3233 n2168 n2190 0.16250000000000001
r3234 n2189 n2190 0.056818181818181816
r3235 n2169 n2191 0.8125
r3236 n2190 n2191 0.034090909090909088
r3237 n2170 n2192 0.40625
r3238 n2191 n2192 0.017045454545454544
r3239 n2171 n2193 0.8125
r3240 n2192 n2193 0.017045454545454544
r3241 n2172 n2194 0.8125
r3242 n2193 n2194 0.011363636363636364
r3243 n2173 n2195 0.8125
r3244 n2194 n2195 0.011363636363636364
r3245 n2174 n2196 0.203125
r3246 n2195 n2196 0.028409090909090908
r3247 n2175 n2197 0.16250000000000001
r3248 n2196 n2197 0.05113636363636364
r3249 n2176 n2198 0.8125
r3250 n2197 n2198 0.034090909090909088
r3251 n2177 n2199 0.081250000000000003
r3252 n2198 n2199 0.0625
r3253 n2178 n2200 0.27083333333333331
r3254 n2199 n2200 0.073863636363636367
r3255 n2179 n2201 0.13541666666666666
r3256 n2200 n2201 0.05113636363636364
r3257 n2180 n2202 0.40625
r3258 n2201 n2202 0.045454545454545456
r3259 n2181 n2203 0.8125
r3260 n2202 n2203 0.017045454545454544
r3261 n2182 n2204 0.8125
r3262 n2203 n2204 0.011363636363636364
r3263 n2183 n2205 0.13541666666666666
r3264 n2204 n2205 0.039772727272727272
r3265 n2184 n2206 0.16250000000000001
r3266 n2205 n2206 0.0625
r3267 n2185 n2207 0.8125
r3268 n2206 n2207 0.034090909090909088
r3269 n2186 n2208 0.203125
r3270 n2207 n2208 0.028409090909090908
r3271 n2187 n2209 0.16250000000000001
r3272 n2208 n2209 0.05113636363636364
r3273 n2188 n2210 0.081250000000000003
r3274 n2189 n2211 0.16250000000000001
r3275 n2210 n2211 0.46875
r3276 n2190 n2212 0.16250000000000001
r3277 n2211 n2212 0.3125
r3278 n2191 n2213 0.8125
r3279 n2212 n2213 0.1875
r3280 n2192 n2214 0.40625
r3281 n2213 n2214 0.09375
r3282 n2193 n2215 0.8125
r3283 n2214 n2215 0.09375
r3284 n2194 n2216 0.8125
r3285 n2215 n2216 0.0625
r3286 n2195 n2217 0.8125
r3287 n2216 n2217 0.0625
r3288 n2196 n2218 0.203125
r3289 n2217 n2218 0.15625
r3290 n2197 n2219 0.16250000000000001
r3291 n2218 n2219 0.28125
r3292 n2198 n2220 0.8125
r3293 n2219 n2220 0.1875
r3294 n2199 n2221 0.081250000000000003
r3295 n2220 n2221 0.34375
r3296 n2200 n2222 0.27083333333333331
r3297 n2221 n2222 0.40625
r3298 n2201 n2223 0.13541666666666666
r3299 n2222 n2223 0.28125
r3300 n2202 n2224 0.40625
r3301 n2223 n2224 0.25
r3302 n2203 n2225 0.8125
r3303 n2224 n2225 0.09375
r3304 n2204 n2226 0.8125
r3305 n2225 n2226 0.0625
r3306 n2205 n2227 0.13541666666666666
r3307 n2226 n2227 0.21875
r3308 n2206 n2228 0.16250000000000001
r3309 n2227 n2228 0.34375
r3310 n2207 n2229 0.8125
r3311 n2228 n2229 0.1875
r3312 n2208 n2230 0.203125
r3313 n2229 n2230 0.15625
r3314 n2209 n2231 0.16250000000000001
r3315 n2230 n2231 0.28125
r3316 n2232 n2233 0.46875
r3317 n2233 n2234 0.3125
r3318 n2234 n2235 0.1875
r3319 n2235 n2236 0.125
r3320 n2236 n2237 0.125
r3321 n2237 n2238 0.3125
r3322 n2238 n2239 0.59375
r3323 n2239 n2240 0.46875
r3324 n2240 n2241 0.3125
r3325 n2241 n2242 0.1875
r3326 n2242 n2243 0.09375
r3327 n2243 n2244 0.09375
r3328 n2244 n2245 0.0625
r3329 n2245 n2246 0.0625
r3330 n2246 n2247 0.15625
r3331 n2247 n2248 0.28125
r3332 n2248 n2249 0.1875
r3333 n2249 n2250 0.34375
r3334 n2232 n2251 0.043749999999999997
r3335 n2233 n2252 0.087499999999999994
r3336 n2251 n2252 0.1875
r3337 n2234 n2253 0.087499999999999994
r3338 n2252 n2253 0.125
r3339 n2235 n2254 0.4375
r3340 n2253 n2254 0.074999999999999997
r3341 n2236 n2255 0.14583333333333334
r3342 n2254 n2255 0.050000000000000003
r3343 n2237 n2256 0.4375
r3344 n2255 n2256 0.050000000000000003
r3345 n2238 n2257 0.048611111111111112
r3346 n2256 n2257 0.125
r3347 n2239 n2258 0.043749999999999997
r3348 n2257 n2258 0.23749999999999999
r3349 n2240 n2259 0.087499999999999994
r3350 n2258 n2259 0.1875
r3351 n2241 n2260 0.087499999999999994
r3352 n2259 n2260 0.125
r3353 n2242 n2261 0.4375
r3354 n2260 n2261 0.074999999999999997
r3355 n2243 n2262 0.21875
r3356 n2261 n2262 0.037499999999999999
r3357 n2244 n2263 0.4375
r3358 n2262 n2263 0.037499999999999999
r3359 n2245 n2264 0.4375
r3360 n2263 n2264 0.025000000000000001
r3361 n2246 n2265 0.4375
r3362 n2264 n2265 0.025000000000000001
r3363 n2247 n2266 0.109375
r3364 n2265 n2266 0.0625
r3365 n2248 n2267 0.087499999999999994
r3366 n2266 n2267 0.1125
r3367 n2249 n2268 0.4375
r3368 n2267 n2268 0.074999999999999997
r3369 n2250 n2269 0.043749999999999997
r3370 n2268 n2269 0.13750000000000001
r3371 n2270 n2271 0.11458333333333333
r3372 n2271 n2272 0.0625
r3373 n2272 n2273 0.14583333333333334
r3374 n2251 n2274 0.068750000000000006
r3375 n2273 n2274 0.23958333333333334
r3376 n2252 n2275 0.13750000000000001
r3377 n2274 n2275 0.15625
r3378 n2253 n2276 0.13750000000000001
r3379 n2275 n2276 0.10416666666666667
r3380 n2254 n2277 0.6875
r3381 n2276 n2277 0.0625
r3382 n2255 n2278 0.22916666666666666
r3383 n2277 n2278 0.041666666666666664
r3384 n2256 n2279 0.6875
r3385 n2278 n2279 0.041666666666666664
r3386 n2257 n2280 0.076388888888888895
r3387 n2279 n2280 0.10416666666666667
r3388 n2258 n2281 0.068750000000000006
r3389 n2280 n2281 0.19791666666666666
r3390 n2259 n2282 0.13750000000000001
r3391 n2281 n2282 0.15625
r3392 n2260 n2283 0.13750000000000001
r3393 n2282 n2283 0.10416666666666667
r3394 n2261 n2284 0.6875
r3395 n2283 n2284 0.0625
r3396 n2262 n2285 0.34375
r3397 n2284 n2285 0.03125
r3398 n2263 n2286 0.6875
r3399 n2285 n2286 0.03125
r3400 n2264 n2287 0.6875
r3401 n2286 n2287 0.020833333333333332
r3402 n2265 n2288 0.6875
r3403 n2287 n2288 0.020833333333333332
r3404 n2266 n2289 0.171875
r3405 n2288 n2289 0.052083333333333336
r3406 n2267 n2290 0.13750000000000001
r3407 n2289 n2290 0.09375
r3408 n2268 n2291 0.6875
r3409 n2290 n2291 0.0625
r3410 n2269 n2292 0.068750000000000006
r3411 n2291 n2292 0.11458333333333333
r3412 n2292 n2293 0.13541666666666666
r3413 n2293 n2294 0.09375
r3414 n2294 n2295 0.083333333333333329
r3415 n2295 n2296 0.03125
r3416 n2296 n2297 0.020833333333333332
r3417 n2297 n2298 0.072916666666666671
r3418 n2298 n2299 0.11458333333333333
r3419 n2299 n2300 0.0625
r3420 n2270 n2301 0.083333333333333329
r3421 n2271 n2302 0.10000000000000001
r3422 n2301 n2302 0.34375
r3423 n2272 n2303 0.5
r3424 n2302 n2303 0.1875
r3425 n2273 n2304 0.038461538461538464
r3426 n2303 n2304 0.4375
r3427 n2274 n2305 0.050000000000000003
r3428 n2304 n2305 0.71875
r3429 n2275 n2306 0.10000000000000001
r3430 n2305 n2306 0.46875
r3431 n2276 n2307 0.10000000000000001
r3432 n2306 n2307 0.3125
r3433 n2277 n2308 0.5
r3434 n2307 n2308 0.1875
r3435 n2278 n2309 0.16666666666666666
r3436 n2308 n2309 0.125
r3437 n2279 n2310 0.5
r3438 n2309 n2310 0.125
r3439 n2280 n2311 0.055555555555555552
r3440 n2310 n2311 0.3125
r3441 n2281 n2312 0.050000000000000003
r3442 n2311 n2312 0.59375
r3443 n2282 n2313 0.10000000000000001
r3444 n2312 n2313 0.46875
r3445 n2283 n2314 0.10000000000000001
r3446 n2313 n2314 0.3125
r3447 n2284 n2315 0.5
r3448 n2314 n2315 0.1875
r3449 n2285 n2316 0.25
r3450 n2315 n2316 0.09375
r3451 n2286 n2317 0.5
r3452 n2316 n2317 0.09375
r3453 n2287 n2318 0.5
r3454 n2317 n2318 0.0625
r3455 n2288 n2319 0.5
r3456 n2318 n2319 0.0625
r3457 n2289 n2320 0.125
r3458 n2319 n2320 0.15625
r3459 n2290 n2321 0.10000000000000001
r3460 n2320 n2321 0.28125
r3461 n2291 n2322 0.5
r3462 n2321 n2322 0.1875
r3463 n2292 n2323 0.050000000000000003
r3464 n2322 n2323 0.34375
r3465 n2293 n2324 0.16666666666666666
r3466 n2323 n2324 0.40625
r3467 n2294 n2325 0.083333333333333329
r3468 n2324 n2325 0.28125
r3469 n2295 n2326 0.25
r3470 n2325 n2326 0.25
r3471 n2296 n2327 0.5
r3472 n2326 n2327 0.09375
r3473 n2297 n2328 0.5
r3474 n2327 n2328 0.0625
r3475 n2298 n2329 0.083333333333333329
r3476 n2328 n2329 0.21875
r3477 n2299 n2330 0.10000000000000001
r3478 n2329 n2330 0.34375
r3479 n2300 n2331 0.5
r3480 n2330 n2331 0.1875
r3481 n2301 n2332 0.1875
r3482 n2302 n2333 0.22500000000000001
r3483 n2332 n2333 0.04296875
r3484 n2303 n2334 1.125
r3485 n2333 n2334 0.0234375
r3486 n2304 n2335 0.086538461538461536
r3487 n2334 n2335 0.0546875
r3488 n2305 n2336 0.1125
r3489 n2335 n2336 0.08984375
r3490 n2306 n2337 0.22500000000000001
r3491 n2336 n2337 0.05859375
r3492 n2307 n2338 0.22500000000000001
r3493 n2337 n2338 0.0390625
r3494 n2308 n2339 1.125
r3495 n2338 n2339 0.0234375
r3496 n2309 n2340 0.375
r3497 n2339 n2340 0.015625
r3498 n2310 n2341 1.125
r3499 n2340 n2341 0.015625
r3500 n2311 n2342 0.125
r3501 n2341 n2342 0.0390625
r3502 n2312 n2343 0.1125
r3503 n2342 n2343 0.07421875
r3504 n2313 n2344 0.22500000000000001
r3505 n2343 n2344 0.05859375
r3506 n2314 n2345 0.22500000000000001
r3507 n2344 n2345 0.0390625
r3508 n2315 n2346 1.125
r3509 n2345 n2346 0.0234375
r3510 n2316 n2347 0.5625
r3511 n2346 n2347 0.01171875
r3512 n2317 n2348 1.125
r3513 n2347 n2348 0.01171875
r3514 n2318 n2349 1.125
r3515 n2348 n2349 0.0078125
r3516 n2319 n2350 1.125
r3517 n2349 n2350 0.0078125
r3518 n2320 n2351 0.28125
r3519 n2350 n2351 0.01953125
r3520 n2321 n2352 0.22500000000000001
r3521 n2351 n2352 0.03515625
r3522 n2322 n2353 1.125
r3523 n2352 n2353 0.0234375
r3524 n2323 n2354 0.1125
r3525 n2353 n2354 0.04296875
r3526 n2324 n2355 0.375
r3527 n2354 n2355 0.05078125
r3528 n2325 n2356 0.1875
r3529 n2355 n2356 0.03515625
r3530 n2326 n2357 0.5625
r3531 n2356 n2357 0.03125
r3532 n2327 n2358 1.125
r3533 n2357 n2358 0.01171875
r3534 n2328 n2359 1.125
r3535 n2358 n2359 0.0078125
r3536 n2329 n2360 0.1875
r3537 n2359 n2360 0.02734375
r3538 n2330 n2361 0.22500000000000001
r3539 n2360 n2361 0.04296875
r3540 n2331 n2362 1.125
r3541 n2361 n2362 0.0234375
r3542 n2332 n2363 0.3125
r3543 n2333 n2364 0.375
r3544 n2363 n2364 0.049107142857142856
r3545 n2334 n2365 1.875
r3546 n2364 n2365 0.026785714285714284
r3547 n2335 n2366 0.14423076923076922
r3548 n2365 n2366 0.0625
r3549 n2336 n2367 0.1875
r3550 n2366 n2367 0.10267857142857142
r3551 n2337 n2368 0.375
r3552 n2367 n2368 0.066964285714285712
r3553 n2338 n2369 0.375
r3554 n2368 n2369 0.044642857142857144
r3555 n2339 n2370 1.875
r3556 n2369 n2370 0.026785714285714284
r3557 n2340 n2371 0.625
r3558 n2370 n2371 0.017857142857142856
r3559 n2341 n2372 1.875
r3560 n2371 n2372 0.017857142857142856
r3561 n2342 n2373 0.20833333333333334
r3562 n2372 n2373 0.044642857142857144
r3563 n2343 n2374 0.1875
r3564 n2373 n2374 0.084821428571428575
r3565 n2344 n2375 0.375
r3566 n2374 n2375 0.066964285714285712
r3567 n2345 n2376 0.375
r3568 n2375 n2376 0.044642857142857144
r3569 n2346 n2377 1.875
r3570 n2376 n2377 0.026785714285714284
r3571 n2347 n2378 0.9375
r3572 n2377 n2378 0.013392857142857142
r3573 n2348 n2379 1.875
r3574 n2378 n2379 0.013392857142857142
r3575 n2349 n2380 1.875
r3576 n2379 n2380 0.0089285714285714281
r3577 n2350 n2381 1.875
r3578 n2380 n2381 0.0089285714285714281
r3579 n2351 n2382 0.46875
r3580 n2381 n2382 0.022321428571428572
r3581 n2352 n2383 0.375
r3582 n2382 n2383 0.040178571428571432
r3583 n2353 n2384 1.875
r3584 n2383 n2384 0.026785714285714284
r3585 n2354 n2385 0.1875
r3586 n2384 n2385 0.049107142857142856
r3587 n2355 n2386 0.625
r3588 n2385 n2386 0.058035714285714288
r3589 n2356 n2387 0.3125
r3590 n2386 n2387 0.040178571428571432
r3591 n2357 n2388 0.9375
r3592 n2387 n2388 0.035714285714285712
r3593 n2358 n2389 1.875
r3594 n2388 n2389 0.013392857142857142
r3595 n2359 n2390 1.875
r3596 n2389 n2390 0.0089285714285714281
r3597 n2360 n2391 0.3125
r3598 n2390 n2391 0.03125
r3599 n2361 n2392 0.375
r3600 n2391 n2392 0.049107142857142856
r3601 n2362 n2393 1.875
r3602 n2392 n2393 0.026785714285714284
r3603 n2363 n2394 0.16666666666666666
r3604 n2364 n2395 0.20000000000000001
r3605 n2394 n2395 0.34375
r3606 n2365 n2396 1
r3607 n2395 n2396 0.1875
r3608 n2366 n2397 0.076923076923076927
r3609 n2396 n2397 0.4375
r3610 n2367 n2398 0.10000000000000001
r3611 n2397 n2398 0.71875
r3612 n2368 n2399 0.20000000000000001
r3613 n2398 n2399 0.46875
r3614 n2369 n2400 0.20000000000000001
r3615 n2399 n2400 0.3125
r3616 n2370 n2401 1
r3617 n2400 n2401 0.1875
r3618 n2371 n2402 0.33333333333333331
r3619 n2401 n2402 0.125
r3620 n2372 n2403 1
r3621 n2402 n2403 0.125
r3622 n2373 n2404 0.1111111111111111
r3623 n2403 n2404 0.3125
r3624 n2374 n2405 0.10000000000000001
r3625 n2404 n2405 0.59375
r3626 n2375 n2406 0.20000000000000001
r3627 n2405 n2406 0.46875
r3628 n2376 n2407 0.20000000000000001
r3629 n2406 n2407 0.3125
r3630 n2377 n2408 1
r3631 n2407 n2408 0.1875
r3632 n2378 n2409 0.5
r3633 n2408 n2409 0.09375
r3634 n2379 n2410 1
r3635 n2409 n2410 0.09375
r3636 n2380 n2411 1
r3637 n2410 n2411 0.0625
r3638 n2381 n2412 1
r3639 n2411 n2412 0.0625
r3640 n2382 n2413 0.25
r3641 n2412 n2413 0.15625
r3642 n2383 n2414 0.20000000000000001
r3643 n2413 n2414 0.28125
r3644 n2384 n2415 1
r3645 n2414 n2415 0.1875
r3646 n2385 n2416 0.10000000000000001
r3647 n2415 n2416 0.34375
r3648 n2386 n2417 0.33333333333333331
r3649 n2416 n2417 0.40625
r3650 n2387 n2418 0.16666666666666666
r3651 n2417 n2418 0.28125
r3652 n2388 n2419 0.5
r3653 n2418 n2419 0.25
r3654 n2389 n2420 1
r3655 n2419 n2420 0.09375
r3656 n2390 n2421 1
r3657 n2420 n2421 0.0625
r3658 n2391 n2422 0.16666666666666666
r3659 n2421 n2422 0.21875
r3660 n2392 n2423 0.20000000000000001
r3661 n2422 n2423 0.34375
r3662 n2393 n2424 1
r3663 n2423 n2424 0.1875
r3664 n2394 n2425 0.0625
r3665 n2395 n2426 0.074999999999999997
r3666 n2425 n2426 0.171875
r3667 n2396 n2427 0.375
r3668 n2426 n2427 0.09375
r3669 n2397 n2428 0.028846153846153848
r3670 n2427 n2428 0.21875
r3671 n2398 n2429 0.037499999999999999
r3672 n2428 n2429 0.359375
r3673 n2399 n2430 0.074999999999999997
r3674 n2429 n2430 0.234375
r3675 n2400 n2431 0.074999999999999997
r3676 n2430 n2431 0.15625
r3677 n2401 n2432 0.375
r3678 n2431 n2432 0.09375
r3679 n2402 n2433 0.125
r3680 n2432 n2433 0.0625
r3681 n2403 n2434 0.375
r3682 n2433 n2434 0.0625
r3683 n2404 n2435 0.041666666666666664
r3684 n2434 n2435 0.15625
r3685 n2405 n2436 0.037499999999999999
r3686 n2435 n2436 0.296875
r3687 n2406 n2437 0.074999999999999997
r3688 n2436 n2437 0.234375
r3689 n2407 n2438 0.074999999999999997
r3690 n2437 n2438 0.15625
r3691 n2408 n2439 0.375
r3692 n2438 n2439 0.09375
r3693 n2409 n2440 0.1875
r3694 n2439 n2440 0.046875
r3695 n2410 n2441 0.375
r3696 n2440 n2441 0.046875
r3697 n2411 n2442 0.375
r3698 n2441 n2442 0.03125
r3699 n2412 n2443 0.375
r3700 n2442 n2443 0.03125
r3701 n2413 n2444 0.09375
r3702 n2443 n2444 0.078125
r3703 n2414 n2445 0.074999999999999997
r3704 n2444 n2445 0.140625
r3705 n2415 n2446 0.375
r3706 n2445 n2446 0.09375
r3707 n2416 n2447 0.037499999999999999
r3708 n2446 n2447 0.171875
r3709 n2417 n2448 0.125
r3710 n2447 n2448 0.203125
r3711 n2418 n2449 0.0625
r3712 n2448 n2449 0.140625
r3713 n2419 n2450 0.1875
r3714 n2449 n2450 0.125
r3715 n2420 n2451 0.375
r3716 n2450 n2451 0.046875
r3717 n2421 n2452 0.375
r3718 n2451 n2452 0.03125
r3719 n2422 n2453 0.0625
r3720 n2452 n2453 0.109375
r3721 n2423 n2454 0.074999999999999997
r3722 n2453 n2454 0.171875
r3723 n2424 n2455 0.375
r3724 n2454 n2455 0.09375
r3725 n2456 n2457 0.125
r3726 n2457 n2458 0.296875
r3727 n2458 n2459 0.46875
r3728 n2459 n2460 0.234375
r3729 n2460 n2461 0.0625
r3730 n2461 n2462 0.09375
r3731 n2425 n2463 0.0625
r3732 n2426 n2464 0.074999999999999997
r3733 n2463 n2464 0.34375
r3734 n2427 n2465 0.375
r3735 n2464 n2465 0.1875
r3736 n2428 n2466 0.028846153846153848
r3737 n2465 n2466 0.4375
r3738 n2429 n2467 0.037499999999999999
r3739 n2466 n2467 0.71875
r3740 n2430 n2468 0.074999999999999997
r3741 n2467 n2468 0.46875
r3742 n2431 n2469 0.074999999999999997
r3743 n2468 n2469 0.3125
r3744 n2432 n2470 0.375
r3745 n2469 n2470 0.1875
r3746 n2433 n2471 0.125
r3747 n2470 n2471 0.125
r3748 n2434 n2472 0.375
r3749 n2471 n2472 0.125
r3750 n2435 n2473 0.041666666666666664
r3751 n2472 n2473 0.3125
r3752 n2436 n2474 0.037499999999999999
r3753 n2473 n2474 0.59375
r3754 n2437 n2475 0.074999999999999997
r3755 n2474 n2475 0.46875
r3756 n2438 n2476 0.074999999999999997
r3757 n2475 n2476 0.3125
r3758 n2439 n2477 0.375
r3759 n2476 n2477 0.1875
r3760 n2440 n2478 0.1875
r3761 n2477 n2478 0.09375
r3762 n2441 n2479 0.375
r3763 n2478 n2479 0.09375
r3764 n2442 n2480 0.375
r3765 n2479 n2480 0.0625
r3766 n2443 n2481 0.375
r3767 n2480 n2481 0.0625
r3768 n2444 n2482 0.09375
r3769 n2481 n2482 0.15625
r3770 n2445 n2483 0.074999999999999997
r3771 n2482 n2483 0.28125
r3772 n2446 n2484 0.375
r3773 n2483 n2484 0.1875
r3774 n2447 n2485 0.037499999999999999
r3775 n2484 n2485 0.34375
r3776 n2448 n2486 0.125
r3777 n2485 n2486 0.40625
r3778 n2449 n2487 0.0625
r3779 n2486 n2487 0.28125
r3780 n2450 n2488 0.1875
r3781 n2487 n2488 0.25
r3782 n2451 n2489 0.375
r3783 n2488 n2489 0.09375
r3784 n2452 n2490 0.375
r3785 n2489 n2490 0.0625
r3786 n2453 n2491 0.0625
r3787 n2490 n2491 0.21875
r3788 n2454 n2492 0.074999999999999997
r3789 n2491 n2492 0.34375
r3790 n2455 n2493 0.375
r3791 n2492 n2493 0.1875
r3792 n2456 n2494 0.0625
r3793 n2457 n2495 0.1875
r3794 n2494 n2495 0.25
r3795 n2458 n2496 0.022058823529411766
r3796 n2495 n2496 0.59375
r3797 n2459 n2497 0.028846153846153848
r3798 n2496 n2497 0.9375
r3799 n2460 n2498 0.1875
r3800 n2497 n2498 0.46875
r3801 n2461 n2499 0.1875
r3802 n2498 n2499 0.125
r3803 n2462 n2500 0.09375
r3804 n2499 n2500 0.1875
r3805 n2467 n2501 0.018749999999999999
r3806 n2468 n2502 0.037499999999999999
r3807 n2501 n2502 0.9375
r3808 n2469 n2503 0.037499999999999999
r3809 n2502 n2503 0.625
r3810 n2470 n2504 0.1875
r3811 n2503 n2504 0.375
r3812 n2471 n2505 0.0625
r3813 n2504 n2505 0.25
r3814 n2472 n2506 0.1875
r3815 n2505 n2506 0.25
r3816 n2473 n2507 0.020833333333333332
r3817 n2506 n2507 0.625
r3818 n2474 n2508 0.018749999999999999
r3819 n2507 n2508 1.1875
r3820 n2475 n2509 0.037499999999999999
r3821 n2508 n2509 0.9375
r3822 n2476 n2510 0.037499999999999999
r3823 n2509 n2510 0.625
r3824 n2477 n2511 0.1875
r3825 n2510 n2511 0.375
r3826 n2478 n2512 0.09375
r3827 n2511 n2512 0.1875
r3828 n2479 n2513 0.1875
r3829 n2512 n2513 0.1875
r3830 n2480 n2514 0.1875
r3831 n2513 n2514 0.125
r3832 n2481 n2515 0.1875
r3833 n2514 n2515 0.125
r3834 n2482 n2516 0.046875
r3835 n2515 n2516 0.3125
r3836 n2483 n2517 0.037499999999999999
r3837 n2516 n2517 0.5625
r3838 n2484 n2518 0.1875
r3839 n2517 n2518 0.375
r3840 n2485 n2519 0.018749999999999999
r3841 n2518 n2519 0.6875
r3842 n2494 n2520 0.03125
r3843 n2495 n2521 0.09375
r3844 n2520 n2521 0.5
r3845 n2496 n2522 0.011029411764705883
r3846 n2521 n2522 1.1875
r3847 n2497 n2523 0.014423076923076924
r3848 n2522 n2523 1.875
r3849 n2498 n2524 0.09375
r3850 n2523 n2524 0.9375
r3851 n2499 n2525 0.09375
r3852 n2524 n2525 0.25
r3853 n2500 n2526 0.046875
r3854 n2525 n2526 0.375
r3855 n2501 n2527 0.03125
r3856 n2502 n2528 0.0625
r3857 n2527 n2528 0.234375
r3858 n2503 n2529 0.0625
r3859 n2528 n2529 0.15625
r3860 n2504 n2530 0.3125
r3861 n2529 n2530 0.09375
r3862 n2505 n2531 0.10416666666666667
r3863 n2530 n2531 0.0625
r3864 n2506 n2532 0.3125
r3865 n2531 n2532 0.0625
r3866 n2507 n2533 0.034722222222222224
r3867 n2532 n2533 0.15625
r3868 n2508 n2534 0.03125
r3869 n2533 n2534 0.296875
r3870 n2509 n2535 0.0625
r3871 n2534 n2535 0.234375
r3872 n2510 n2536 0.0625
r3873 n2535 n2536 0.15625
r3874 n2511 n2537 0.3125
r3875 n2536 n2537 0.09375
r3876 n2512 n2538 0.15625
r3877 n2537 n2538 0.046875
r3878 n2513 n2539 0.3125
r3879 n2538 n2539 0.046875
r3880 n2514 n2540 0.3125
r3881 n2539 n2540 0.03125
r3882 n2515 n2541 0.3125
r3883 n2540 n2541 0.03125
r3884 n2516 n2542 0.078125
r3885 n2541 n2542 0.078125
r3886 n2517 n2543 0.0625
r3887 n2542 n2543 0.140625
r3888 n2518 n2544 0.3125
r3889 n2543 n2544 0.09375
r3890 n2519 n2545 0.03125
r3891 n2544 n2545 0.171875
r3892 n2546 n2547 0.1875
r3893 n2547 n2548 0.203125
r3894 n2520 n2549 0.052083333333333336
r3895 n2548 n2549 0.171875
r3896 n2521 n2550 0.15625
r3897 n2549 n2550 0.125
r3898 n2522 n2551 0.018382352941176471
r3899 n2550 n2551 0.296875
r3900 n2523 n2552 0.02403846153846154
r3901 n2551 n2552 0.46875
r3902 n2524 n2553 0.15625
r3903 n2552 n2553 0.234375
r3904 n2525 n2554 0.15625
r3905 n2553 n2554 0.0625
r3906 n2526 n2555 0.078125
r3907 n2554 n2555 0.09375
r3908 n2555 n2556 0.140625
r3909 n2556 n2557 0.203125
r3910 n2557 n2558 0.1875
r3911 n2527 n2559 0.037499999999999999
r3912 n2528 n2560 0.074999999999999997
r3913 n2559 n2560 0.46875
r3914 n2529 n2561 0.074999999999999997
r3915 n2560 n2561 0.3125
r3916 n2530 n2562 0.375
r3917 n2561 n2562 0.1875
r3918 n2531 n2563 0.125
r3919 n2562 n2563 0.125
r3920 n2532 n2564 0.375
r3921 n2563 n2564 0.125
r3922 n2533 n2565 0.041666666666666664
r3923 n2564 n2565 0.3125
r3924 n2534 n2566 0.037499999999999999
r3925 n2565 n2566 0.59375
r3926 n2535 n2567 0.074999999999999997
r3927 n2566 n2567 0.46875
r3928 n2536 n2568 0.074999999999999997
r3929 n2567 n2568 0.3125
r3930 n2537 n2569 0.375
r3931 n2568 n2569 0.1875
r3932 n2538 n2570 0.1875
r3933 n2569 n2570 0.09375
r3934 n2539 n2571 0.375
r3935 n2570 n2571 0.09375
r3936 n2540 n2572 0.375
r3937 n2571 n2572 0.0625
r3938 n2541 n2573 0.375
r3939 n2572 n2573 0.0625
r3940 n2542 n2574 0.09375
r3941 n2573 n2574 0.15625
r3942 n2543 n2575 0.074999999999999997
r3943 n2574 n2575 0.28125
r3944 n2544 n2576 0.375
r3945 n2575 n2576 0.1875
r3946 n2545 n2577 0.037499999999999999
r3947 n2576 n2577 0.34375
r3948 n2546 n2578 0.09375
r3949 n2547 n2579 0.046875
r3950 n2578 n2579 0.375
r3951 n2548 n2580 0.074999999999999997
r3952 n2579 n2580 0.40625
r3953 n2549 n2581 0.0625
r3954 n2580 n2581 0.34375
r3955 n2550 n2582 0.1875
r3956 n2581 n2582 0.25
r3957 n2551 n2583 0.022058823529411766
r3958 n2582 n2583 0.59375
r3959 n2552 n2584 0.028846153846153848
r3960 n2583 n2584 0.9375
r3961 n2553 n2585 0.1875
r3962 n2584 n2585 0.46875
r3963 n2554 n2586 0.1875
r3964 n2585 n2586 0.125
r3965 n2555 n2587 0.09375
r3966 n2586 n2587 0.1875
r3967 n2556 n2588 0.074999999999999997
r3968 n2587 n2588 0.28125
r3969 n2557 n2589 0.046875
r3970 n2588 n2589 0.40625
r3971 n2558 n2590 0.09375
r3972 n2589 n2590 0.375
r3973 n2578 n2591 0.109375
r3974 n2579 n2592 0.0546875
r3975 n2591 n2592 0.14999999999999999
r3976 n2580 n2593 0.087499999999999994
r3977 n2592 n2593 0.16250000000000001
r3978 n2581 n2594 0.072916666666666671
r3979 n2593 n2594 0.13750000000000001
r3980 n2582 n2595 0.21875
r3981 n2594 n2595 0.10000000000000001
r3982 n2583 n2596 0.025735294117647058
r3983 n2595 n2596 0.23749999999999999
r3984 n2584 n2597 0.033653846153846152
r3985 n2596 n2597 0.375
r3986 n2585 n2598 0.21875
r3987 n2597 n2598 0.1875
r3988 n2586 n2599 0.21875
r3989 n2598 n2599 0.050000000000000003
r3990 n2587 n2600 0.109375
r3991 n2599 n2600 0.074999999999999997
r3992 n2588 n2601 0.087499999999999994
r3993 n2600 n2601 0.1125
r3994 n2589 n2602 0.0546875
r3995 n2601 n2602 0.16250000000000001
r3996 n2590 n2603 0.109375
r3997 n2602 n2603 0.14999999999999999
r3998 n2591 n2604 0.109375
r3999 n2592 n2605 0.0546875
r4000 n2604 n2605 0.375
r4001 n2593 n2606 0.087499999999999994
r4002 n2605 n2606 0.40625
r4003 n2594 n2607 0.072916666666666671
r4004 n2606 n2607 0.34375
r4005 n2595 n2608 0.21875
r4006 n2607 n2608 0.25
r4007 n2596 n2609 0.025735294117647058
r4008 n2608 n2609 0.59375
r4009 n2597 n2610 0.033653846153846152
r4010 n2609 n2610 0.9375
r4011 n2598 n2611 0.21875
r4012 n2610 n2611 0.46875
r4013 n2599 n2612 0.21875
r4014 n2611 n2612 0.125
r4015 n2600 n2613 0.109375
r4016 n2612 n2613 0.1875
r4017 n2601 n2614 0.087499999999999994
r4018 n2613 n2614 0.28125
r4019 n2602 n2615 0.0546875
r4020 n2614 n2615 0.40625
r4021 n2603 n2616 0.109375
r4022 n2615 n2616 0.375
r4023 n2604 n2617 0.0625
r4024 n2605 n2618 0.03125
r4025 n2617 n2618 0.375
r4026 n2606 n2619 0.050000000000000003
r4027 n2618 n2619 0.40625
r4028 n2607 n2620 0.041666666666666664
r4029 n2619 n2620 0.34375
r4030 n2608 n2621 0.125
r4031 n2620 n2621 0.25
r4032 n2609 n2622 0.014705882352941176
r4033 n2621 n2622 0.59375
r4034 n2610 n2623 0.019230769230769232
r4035 n2622 n2623 0.9375
r4036 n2611 n2624 0.125
r4037 n2623 n2624 0.46875
r4038 n2612 n2625 0.125
r4039 n2624 n2625 0.125
r4040 n2613 n2626 0.0625
r4041 n2625 n2626 0.1875
r4042 n2614 n2627 0.050000000000000003
r4043 n2626 n2627 0.28125
r4044 n2615 n2628 0.03125
r4045 n2627 n2628 0.40625
r4046 n2616 n2629 0.0625
r4047 n2628 n2629 0.375
r4048 n2617 n2630 0.46875
r4049 n2618 n2631 0.234375
r4050 n2630 n2631 0.026785714285714284
r4051 n2619 n2632 0.375
r4052 n2631 n2632 0.029017857142857144
r4053 n2620 n2633 0.3125
r4054 n2632 n2633 0.024553571428571428
r4055 n2621 n2634 0.9375
r4056 n2633 n2634 0.017857142857142856
r4057 n2622 n2635 0.11029411764705882
r4058 n2634 n2635 0.042410714285714288
r4059 n2623 n2636 0.14423076923076922
r4060 n2635 n2636 0.066964285714285712
r4061 n2624 n2637 0.9375
r4062 n2636 n2637 0.033482142857142856
r4063 n2625 n2638 0.9375
r4064 n2637 n2638 0.0089285714285714281
r4065 n2626 n2639 0.46875
r4066 n2638 n2639 0.013392857142857142
r4067 n2627 n2640 0.375
r4068 n2639 n2640 0.020089285714285716
r4069 n2628 n2641 0.234375
r4070 n2640 n2641 0.029017857142857144
r4071 n2629 n2642 0.46875
r4072 n2641 n2642 0.026785714285714284
r4073 n2630 n2643 0.46875
r4074 n2631 n2644 0.234375
r4075 n2643 n2644 0.375
r4076 n2632 n2645 0.375
r4077 n2644 n2645 0.40625
r4078 n2633 n2646 0.3125
r4079 n2645 n2646 0.34375
r4080 n2634 n2647 0.9375
r4081 n2646 n2647 0.25
r4082 n2635 n2648 0.11029411764705882
r4083 n2647 n2648 0.59375
r4084 n2636 n2649 0.14423076923076922
r4085 n2648 n2649 0.9375
r4086 n2637 n2650 0.9375
r4087 n2649 n2650 0.46875
r4088 n2638 n2651 0.9375
r4089 n2650 n2651 0.125
r4090 n2639 n2652 0.46875
r4091 n2651 n2652 0.1875
r4092 n2640 n2653 0.375
r4093 n2652 n2653 0.28125
r4094 n2641 n2654 0.234375
r4095 n2653 n2654 0.40625
r4096 n2642 n2655 0.46875
r4097 n2654 n2655 0.375
r4098 n2643 n2656 0.0625
r4099 n2644 n2657 0.03125
r4100 n2656 n2657 0.375
r4101 n2645 n2658 0.050000000000000003
r4102 n2657 n2658 0.40625
r4103 n2646 n2659 0.041666666666666664
r4104 n2658 n2659 0.34375
r4105 n2647 n2660 0.125
r4106 n2659 n2660 0.25
r4107 n2648 n2661 0.014705882352941176
r4108 n2660 n2661 0.59375
r4109 n2649 n2662 0.019230769230769232
r4110 n2661 n2662 0.9375
r4111 n2650 n2663 0.125
r4112 n2662 n2663 0.46875
r4113 n2651 n2664 0.125
r4114 n2663 n2664 0.125
r4115 n2652 n2665 0.0625
r4116 n2664 n2665 0.1875
r4117 n2653 n2666 0.050000000000000003
r4118 n2665 n2666 0.28125
r4119 n2654 n2667 0.03125
r4120 n2666 n2667 0.40625
r4121 n2655 n2668 0.0625
r4122 n2667 n2668 0.375
r4123 n2656 n2669 0.0625
r4124 n2657 n2670 0.03125
r4125 n2669 n2670 0.375
r4126 n2658 n2671 0.050000000000000003
r4127 n2670 n2671 0.40625
r4128 n2659 n2672 0.041666666666666664
r4129 n2671 n2672 0.34375
r4130 n2660 n2673 0.125
r4131 n2672 n2673 0.25
r4132 n2661 n2674 0.014705882352941176
r4133 n2673 n2674 0.59375
r4134 n2662 n2675 0.019230769230769232
r4135 n2674 n2675 0.9375
r4136 n2663 n2676 0.125
r4137 n2675 n2676 0.46875
r4138 n2664 n2677 0.125
r4139 n2676 n2677 0.125
r4140 n2665 n2678 0.0625
r4141 n2677 n2678 0.1875
r4142 n2666 n2679 0.050000000000000003
r4143 n2678 n2679 0.28125
r4144 n2667 n2680 0.03125
r4145 n2679 n2680 0.40625
r4146 n2668 n2681 0.0625
r4147 n2680 n2681 0.375
r4148 n2669 n2682 0.09375
r4149 n2670 n2683 0.046875
r4150 n2682 n2683 0.1875
r4151 n2671 n2684 0.074999999999999997
r4152 n2683 n2684 0.203125
r4153 n2672 n2685 0.0625
r4154 n2684 n2685 0.171875
r4155 n2673 n2686 0.1875
r4156 n2685 n2686 0.125
r4157 n2674 n2687 0.022058823529411766
r4158 n2686 n2687 0.296875
r4159 n2675 n2688 0.028846153846153848
r4160 n2687 n2688 0.46875
r4161 n2676 n2689 0.1875
r4162 n2688 n2689 0.234375
r4163 n2677 n2690 0.1875
r4164 n2689 n2690 0.0625
r4165 n2678 n2691 0.09375
r4166 n2690 n2691 0.09375
r4167 n2679 n2692 0.074999999999999997
r4168 n2691 n2692 0.140625
r4169 n2680 n2693 0.046875
r4170 n2692 n2693 0.203125
r4171 n2681 n2694 0.09375
r4172 n2693 n2694 0.1875
r4173 n2695 n2696 0.13392857142857142
r4174 n2696 n2697 0.089285714285714288
r4175 n2697 n2698 0.053571428571428568
r4176 n2698 n2699 0.035714285714285712
r4177 n2699 n2700 0.035714285714285712
r4178 n2700 n2701 0.089285714285714288
r4179 n2701 n2702 0.16964285714285715
r4180 n2702 n2703 0.13392857142857142
r4181 n2703 n2704 0.089285714285714288
r4182 n2704 n2705 0.053571428571428568
r4183 n2705 n2706 0.026785714285714284
r4184 n2706 n2707 0.026785714285714284
r4185 n2707 n2708 0.017857142857142856
r4186 n2708 n2709 0.017857142857142856
r4187 n2709 n2710 0.044642857142857144
r4188 n2710 n2711 0.080357142857142863
r4189 n2711 n2712 0.053571428571428568
r4190 n2712 n2713 0.098214285714285712
r4191 n2682 n2714 0.171875
r4192 n2683 n2715 0.0859375
r4193 n2714 n2715 0.10714285714285714
r4194 n2684 n2716 0.13750000000000001
r4195 n2715 n2716 0.11607142857142858
r4196 n2685 n2717 0.11458333333333333
r4197 n2716 n2717 0.098214285714285712
r4198 n2686 n2718 0.34375
r4199 n2717 n2718 0.071428571428571425
r4200 n2687 n2719 0.040441176470588237
r4201 n2718 n2719 0.16964285714285715
r4202 n2688 n2720 0.052884615384615384
r4203 n2719 n2720 0.26785714285714285
r4204 n2689 n2721 0.34375
r4205 n2720 n2721 0.13392857142857142
r4206 n2690 n2722 0.34375
r4207 n2721 n2722 0.035714285714285712
r4208 n2691 n2723 0.171875
r4209 n2722 n2723 0.053571428571428568
r4210 n2692 n2724 0.13750000000000001
r4211 n2723 n2724 0.080357142857142863
r4212 n2693 n2725 0.0859375
r4213 n2724 n2725 0.11607142857142858
r4214 n2694 n2726 0.171875
r4215 n2725 n2726 0.10714285714285714
r4216 n2727 n2728 0.22916666666666666
r4217 n2728 n2729 0.125
r4218 n2729 n2730 0.29166666666666669
r4219 n2695 n2731 0.0625
r4220 n2730 n2731 0.47916666666666669
r4221 n2696 n2732 0.125
r4222 n2731 n2732 0.3125
r4223 n2697 n2733 0.125
r4224 n2732 n2733 0.20833333333333334
r4225 n2698 n2734 0.625
r4226 n2733 n2734 0.125
r4227 n2699 n2735 0.20833333333333334
r4228 n2734 n2735 0.083333333333333329
r4229 n2700 n2736 0.625
r4230 n2735 n2736 0.083333333333333329
r4231 n2701 n2737 0.069444444444444448
r4232 n2736 n2737 0.20833333333333334
r4233 n2702 n2738 0.0625
r4234 n2737 n2738 0.39583333333333331
r4235 n2703 n2739 0.125
r4236 n2738 n2739 0.3125
r4237 n2704 n2740 0.125
r4238 n2739 n2740 0.20833333333333334
r4239 n2705 n2741 0.625
r4240 n2740 n2741 0.125
r4241 n2706 n2742 0.3125
r4242 n2741 n2742 0.0625
r4243 n2707 n2743 0.625
r4244 n2742 n2743 0.0625
r4245 n2708 n2744 0.625
r4246 n2743 n2744 0.041666666666666664
r4247 n2709 n2745 0.625
r4248 n2744 n2745 0.041666666666666664
r4249 n2710 n2746 0.15625
r4250 n2745 n2746 0.10416666666666667
r4251 n2711 n2747 0.125
r4252 n2746 n2747 0.1875
r4253 n2712 n2748 0.625
r4254 n2747 n2748 0.125
r4255 n2713 n2749 0.0625
r4256 n2748 n2749 0.22916666666666666
r4257 n2749 n2750 0.27083333333333331
r4258 n2750 n2751 0.1875
r4259 n2751 n2752 0.16666666666666666
r4260 n2752 n2753 0.0625
r4261 n2753 n2754 0.041666666666666664
r4262 n2754 n2755 0.14583333333333334
r4263 n2755 n2756 0.22916666666666666
r4264 n2756 n2757 0.125
r4265 n2717 n2758 0.10416666666666667
r4266 n2718 n2759 0.3125
r4267 n2758 n2759 0.16666666666666666
r4268 n2719 n2760 0.036764705882352942
r4269 n2759 n2760 0.39583333333333331
r4270 n2720 n2761 0.04807692307692308
r4271 n2760 n2761 0.625
r4272 n2721 n2762 0.3125
r4273 n2761 n2762 0.3125
r4274 n2722 n2763 0.3125
r4275 n2762 n2763 0.083333333333333329
r4276 n2723 n2764 0.15625
r4277 n2763 n2764 0.125
r4278 n2727 n2765 0.0625
r4279 n2728 n2766 0.074999999999999997
r4280 n2765 n2766 0.22916666666666666
r4281 n2729 n2767 0.375
r4282 n2766 n2767 0.125
r4283 n2730 n2768 0.028846153846153848
r4284 n2767 n2768 0.29166666666666669
r4285 n2731 n2769 0.037499999999999999
r4286 n2768 n2769 0.47916666666666669
r4287 n2732 n2770 0.074999999999999997
r4288 n2769 n2770 0.3125
r4289 n2733 n2771 0.074999999999999997
r4290 n2770 n2771 0.20833333333333334
r4291 n2734 n2772 0.375
r4292 n2771 n2772 0.125
r4293 n2735 n2773 0.125
r4294 n2772 n2773 0.083333333333333329
r4295 n2736 n2774 0.375
r4296 n2773 n2774 0.083333333333333329
r4297 n2737 n2775 0.041666666666666664
r4298 n2774 n2775 0.20833333333333334
r4299 n2738 n2776 0.037499999999999999
r4300 n2775 n2776 0.39583333333333331
r4301 n2739 n2777 0.074999999999999997
r4302 n2776 n2777 0.3125
r4303 n2740 n2778 0.074999999999999997
r4304 n2777 n2778 0.20833333333333334
r4305 n2741 n2779 0.375
r4306 n2778 n2779 0.125
r4307 n2742 n2780 0.1875
r4308 n2779 n2780 0.0625
r4309 n2743 n2781 0.375
r4310 n2780 n2781 0.0625
r4311 n2744 n2782 0.375
r4312 n2781 n2782 0.041666666666666664
r4313 n2745 n2783 0.375
r4314 n2782 n2783 0.041666666666666664
r4315 n2746 n2784 0.09375
r4316 n2783 n2784 0.10416666666666667
r4317 n2747 n2785 0.074999999999999997
r4318 n2784 n2785 0.1875
r4319 n2748 n2786 0.375
r4320 n2785 n2786 0.125
r4321 n2749 n2787 0.037499999999999999
r4322 n2786 n2787 0.22916666666666666
r4323 n2750 n2788 0.125
r4324 n2787 n2788 0.27083333333333331
r4325 n2751 n2789 0.0625
r4326 n2788 n2789 0.1875
r4327 n2752 n2790 0.1875
r4328 n2789 n2790 0.16666666666666666
r4329 n2753 n2791 0.375
r4330 n2790 n2791 0.0625
r4331 n2754 n2792 0.375
r4332 n2791 n2792 0.041666666666666664
r4333 n2755 n2793 0.0625
r4334 n2792 n2793 0.14583333333333334
r4335 n2756 n2794 0.074999999999999997
r4336 n2793 n2794 0.22916666666666666
r4337 n2757 n2795 0.375
r4338 n2794 n2795 0.125
r4339 n2758 n2796 0.0625
r4340 n2759 n2797 0.1875
r4341 n2796 n2797 0.16666666666666666
r4342 n2760 n2798 0.022058823529411766
r4343 n2797 n2798 0.39583333333333331
r4344 n2761 n2799 0.028846153846153848
r4345 n2798 n2799 0.625
r4346 n2762 n2800 0.1875
r4347 n2799 n2800 0.3125
r4348 n2763 n2801 0.1875
r4349 n2800 n2801 0.083333333333333329
r4350 n2764 n2802 0.09375
r4351 n2801 n2802 0.125
r4352 n2765 n2803 0.052083333333333336
r4353 n2766 n2804 0.0625
r4354 n2803 n2804 0.34375
r4355 n2767 n2805 0.3125
r4356 n2804 n2805 0.1875
r4357 n2768 n2806 0.02403846153846154
r4358 n2805 n2806 0.4375
r4359 n2769 n2807 0.03125
r4360 n2806 n2807 0.71875
r4361 n2770 n2808 0.0625
r4362 n2807 n2808 0.46875
r4363 n2771 n2809 0.0625
r4364 n2808 n2809 0.3125
r4365 n2772 n2810 0.3125
r4366 n2809 n2810 0.1875
r4367 n2773 n2811 0.10416666666666667
r4368 n2810 n2811 0.125
r4369 n2774 n2812 0.3125
r4370 n2811 n2812 0.125
r4371 n2775 n2813 0.034722222222222224
r4372 n2812 n2813 0.3125
r4373 n2776 n2814 0.03125
r4374 n2813 n2814 0.59375
r4375 n2777 n2815 0.0625
r4376 n2814 n2815 0.46875
r4377 n2778 n2816 0.0625
r4378 n2815 n2816 0.3125
r4379 n2779 n2817 0.3125
r4380 n2816 n2817 0.1875
r4381 n2780 n2818 0.15625
r4382 n2817 n2818 0.09375
r4383 n2781 n2819 0.3125
r4384 n2818 n2819 0.09375
r4385 n2782 n2820 0.3125
r4386 n2819 n2820 0.0625
r4387 n2783 n2821 0.3125
r4388 n2820 n2821 0.0625
r4389 n2784 n2822 0.078125
r4390 n2821 n2822 0.15625
r4391 n2785 n2823 0.0625
r4392 n2822 n2823 0.28125
r4393 n2786 n2824 0.3125
r4394 n2823 n2824 0.1875
r4395 n2787 n2825 0.03125
r4396 n2824 n2825 0.34375
r4397 n2788 n2826 0.10416666666666667
r4398 n2825 n2826 0.40625
r4399 n2789 n2827 0.052083333333333336
r4400 n2826 n2827 0.28125
r4401 n2790 n2828 0.15625
r4402 n2827 n2828 0.25
r4403 n2791 n2829 0.3125
r4404 n2828 n2829 0.09375
r4405 n2792 n2830 0.3125
r4406 n2829 n2830 0.0625
r4407 n2793 n2831 0.052083333333333336
r4408 n2830 n2831 0.21875
r4409 n2794 n2832 0.0625
r4410 n2831 n2832 0.34375
r4411 n2795 n2833 0.3125
r4412 n2832 n2833 0.1875
r4413 n2803 n2834 0.17708333333333334
r4414 n2804 n2835 0.21249999999999999
r4415 n2834 n2835 0.04583333333333333
r4416 n2805 n2836 1.0625
r4417 n2835 n2836 0.025000000000000001
r4418 n2806 n2837 0.081730769230769232
r4419 n2836 n2837 0.058333333333333334
r4420 n2807 n2838 0.10625
r4421 n2837 n2838 0.09583333333333334
r4422 n2808 n2839 0.21249999999999999
r4423 n2838 n2839 0.0625
r4424 n2809 n2840 0.21249999999999999
r4425 n2839 n2840 0.041666666666666664
r4426 n2810 n2841 1.0625
r4427 n2840 n2841 0.025000000000000001
r4428 n2811 n2842 0.35416666666666669
r4429 n2841 n2842 0.016666666666666666
r4430 n2812 n2843 1.0625
r4431 n2842 n2843 0.016666666666666666
r4432 n2813 n2844 0.11805555555555555
r4433 n2843 n2844 0.041666666666666664
r4434 n2814 n2845 0.10625
r4435 n2844 n2845 0.079166666666666663
r4436 n2815 n2846 0.21249999999999999
r4437 n2845 n2846 0.0625
r4438 n2816 n2847 0.21249999999999999
r4439 n2846 n2847 0.041666666666666664
r4440 n2817 n2848 1.0625
r4441 n2847 n2848 0.025000000000000001
r4442 n2818 n2849 0.53125
r4443 n2848 n2849 0.012500000000000001
r4444 n2819 n2850 1.0625
r4445 n2849 n2850 0.012500000000000001
r4446 n2820 n2851 1.0625
r4447 n2850 n2851 0.0083333333333333332
r4448 n2821 n2852 1.0625
r4449 n2851 n2852 0.0083333333333333332
r4450 n2822 n2853 0.265625
r4451 n2852 n2853 0.020833333333333332
r4452 n2823 n2854 0.21249999999999999
r4453 n2853 n2854 0.037499999999999999
r4454 n2824 n2855 1.0625
r4455 n2854 n2855 0.025000000000000001
r4456 n2825 n2856 0.10625
r4457 n2855 n2856 0.04583333333333333
r4458 n2826 n2857 0.35416666666666669
r4459 n2856 n2857 0.054166666666666669
r4460 n2827 n2858 0.17708333333333334
r4461 n2857 n2858 0.037499999999999999
r4462 n2828 n2859 0.53125
r4463 n2858 n2859 0.033333333333333333
r4464 n2829 n2860 1.0625
r4465 n2859 n2860 0.012500000000000001
r4466 n2830 n2861 1.0625
r4467 n2860 n2861 0.0083333333333333332
r4468 n2831 n2862 0.17708333333333334
r4469 n2861 n2862 0.029166666666666667
r4470 n2832 n2863 0.21249999999999999
r4471 n2862 n2863 0.04583333333333333
r4472 n2833 n2864 1.0625
r4473 n2863 n2864 0.025000000000000001
r4474 n2834 n2865 0.3125
r4475 n2835 n2866 0.375
r4476 n2865 n2866 0.04583333333333333
r4477 n2836 n2867 1.875
r4478 n2866 n2867 0.025000000000000001
r4479 n2837 n2868 0.14423076923076922
r4480 n2867 n2868 0.058333333333333334
r4481 n2838 n2869 0.1875
r4482 n2868 n2869 0.09583333333333334
r4483 n2839 n2870 0.375
r4484 n2869 n2870 0.0625
r4485 n2840 n2871 0.375
r4486 n2870 n2871 0.041666666666666664
r4487 n2841 n2872 1.875
r4488 n2871 n2872 0.025000000000000001
r4489 n2842 n2873 0.625
r4490 n2872 n2873 0.016666666666666666
r4491 n2843 n2874 1.875
r4492 n2873 n2874 0.016666666666666666
r4493 n2844 n2875 0.20833333333333334
r4494 n2874 n2875 0.041666666666666664
r4495 n2845 n2876 0.1875
r4496 n2875 n2876 0.079166666666666663
r4497 n2846 n2877 0.375
r4498 n2876 n2877 0.0625
r4499 n2847 n2878 0.375
r4500 n2877 n2878 0.041666666666666664
r4501 n2848 n2879 1.875
r4502 n2878 n2879 0.025000000000000001
r4503 n2849 n2880 0.9375
r4504 n2879 n2880 0.012500000000000001
r4505 n2850 n2881 1.875
r4506 n2880 n2881 0.012500000000000001
r4507 n2851 n2882 1.875
r4508 n2881 n2882 0.0083333333333333332
r4509 n2852 n2883 1.875
r4510 n2882 n2883 0.0083333333333333332
r4511 n2853 n2884 0.46875
r4512 n2883 n2884 0.020833333333333332
r4513 n2854 n2885 0.375
r4514 n2884 n2885 0.037499999999999999
r4515 n2855 n2886 1.875
r4516 n2885 n2886 0.025000000000000001
r4517 n2856 n2887 0.1875
r4518 n2886 n2887 0.04583333333333333
r4519 n2857 n2888 0.625
r4520 n2887 n2888 0.054166666666666669
r4521 n2858 n2889 0.3125
r4522 n2888 n2889 0.037499999999999999
r4523 n2859 n2890 0.9375
r4524 n2889 n2890 0.033333333333333333
r4525 n2860 n2891 1.875
r4526 n2890 n2891 0.012500000000000001
r4527 n2861 n2892 1.875
r4528 n2891 n2892 0.0083333333333333332
r4529 n2862 n2893 0.3125
r4530 n2892 n2893 0.029166666666666667
r4531 n2863 n2894 0.375
r4532 n2893 n2894 0.04583333333333333
r4533 n2864 n2895 1.875
r4534 n2894 n2895 0.025000000000000001
r4535 n2865 n2896 0.17708333333333334
r4536 n2866 n2897 0.21249999999999999
r4537 n2896 n2897 0.34375
r4538 n2867 n2898 1.0625
r4539 n2897 n2898 0.1875
r4540 n2868 n2899 0.081730769230769232
r4541 n2898 n2899 0.4375
r4542 n2869 n2900 0.10625
r4543 n2899 n2900 0.71875
r4544 n2870 n2901 0.21249999999999999
r4545 n2900 n2901 0.46875
r4546 n2871 n2902 0.21249999999999999
r4547 n2901 n2902 0.3125
r4548 n2872 n2903 1.0625
r4549 n2902 n2903 0.1875
r4550 n2873 n2904 0.35416666666666669
r4551 n2903 n2904 0.125
r4552 n2874 n2905 1.0625
r4553 n2904 n2905 0.125
r4554 n2875 n2906 0.11805555555555555
r4555 n2905 n2906 0.3125
r4556 n2876 n2907 0.10625
r4557 n2906 n2907 0.59375
r4558 n2877 n2908 0.21249999999999999
r4559 n2907 n2908 0.46875
r4560 n2878 n2909 0.21249999999999999
r4561 n2908 n2909 0.3125
r4562 n2879 n2910 1.0625
r4563 n2909 n2910 0.1875
r4564 n2880 n2911 0.53125
r4565 n2910 n2911 0.09375
r4566 n2881 n2912 1.0625
r4567 n2911 n2912 0.09375
r4568 n2882 n2913 1.0625
r4569 n2912 n2913 0.0625
r4570 n2883 n2914 1.0625
r4571 n2913 n2914 0.0625
r4572 n2884 n2915 0.265625
r4573 n2914 n2915 0.15625
r4574 n2885 n2916 0.21249999999999999
r4575 n2915 n2916 0.28125
r4576 n2886 n2917 1.0625
r4577 n2916 n2917 0.1875
r4578 n2887 n2918 0.10625
r4579 n2917 n2918 0.34375
r4580 n2888 n2919 0.35416666666666669
r4581 n2918 n2919 0.40625
r4582 n2889 n2920 0.17708333333333334
r4583 n2919 n2920 0.28125
r4584 n2890 n2921 0.53125
r4585 n2920 n2921 0.25
r4586 n2891 n2922 1.0625
r4587 n2921 n2922 0.09375
r4588 n2892 n2923 1.0625
r4589 n2922 n2923 0.0625
r4590 n2893 n2924 0.17708333333333334
r4591 n2923 n2924 0.21875
r4592 n2894 n2925 0.21249999999999999
r4593 n2924 n2925 0.34375
r4594 n2895 n2926 1.0625
r4595 n2925 n2926 0.1875
r4596 n2896 n2927 0.052083333333333336
r4597 n2897 n2928 0.0625
r4598 n2927 n2928 0.22916666666666666
r4599 n2898 n2929 0.3125
r4600 n2928 n2929 0.125
r4601 n2899 n2930 0.02403846153846154
r4602 n2929 n2930 0.29166666666666669
r4603 n2900 n2931 0.03125
r4604 n2930 n2931 0.47916666666666669
r4605 n2901 n2932 0.0625
r4606 n2931 n2932 0.3125
r4607 n2902 n2933 0.0625
r4608 n2932 n2933 0.20833333333333334
r4609 n2903 n2934 0.3125
r4610 n2933 n2934 0.125
r4611 n2904 n2935 0.10416666666666667
r4612 n2934 n2935 0.083333333333333329
r4613 n2905 n2936 0.3125
r4614 n2935 n2936 0.083333333333333329
r4615 n2906 n2937 0.034722222222222224
r4616 n2936 n2937 0.20833333333333334
r4617 n2907 n2938 0.03125
r4618 n2937 n2938 0.39583333333333331
r4619 n2908 n2939 0.0625
r4620 n2938 n2939 0.3125
r4621 n2909 n2940 0.0625
r4622 n2939 n2940 0.20833333333333334
r4623 n2910 n2941 0.3125
r4624 n2940 n2941 0.125
r4625 n2911 n2942 0.15625
r4626 n2941 n2942 0.0625
r4627 n2912 n2943 0.3125
r4628 n2942 n2943 0.0625
r4629 n2913 n2944 0.3125
r4630 n2943 n2944 0.041666666666666664
r4631 n2914 n2945 0.3125
r4632 n2944 n2945 0.041666666666666664
r4633 n2915 n2946 0.078125
r4634 n2945 n2946 0.10416666666666667
r4635 n2916 n2947 0.0625
r4636 n2946 n2947 0.1875
r4637 n2917 n2948 0.3125
r4638 n2947 n2948 0.125
r4639 n2918 n2949 0.03125
r4640 n2948 n2949 0.22916666666666666
r4641 n2919 n2950 0.10416666666666667
r4642 n2949 n2950 0.27083333333333331
r4643 n2920 n2951 0.052083333333333336
r4644 n2950 n2951 0.1875
r4645 n2921 n2952 0.15625
r4646 n2951 n2952 0.16666666666666666
r4647 n2922 n2953 0.3125
r4648 n2952 n2953 0.0625
r4649 n2923 n2954 0.3125
r4650 n2953 n2954 0.041666666666666664
r4651 n2924 n2955 0.052083333333333336
r4652 n2954 n2955 0.14583333333333334
r4653 n2925 n2956 0.0625
r4654 n2955 n2956 0.22916666666666666
r4655 n2926 n2957 0.3125
r4656 n2956 n2957 0.125
r4657 n2927 n2958 0.0625
r4658 n2928 n2959 0.074999999999999997
r4659 n2958 n2959 0.22916666666666666
r4660 n2929 n2960 0.375
r4661 n2959 n2960 0.125
r4662 n2930 n2961 0.028846153846153848
r4663 n2960 n2961 0.29166666666666669
r4664 n2931 n2962 0.037499999999999999
r4665 n2961 n2962 0.47916666666666669
r4666 n2932 n2963 0.074999999999999997
r4667 n2962 n2963 0.3125
r4668 n2933 n2964 0.074999999999999997
r4669 n2963 n2964 0.20833333333333334
r4670 n2934 n2965 0.375
r4671 n2964 n2965 0.125
r4672 n2935 n2966 0.125
r4673 n2965 n2966 0.083333333333333329
r4674 n2936 n2967 0.375
r4675 n2966 n2967 0.083333333333333329
r4676 n2937 n2968 0.041666666666666664
r4677 n2967 n2968 0.20833333333333334
r4678 n2938 n2969 0.037499999999999999
r4679 n2968 n2969 0.39583333333333331
r4680 n2939 n2970 0.074999999999999997
r4681 n2969 n2970 0.3125
r4682 n2940 n2971 0.074999999999999997
r4683 n2970 n2971 0.20833333333333334
r4684 n2941 n2972 0.375
r4685 n2971 n2972 0.125
r4686 n2942 n2973 0.1875
r4687 n2972 n2973 0.0625
r4688 n2943 n2974 0.375
r4689 n2973 n2974 0.0625
r4690 n2944 n2975 0.375
r4691 n2974 n2975 0.041666666666666664
r4692 n2945 n2976 0.375
r4693 n2975 n2976 0.041666666666666664
r4694 n2946 n2977 0.09375
r4695 n2976 n2977 0.10416666666666667
r4696 n2947 n2978 0.074999999999999997
r4697 n2977 n2978 0.1875
r4698 n2948 n2979 0.375
r4699 n2978 n2979 0.125
r4700 n2949 n2980 0.037499999999999999
r4701 n2979 n2980 0.22916666666666666
r4702 n2950 n2981 0.125
r4703 n2980 n2981 0.27083333333333331
r4704 n2951 n2982 0.0625
r4705 n2981 n2982 0.1875
r4706 n2952 n2983 0.1875
r4707 n2982 n2983 0.16666666666666666
r4708 n2953 n2984 0.375
r4709 n2983 n2984 0.0625
r4710 n2954 n2985 0.375
r4711 n2984 n2985 0.041666666666666664
r4712 n2955 n2986 0.0625
r4713 n2985 n2986 0.14583333333333334
r4714 n2956 n2987 0.074999999999999997
r4715 n2986 n2987 0.22916666666666666
r4716 n2957 n2988 0.375
r4717 n2987 n2988 0.125
r4718 n2962 n2989 0.0625
r4719 n2963 n2990 0.125
r4720 n2989 n2990 0.13392857142857142
r4721 n2964 n2991 0.125
r4722 n2990 n2991 0.089285714285714288
r4723 n2965 n2992 0.625
r4724 n2991 n2992 0.053571428571428568
r4725 n2966 n2993 0.20833333333333334
r4726 n2992 n2993 0.035714285714285712
r4727 n2967 n2994 0.625
r4728 n2993 n2994 0.035714285714285712
r4729 n2968 n2995 0.069444444444444448
r4730 n2994 n2995 0.089285714285714288
r4731 n2969 n2996 0.0625
r4732 n2995 n2996 0.16964285714285715
r4733 n2970 n2997 0.125
r4734 n2996 n2997 0.13392857142857142
r4735 n2971 n2998 0.125
r4736 n2997 n2998 0.089285714285714288
r4737 n2972 n2999 0.625
r4738 n2998 n2999 0.053571428571428568
r4739 n2973 n3000 0.3125
r4740 n2999 n3000 0.026785714285714284
r4741 n2974 n3001 0.625
r4742 n3000 n3001 0.026785714285714284
r4743 n2975 n3002 0.625
r4744 n3001 n3002 0.017857142857142856
r4745 n2976 n3003 0.625
r4746 n3002 n3003 0.017857142857142856
r4747 n2977 n3004 0.15625
r4748 n3003 n3004 0.044642857142857144
r4749 n2978 n3005 0.125
r4750 n3004 n3005 0.080357142857142863
r4751 n2979 n3006 0.625
r4752 n3005 n3006 0.053571428571428568
r4753 n2980 n3007 0.0625
r4754 n3006 n3007 0.098214285714285712
r4755 n3008 n3009 0.78125
r4756 n3009 n3010 1
r4757 n3010 n3011 1
r4758 n3011 n3012 0.78125
r4759 n3008 n3013 0.035326086956521736
r4760 n3009 n3014 0.40625
r4761 n3013 n3014 0.14204545454545456
r4762 n3010 n3015 0.027083333333333334
r4763 n3014 n3015 0.18181818181818182
r4764 n3011 n3016 0.40625
r4765 n3015 n3016 0.18181818181818182
r4766 n3012 n3017 0.035326086956521736
r4767 n3016 n3017 0.14204545454545456
r4768 n3013 n3018 0.035326086956521736
r4769 n3014 n3019 0.40625
r4770 n3018 n3019 0.78125
r4771 n3015 n3020 0.027083333333333334
r4772 n3019 n3020 1
r4773 n3016 n3021 0.40625
r4774 n3020 n3021 1
r4775 n3017 n3022 0.035326086956521736
r4776 n3021 n3022 0.78125
r4777 n3018 n3023 0.086956521739130432
r4778 n3019 n3024 1
r4779 n3023 n3024 0.052083333333333336
r4780 n3020 n3025 0.066666666666666666
r4781 n3024 n3025 0.066666666666666666
r4782 n3021 n3026 1
r4783 n3025 n3026 0.066666666666666666
r4784 n3022 n3027 0.086956521739130432
r4785 n3026 n3027 0.052083333333333336
r4786 n3023 n3028 0.086956521739130432
r4787 n3024 n3029 1
r4788 n3028 n3029 0.78125
r4789 n3025 n3030 0.066666666666666666
r4790 n3029 n3030 1
r4791 n3026 n3031 1
r4792 n3030 n3031 1
r4793 n3027 n3032 0.086956521739130432
r4794 n3031 n3032 0.78125
r4795 n3028 n3033 0.035326086956521736
r4796 n3029 n3034 0.40625
r4797 n3033 n3034 0.14204545454545456
r4798 n3030 n3035 0.027083333333333334
r4799 n3034 n3035 0.18181818181818182
r4800 n3031 n3036 0.40625
r4801 n3035 n3036 0.18181818181818182
r4802 n3032 n3037 0.035326086956521736
r4803 n3036 n3037 0.14204545454545456
r4804 n3033 n3038 0.035326086956521736
r4805 n3034 n3039 0.40625
r4806 n3038 n3039 0.78125
r4807 n3035 n3040 0.027083333333333334
r4808 n3039 n3040 1
r4809 n3036 n3041 0.40625
r4810 n3040 n3041 1
r4811 n3037 n3042 0.035326086956521736
r4812 n3041 n3042 0.78125
r4813 n3043 n3044 0.3125
r4814 n3044 n3045 0.1875
r4815 n3045 n3046 0.09375
r4816 n3046 n3047 0.09375
r4817 n3047 n3048 0.0625
r4818 n3048 n3049 0.0625
r4819 n3049 n3050 0.15625
r4820 n3050 n3051 0.28125
r4821 n3051 n3052 0.1875
r4822 n3052 n3053 0.34375
r4823 n3053 n3054 0.40625
r4824 n3054 n3055 0.28125
r4825 n3055 n3056 0.25
r4826 n3056 n3057 0.09375
r4827 n3057 n3058 0.0625
r4828 n3058 n3059 0.21875
r4829 n3059 n3060 0.34375
r4830 n3060 n3061 0.1875
r4831 n3061 n3062 0.15625
r4832 n3062 n3063 0.28125
r4833 n3063 n3064 0.25
r4834 n3064 n3065 0.3125
r4835 n3066 n3067 0.78125
r4836 n3067 n3068 1.0625
r4837 n3068 n3069 0.9375
r4838 n3069 n3070 1.0625
r4839 n3070 n3071 0.78125
r4840 n3043 n3072 0.0625
r4841 n3044 n3073 0.0625
r4842 n3072 n3073 0.20833333333333334
r4843 n3045 n3074 0.3125
r4844 n3073 n3074 0.125
r4845 n3046 n3075 0.15625
r4846 n3074 n3075 0.0625
r4847 n3047 n3076 0.3125
r4848 n3075 n3076 0.0625
r4849 n3048 n3077 0.3125
r4850 n3076 n3077 0.041666666666666664
r4851 n3049 n3078 0.3125
r4852 n3077 n3078 0.041666666666666664
r4853 n3050 n3079 0.078125
r4854 n3078 n3079 0.10416666666666667
r4855 n3051 n3080 0.0625
r4856 n3079 n3080 0.1875
r4857 n3052 n3081 0.3125
r4858 n3080 n3081 0.125
r4859 n3053 n3082 0.03125
r4860 n3081 n3082 0.22916666666666666
r4861 n3054 n3083 0.10416666666666667
r4862 n3082 n3083 0.27083333333333331
r4863 n3055 n3084 0.052083333333333336
r4864 n3083 n3084 0.1875
r4865 n3056 n3085 0.15625
r4866 n3084 n3085 0.16666666666666666
r4867 n3057 n3086 0.3125
r4868 n3085 n3086 0.0625
r4869 n3058 n3087 0.3125
r4870 n3086 n3087 0.041666666666666664
r4871 n3059 n3088 0.052083333333333336
r4872 n3087 n3088 0.14583333333333334
r4873 n3060 n3089 0.0625
r4874 n3088 n3089 0.22916666666666666
r4875 n3061 n3090 0.3125
r4876 n3089 n3090 0.125
r4877 n3062 n3091 0.078125
r4878 n3090 n3091 0.10416666666666667
r4879 n3063 n3092 0.0625
r4880 n3091 n3092 0.1875
r4881 n3064 n3093 0.10416666666666667
r4882 n3092 n3093 0.16666666666666666
r4883 n3065 n3094 0.044642857142857144
r4884 n3093 n3094 0.20833333333333334
r4885 n3066 n3095 0.044642857142857144
r4886 n3067 n3096 0.017361111111111112
r4887 n3095 n3096 0.52083333333333337
r4888 n3068 n3097 0.01953125
r4889 n3096 n3097 0.70833333333333337
r4890 n3069 n3098 0.022321428571428572
r4891 n3097 n3098 0.625
r4892 n3070 n3099 0.015625
r4893 n3098 n3099 0.70833333333333337
r4894 n3071 n3100 0.0625
r4895 n3099 n3100 0.52083333333333337
r4896 n3072 t_r1_a 0.10000000000000001
r4897 n3073 t_r1_a 0.10000000000000001
r4898 n3074 t_r1_a 0.5
r4899 n3075 t_r1_a 0.25
r4900 n3076 t_r1_a 0.5
r4901 n3077 t_r1_a 0.5
r4902 n3078 t_r1_a 0.5
r4903 n3079 t_r1_a 0.125
r4904 n3080 t_r1_a 0.10000000000000001
r4905 n3081 t_r1_a 0.5
r4906 n3082 t_r1_a 0.050000000000000003
r4907 n3083 t_r1_a 0.16666666666666666
r4908 n3084 t_r1_a 0.083333333333333329
r4909 n3085 t_r1_a 0.25
r4910 n3086 t_r1_a 0.5
r4911 n3087 t_r1_a 0.5
r4912 n3088 t_r1_a 0.083333333333333329
r4913 n3089 t_r1_a 0.10000000000000001
r4914 n3090 t_r1_a 0.5
r4915 n3091 t_r1_a 0.125
r4916 n3092 t_r1_a 0.10000000000000001
r4917 n3093 t_r1_a 0.16666666666666666
r4918 n3094 t_r1_a 0.071428571428571425
r4919 n3095 t_r1_b 0.071428571428571425
r4920 n3096 t_r1_b 0.027777777777777776
r4921 n3097 t_r1_b 0.03125
r4922 n3098 t_r1_b 0.035714285714285712
r4923 n3099 t_r1_b 0.025000000000000001
r4924 n3100 t_r1_b 0.10000000000000001
r4925 t_r1_a n3668 0.10000000000000001
r4926 t_r1_a n3669 0.10000000000000001
r4927 n3668 n3669 0.20833333333333334
r4928 t_r1_a n3670 0.5
r4929 n3669 n3670 0.125
r4930 t_r1_a n3671 0.25
r4931 n3670 n3671 0.0625
r4932 t_r1_a n3672 0.5
r4933 n3671 n3672 0.0625
r4934 t_r1_a n3673 0.5
r4935 n3672 n3673 0.041666666666666664
r4936 t_r1_a n3674 0.5
r4937 n3673 n3674 0.041666666666666664
r4938 t_r1_a n3675 0.125
r4939 n3674 n3675 0.10416666666666667
r4940 t_r1_a n3676 0.10000000000000001
r4941 n3675 n3676 0.1875
r4942 t_r1_a n3677 0.5
r4943 n3676 n3677 0.125
r4944 t_r1_a n3678 0.050000000000000003
r4945 n3677 n3678 0.22916666666666666
r4946 t_r1_a n3679 0.16666666666666666
r4947 n3678 n3679 0.27083333333333331
r4948 t_r1_a n3680 0.083333333333333329
r4949 n3679 n3680 0.1875
r4950 t_r1_a n3681 0.25
r4951 n3680 n3681 0.16666666666666666
r4952 t_r1_a n3682 0.5
r4953 n3681 n3682 0.0625
r4954 t_r1_a n3683 0.5
r4955 n3682 n3683 0.041666666666666664
r4956 t_r1_a n3684 0.083333333333333329
r4957 n3683 n3684 0.14583333333333334
r4958 t_r1_a n3685 0.10000000000000001
r4959 n3684 n3685 0.22916666666666666
r4960 t_r1_a n3686 0.5
r4961 n3685 n3686 0.125
r4962 t_r1_a n3687 0.125
r4963 n3686 n3687 0.10416666666666667
r4964 t_r1_a n3688 0.10000000000000001
r4965 n3687 n3688 0.1875
r4966 t_r1_a n3689 0.16666666666666666
r4967 n3688 n3689 0.16666666666666666
r4968 t_r1_a n3690 0.071428571428571425
r4969 n3689 n3690 0.20833333333333334
r4970 t_r1_b n3691 0.071428571428571425
r4971 t_r1_b n3692 0.027777777777777776
r4972 n3691 n3692 0.52083333333333337
r4973 t_r1_b n3693 0.03125
r4974 n3692 n3693 0.70833333333333337
r4975 t_r1_b n3694 0.035714285714285712
r4976 n3693 n3694 0.625
r4977 t_r1_b n3695 0.025000000000000001
r4978 n3694 n3695 0.70833333333333337
r4979 t_r1_b n3696 0.10000000000000001
r4980 n3695 n3696 0.52083333333333337
r4981 n3668 n3697 0.0625
r4982 n3669 n3698 0.0625
r4983 n3697 n3698 0.3125
r4984 n3670 n3699 0.3125
r4985 n3698 n3699 0.1875
r4986 n3671 n3700 0.15625
r4987 n3699 n3700 0.09375
r4988 n3672 n3701 0.3125
r4989 n3700 n3701 0.09375
r4990 n3673 n3702 0.3125
r4991 n3701 n3702 0.0625
r4992 n3674 n3703 0.3125
r4993 n3702 n3703 0.0625
r4994 n3675 n3704 0.078125
r4995 n3703 n3704 0.15625
r4996 n3676 n3705 0.0625
r4997 n3704 n3705 0.28125
r4998 n3677 n3706 0.3125
r4999 n3705 n3706 0.1875
r5000 n3678 n3707 0.03125
r5001 n3706 n3707 0.34375
r5002 n3679 n3708 0.10416666666666667
r5003 n3707 n3708 0.40625
r5004 n3680 n3709 0.052083333333333336
r5005 n3708 n3709 0.28125
r5006 n3681 n3710 0.15625
r5007 n3709 n3710 0.25
r5008 n3682 n3711 0.3125
r5009 n3710 n3711 0.09375
r5010 n3683 n3712 0.3125
r5011 n3711 n3712 0.0625
r5012 n3684 n3713 0.052083333333333336
r5013 n3712 n3713 0.21875
r5014 n3685 n3714 0.0625
r5015 n3713 n3714 0.34375
r5016 n3686 n3715 0.3125
r5017 n3714 n3715 0.1875
r5018 n3687 n3716 0.078125
r5019 n3715 n3716 0.15625
r5020 n3688 n3717 0.0625
r5021 n3716 n3717 0.28125
r5022 n3689 n3718 0.10416666666666667
r5023 n3717 n3718 0.25
r5024 n3690 n3719 0.044642857142857144
r5025 n3718 n3719 0.3125
r5026 n3691 n3720 0.044642857142857144
r5027 n3692 n3721 0.017361111111111112
r5028 n3720 n3721 0.78125
r5029 n3693 n3722 0.01953125
r5030 n3721 n3722 1.0625
r5031 n3694 n3723 0.022321428571428572
r5032 n3722 n3723 0.9375
r5033 n3695 n3724 0.015625
r5034 n3723 n3724 1.0625
r5035 n3696 n3725 0.0625
r5036 n3724 n3725 0.78125
r5037 n3726 n3727 0.13437499999999999
r5038 n3727 n3728 0.109375
r5039 n3728 n3729 0.10000000000000001
r5040 n3729 n3730 0.10000000000000001
r5041 n3730 n3731 0.109375
r5042 n3731 n3732 0.13437499999999999
r5043 n3751 n3752 0.0625
r5044 n3752 n3753 0.109375
r5045 n3753 n3754 0.081250000000000003
r5046 n3754 n3755 0.090624999999999997
r5047 n3755 n3756 0.090624999999999997
r5048 n3756 n3757 0.081250000000000003
r5049 n3757 n3758 0.109375
r5050 n3758 n3759 0.0625
r5051 n3726 n3760 0.26874999999999999
r5052 n3727 n3761 0.081439393939393936
r5053 n3760 n3761 0.11684782608695653
r5054 n3728 n3762 1.34375
r5055 n3761 n3762 0.095108695652173919
r5056 n3729 n3763 0.089583333333333334
r5057 n3762 n3763 0.086956521739130432
r5058 n3730 n3764 1.34375
r5059 n3763 n3764 0.086956521739130432
r5060 n3731 n3765 0.081439393939393936
r5061 n3764 n3765 0.095108695652173919
r5062 n3732 n3766 0.26874999999999999
r5063 n3765 n3766 0.11684782608695653
r5064 n3751 n3785 0.26874999999999999
r5065 n3752 n3786 0.26874999999999999
r5066 n3785 n3786 0.05434782608695652
r5067 n3753 n3787 0.1075
r5068 n3786 n3787 0.095108695652173919
r5069 n3754 n3788 2.6875
r5070 n3787 n3788 0.070652173913043473
r5071 n3755 n3789 0.095982142857142863
r5072 n3788 n3789 0.07880434782608696
r5073 n3756 n3790 2.6875
r5074 n3789 n3790 0.07880434782608696
r5075 n3757 n3791 0.1075
r5076 n3790 n3791 0.070652173913043473
r5077 n3758 n3792 0.26874999999999999
r5078 n3791 n3792 0.095108695652173919
r5079 n3759 n3793 0.26874999999999999
r5080 n3792 n3793 0.05434782608695652
r5081 n3760 n3794 0.15625
r5082 n3761 n3795 0.047348484848484848
r5083 n3794 n3795 1.34375
r5084 n3762 n3796 0.78125
r5085 n3795 n3796 1.09375
r5086 n3763 n3797 0.052083333333333336
r5087 n3796 n3797 1
r5088 n3764 n3798 0.78125
r5089 n3797 n3798 1
r5090 n3765 n3799 0.047348484848484848
r5091 n3798 n3799 1.09375
r5092 n3766 n3800 0.15625
r5093 n3799 n3800 1.34375
r5094 n3785 n3819 0.15625
r5095 n3786 n3820 0.15625
r5096 n3819 n3820 0.625
r5097 n3787 n3821 0.0625
r5098 n3820 n3821 1.09375
r5099 n3788 n3822 1.5625
r5100 n3821 n3822 0.8125
r5101 n3789 n3823 0.055803571428571432
r5102 n3822 n3823 0.90625
r5103 n3790 n3824 1.5625
r5104 n3823 n3824 0.90625
r5105 n3791 n3825 0.0625
r5106 n3824 n3825 0.8125
r5107 n3792 n3826 0.15625
r5108 n3825 n3826 1.09375
r5109 n3793 n3827 0.15625
r5110 n3826 n3827 0.625
r5111 n3794 n3828 0.20000000000000001
r5112 n3795 n3829 0.060606060606060608
r5113 n3828 n3829 0.089583333333333334
r5114 n3796 n3830 1
r5115 n3829 n3830 0.072916666666666671
r5116 n3797 n3831 0.066666666666666666
r5117 n3830 n3831 0.066666666666666666
r5118 n3798 n3832 1
r5119 n3831 n3832 0.066666666666666666
r5120 n3799 n3833 0.060606060606060608
r5121 n3832 n3833 0.072916666666666671
r5122 n3800 n3834 0.20000000000000001
r5123 n3833 n3834 0.089583333333333334
r5124 n3819 n3853 0.20000000000000001
r5125 n3820 n3854 0.20000000000000001
r5126 n3853 n3854 0.041666666666666664
r5127 n3821 n3855 0.080000000000000002
r5128 n3854 n3855 0.072916666666666671
r5129 n3822 n3856 2
r5130 n3855 n3856 0.054166666666666669
r5131 n3823 n3857 0.071428571428571425
r5132 n3856 n3857 0.060416666666666667
r5133 n3824 n3858 2
r5134 n3857 n3858 0.060416666666666667
r5135 n3825 n3859 0.080000000000000002
r5136 n3858 n3859 0.054166666666666669
r5137 n3826 n3860 0.20000000000000001
r5138 n3859 n3860 0.072916666666666671
r5139 n3827 n3861 0.20000000000000001
r5140 n3860 n3861 0.041666666666666664
r5141 n3828 n3862 0.20000000000000001
r5142 n3829 n3863 0.060606060606060608
r5143 n3862 n3863 1.34375
r5144 n3830 n3864 1
r5145 n3863 n3864 1.09375
r5146 n3831 n3865 0.066666666666666666
r5147 n3864 n3865 1
r5148 n3832 n3866 1
r5149 n3865 n3866 1
r5150 n3833 n3867 0.060606060606060608
r5151 n3866 n3867 1.09375
r5152 n3834 n3868 0.20000000000000001
r5153 n3867 n3868 1.34375
r5154 n3853 n3887 0.20000000000000001
r5155 n3854 n3888 0.20000000000000001
r5156 n3887 n3888 0.625
r5157 n3855 n3889 0.080000000000000002
r5158 n3888 n3889 1.09375
r5159 n3856 n3890 2
r5160 n3889 n3890 0.8125
r5161 n3857 n3891 0.071428571428571425
r5162 n3890 n3891 0.90625
r5163 n3858 n3892 2
r5164 n3891 n3892 0.90625
r5165 n3859 n3893 0.080000000000000002
r5166 n3892 n3893 0.8125
r5167 n3860 n3894 0.20000000000000001
r5168 n3893 n3894 1.09375
r5169 n3861 n3895 0.20000000000000001
r5170 n3894 n3895 0.625
r5171 n3862 n3896 0.15625
r5172 n3863 n3897 0.047348484848484848
r5173 n3896 n3897 0.11684782608695653
r5174 n3864 n3898 0.78125
r5175 n3897 n3898 0.095108695652173919
r5176 n3865 n3899 0.052083333333333336
r5177 n3898 n3899 0.086956521739130432
r5178 n3866 n3900 0.78125
r5179 n3899 n3900 0.086956521739130432
r5180 n3867 n3901 0.047348484848484848
r5181 n3900 n3901 0.095108695652173919
r5182 n3868 n3902 0.15625
r5183 n3901 n3902 0.11684782608695653
r5184 n3887 n3921 0.15625
r5185 n3888 n3922 0.15625
r5186 n3921 n3922 0.05434782608695652
r5187 n3889 n3923 0.0625
r5188 n3922 n3923 0.095108695652173919
r5189 n3890 n3924 1.5625
r5190 n3923 n3924 0.070652173913043473
r5191 n3891 n3925 0.055803571428571432
r5192 n3924 n3925 0.07880434782608696
r5193 n3892 n3926 1.5625
r5194 n3925 n3926 0.07880434782608696
r5195 n3893 n3927 0.0625
r5196 n3926 n3927 0.070652173913043473
r5197 n3894 n3928 0.15625
r5198 n3927 n3928 0.095108695652173919
r5199 n3895 n3929 0.15625
r5200 n3928 n3929 0.05434782608695652
r5201 n3896 n3930 0.26874999999999999
r5202 n3897 n3931 0.081439393939393936
r5203 n3930 n3931 0.13437499999999999
r5204 n3898 n3932 1.34375
r5205 n3931 n3932 0.109375
r5206 n3899 n3933 0.089583333333333334
r5207 n3932 n3933 0.10000000000000001
r5208 n3900 n3934 1.34375
r5209 n3933 n3934 0.10000000000000001
r5210 n3901 n3935 0.081439393939393936
r5211 n3934 n3935 0.109375
r5212 n3902 n3936 0.26874999999999999
r5213 n3935 n3936 0.13437499999999999
r5214 n3921 n3955 0.26874999999999999
r5215 n3922 n3956 0.26874999999999999
r5216 n3955 n3956 0.0625
r5217 n3923 n3957 0.1075
r5218 n3956 n3957 0.109375
r5219 n3924 n3958 2.6875
r5220 n3957 n3958 0.081250000000000003
r5221 n3925 n3959 0.095982142857142863
r5222 n3958 n3959 0.090624999999999997
r5223 n3926 n3960 2.6875
r5224 n3959 n3960 0.090624999999999997
r5225 n3927 n3961 0.1075
r5226 n3960 n3961 0.081250000000000003
r5227 n3928 n3962 0.26874999999999999
r5228 n3961 n3962 0.109375
r5229 n3929 n3963 0.26874999999999999
r5230 n3962 n3963 0.0625
r5231 n3931 n3964 0.12878787878787878
r5232 n3932 n3965 2.125
r5233 n3964 n3965 0.045572916666666664
r5234 n3933 n3966 0.14166666666666666
r5235 n3965 n3966 0.041666666666666664
r5236 n3934 n3967 2.125
r5237 n3966 n3967 0.041666666666666664
r5238 n3935 n3968 0.12878787878787878
r5239 n3967 n3968 0.045572916666666664
r5240 in n3969 0.84999999999999998
r5241 in n3970 0.70833333333333337
r5242 n3969 n3970 0.014322916666666666
r5243 in n3971 2.125
r5244 n3970 n3971 0.010416666666666666
r5245 in n3972 0.25
r5246 n3971 n3972 0.024739583333333332
r5247 in n3973 0.32692307692307693
r5248 n3972 n3973 0.0390625
r5249 in n3974 2.125
r5250 n3973 n3974 0.01953125
r5251 in n3975 2.125
r5252 n3974 n3975 0.005208333333333333
r5253 in n3976 1.0625
r5254 n3975 n3976 0.0078125
r5255 in n3977 0.84999999999999998
r5256 n3976 n3977 0.01171875
r5257 n3956 n3978 0.42499999999999999
r5258 n3957 n3979 0.17000000000000001
r5259 n3978 n3979 0.045572916666666664
r5260 n3958 n3980 4.25
r5261 n3979 n3980 0.033854166666666664
r5262 n3959 n3981 0.15178571428571427
r5263 n3980 n3981 0.037760416666666664
r5264 n3960 n3982 4.25
r5265 n3981 n3982 0.037760416666666664
r5266 n3961 n3983 0.17000000000000001
r5267 n3982 n3983 0.033854166666666664
r5268 n3962 n3984 0.42499999999999999
r5269 n3983 n3984 0.045572916666666664
r5270 n3964 n3985 0.18181818181818182
r5271 n3965 n3986 3
r5272 n3985 n3986 0.045572916666666664
r5273 n3966 n3987 0.20000000000000001
r5274 n3986 n3987 0.041666666666666664
r5275 n3967 n3988 3
r5276 n3987 n3988 0.041666666666666664
r5277 n3968 n3989 0.18181818181818182
r5278 n3988 n3989 0.045572916666666664
r5279 n3969 n3990 1.2
r5280 n3970 n3991 1
r5281 n3990 n3991 0.014322916666666666
r5282 n3971 n3992 3
r5283 n3991 n3992 0.010416666666666666
r5284 n3972 n3993 0.35294117647058826
r5285 n3992 n3993 0.024739583333333332
r5286 n3973 n3994 0.46153846153846156
r5287 n3993 n3994 0.0390625
r5288 n3974 n3995 3
r5289 n3994 n3995 0.01953125
r5290 n3975 n3996 3
r5291 n3995 n3996 0.005208333333333333
r5292 n3976 n3997 1.5
r5293 n3996 n3997 0.0078125
r5294 n3977 n3998 1.2
r5295 n3997 n3998 0.01171875
r5296 n3978 n3999 0.59999999999999998
r5297 n3979 n4000 0.23999999999999999
r5298 n3999 n4000 0.045572916666666664
r5299 n3980 n4001 6
r5300 n4000 n4001 0.033854166666666664
r5301 n3981 n4002 0.21428571428571427
r5302 n4001 n4002 0.037760416666666664
r5303 n3982 n4003 6
r5304 n4002 n4003 0.037760416666666664
r5305 n3983 n4004 0.23999999999999999
r5306 n4003 n4004 0.033854166666666664
r5307 n3984 n4005 0.59999999999999998
r5308 n4004 n4005 0.045572916666666664
r5309 n3985 n4006 0.18181818181818182
r5310 n3986 n4007 3
r5311 n4006 n4007 0.045572916666666664
r5312 n3987 n4008 0.20000000000000001
r5313 n4007 n4008 0.041666666666666664
r5314 n3988 n4009 3
r5315 n4008 n4009 0.041666666666666664
r5316 n3989 n4010 0.18181818181818182
r5317 n4009 n4010 0.045572916666666664
r5318 n3990 n4011 1.2
r5319 n3991 n4012 1
r5320 n4011 n4012 0.014322916666666666
r5321 n3992 n4013 3
r5322 n4012 n4013 0.010416666666666666
r5323 n3993 n4014 0.35294117647058826
r5324 n4013 n4014 0.024739583333333332
r5325 n3994 n4015 0.46153846153846156
r5326 n4014 n4015 0.0390625
r5327 n3995 n4016 3
r5328 n4015 n4016 0.01953125
r5329 n3996 n4017 3
r5330 n4016 n4017 0.005208333333333333
r5331 n3997 n4018 1.5
r5332 n4017 n4018 0.0078125
r5333 n3998 n4019 1.2
r5334 n4018 n4019 0.01171875
r5335 n3999 n4020 0.59999999999999998
r5336 n4000 n4021 0.23999999999999999
r5337 n4020 n4021 0.045572916666666664
r5338 n4001 n4022 6
r5339 n4021 n4022 0.033854166666666664
r5340 n4002 n4023 0.21428571428571427
r5341 n4022 n4023 0.037760416666666664
r5342 n4003 n4024 6
r5343 n4023 n4024 0.037760416666666664
r5344 n4004 n4025 0.23999999999999999
r5345 n4024 n4025 0.033854166666666664
r5346 n4005 n4026 0.59999999999999998
r5347 n4025 n4026 0.045572916666666664
r5348 n4006 n4027 0.094696969696969696
r5349 n4007 n4028 1.5625
r5350 n4027 n4028 1.09375
r5351 n4008 n4029 0.10416666666666667
r5352 n4028 n4029 1
r5353 n4009 n4030 1.5625
r5354 n4029 n4030 1
r5355 n4010 n4031 0.094696969696969696
r5356 n4030 n4031 1.09375
r5357 n4032 n4033 0.46875
r5358 n4033 n4034 0.3125
r5359 n4034 n4035 0.1875
r5360 n4035 n4036 0.09375
r5361 n4036 n4037 0.09375
r5362 n4037 n4038 0.0625
r5363 n4038 n4039 0.0625
r5364 n4039 n4040 0.15625
r5365 n4040 n4041 0.28125
r5366 n4041 n4042 0.1875
r5367 n4042 n4043 0.34375
r5368 n4043 n4044 0.40625
r5369 n4044 n4045 0.28125
r5370 n4045 n4046 0.25
r5371 n4046 n4047 0.09375
r5372 n4047 n4048 0.0625
r5373 n4048 n4049 0.21875
r5374 n4049 n4050 0.34375
r5375 n4050 n4051 0.1875
r5376 n4051 n4052 0.15625
r5377 n4052 n4053 0.28125
r5378 n4011 n4054 0.625
r5379 n4012 n4055 0.52083333333333337
r5380 n4054 n4055 0.34375
r5381 n4013 n4056 1.5625
r5382 n4055 n4056 0.25
r5383 n4014 n4057 0.18382352941176472
r5384 n4056 n4057 0.59375
r5385 n4015 n4058 0.24038461538461539
r5386 n4057 n4058 0.9375
r5387 n4016 n4059 1.5625
r5388 n4058 n4059 0.46875
r5389 n4017 n4060 1.5625
r5390 n4059 n4060 0.125
r5391 n4018 n4061 0.78125
r5392 n4060 n4061 0.1875
r5393 n4019 n4062 0.625
r5394 n4061 n4062 0.28125
r5395 n4020 n4063 0.3125
r5396 n4021 n4064 0.125
r5397 n4063 n4064 1.09375
r5398 n4022 n4065 3.125
r5399 n4064 n4065 0.8125
r5400 n4023 n4066 0.11160714285714286
r5401 n4065 n4066 0.90625
r5402 n4024 n4067 3.125
r5403 n4066 n4067 0.90625
r5404 n4025 n4068 0.125
r5405 n4067 n4068 0.8125
r5406 n4026 n4069 0.3125
r5407 n4068 n4069 1.09375
r5408 n4027 n4070 0.02462121212121212
r5409 n4028 n4071 0.40625
r5410 n4070 n4071 0.19886363636363635
r5411 n4029 n4072 0.027083333333333334
r5412 n4071 n4072 0.18181818181818182
r5413 n4030 n4073 0.40625
r5414 n4072 n4073 0.18181818181818182
r5415 n4031 n4074 0.02462121212121212
r5416 n4073 n4074 0.19886363636363635
r5417 n4074 n4075 0.24431818181818182
r5418 n4075 n4076 0.28977272727272729
r5419 n4076 n4077 0.46590909090909088
r5420 n4077 n4078 0.46590909090909088
r5421 n4078 n4079 0.42613636363636365
r5422 n4079 n4080 0.34886363636363638
r5423 n4080 n4081 0.3125
r5424 n4081 n4082 0.34999999999999998
r5425 n4082 n4083 0.26704545454545453
r5426 n4083 n4084 0.30113636363636365
r5427 n4084 n4085 0.23295454545454544
r5428 n4085 n4086 0.19318181818181818
r5429 n4086 n4087 0.19318181818181818
r5430 n4087 n4088 0.13636363636363635
r5431 n4088 n4089 0.15340909090909091
r5432 n4089 n4090 0.056818181818181816
r5433 n4090 n4091 0.0625
r5434 n4091 n4092 0.034090909090909088
r5435 n4092 n4093 0.079545454545454544
r5436 n4093 n4094 0.13068181818181818
r5437 n4094 n4095 0.085227272727272721
r5438 n4095 n4096 0.056818181818181816
r5439 n4096 n4097 0.034090909090909088
r5440 n4097 n4098 0.022727272727272728
r5441 n4098 n4099 0.022727272727272728
r5442 n4099 n4100 0.056818181818181816
r5443 n4032 n4101 0.081250000000000003
r5444 n4100 n4101 0.10795454545454546
r5445 n4033 n4102 0.16250000000000001
r5446 n4101 n4102 0.085227272727272721
r5447 n4034 n4103 0.16250000000000001
r5448 n4102 n4103 0.056818181818181816
r5449 n4035 n4104 0.8125
r5450 n4103 n4104 0.034090909090909088
r5451 n4036 n4105 0.40625
r5452 n4104 n4105 0.017045454545454544
r5453 n4037 n4106 0.8125
r5454 n4105 n4106 0.017045454545454544
r5455 n4038 n4107 0.8125
r5456 n4106 n4107 0.011363636363636364
r5457 n4039 n4108 0.8125
r5458 n4107 n4108 0.011363636363636364
r5459 n4040 n4109 0.203125
r5460 n4108 n4109 0.028409090909090908
r5461 n4041 n4110 0.16250000000000001
r5462 n4109 n4110 0.05113636363636364
r5463 n4042 n4111 0.8125
r5464 n4110 n4111 0.034090909090909088
r5465 n4043 n4112 0.081250000000000003
r5466 n4111 n4112 0.0625
r5467 n4044 n4113 0.27083333333333331
r5468 n4112 n4113 0.073863636363636367
r5469 n4045 n4114 0.13541666666666666
r5470 n4113 n4114 0.05113636363636364
r5471 n4046 n4115 0.40625
r5472 n4114 n4115 0.045454545454545456
r5473 n4047 n4116 0.8125
r5474 n4115 n4116 0.017045454545454544
r5475 n4048 n4117 0.8125
r5476 n4116 n4117 0.011363636363636364
r5477 n4049 n4118 0.13541666666666666
r5478 n4117 n4118 0.039772727272727272
r5479 n4050 n4119 0.16250000000000001
r5480 n4118 n4119 0.0625
r5481 n4051 n4120 0.8125
r5482 n4119 n4120 0.034090909090909088
r5483 n4052 n4121 0.203125
r5484 n4120 n4121 0.028409090909090908
r5485 n4053 n4122 0.16250000000000001
r5486 n4121 n4122 0.05113636363636364
r5487 n4054 n4123 0.16250000000000001
r5488 n4055 n4124 0.13541666666666666
r5489 n4123 n4124 0.0625
r5490 n4056 n4125 0.40625
r5491 n4124 n4125 0.045454545454545456
r5492 n4057 n4126 0.04779411764705882
r5493 n4125 n4126 0.10795454545454546
r5494 n4058 n4127 0.0625
r5495 n4126 n4127 0.17045454545454544
r5496 n4059 n4128 0.40625
r5497 n4127 n4128 0.085227272727272721
r5498 n4060 n4129 0.40625
r5499 n4128 n4129 0.022727272727272728
r5500 n4061 n4130 0.203125
r5501 n4129 n4130 0.034090909090909088
r5502 n4062 n4131 0.16250000000000001
r5503 n4130 n4131 0.05113636363636364
r5504 n4063 n4132 0.081250000000000003
r5505 n4064 n4133 0.032500000000000001
r5506 n4132 n4133 0.19886363636363635
r5507 n4065 n4134 0.8125
r5508 n4133 n4134 0.14772727272727273
r5509 n4066 n4135 0.029017857142857144
r5510 n4134 n4135 0.16477272727272727
r5511 n4067 n4136 0.8125
r5512 n4135 n4136 0.16477272727272727
r5513 n4068 n4137 0.032500000000000001
r5514 n4136 n4137 0.14772727272727273
r5515 n4069 n4138 0.081250000000000003
r5516 n4137 n4138 0.19886363636363635
r5517 n4070 n4139 0.02462121212121212
r5518 n4071 n4140 0.40625
r5519 n4139 n4140 1.09375
r5520 n4072 n4141 0.027083333333333334
r5521 n4140 n4141 1
r5522 n4073 n4142 0.40625
r5523 n4141 n4142 1
r5524 n4074 n4143 0.02462121212121212
r5525 n4142 n4143 1.09375
r5526 n4075 n4144 0.081250000000000003
r5527 n4143 n4144 1.34375
r5528 n4076 n4145 0.019817073170731708
r5529 n4144 n4145 1.59375
r5530 n4077 n4146 0.019817073170731708
r5531 n4145 n4146 2.5625
r5532 n4078 n4147 0.019817073170731708
r5533 n4146 n4147 2.5625
r5534 n4079 n4148 0.02389705882352941
r5535 n4147 n4148 2.34375
r5536 n4080 n4149 0.029653284671532845
r5537 n4148 n4149 1.91875
r5538 n4081 n4150 0.029438405797101448
r5539 n4149 n4150 1.71875
r5540 n4082 n4151 0.02389705882352941
r5541 n4150 n4151 1.925
r5542 n4083 n4152 0.0625
r5543 n4151 n4152 1.46875
r5544 n4084 n4153 0.020312500000000001
r5545 n4152 n4153 1.65625
r5546 n4085 n4154 0.8125
r5547 n4153 n4154 1.28125
r5548 n4086 n4155 0.02462121212121212
r5549 n4154 n4155 1.0625
r5550 n4087 n4156 0.8125
r5551 n4155 n4156 1.0625
r5552 n4088 n4157 0.035326086956521736
r5553 n4156 n4157 0.75
r5554 n4089 n4158 0.203125
r5555 n4157 n4158 0.84375
r5556 n4090 n4159 0.13541666666666666
r5557 n4158 n4159 0.3125
r5558 n4091 n4160 0.16250000000000001
r5559 n4159 n4160 0.34375
r5560 n4092 n4161 0.8125
r5561 n4160 n4161 0.1875
r5562 n4093 n4162 0.0625
r5563 n4161 n4162 0.4375
r5564 n4094 n4163 0.081250000000000003
r5565 n4162 n4163 0.71875
r5566 n4095 n4164 0.16250000000000001
r5567 n4163 n4164 0.46875
r5568 n4096 n4165 0.16250000000000001
r5569 n4164 n4165 0.3125
r5570 n4097 n4166 0.8125
r5571 n4165 n4166 0.1875
r5572 n4098 n4167 0.27083333333333331
r5573 n4166 n4167 0.125
r5574 n4099 n4168 0.8125
r5575 n4167 n4168 0.125
r5576 n4100 n4169 0.090277777777777776
r5577 n4168 n4169 0.3125
r5578 n4101 n4170 0.081250000000000003
r5579 n4169 n4170 0.59375
r5580 n4102 n4171 0.16250000000000001
r5581 n4170 n4171 0.46875
r5582 n4103 n4172 0.16250000000000001
r5583 n4171 n4172 0.3125
r5584 n4104 n4173 0.8125
r5585 n4172 n4173 0.1875
r5586 n4105 n4174 0.40625
r5587 n4173 n4174 0.09375
r5588 n4106 n4175 0.8125
r5589 n4174 n4175 0.09375
r5590 n4107 n4176 0.8125
r5591 n4175 n4176 0.0625
r5592 n4108 n4177 0.8125
r5593 n4176 n4177 0.0625
r5594 n4109 n4178 0.203125
r5595 n4177 n4178 0.15625
r5596 n4110 n4179 0.16250000000000001
r5597 n4178 n4179 0.28125
r5598 n4111 n4180 0.8125
r5599 n4179 n4180 0.1875
r5600 n4112 n4181 0.081250000000000003
r5601 n4180 n4181 0.34375
r5602 n4113 n4182 0.27083333333333331
r5603 n4181 n4182 0.40625
r5604 n4114 n4183 0.13541666666666666
r5605 n4182 n4183 0.28125
r5606 n4115 n4184 0.40625
r5607 n4183 n4184 0.25
r5608 n4116 n4185 0.8125
r5609 n4184 n4185 0.09375
r5610 n4117 n4186 0.8125
r5611 n4185 n4186 0.0625
r5612 n4118 n4187 0.13541666666666666
r5613 n4186 n4187 0.21875
r5614 n4119 n4188 0.16250000000000001
r5615 n4187 n4188 0.34375
r5616 n4120 n4189 0.8125
r5617 n4188 n4189 0.1875
r5618 n4121 n4190 0.203125
r5619 n4189 n4190 0.15625
r5620 n4122 n4191 0.16250000000000001
r5621 n4190 n4191 0.28125
r5622 n4123 n4192 0.16250000000000001
r5623 n4124 n4193 0.13541666666666666
r5624 n4192 n4193 0.34375
r5625 n4125 n4194 0.40625
r5626 n4193 n4194 0.25
r5627 n4126 n4195 0.04779411764705882
r5628 n4194 n4195 0.59375
r5629 n4127 n4196 0.0625
r5630 n4195 n4196 0.9375
r5631 n4128 n4197 0.40625
r5632 n4196 n4197 0.46875
r5633 n4129 n4198 0.40625
r5634 n4197 n4198 0.125
r5635 n4130 n4199 0.203125
r5636 n4198 n4199 0.1875
r5637 n4131 n4200 0.16250000000000001
r5638 n4199 n4200 0.28125
r5639 n4132 n4201 0.081250000000000003
r5640 n4133 n4202 0.032500000000000001
r5641 n4201 n4202 1.09375
r5642 n4134 n4203 0.8125
r5643 n4202 n4203 0.8125
r5644 n4135 n4204 0.029017857142857144
r5645 n4203 n4204 0.90625
r5646 n4136 n4205 0.8125
r5647 n4204 n4205 0.90625
r5648 n4137 n4206 0.032500000000000001
r5649 n4205 n4206 0.8125
r5650 n4138 n4207 0.081250000000000003
r5651 n4206 n4207 1.09375
r5652 n4139 n4208 0.060606060606060608
r5653 n4140 n4209 1
r5654 n4208 n4209 0.072916666666666671
r5655 n4141 n4210 0.066666666666666666
r5656 n4209 n4210 0.066666666666666666
r5657 n4142 n4211 1
r5658 n4210 n4211 0.066666666666666666
r5659 n4143 n4212 0.060606060606060608
r5660 n4211 n4212 0.072916666666666671
r5661 n4144 n4213 0.20000000000000001
r5662 n4212 n4213 0.089583333333333334
r5663 n4145 n4214 0.04878048780487805
r5664 n4213 n4214 0.10625
r5665 n4146 n4215 0.04878048780487805
r5666 n4214 n4215 0.17083333333333334
r5667 n4147 n4216 0.04878048780487805
r5668 n4215 n4216 0.17083333333333334
r5669 n4148 n4217 0.058823529411764705
r5670 n4216 n4217 0.15625
r5671 n4149 n4218 0.072992700729927001
r5672 n4217 n4218 0.12791666666666668
r5673 n4150 n4219 0.072463768115942032
r5674 n4218 n4219 0.11458333333333333
r5675 n4151 n4220 0.058823529411764705
r5676 n4219 n4220 0.12833333333333333
r5677 n4152 n4221 0.15384615384615385
r5678 n4220 n4221 0.097916666666666666
r5679 n4153 n4222 0.050000000000000003
r5680 n4221 n4222 0.11041666666666666
r5681 n4154 n4223 2
r5682 n4222 n4223 0.085416666666666669
r5683 n4155 n4224 0.060606060606060608
r5684 n4223 n4224 0.070833333333333331
r5685 n4156 n4225 2
r5686 n4224 n4225 0.070833333333333331
r5687 n4157 n4226 0.086956521739130432
r5688 n4225 n4226 0.050000000000000003
r5689 n4158 n4227 0.5
r5690 n4226 n4227 0.056250000000000001
r5691 n4159 n4228 0.33333333333333331
r5692 n4227 n4228 0.020833333333333332
r5693 n4160 n4229 0.40000000000000002
r5694 n4228 n4229 0.022916666666666665
r5695 n4161 n4230 2
r5696 n4229 n4230 0.012500000000000001
r5697 n4162 n4231 0.15384615384615385
r5698 n4230 n4231 0.029166666666666667
r5699 n4163 n4232 0.20000000000000001
r5700 n4231 n4232 0.04791666666666667
r5701 n4164 n4233 0.40000000000000002
r5702 n4232 n4233 0.03125
r5703 n4165 n4234 0.40000000000000002
r5704 n4233 n4234 0.020833333333333332
r5705 n4166 n4235 2
r5706 n4234 n4235 0.012500000000000001
r5707 n4167 n4236 0.66666666666666663
r5708 n4235 n4236 0.0083333333333333332
r5709 n4168 n4237 2
r5710 n4236 n4237 0.0083333333333333332
r5711 n4169 n4238 0.22222222222222221
r5712 n4237 n4238 0.020833333333333332
r5713 n4170 n4239 0.20000000000000001
r5714 n4238 n4239 0.039583333333333331
r5715 n4171 n4240 0.40000000000000002
r5716 n4239 n4240 0.03125
r5717 n4172 n4241 0.40000000000000002
r5718 n4240 n4241 0.020833333333333332
r5719 n4173 n4242 2
r5720 n4241 n4242 0.012500000000000001
r5721 n4174 n4243 1
r5722 n4242 n4243 0.0062500000000000003
r5723 n4175 n4244 2
r5724 n4243 n4244 0.0062500000000000003
r5725 n4176 n4245 2
r5726 n4244 n4245 0.0041666666666666666
r5727 n4177 n4246 2
r5728 n4245 n4246 0.0041666666666666666
r5729 n4178 n4247 0.5
r5730 n4246 n4247 0.010416666666666666
r5731 n4179 n4248 0.40000000000000002
r5732 n4247 n4248 0.018749999999999999
r5733 n4180 n4249 2
r5734 n4248 n4249 0.012500000000000001
r5735 n4181 n4250 0.20000000000000001
r5736 n4249 n4250 0.022916666666666665
r5737 n4182 n4251 0.66666666666666663
r5738 n4250 n4251 0.027083333333333334
r5739 n4183 n4252 0.33333333333333331
r5740 n4251 n4252 0.018749999999999999
r5741 n4184 n4253 1
r5742 n4252 n4253 0.016666666666666666
r5743 n4185 n4254 2
r5744 n4253 n4254 0.0062500000000000003
r5745 n4186 n4255 2
r5746 n4254 n4255 0.0041666666666666666
r5747 n4187 n4256 0.33333333333333331
r5748 n4255 n4256 0.014583333333333334
r5749 n4188 n4257 0.40000000000000002
r5750 n4256 n4257 0.022916666666666665
r5751 n4189 n4258 2
r5752 n4257 n4258 0.012500000000000001
r5753 n4190 n4259 0.5
r5754 n4258 n4259 0.010416666666666666
r5755 n4191 n4260 0.40000000000000002
r5756 n4259 n4260 0.018749999999999999
r5757 n4192 n4261 0.40000000000000002
r5758 n4193 n4262 0.33333333333333331
r5759 n4261 n4262 0.022916666666666665
r5760 n4194 n4263 1
r5761 n4262 n4263 0.016666666666666666
r5762 n4195 n4264 0.11764705882352941
r5763 n4263 n4264 0.039583333333333331
r5764 n4196 n4265 0.15384615384615385
r5765 n4264 n4265 0.0625
r5766 n4197 n4266 1
r5767 n4265 n4266 0.03125
r5768 n4198 n4267 1
r5769 n4266 n4267 0.0083333333333333332
r5770 n4199 n4268 0.5
r5771 n4267 n4268 0.012500000000000001
r5772 n4200 n4269 0.40000000000000002
r5773 n4268 n4269 0.018749999999999999
r5774 n4201 n4270 0.20000000000000001
r5775 n4202 n4271 0.080000000000000002
r5776 n4270 n4271 0.072916666666666671
r5777 n4203 n4272 2
r5778 n4271 n4272 0.054166666666666669
r5779 n4204 n4273 0.071428571428571425
r5780 n4272 n4273 0.060416666666666667
r5781 n4205 n4274 2
r5782 n4273 n4274 0.060416666666666667
r5783 n4206 n4275 0.080000000000000002
r5784 n4274 n4275 0.054166666666666669
r5785 n4207 n4276 0.20000000000000001
r5786 n4275 n4276 0.072916666666666671
r5787 n4208 n4277 0.060606060606060608
r5788 n4209 n4278 1
r5789 n4277 n4278 1.09375
r5790 n4210 n4279 0.066666666666666666
r5791 n4278 n4279 1
r5792 n4211 n4280 1
r5793 n4279 n4280 1
r5794 n4212 n4281 0.060606060606060608
r5795 n4280 n4281 1.09375
r5796 n4213 n4282 0.20000000000000001
r5797 n4281 n4282 1.34375
r5798 n4214 n4283 0.04878048780487805
r5799 n4282 n4283 1.59375
r5800 n4215 n4284 0.04878048780487805
r5801 n4283 n4284 2.5625
r5802 n4216 n4285 0.04878048780487805
r5803 n4284 n4285 2.5625
r5804 n4217 n4286 0.058823529411764705
r5805 n4285 n4286 2.34375
r5806 n4218 n4287 0.072992700729927001
r5807 n4286 n4287 1.91875
r5808 n4219 n4288 0.072463768115942032
r5809 n4287 n4288 1.71875
r5810 n4220 n4289 0.058823529411764705
r5811 n4288 n4289 1.925
r5812 n4221 n4290 0.15384615384615385
r5813 n4289 n4290 1.46875
r5814 n4222 n4291 0.050000000000000003
r5815 n4290 n4291 1.65625
r5816 n4223 n4292 2
r5817 n4291 n4292 1.28125
r5818 n4224 n4293 0.060606060606060608
r5819 n4292 n4293 1.0625
r5820 n4225 n4294 2
r5821 n4293 n4294 1.0625
r5822 n4226 n4295 0.086956521739130432
r5823 n4294 n4295 0.75
r5824 n4227 n4296 0.5
r5825 n4295 n4296 0.84375
r5826 n4228 n4297 0.33333333333333331
r5827 n4296 n4297 0.3125
r5828 n4229 n4298 0.40000000000000002
r5829 n4297 n4298 0.34375
r5830 n4230 n4299 2
r5831 n4298 n4299 0.1875
r5832 n4231 n4300 0.15384615384615385
r5833 n4299 n4300 0.4375
r5834 n4232 n4301 0.20000000000000001
r5835 n4300 n4301 0.71875
r5836 n4233 n4302 0.40000000000000002
r5837 n4301 n4302 0.46875
r5838 n4234 n4303 0.40000000000000002
r5839 n4302 n4303 0.3125
r5840 n4235 n4304 2
r5841 n4303 n4304 0.1875
r5842 n4236 n4305 0.66666666666666663
r5843 n4304 n4305 0.125
r5844 n4237 n4306 2
r5845 n4305 n4306 0.125
r5846 n4238 n4307 0.22222222222222221
r5847 n4306 n4307 0.3125
r5848 n4239 n4308 0.20000000000000001
r5849 n4307 n4308 0.59375
r5850 n4240 n4309 0.40000000000000002
r5851 n4308 n4309 0.46875
r5852 n4241 n4310 0.40000000000000002
r5853 n4309 n4310 0.3125
r5854 n4242 n4311 2
r5855 n4310 n4311 0.1875
r5856 n4243 n4312 1
r5857 n4311 n4312 0.09375
r5858 n4244 n4313 2
r5859 n4312 n4313 0.09375
r5860 n4245 n4314 2
r5861 n4313 n4314 0.0625
r5862 n4246 n4315 2
r5863 n4314 n4315 0.0625
r5864 n4247 n4316 0.5
r5865 n4315 n4316 0.15625
r5866 n4248 n4317 0.40000000000000002
r5867 n4316 n4317 0.28125
r5868 n4249 n4318 2
r5869 n4317 n4318 0.1875
r5870 n4250 n4319 0.20000000000000001
r5871 n4318 n4319 0.34375
r5872 n4251 n4320 0.66666666666666663
r5873 n4319 n4320 0.40625
r5874 n4252 n4321 0.33333333333333331
r5875 n4320 n4321 0.28125
r5876 n4253 n4322 1
r5877 n4321 n4322 0.25
r5878 n4254 n4323 2
r5879 n4322 n4323 0.09375
r5880 n4255 n4324 2
r5881 n4323 n4324 0.0625
r5882 n4256 n4325 0.33333333333333331
r5883 n4324 n4325 0.21875
r5884 n4257 n4326 0.40000000000000002
r5885 n4325 n4326 0.34375
r5886 n4258 n4327 2
r5887 n4326 n4327 0.1875
r5888 n4259 n4328 0.5
r5889 n4327 n4328 0.15625
r5890 n4260 n4329 0.40000000000000002
r5891 n4328 n4329 0.28125
r5892 n4261 n4330 0.40000000000000002
r5893 n4262 n4331 0.33333333333333331
r5894 n4330 n4331 0.34375
r5895 n4263 n4332 1
r5896 n4331 n4332 0.25
r5897 n4264 n4333 0.11764705882352941
r5898 n4332 n4333 0.59375
r5899 n4265 n4334 0.15384615384615385
r5900 n4333 n4334 0.9375
r5901 n4266 n4335 1
r5902 n4334 n4335 0.46875
r5903 n4267 n4336 1
r5904 n4335 n4336 0.125
r5905 n4268 n4337 0.5
r5906 n4336 n4337 0.1875
r5907 n4269 n4338 0.40000000000000002
r5908 n4337 n4338 0.28125
r5909 n4270 n4339 0.20000000000000001
r5910 n4271 n4340 0.080000000000000002
r5911 n4339 n4340 1.09375
r5912 n4272 n4341 2
r5913 n4340 n4341 0.8125
r5914 n4273 n4342 0.071428571428571425
r5915 n4341 n4342 0.90625
r5916 n4274 n4343 2
r5917 n4342 n4343 0.90625
r5918 n4275 n4344 0.080000000000000002
r5919 n4343 n4344 0.8125
r5920 n4276 n4345 0.20000000000000001
r5921 n4344 n4345 1.09375
r5922 n4277 n4346 0.02462121212121212
r5923 n4278 n4347 0.40625
r5924 n4346 n4347 0.19886363636363635
r5925 n4279 n4348 0.027083333333333334
r5926 n4347 n4348 0.18181818181818182
r5927 n4280 n4349 0.40625
r5928 n4348 n4349 0.18181818181818182
r5929 n4281 n4350 0.02462121212121212
r5930 n4349 n4350 0.19886363636363635
r5931 n4282 n4351 0.081250000000000003
r5932 n4350 n4351 0.24431818181818182
r5933 n4283 n4352 0.019817073170731708
r5934 n4351 n4352 0.28977272727272729
r5935 n4284 n4353 0.019817073170731708
r5936 n4352 n4353 0.46590909090909088
r5937 n4285 n4354 0.019817073170731708
r5938 n4353 n4354 0.46590909090909088
r5939 n4286 n4355 0.02389705882352941
r5940 n4354 n4355 0.42613636363636365
r5941 n4287 n4356 0.029653284671532845
r5942 n4355 n4356 0.34886363636363638
r5943 n4288 n4357 0.029438405797101448
r5944 n4356 n4357 0.3125
r5945 n4289 n4358 0.02389705882352941
r5946 n4357 n4358 0.34999999999999998
r5947 n4290 n4359 0.0625
r5948 n4358 n4359 0.26704545454545453
r5949 n4291 n4360 0.020312500000000001
r5950 n4359 n4360 0.30113636363636365
r5951 n4292 n4361 0.8125
r5952 n4360 n4361 0.23295454545454544
r5953 n4293 n4362 0.02462121212121212
r5954 n4361 n4362 0.19318181818181818
r5955 n4294 n4363 0.8125
r5956 n4362 n4363 0.19318181818181818
r5957 n4295 n4364 0.035326086956521736
r5958 n4363 n4364 0.13636363636363635
r5959 n4296 n4365 0.203125
r5960 n4364 n4365 0.15340909090909091
r5961 n4297 n4366 0.13541666666666666
r5962 n4365 n4366 0.056818181818181816
r5963 n4298 n4367 0.16250000000000001
r5964 n4366 n4367 0.0625
r5965 n4299 n4368 0.8125
r5966 n4367 n4368 0.034090909090909088
r5967 n4300 n4369 0.0625
r5968 n4368 n4369 0.079545454545454544
r5969 n4301 n4370 0.081250000000000003
r5970 n4369 n4370 0.13068181818181818
r5971 n4302 n4371 0.16250000000000001
r5972 n4370 n4371 0.085227272727272721
r5973 n4303 n4372 0.16250000000000001
r5974 n4371 n4372 0.056818181818181816
r5975 n4304 n4373 0.8125
r5976 n4372 n4373 0.034090909090909088
r5977 n4305 n4374 0.27083333333333331
r5978 n4373 n4374 0.022727272727272728
r5979 n4306 n4375 0.8125
r5980 n4374 n4375 0.022727272727272728
r5981 n4307 n4376 0.090277777777777776
r5982 n4375 n4376 0.056818181818181816
r5983 n4308 n4377 0.081250000000000003
r5984 n4376 n4377 0.10795454545454546
r5985 n4309 n4378 0.16250000000000001
r5986 n4377 n4378 0.085227272727272721
r5987 n4310 n4379 0.16250000000000001
r5988 n4378 n4379 0.056818181818181816
r5989 n4311 n4380 0.8125
r5990 n4379 n4380 0.034090909090909088
r5991 n4312 n4381 0.40625
r5992 n4380 n4381 0.017045454545454544
r5993 n4313 n4382 0.8125
r5994 n4381 n4382 0.017045454545454544
r5995 n4314 n4383 0.8125
r5996 n4382 n4383 0.011363636363636364
r5997 n4315 n4384 0.8125
r5998 n4383 n4384 0.011363636363636364
r5999 n4316 n4385 0.203125
r6000 n4384 n4385 0.028409090909090908
r6001 n4317 n4386 0.16250000000000001
r6002 n4385 n4386 0.05113636363636364
r6003 n4318 n4387 0.8125
r6004 n4386 n4387 0.034090909090909088
r6005 n4319 n4388 0.081250000000000003
r6006 n4387 n4388 0.0625
r6007 n4320 n4389 0.27083333333333331
r6008 n4388 n4389 0.073863636363636367
r6009 n4321 n4390 0.13541666666666666
r6010 n4389 n4390 0.05113636363636364
r6011 n4322 n4391 0.40625
r6012 n4390 n4391 0.045454545454545456
r6013 n4323 n4392 0.8125
r6014 n4391 n4392 0.017045454545454544
r6015 n4324 n4393 0.8125
r6016 n4392 n4393 0.011363636363636364
r6017 n4325 n4394 0.13541666666666666
r6018 n4393 n4394 0.039772727272727272
r6019 n4326 n4395 0.16250000000000001
r6020 n4394 n4395 0.0625
r6021 n4327 n4396 0.8125
r6022 n4395 n4396 0.034090909090909088
r6023 n4328 n4397 0.203125
r6024 n4396 n4397 0.028409090909090908
r6025 n4329 n4398 0.16250000000000001
r6026 n4397 n4398 0.05113636363636364
r6027 n4330 n4399 0.16250000000000001
r6028 n4331 n4400 0.13541666666666666
r6029 n4399 n4400 0.0625
r6030 n4332 n4401 0.40625
r6031 n4400 n4401 0.045454545454545456
r6032 n4333 n4402 0.04779411764705882
r6033 n4401 n4402 0.10795454545454546
r6034 n4334 n4403 0.0625
r6035 n4402 n4403 0.17045454545454544
r6036 n4335 n4404 0.40625
r6037 n4403 n4404 0.085227272727272721
r6038 n4336 n4405 0.40625
r6039 n4404 n4405 0.022727272727272728
r6040 n4337 n4406 0.203125
r6041 n4405 n4406 0.034090909090909088
r6042 n4338 n4407 0.16250000000000001
r6043 n4406 n4407 0.05113636363636364
r6044 n4339 n4408 0.081250000000000003
r6045 n4340 n4409 0.032500000000000001
r6046 n4408 n4409 0.19886363636363635
r6047 n4341 n4410 0.8125
r6048 n4409 n4410 0.14772727272727273
r6049 n4342 n4411 0.029017857142857144
r6050 n4410 n4411 0.16477272727272727
r6051 n4343 n4412 0.8125
r6052 n4411 n4412 0.16477272727272727
r6053 n4344 n4413 0.032500000000000001
r6054 n4412 n4413 0.14772727272727273
r6055 n4345 n4414 0.081250000000000003
r6056 n4413 n4414 0.19886363636363635
r6057 n4346 n4415 0.02462121212121212
r6058 n4347 n4416 0.40625
r6059 n4415 n4416 1.09375
r6060 n4348 n4417 0.027083333333333334
r6061 n4416 n4417 1
r6062 n4349 n4418 0.40625
r6063 n4417 n4418 1
r6064 n4350 n4419 0.02462121212121212
r6065 n4418 n4419 1.09375
r6066 n4377 n4420 0.081250000000000003
r6067 n4378 n4421 0.16250000000000001
r6068 n4420 n4421 0.46875
r6069 n4379 n4422 0.16250000000000001
r6070 n4421 n4422 0.3125
r6071 n4380 n4423 0.8125
r6072 n4422 n4423 0.1875
r6073 n4381 n4424 0.40625
r6074 n4423 n4424 0.09375
r6075 n4382 n4425 0.8125
r6076 n4424 n4425 0.09375
r6077 n4383 n4426 0.8125
r6078 n4425 n4426 0.0625
r6079 n4384 n4427 0.8125
r6080 n4426 n4427 0.0625
r6081 n4385 n4428 0.203125
r6082 n4427 n4428 0.15625
r6083 n4386 n4429 0.16250000000000001
r6084 n4428 n4429 0.28125
r6085 n4387 n4430 0.8125
r6086 n4429 n4430 0.1875
r6087 n4388 n4431 0.081250000000000003
r6088 n4430 n4431 0.34375
r6089 n4389 n4432 0.27083333333333331
r6090 n4431 n4432 0.40625
r6091 n4390 n4433 0.13541666666666666
r6092 n4432 n4433 0.28125
r6093 n4391 n4434 0.40625
r6094 n4433 n4434 0.25
r6095 n4392 n4435 0.8125
r6096 n4434 n4435 0.09375
r6097 n4393 n4436 0.8125
r6098 n4435 n4436 0.0625
r6099 n4394 n4437 0.13541666666666666
r6100 n4436 n4437 0.21875
r6101 n4395 n4438 0.16250000000000001
r6102 n4437 n4438 0.34375
r6103 n4396 n4439 0.8125
r6104 n4438 n4439 0.1875
r6105 n4397 n4440 0.203125
r6106 n4439 n4440 0.15625
r6107 n4398 n4441 0.16250000000000001
r6108 n4440 n4441 0.28125
r6109 n4399 n4442 0.16250000000000001
r6110 n4400 n4443 0.13541666666666666
r6111 n4442 n4443 0.34375
r6112 n4401 n4444 0.40625
r6113 n4443 n4444 0.25
r6114 n4402 n4445 0.04779411764705882
r6115 n4444 n4445 0.59375
r6116 n4403 n4446 0.0625
r6117 n4445 n4446 0.9375
r6118 n4404 n4447 0.40625
r6119 n4446 n4447 0.46875
r6120 n4405 n4448 0.40625
r6121 n4447 n4448 0.125
r6122 n4406 n4449 0.203125
r6123 n4448 n4449 0.1875
r6124 n4407 n4450 0.16250000000000001
r6125 n4449 n4450 0.28125
r6126 n4408 n4451 0.081250000000000003
r6127 n4409 n4452 0.032500000000000001
r6128 n4451 n4452 1.09375
r6129 n4410 n4453 0.8125
r6130 n4452 n4453 0.8125
r6131 n4411 n4454 0.029017857142857144
r6132 n4453 n4454 0.90625
r6133 n4412 n4455 0.8125
r6134 n4454 n4455 0.90625
r6135 n4413 n4456 0.032500000000000001
r6136 n4455 n4456 0.8125
r6137 n4414 n4457 0.081250000000000003
r6138 n4456 n4457 1.09375
r6139 n4415 n4458 0.070075757575757569
r6140 n4416 n4459 1.15625
r6141 n4458 n4459 0.0625
r6142 n4417 n4460 0.077083333333333337
r6143 n4459 n4460 0.057142857142857141
r6144 n4418 n4461 1.15625
r6145 n4460 n4461 0.057142857142857141
r6146 n4419 n4462 0.070075757575757569
r6147 n4461 n4462 0.0625
r6148 n4442 n4463 0.46250000000000002
r6149 n4443 n4464 0.38541666666666669
r6150 n4463 n4464 0.019642857142857142
r6151 n4444 n4465 1.15625
r6152 n4464 n4465 0.014285714285714285
r6153 n4445 n4466 0.13602941176470587
r6154 n4465 n4466 0.033928571428571426
r6155 n4446 n4467 0.17788461538461539
r6156 n4466 n4467 0.053571428571428568
r6157 n4447 n4468 1.15625
r6158 n4467 n4468 0.026785714285714284
r6159 n4448 n4469 1.15625
r6160 n4468 n4469 0.0071428571428571426
r6161 n4449 n4470 0.578125
r6162 n4469 n4470 0.010714285714285714
r6163 n4450 n4471 0.46250000000000002
r6164 n4470 n4471 0.01607142857142857
r6165 n4451 n4472 0.23125000000000001
r6166 n4452 n4473 0.092499999999999999
r6167 n4472 n4473 0.0625
r6168 n4453 n4474 2.3125
r6169 n4473 n4474 0.04642857142857143
r6170 n4454 n4475 0.082589285714285712
r6171 n4474 n4475 0.051785714285714289
r6172 n4455 n4476 2.3125
r6173 n4475 n4476 0.051785714285714289
r6174 n4456 n4477 0.092499999999999999
r6175 n4476 n4477 0.04642857142857143
r6176 n4457 n4478 0.23125000000000001
r6177 n4477 n4478 0.0625
r6178 n4458 n4479 0.13068181818181818
r6179 n4459 n4480 2.15625
r6180 n4479 n4480 0.064338235294117641
r6181 n4460 n4481 0.14374999999999999
r6182 n4480 n4481 0.058823529411764705
r6183 n4461 n4482 2.15625
r6184 n4481 n4482 0.058823529411764705
r6185 n4462 n4483 0.13068181818181818
r6186 n4482 n4483 0.064338235294117641
r6187 n4463 n4484 0.86250000000000004
r6188 n4464 n4485 0.71875
r6189 n4484 n4485 0.020220588235294119
r6190 n4465 n4486 2.15625
r6191 n4485 n4486 0.014705882352941176
r6192 n4466 n4487 0.25367647058823528
r6193 n4486 n4487 0.034926470588235295
r6194 n4467 n4488 0.33173076923076922
r6195 n4487 n4488 0.05514705882352941
r6196 n4468 n4489 2.15625
r6197 n4488 n4489 0.027573529411764705
r6198 n4469 n4490 2.15625
r6199 n4489 n4490 0.0073529411764705881
r6200 n4470 n4491 1.078125
r6201 n4490 n4491 0.011029411764705883
r6202 n4471 n4492 0.86250000000000004
r6203 n4491 n4492 0.016544117647058824
r6204 n4472 n4493 0.43125000000000002
r6205 n4473 n4494 0.17249999999999999
r6206 n4493 n4494 0.064338235294117641
r6207 n4474 n4495 4.3125
r6208 n4494 n4495 0.04779411764705882
r6209 n4475 n4496 0.15401785714285715
r6210 n4495 n4496 0.053308823529411763
r6211 n4476 n4497 4.3125
r6212 n4496 n4497 0.053308823529411763
r6213 n4477 n4498 0.17249999999999999
r6214 n4497 n4498 0.04779411764705882
r6215 n4478 n4499 0.43125000000000002
r6216 n4498 n4499 0.064338235294117641
r6217 n4479 n4500 0.077651515151515152
r6218 n4480 n4501 1.28125
r6219 n4500 n4501 0.3125
r6220 n4481 n4502 0.085416666666666669
r6221 n4501 n4502 0.2857142857142857
r6222 n4482 n4503 1.28125
r6223 n4502 n4503 0.2857142857142857
r6224 n4483 n4504 0.077651515151515152
r6225 n4503 n4504 0.3125
r6226 n4484 n4505 0.51249999999999996
r6227 n4485 n4506 0.42708333333333331
r6228 n4505 n4506 0.098214285714285712
r6229 n4486 n4507 1.28125
r6230 n4506 n4507 0.071428571428571425
r6231 n4487 n4508 0.15073529411764705
r6232 n4507 n4508 0.16964285714285715
r6233 n4488 n4509 0.19711538461538461
r6234 n4508 n4509 0.26785714285714285
r6235 n4489 n4510 1.28125
r6236 n4509 n4510 0.13392857142857142
r6237 n4490 n4511 1.28125
r6238 n4510 n4511 0.035714285714285712
r6239 n4491 n4512 0.640625
r6240 n4511 n4512 0.053571428571428568
r6241 n4492 n4513 0.51249999999999996
r6242 n4512 n4513 0.080357142857142863
r6243 n4493 n4514 0.25624999999999998
r6244 n4494 n4515 0.10249999999999999
r6245 n4514 n4515 0.3125
r6246 n4495 n4516 2.5625
r6247 n4515 n4516 0.23214285714285715
r6248 n4496 n4517 0.091517857142857137
r6249 n4516 n4517 0.25892857142857145
r6250 n4497 n4518 2.5625
r6251 n4517 n4518 0.25892857142857145
r6252 n4498 n4519 0.10249999999999999
r6253 n4518 n4519 0.23214285714285715
r6254 n4499 n4520 0.25624999999999998
r6255 n4519 n4520 0.3125
r6256 n4500 n4521 0.017045454545454544
r6257 n4501 n4522 0.28125
r6258 n4521 n4522 1.09375
r6259 n4502 n4523 0.018749999999999999
r6260 n4522 n4523 1
r6261 n4503 n4524 0.28125
r6262 n4523 n4524 1
r6263 n4504 n4525 0.017045454545454544
r6264 n4524 n4525 1.09375
r6265 n4526 n4527 0.46875
r6266 n4527 n4528 0.3125
r6267 n4528 n4529 0.1875
r6268 n4529 n4530 0.125
r6269 n4530 n4531 0.125
r6270 n4531 n4532 0.3125
r6271 n4532 n4533 0.59375
r6272 n4533 n4534 0.46875
r6273 n4534 n4535 0.3125
r6274 n4535 n4536 0.1875
r6275 n4536 n4537 0.09375
r6276 n4537 n4538 0.09375
r6277 n4538 n4539 0.0625
r6278 n4539 n4540 0.0625
r6279 n4540 n4541 0.15625
r6280 n4541 n4542 0.28125
r6281 n4542 n4543 0.1875
r6282 n4543 n4544 0.34375
r6283 n4505 n4545 0.1125
r6284 n4506 n4546 0.09375
r6285 n4545 n4546 0.34375
r6286 n4507 n4547 0.28125
r6287 n4546 n4547 0.25
r6288 n4508 n4548 0.033088235294117647
r6289 n4547 n4548 0.59375
r6290 n4509 n4549 0.043269230769230768
r6291 n4548 n4549 0.9375
r6292 n4510 n4550 0.28125
r6293 n4549 n4550 0.46875
r6294 n4511 n4551 0.28125
r6295 n4550 n4551 0.125
r6296 n4512 n4552 0.140625
r6297 n4551 n4552 0.1875
r6298 n4513 n4553 0.1125
r6299 n4552 n4553 0.28125
r6300 n4514 n4554 0.056250000000000001
r6301 n4515 n4555 0.022499999999999999
r6302 n4554 n4555 1.09375
r6303 n4516 n4556 0.5625
r6304 n4555 n4556 0.8125
r6305 n4517 n4557 0.020089285714285716
r6306 n4556 n4557 0.90625
r6307 n4518 n4558 0.5625
r6308 n4557 n4558 0.90625
r6309 n4519 n4559 0.022499999999999999
r6310 n4558 n4559 0.8125
r6311 n4520 n4560 0.056250000000000001
r6312 n4559 n4560 1.09375
r6313 n4521 n4561 0.013257575757575758
r6314 n4522 n4562 0.21875
r6315 n4561 n4562 0.4375
r6316 n4523 n4563 0.014583333333333334
r6317 n4562 n4563 0.40000000000000002
r6318 n4524 n4564 0.21875
r6319 n4563 n4564 0.40000000000000002
r6320 n4525 n4565 0.013257575757575758
r6321 n4564 n4565 0.4375
r6322 n4565 n4566 0.53749999999999998
r6323 n4566 n4567 0.63749999999999996
r6324 n4567 n4568 1.0249999999999999
r6325 n4568 n4569 1.0249999999999999
r6326 n4569 n4570 0.9375
r6327 n4570 n4571 0.76749999999999996
r6328 n4571 n4572 0.6875
r6329 n4572 n4573 0.77000000000000002
r6330 n4573 n4574 0.58750000000000002
r6331 n4574 n4575 0.66249999999999998
r6332 n4575 n4576 0.51249999999999996
r6333 n4576 n4577 0.42499999999999999
r6334 n4577 n4578 0.42499999999999999
r6335 n4578 n4579 0.29999999999999999
r6336 n4579 n4580 0.33750000000000002
r6337 n4580 n4581 0.125
r6338 n4581 n4582 0.13750000000000001
r6339 n4582 n4583 0.074999999999999997
r6340 n4583 n4584 0.17499999999999999
r6341 n4526 n4585 0.043749999999999997
r6342 n4584 n4585 0.28749999999999998
r6343 n4527 n4586 0.087499999999999994
r6344 n4585 n4586 0.1875
r6345 n4528 n4587 0.087499999999999994
r6346 n4586 n4587 0.125
r6347 n4529 n4588 0.4375
r6348 n4587 n4588 0.074999999999999997
r6349 n4530 n4589 0.14583333333333334
r6350 n4588 n4589 0.050000000000000003
r6351 n4531 n4590 0.4375
r6352 n4589 n4590 0.050000000000000003
r6353 n4532 n4591 0.048611111111111112
r6354 n4590 n4591 0.125
r6355 n4533 n4592 0.043749999999999997
r6356 n4591 n4592 0.23749999999999999
r6357 n4534 n4593 0.087499999999999994
r6358 n4592 n4593 0.1875
r6359 n4535 n4594 0.087499999999999994
r6360 n4593 n4594 0.125
r6361 n4536 n4595 0.4375
r6362 n4594 n4595 0.074999999999999997
r6363 n4537 n4596 0.21875
r6364 n4595 n4596 0.037499999999999999
r6365 n4538 n4597 0.4375
r6366 n4596 n4597 0.037499999999999999
r6367 n4539 n4598 0.4375
r6368 n4597 n4598 0.025000000000000001
r6369 n4540 n4599 0.4375
r6370 n4598 n4599 0.025000000000000001
r6371 n4541 n4600 0.109375
r6372 n4599 n4600 0.0625
r6373 n4542 n4601 0.087499999999999994
r6374 n4600 n4601 0.1125
r6375 n4543 n4602 0.4375
r6376 n4601 n4602 0.074999999999999997
r6377 n4544 n4603 0.043749999999999997
r6378 n4602 n4603 0.13750000000000001
r6379 n4545 n4604 0.087499999999999994
r6380 n4546 n4605 0.072916666666666671
r6381 n4604 n4605 0.13750000000000001
r6382 n4547 n4606 0.21875
r6383 n4605 n4606 0.10000000000000001
r6384 n4548 n4607 0.025735294117647058
r6385 n4606 n4607 0.23749999999999999
r6386 n4549 n4608 0.033653846153846152
r6387 n4607 n4608 0.375
r6388 n4550 n4609 0.21875
r6389 n4608 n4609 0.1875
r6390 n4551 n4610 0.21875
r6391 n4609 n4610 0.050000000000000003
r6392 n4552 n4611 0.109375
r6393 n4610 n4611 0.074999999999999997
r6394 n4553 n4612 0.087499999999999994
r6395 n4611 n4612 0.1125
r6396 n4554 n4613 0.043749999999999997
r6397 n4555 n4614 0.017500000000000002
r6398 n4613 n4614 0.4375
r6399 n4556 n4615 0.4375
r6400 n4614 n4615 0.32500000000000001
r6401 n4557 n4616 0.015625
r6402 n4615 n4616 0.36249999999999999
r6403 n4558 n4617 0.4375
r6404 n4616 n4617 0.36249999999999999
r6405 n4559 n4618 0.017500000000000002
r6406 n4617 n4618 0.32500000000000001
r6407 n4560 n4619 0.043749999999999997
r6408 n4618 n4619 0.4375
r6409 n4561 n4620 0.020833333333333332
r6410 n4562 n4621 0.34375
r6411 n4620 n4621 0.36458333333333331
r6412 n4563 n4622 0.022916666666666665
r6413 n4621 n4622 0.33333333333333331
r6414 n4564 n4623 0.34375
r6415 n4622 n4623 0.33333333333333331
r6416 n4565 n4624 0.020833333333333332
r6417 n4623 n4624 0.36458333333333331
r6418 n4566 n4625 0.068750000000000006
r6419 n4624 n4625 0.44791666666666669
r6420 n4567 n4626 0.01676829268292683
r6421 n4625 n4626 0.53125
r6422 n4568 n4627 0.01676829268292683
r6423 n4626 n4627 0.85416666666666663
r6424 n4569 n4628 0.01676829268292683
r6425 n4627 n4628 0.85416666666666663
r6426 n4570 n4629 0.020220588235294119
r6427 n4628 n4629 0.78125
r6428 n4571 n4630 0.025091240875912409
r6429 n4629 n4630 0.63958333333333328
r6430 n4572 n4631 0.024909420289855072
r6431 n4630 n4631 0.57291666666666663
r6432 n4573 n4632 0.020220588235294119
r6433 n4631 n4632 0.64166666666666672
r6434 n4574 n4633 0.052884615384615384
r6435 n4632 n4633 0.48958333333333331
r6436 n4575 n4634 0.017187500000000001
r6437 n4633 n4634 0.55208333333333337
r6438 n4576 n4635 0.6875
r6439 n4634 n4635 0.42708333333333331
r6440 n4577 n4636 0.020833333333333332
r6441 n4635 n4636 0.35416666666666669
r6442 n4578 n4637 0.6875
r6443 n4636 n4637 0.35416666666666669
r6444 n4579 n4638 0.029891304347826088
r6445 n4637 n4638 0.25
r6446 n4580 n4639 0.171875
r6447 n4638 n4639 0.28125
r6448 n4581 n4640 0.11458333333333333
r6449 n4639 n4640 0.10416666666666667
r6450 n4582 n4641 0.13750000000000001
r6451 n4640 n4641 0.11458333333333333
r6452 n4583 n4642 0.6875
r6453 n4641 n4642 0.0625
r6454 n4584 n4643 0.052884615384615384
r6455 n4642 n4643 0.14583333333333334
r6456 n4585 n4644 0.068750000000000006
r6457 n4643 n4644 0.23958333333333334
r6458 n4586 n4645 0.13750000000000001
r6459 n4644 n4645 0.15625
r6460 n4587 n4646 0.13750000000000001
r6461 n4645 n4646 0.10416666666666667
r6462 n4588 n4647 0.6875
r6463 n4646 n4647 0.0625
r6464 n4589 n4648 0.22916666666666666
r6465 n4647 n4648 0.041666666666666664
r6466 n4590 n4649 0.6875
r6467 n4648 n4649 0.041666666666666664
r6468 n4591 n4650 0.076388888888888895
r6469 n4649 n4650 0.10416666666666667
r6470 n4592 n4651 0.068750000000000006
r6471 n4650 n4651 0.19791666666666666
r6472 n4593 n4652 0.13750000000000001
r6473 n4651 n4652 0.15625
r6474 n4594 n4653 0.13750000000000001
r6475 n4652 n4653 0.10416666666666667
r6476 n4595 n4654 0.6875
r6477 n4653 n4654 0.0625
r6478 n4596 n4655 0.34375
r6479 n4654 n4655 0.03125
r6480 n4597 n4656 0.6875
r6481 n4655 n4656 0.03125
r6482 n4598 n4657 0.6875
r6483 n4656 n4657 0.020833333333333332
r6484 n4599 n4658 0.6875
r6485 n4657 n4658 0.020833333333333332
r6486 n4600 n4659 0.171875
r6487 n4658 n4659 0.052083333333333336
r6488 n4601 n4660 0.13750000000000001
r6489 n4659 n4660 0.09375
r6490 n4602 n4661 0.6875
r6491 n4660 n4661 0.0625
r6492 n4603 n4662 0.068750000000000006
r6493 n4661 n4662 0.11458333333333333
r6494 n4604 n4663 0.13750000000000001
r6495 n4605 n4664 0.11458333333333333
r6496 n4663 n4664 0.11458333333333333
r6497 n4606 n4665 0.34375
r6498 n4664 n4665 0.083333333333333329
r6499 n4607 n4666 0.040441176470588237
r6500 n4665 n4666 0.19791666666666666
r6501 n4608 n4667 0.052884615384615384
r6502 n4666 n4667 0.3125
r6503 n4609 n4668 0.34375
r6504 n4667 n4668 0.15625
r6505 n4610 n4669 0.34375
r6506 n4668 n4669 0.041666666666666664
r6507 n4611 n4670 0.171875
r6508 n4669 n4670 0.0625
r6509 n4612 n4671 0.13750000000000001
r6510 n4670 n4671 0.09375
r6511 n4613 n4672 0.068750000000000006
r6512 n4614 n4673 0.0275
r6513 n4672 n4673 0.36458333333333331
r6514 n4615 n4674 0.6875
r6515 n4673 n4674 0.27083333333333331
r6516 n4616 n4675 0.024553571428571428
r6517 n4674 n4675 0.30208333333333331
r6518 n4617 n4676 0.6875
r6519 n4675 n4676 0.30208333333333331
r6520 n4618 n4677 0.0275
r6521 n4676 n4677 0.27083333333333331
r6522 n4619 n4678 0.068750000000000006
r6523 n4677 n4678 0.36458333333333331
r6524 n4620 n4679 0.015151515151515152
r6525 n4621 n4680 0.25
r6526 n4679 n4680 1.09375
r6527 n4622 n4681 0.016666666666666666
r6528 n4680 n4681 1
r6529 n4623 n4682 0.25
r6530 n4681 n4682 1
r6531 n4624 n4683 0.015151515151515152
r6532 n4682 n4683 1.09375
r6533 n4625 n4684 0.050000000000000003
r6534 n4683 n4684 1.34375
r6535 n4626 n4685 0.012195121951219513
r6536 n4684 n4685 1.59375
r6537 n4627 n4686 0.012195121951219513
r6538 n4685 n4686 2.5625
r6539 n4628 n4687 0.012195121951219513
r6540 n4686 n4687 2.5625
r6541 n4629 n4688 0.014705882352941176
r6542 n4687 n4688 2.34375
r6543 n4630 n4689 0.01824817518248175
r6544 n4688 n4689 1.91875
r6545 n4631 n4690 0.018115942028985508
r6546 n4689 n4690 1.71875
r6547 n4632 n4691 0.014705882352941176
r6548 n4690 n4691 1.925
r6549 n4633 n4692 0.038461538461538464
r6550 n4691 n4692 1.46875
r6551 n4634 n4693 0.012500000000000001
r6552 n4692 n4693 1.65625
r6553 n4635 n4694 0.5
r6554 n4693 n4694 1.28125
r6555 n4636 n4695 0.015151515151515152
r6556 n4694 n4695 1.0625
r6557 n4637 n4696 0.5
r6558 n4695 n4696 1.0625
r6559 n4638 n4697 0.021739130434782608
r6560 n4696 n4697 0.75
r6561 n4639 n4698 0.125
r6562 n4697 n4698 0.84375
r6563 n4640 n4699 0.083333333333333329
r6564 n4698 n4699 0.3125
r6565 n4641 n4700 0.10000000000000001
r6566 n4699 n4700 0.34375
r6567 n4642 n4701 0.5
r6568 n4700 n4701 0.1875
r6569 n4643 n4702 0.038461538461538464
r6570 n4701 n4702 0.4375
r6571 n4644 n4703 0.050000000000000003
r6572 n4702 n4703 0.71875
r6573 n4645 n4704 0.10000000000000001
r6574 n4703 n4704 0.46875
r6575 n4646 n4705 0.10000000000000001
r6576 n4704 n4705 0.3125
r6577 n4647 n4706 0.5
r6578 n4705 n4706 0.1875
r6579 n4648 n4707 0.16666666666666666
r6580 n4706 n4707 0.125
r6581 n4649 n4708 0.5
r6582 n4707 n4708 0.125
r6583 n4650 n4709 0.055555555555555552
r6584 n4708 n4709 0.3125
r6585 n4651 n4710 0.050000000000000003
r6586 n4709 n4710 0.59375
r6587 n4652 n4711 0.10000000000000001
r6588 n4710 n4711 0.46875
r6589 n4653 n4712 0.10000000000000001
r6590 n4711 n4712 0.3125
r6591 n4654 n4713 0.5
r6592 n4712 n4713 0.1875
r6593 n4655 n4714 0.25
r6594 n4713 n4714 0.09375
r6595 n4656 n4715 0.5
r6596 n4714 n4715 0.09375
r6597 n4657 n4716 0.5
r6598 n4715 n4716 0.0625
r6599 n4658 n4717 0.5
r6600 n4716 n4717 0.0625
r6601 n4659 n4718 0.125
r6602 n4717 n4718 0.15625
r6603 n4660 n4719 0.10000000000000001
r6604 n4718 n4719 0.28125
r6605 n4661 n4720 0.5
r6606 n4719 n4720 0.1875
r6607 n4662 n4721 0.050000000000000003
r6608 n4720 n4721 0.34375
r6609 n4663 n4722 0.10000000000000001
r6610 n4664 n4723 0.083333333333333329
r6611 n4722 n4723 0.34375
r6612 n4665 n4724 0.25
r6613 n4723 n4724 0.25
r6614 n4666 n4725 0.029411764705882353
r6615 n4724 n4725 0.59375
r6616 n4667 n4726 0.038461538461538464
r6617 n4725 n4726 0.9375
r6618 n4668 n4727 0.25
r6619 n4726 n4727 0.46875
r6620 n4669 n4728 0.25
r6621 n4727 n4728 0.125
r6622 n4670 n4729 0.125
r6623 n4728 n4729 0.1875
r6624 n4671 n4730 0.10000000000000001
r6625 n4729 n4730 0.28125
r6626 n4672 n4731 0.050000000000000003
r6627 n4673 n4732 0.02
r6628 n4731 n4732 1.09375
r6629 n4674 n4733 0.5
r6630 n4732 n4733 0.8125
r6631 n4675 n4734 0.017857142857142856
r6632 n4733 n4734 0.90625
r6633 n4676 n4735 0.5
r6634 n4734 n4735 0.90625
r6635 n4677 n4736 0.02
r6636 n4735 n4736 0.8125
r6637 n4678 n4737 0.050000000000000003
r6638 n4736 n4737 1.09375
r6639 n4679 n4738 0.034090909090909088
r6640 n4680 n4739 0.5625
r6641 n4738 n4739 0.13671875
r6642 n4681 n4740 0.037499999999999999
r6643 n4739 n4740 0.125
r6644 n4682 n4741 0.5625
r6645 n4740 n4741 0.125
r6646 n4683 n4742 0.034090909090909088
r6647 n4741 n4742 0.13671875
r6648 n4684 n4743 0.1125
r6649 n4742 n4743 0.16796875
r6650 n4685 n4744 0.027439024390243903
r6651 n4743 n4744 0.19921875
r6652 n4686 n4745 0.027439024390243903
r6653 n4744 n4745 0.3203125
r6654 n4687 n4746 0.027439024390243903
r6655 n4745 n4746 0.3203125
r6656 n4688 n4747 0.033088235294117647
r6657 n4746 n4747 0.29296875
r6658 n4689 n4748 0.04105839416058394
r6659 n4747 n4748 0.23984374999999999
r6660 n4690 n4749 0.040760869565217392
r6661 n4748 n4749 0.21484375
r6662 n4691 n4750 0.033088235294117647
r6663 n4749 n4750 0.24062500000000001
r6664 n4692 n4751 0.086538461538461536
r6665 n4750 n4751 0.18359375
r6666 n4693 n4752 0.028125000000000001
r6667 n4751 n4752 0.20703125
r6668 n4694 n4753 1.125
r6669 n4752 n4753 0.16015625
r6670 n4695 n4754 0.034090909090909088
r6671 n4753 n4754 0.1328125
r6672 n4696 n4755 1.125
r6673 n4754 n4755 0.1328125
r6674 n4697 n4756 0.048913043478260872
r6675 n4755 n4756 0.09375
r6676 n4698 n4757 0.28125
r6677 n4756 n4757 0.10546875
r6678 n4699 n4758 0.1875
r6679 n4757 n4758 0.0390625
r6680 n4700 n4759 0.22500000000000001
r6681 n4758 n4759 0.04296875
r6682 n4701 n4760 1.125
r6683 n4759 n4760 0.0234375
r6684 n4702 n4761 0.086538461538461536
r6685 n4760 n4761 0.0546875
r6686 n4703 n4762 0.1125
r6687 n4761 n4762 0.08984375
r6688 n4704 n4763 0.22500000000000001
r6689 n4762 n4763 0.05859375
r6690 n4705 n4764 0.22500000000000001
r6691 n4763 n4764 0.0390625
r6692 n4706 n4765 1.125
r6693 n4764 n4765 0.0234375
r6694 n4707 n4766 0.375
r6695 n4765 n4766 0.015625
r6696 n4708 n4767 1.125
r6697 n4766 n4767 0.015625
r6698 n4709 n4768 0.125
r6699 n4767 n4768 0.0390625
r6700 n4710 n4769 0.1125
r6701 n4768 n4769 0.07421875
r6702 n4711 n4770 0.22500000000000001
r6703 n4769 n4770 0.05859375
r6704 n4712 n4771 0.22500000000000001
r6705 n4770 n4771 0.0390625
r6706 n4713 n4772 1.125
r6707 n4771 n4772 0.0234375
r6708 n4714 n4773 0.5625
r6709 n4772 n4773 0.01171875
r6710 n4715 n4774 1.125
r6711 n4773 n4774 0.01171875
r6712 n4716 n4775 1.125
r6713 n4774 n4775 0.0078125
r6714 n4717 n4776 1.125
r6715 n4775 n4776 0.0078125
r6716 n4718 n4777 0.28125
r6717 n4776 n4777 0.01953125
r6718 n4719 n4778 0.22500000000000001
r6719 n4777 n4778 0.03515625
r6720 n4720 n4779 1.125
r6721 n4778 n4779 0.0234375
r6722 n4721 n4780 0.1125
r6723 n4779 n4780 0.04296875
r6724 n4722 n4781 0.22500000000000001
r6725 n4723 n4782 0.1875
r6726 n4781 n4782 0.04296875
r6727 n4724 n4783 0.5625
r6728 n4782 n4783 0.03125
r6729 n4725 n4784 0.066176470588235295
r6730 n4783 n4784 0.07421875
r6731 n4726 n4785 0.086538461538461536
r6732 n4784 n4785 0.1171875
r6733 n4727 n4786 0.5625
r6734 n4785 n4786 0.05859375
r6735 n4728 n4787 0.5625
r6736 n4786 n4787 0.015625
r6737 n4729 n4788 0.28125
r6738 n4787 n4788 0.0234375
r6739 n4730 n4789 0.22500000000000001
r6740 n4788 n4789 0.03515625
r6741 n4731 n4790 0.1125
r6742 n4732 n4791 0.044999999999999998
r6743 n4790 n4791 0.13671875
r6744 n4733 n4792 1.125
r6745 n4791 n4792 0.1015625
r6746 n4734 n4793 0.040178571428571432
r6747 n4792 n4793 0.11328125
r6748 n4735 n4794 1.125
r6749 n4793 n4794 0.11328125
r6750 n4736 n4795 0.044999999999999998
r6751 n4794 n4795 0.1015625
r6752 n4737 n4796 0.1125
r6753 n4795 n4796 0.13671875
r6754 n4738 n4797 0.056818181818181816
r6755 n4739 n4798 0.9375
r6756 n4797 n4798 0.15625
r6757 n4740 n4799 0.0625
r6758 n4798 n4799 0.14285714285714285
r6759 n4741 n4800 0.9375
r6760 n4799 n4800 0.14285714285714285
r6761 n4742 n4801 0.056818181818181816
r6762 n4800 n4801 0.15625
r6763 n4743 n4802 0.1875
r6764 n4801 n4802 0.19196428571428573
r6765 n4744 n4803 0.04573170731707317
r6766 n4802 n4803 0.22767857142857142
r6767 n4745 n4804 0.04573170731707317
r6768 n4803 n4804 0.36607142857142855
r6769 n4746 n4805 0.04573170731707317
r6770 n4804 n4805 0.36607142857142855
r6771 n4747 n4806 0.05514705882352941
r6772 n4805 n4806 0.33482142857142855
r6773 n4748 n4807 0.068430656934306569
r6774 n4806 n4807 0.27410714285714288
r6775 n4749 n4808 0.067934782608695649
r6776 n4807 n4808 0.24553571428571427
r6777 n4750 n4809 0.05514705882352941
r6778 n4808 n4809 0.27500000000000002
r6779 n4751 n4810 0.14423076923076922
r6780 n4809 n4810 0.20982142857142858
r6781 n4752 n4811 0.046875
r6782 n4810 n4811 0.23660714285714285
r6783 n4753 n4812 1.875
r6784 n4811 n4812 0.18303571428571427
r6785 n4754 n4813 0.056818181818181816
r6786 n4812 n4813 0.15178571428571427
r6787 n4755 n4814 1.875
r6788 n4813 n4814 0.15178571428571427
r6789 n4756 n4815 0.081521739130434784
r6790 n4814 n4815 0.10714285714285714
r6791 n4757 n4816 0.46875
r6792 n4815 n4816 0.12053571428571429
r6793 n4758 n4817 0.3125
r6794 n4816 n4817 0.044642857142857144
r6795 n4759 n4818 0.375
r6796 n4817 n4818 0.049107142857142856
r6797 n4760 n4819 1.875
r6798 n4818 n4819 0.026785714285714284
r6799 n4761 n4820 0.14423076923076922
r6800 n4819 n4820 0.0625
r6801 n4762 n4821 0.1875
r6802 n4820 n4821 0.10267857142857142
r6803 n4763 n4822 0.375
r6804 n4821 n4822 0.066964285714285712
r6805 n4764 n4823 0.375
r6806 n4822 n4823 0.044642857142857144
r6807 n4765 n4824 1.875
r6808 n4823 n4824 0.026785714285714284
r6809 n4766 n4825 0.625
r6810 n4824 n4825 0.017857142857142856
r6811 n4767 n4826 1.875
r6812 n4825 n4826 0.017857142857142856
r6813 n4768 n4827 0.20833333333333334
r6814 n4826 n4827 0.044642857142857144
r6815 n4769 n4828 0.1875
r6816 n4827 n4828 0.084821428571428575
r6817 n4770 n4829 0.375
r6818 n4828 n4829 0.066964285714285712
r6819 n4771 n4830 0.375
r6820 n4829 n4830 0.044642857142857144
r6821 n4772 n4831 1.875
r6822 n4830 n4831 0.026785714285714284
r6823 n4773 n4832 0.9375
r6824 n4831 n4832 0.013392857142857142
r6825 n4774 n4833 1.875
r6826 n4832 n4833 0.013392857142857142
r6827 n4775 n4834 1.875
r6828 n4833 n4834 0.0089285714285714281
r6829 n4776 n4835 1.875
r6830 n4834 n4835 0.0089285714285714281
r6831 n4777 n4836 0.46875
r6832 n4835 n4836 0.022321428571428572
r6833 n4778 n4837 0.375
r6834 n4836 n4837 0.040178571428571432
r6835 n4779 n4838 1.875
r6836 n4837 n4838 0.026785714285714284
r6837 n4780 n4839 0.1875
r6838 n4838 n4839 0.049107142857142856
r6839 n4781 n4840 0.375
r6840 n4782 n4841 0.3125
r6841 n4840 n4841 0.049107142857142856
r6842 n4783 n4842 0.9375
r6843 n4841 n4842 0.035714285714285712
r6844 n4784 n4843 0.11029411764705882
r6845 n4842 n4843 0.084821428571428575
r6846 n4785 n4844 0.14423076923076922
r6847 n4843 n4844 0.13392857142857142
r6848 n4786 n4845 0.9375
r6849 n4844 n4845 0.066964285714285712
r6850 n4787 n4846 0.9375
r6851 n4845 n4846 0.017857142857142856
r6852 n4788 n4847 0.46875
r6853 n4846 n4847 0.026785714285714284
r6854 n4789 n4848 0.375
r6855 n4847 n4848 0.040178571428571432
r6856 n4790 n4849 0.1875
r6857 n4791 n4850 0.074999999999999997
r6858 n4849 n4850 0.15625
r6859 n4792 n4851 1.875
r6860 n4850 n4851 0.11607142857142858
r6861 n4793 n4852 0.066964285714285712
r6862 n4851 n4852 0.12946428571428573
r6863 n4794 n4853 1.875
r6864 n4852 n4853 0.12946428571428573
r6865 n4795 n4854 0.074999999999999997
r6866 n4853 n4854 0.11607142857142858
r6867 n4796 n4855 0.1875
r6868 n4854 n4855 0.15625
r6869 n4797 n4856 0.030303030303030304
r6870 n4798 n4857 0.5
r6871 n4856 n4857 1.09375
r6872 n4799 n4858 0.033333333333333333
r6873 n4857 n4858 1
r6874 n4800 n4859 0.5
r6875 n4858 n4859 1
r6876 n4801 n4860 0.030303030303030304
r6877 n4859 n4860 1.09375
r6878 n4802 n4861 0.10000000000000001
r6879 n4860 n4861 1.34375
r6880 n4803 n4862 0.024390243902439025
r6881 n4861 n4862 1.59375
r6882 n4804 n4863 0.024390243902439025
r6883 n4862 n4863 2.5625
r6884 n4805 n4864 0.024390243902439025
r6885 n4863 n4864 2.5625
r6886 n4806 n4865 0.029411764705882353
r6887 n4864 n4865 2.34375
r6888 n4807 n4866 0.036496350364963501
r6889 n4865 n4866 1.91875
r6890 n4808 n4867 0.036231884057971016
r6891 n4866 n4867 1.71875
r6892 n4809 n4868 0.029411764705882353
r6893 n4867 n4868 1.925
r6894 n4810 n4869 0.076923076923076927
r6895 n4868 n4869 1.46875
r6896 n4811 n4870 0.025000000000000001
r6897 n4869 n4870 1.65625
r6898 n4812 n4871 1
r6899 n4870 n4871 1.28125
r6900 n4813 n4872 0.030303030303030304
r6901 n4871 n4872 1.0625
r6902 n4814 n4873 1
r6903 n4872 n4873 1.0625
r6904 n4815 n4874 0.043478260869565216
r6905 n4873 n4874 0.75
r6906 n4816 n4875 0.25
r6907 n4874 n4875 0.84375
r6908 n4817 n4876 0.16666666666666666
r6909 n4875 n4876 0.3125
r6910 n4818 n4877 0.20000000000000001
r6911 n4876 n4877 0.34375
r6912 n4819 n4878 1
r6913 n4877 n4878 0.1875
r6914 n4820 n4879 0.076923076923076927
r6915 n4878 n4879 0.4375
r6916 n4821 n4880 0.10000000000000001
r6917 n4879 n4880 0.71875
r6918 n4822 n4881 0.20000000000000001
r6919 n4880 n4881 0.46875
r6920 n4823 n4882 0.20000000000000001
r6921 n4881 n4882 0.3125
r6922 n4824 n4883 1
r6923 n4882 n4883 0.1875
r6924 n4825 n4884 0.33333333333333331
r6925 n4883 n4884 0.125
r6926 n4826 n4885 1
r6927 n4884 n4885 0.125
r6928 n4827 n4886 0.1111111111111111
r6929 n4885 n4886 0.3125
r6930 n4828 n4887 0.10000000000000001
r6931 n4886 n4887 0.59375
r6932 n4829 n4888 0.20000000000000001
r6933 n4887 n4888 0.46875
r6934 n4830 n4889 0.20000000000000001
r6935 n4888 n4889 0.3125
r6936 n4831 n4890 1
r6937 n4889 n4890 0.1875
r6938 n4832 n4891 0.5
r6939 n4890 n4891 0.09375
r6940 n4833 n4892 1
r6941 n4891 n4892 0.09375
r6942 n4834 n4893 1
r6943 n4892 n4893 0.0625
r6944 n4835 n4894 1
r6945 n4893 n4894 0.0625
r6946 n4836 n4895 0.25
r6947 n4894 n4895 0.15625
r6948 n4837 n4896 0.20000000000000001
r6949 n4895 n4896 0.28125
r6950 n4838 n4897 1
r6951 n4896 n4897 0.1875
r6952 n4839 n4898 0.10000000000000001
r6953 n4897 n4898 0.34375
r6954 n4840 n4899 0.20000000000000001
r6955 n4841 n4900 0.16666666666666666
r6956 n4899 n4900 0.34375
r6957 n4842 n4901 0.5
r6958 n4900 n4901 0.25
r6959 n4843 n4902 0.058823529411764705
r6960 n4901 n4902 0.59375
r6961 n4844 n4903 0.076923076923076927
r6962 n4902 n4903 0.9375
r6963 n4845 n4904 0.5
r6964 n4903 n4904 0.46875
r6965 n4846 n4905 0.5
r6966 n4904 n4905 0.125
r6967 n4847 n4906 0.25
r6968 n4905 n4906 0.1875
r6969 n4848 n4907 0.20000000000000001
r6970 n4906 n4907 0.28125
r6971 n4849 n4908 0.10000000000000001
r6972 n4850 n4909 0.040000000000000001
r6973 n4908 n4909 1.09375
r6974 n4851 n4910 1
r6975 n4909 n4910 0.8125
r6976 n4852 n4911 0.035714285714285712
r6977 n4910 n4911 0.90625
r6978 n4853 n4912 1
r6979 n4911 n4912 0.90625
r6980 n4854 n4913 0.040000000000000001
r6981 n4912 n4913 0.8125
r6982 n4855 n4914 0.10000000000000001
r6983 n4913 n4914 1.09375
r6984 n4856 n4915 0.011363636363636364
r6985 n4857 n4916 0.1875
r6986 n4915 n4916 0.546875
r6987 n4858 n4917 0.012500000000000001
r6988 n4916 n4917 0.5
r6989 n4859 n4918 0.1875
r6990 n4917 n4918 0.5
r6991 n4860 n4919 0.011363636363636364
r6992 n4918 n4919 0.546875
r6993 n4861 n4920 0.037499999999999999
r6994 n4919 n4920 0.671875
r6995 n4862 n4921 0.0091463414634146336
r6996 n4920 n4921 0.796875
r6997 n4863 n4922 0.0091463414634146336
r6998 n4921 n4922 1.28125
r6999 n4864 n4923 0.0091463414634146336
r7000 n4922 n4923 1.28125
r7001 n4865 n4924 0.011029411764705883
r7002 n4923 n4924 1.171875
r7003 n4866 n4925 0.013686131386861315
r7004 n4924 n4925 0.95937499999999998
r7005 n4867 n4926 0.01358695652173913
r7006 n4925 n4926 0.859375
r7007 n4868 n4927 0.011029411764705883
r7008 n4926 n4927 0.96250000000000002
r7009 n4869 n4928 0.028846153846153848
r7010 n4927 n4928 0.734375
r7011 n4870 n4929 0.0093749999999999997
r7012 n4928 n4929 0.828125
r7013 n4871 n4930 0.375
r7014 n4929 n4930 0.640625
r7015 n4872 n4931 0.011363636363636364
r7016 n4930 n4931 0.53125
r7017 n4873 n4932 0.375
r7018 n4931 n4932 0.53125
r7019 n4874 n4933 0.016304347826086956
r7020 n4932 n4933 0.375
r7021 n4875 n4934 0.09375
r7022 n4933 n4934 0.421875
r7023 n4876 n4935 0.0625
r7024 n4934 n4935 0.15625
r7025 n4877 n4936 0.074999999999999997
r7026 n4935 n4936 0.171875
r7027 n4878 n4937 0.375
r7028 n4936 n4937 0.09375
r7029 n4879 n4938 0.028846153846153848
r7030 n4937 n4938 0.21875
r7031 n4880 n4939 0.037499999999999999
r7032 n4938 n4939 0.359375
r7033 n4881 n4940 0.074999999999999997
r7034 n4939 n4940 0.234375
r7035 n4882 n4941 0.074999999999999997
r7036 n4940 n4941 0.15625
r7037 n4883 n4942 0.375
r7038 n4941 n4942 0.09375
r7039 n4884 n4943 0.125
r7040 n4942 n4943 0.0625
r7041 n4885 n4944 0.375
r7042 n4943 n4944 0.0625
r7043 n4886 n4945 0.041666666666666664
r7044 n4944 n4945 0.15625
r7045 n4887 n4946 0.037499999999999999
r7046 n4945 n4946 0.296875
r7047 n4888 n4947 0.074999999999999997
r7048 n4946 n4947 0.234375
r7049 n4889 n4948 0.074999999999999997
r7050 n4947 n4948 0.15625
r7051 n4890 n4949 0.375
r7052 n4948 n4949 0.09375
r7053 n4891 n4950 0.1875
r7054 n4949 n4950 0.046875
r7055 n4892 n4951 0.375
r7056 n4950 n4951 0.046875
r7057 n4893 n4952 0.375
r7058 n4951 n4952 0.03125
r7059 n4894 n4953 0.375
r7060 n4952 n4953 0.03125
r7061 n4895 n4954 0.09375
r7062 n4953 n4954 0.078125
r7063 n4896 n4955 0.074999999999999997
r7064 n4954 n4955 0.140625
r7065 n4897 n4956 0.375
r7066 n4955 n4956 0.09375
r7067 n4898 n4957 0.037499999999999999
r7068 n4956 n4957 0.171875
r7069 n4899 n4958 0.074999999999999997
r7070 n4900 n4959 0.0625
r7071 n4958 n4959 0.171875
r7072 n4901 n4960 0.1875
r7073 n4959 n4960 0.125
r7074 n4902 n4961 0.022058823529411766
r7075 n4960 n4961 0.296875
r7076 n4903 n4962 0.028846153846153848
r7077 n4961 n4962 0.46875
r7078 n4904 n4963 0.1875
r7079 n4962 n4963 0.234375
r7080 n4905 n4964 0.1875
r7081 n4963 n4964 0.0625
r7082 n4906 n4965 0.09375
r7083 n4964 n4965 0.09375
r7084 n4907 n4966 0.074999999999999997
r7085 n4965 n4966 0.140625
r7086 n4908 n4967 0.037499999999999999
r7087 n4909 n4968 0.014999999999999999
r7088 n4967 n4968 0.546875
r7089 n4910 n4969 0.375
r7090 n4968 n4969 0.40625
r7091 n4911 n4970 0.013392857142857142
r7092 n4969 n4970 0.453125
r7093 n4912 n4971 0.375
r7094 n4970 n4971 0.453125
r7095 n4913 n4972 0.014999999999999999
r7096 n4971 n4972 0.40625
r7097 n4914 n4973 0.037499999999999999
r7098 n4972 n4973 0.546875
r7099 n4915 n4974 0.011363636363636364
r7100 n4916 n4975 0.1875
r7101 n4974 n4975 1.09375
r7102 n4917 n4976 0.012500000000000001
r7103 n4975 n4976 1
r7104 n4918 n4977 0.1875
r7105 n4976 n4977 1
r7106 n4919 n4978 0.011363636363636364
r7107 n4977 n4978 1.09375
r7108 n4920 n4979 0.037499999999999999
r7109 n4978 n4979 1.34375
r7110 n4921 n4980 0.0091463414634146336
r7111 n4979 n4980 1.59375
r7112 n4922 n4981 0.0091463414634146336
r7113 n4980 n4981 2.5625
r7114 n4923 n4982 0.0091463414634146336
r7115 n4981 n4982 2.5625
r7116 n4924 n4983 0.011029411764705883
r7117 n4982 n4983 2.34375
r7118 n4925 n4984 0.013686131386861315
r7119 n4983 n4984 1.91875
r7120 n4926 n4985 0.01358695652173913
r7121 n4984 n4985 1.71875
r7122 n4927 n4986 0.011029411764705883
r7123 n4985 n4986 1.925
r7124 n4928 n4987 0.028846153846153848
r7125 n4986 n4987 1.46875
r7126 n4929 n4988 0.0093749999999999997
r7127 n4987 n4988 1.65625
r7128 n4930 n4989 0.375
r7129 n4988 n4989 1.28125
r7130 n4931 n4990 0.011363636363636364
r7131 n4989 n4990 1.0625
r7132 n4932 n4991 0.375
r7133 n4990 n4991 1.0625
r7134 n4933 n4992 0.016304347826086956
r7135 n4991 n4992 0.75
r7136 n4934 n4993 0.09375
r7137 n4992 n4993 0.84375
r7138 n4935 n4994 0.0625
r7139 n4993 n4994 0.3125
r7140 n4936 n4995 0.074999999999999997
r7141 n4994 n4995 0.34375
r7142 n4937 n4996 0.375
r7143 n4995 n4996 0.1875
r7144 n4938 n4997 0.028846153846153848
r7145 n4996 n4997 0.4375
r7146 n4939 n4998 0.037499999999999999
r7147 n4997 n4998 0.71875
r7148 n4940 n4999 0.074999999999999997
r7149 n4998 n4999 0.46875
r7150 n4941 n5000 0.074999999999999997
r7151 n4999 n5000 0.3125
r7152 n4942 n5001 0.375
r7153 n5000 n5001 0.1875
r7154 n4943 n5002 0.125
r7155 n5001 n5002 0.125
r7156 n4944 n5003 0.375
r7157 n5002 n5003 0.125
r7158 n4945 n5004 0.041666666666666664
r7159 n5003 n5004 0.3125
r7160 n4946 n5005 0.037499999999999999
r7161 n5004 n5005 0.59375
r7162 n4947 n5006 0.074999999999999997
r7163 n5005 n5006 0.46875
r7164 n4948 n5007 0.074999999999999997
r7165 n5006 n5007 0.3125
r7166 n4949 n5008 0.375
r7167 n5007 n5008 0.1875
r7168 n4950 n5009 0.1875
r7169 n5008 n5009 0.09375
r7170 n4951 n5010 0.375
r7171 n5009 n5010 0.09375
r7172 n4952 n5011 0.375
r7173 n5010 n5011 0.0625
r7174 n4953 n5012 0.375
r7175 n5011 n5012 0.0625
r7176 n4954 n5013 0.09375
r7177 n5012 n5013 0.15625
r7178 n4955 n5014 0.074999999999999997
r7179 n5013 n5014 0.28125
r7180 n4956 n5015 0.375
r7181 n5014 n5015 0.1875
r7182 n4957 n5016 0.037499999999999999
r7183 n5015 n5016 0.34375
r7184 n4958 n5017 0.074999999999999997
r7185 n4959 n5018 0.0625
r7186 n5017 n5018 0.34375
r7187 n4960 n5019 0.1875
r7188 n5018 n5019 0.25
r7189 n4961 n5020 0.022058823529411766
r7190 n5019 n5020 0.59375
r7191 n4962 n5021 0.028846153846153848
r7192 n5020 n5021 0.9375
r7193 n4963 n5022 0.1875
r7194 n5021 n5022 0.46875
r7195 n4964 n5023 0.1875
r7196 n5022 n5023 0.125
r7197 n4965 n5024 0.09375
r7198 n5023 n5024 0.1875
r7199 n4966 n5025 0.074999999999999997
r7200 n5024 n5025 0.28125
r7201 n4967 n5026 0.037499999999999999
r7202 n4968 n5027 0.014999999999999999
r7203 n5026 n5027 1.09375
r7204 n4969 n5028 0.375
r7205 n5027 n5028 0.8125
r7206 n4970 n5029 0.013392857142857142
r7207 n5028 n5029 0.90625
r7208 n4971 n5030 0.375
r7209 n5029 n5030 0.90625
r7210 n4972 n5031 0.014999999999999999
r7211 n5030 n5031 0.8125
r7212 n4973 n5032 0.037499999999999999
r7213 n5031 n5032 1.09375
r7214 n4974 n5033 0.005681818181818182
r7215 n4975 n5034 0.09375
r7216 n5033 n5034 2.1875
r7217 n4976 n5035 0.0062500000000000003
r7218 n5034 n5035 2
r7219 n4977 n5036 0.09375
r7220 n5035 n5036 2
r7221 n4978 n5037 0.005681818181818182
r7222 n5036 n5037 2.1875
r7223 n4979 n5038 0.018749999999999999
r7224 n5037 n5038 2.6875
r7225 n4980 n5039 0.0045731707317073168
r7226 n5038 n5039 3.1875
r7227 n4981 n5040 0.0045731707317073168
r7228 n5039 n5040 5.125
r7229 n4982 n5041 0.0045731707317073168
r7230 n5040 n5041 5.125
r7231 n4983 n5042 0.0055147058823529415
r7232 n5041 n5042 4.6875
r7233 n4984 n5043 0.0068430656934306573
r7234 n5042 n5043 3.8374999999999999
r7235 n4985 n5044 0.006793478260869565
r7236 n5043 n5044 3.4375
r7237 n4986 n5045 0.0055147058823529415
r7238 n5044 n5045 3.8500000000000001
r7239 n4987 n5046 0.014423076923076924
r7240 n5045 n5046 2.9375
r7241 n4988 n5047 0.0046874999999999998
r7242 n5046 n5047 3.3125
r7243 n4989 n5048 0.1875
r7244 n5047 n5048 2.5625
r7245 n4990 n5049 0.005681818181818182
r7246 n5048 n5049 2.125
r7247 n4991 n5050 0.1875
r7248 n5049 n5050 2.125
r7249 n4992 n5051 0.008152173913043478
r7250 n5050 n5051 1.5
r7251 n4993 n5052 0.046875
r7252 n5051 n5052 1.6875
r7253 n4994 n5053 0.03125
r7254 n5052 n5053 0.625
r7255 n4995 n5054 0.037499999999999999
r7256 n5053 n5054 0.6875
r7257 n4996 n5055 0.1875
r7258 n5054 n5055 0.375
r7259 n4997 n5056 0.014423076923076924
r7260 n5055 n5056 0.875
r7261 n4998 n5057 0.018749999999999999
r7262 n5056 n5057 1.4375
r7263 n4999 n5058 0.037499999999999999
r7264 n5057 n5058 0.9375
r7265 n5000 n5059 0.037499999999999999
r7266 n5058 n5059 0.625
r7267 n5001 n5060 0.1875
r7268 n5059 n5060 0.375
r7269 n5002 n5061 0.0625
r7270 n5060 n5061 0.25
r7271 n5003 n5062 0.1875
r7272 n5061 n5062 0.25
r7273 n5004 n5063 0.020833333333333332
r7274 n5062 n5063 0.625
r7275 n5005 n5064 0.018749999999999999
r7276 n5063 n5064 1.1875
r7277 n5006 n5065 0.037499999999999999
r7278 n5064 n5065 0.9375
r7279 n5007 n5066 0.037499999999999999
r7280 n5065 n5066 0.625
r7281 n5008 n5067 0.1875
r7282 n5066 n5067 0.375
r7283 n5009 n5068 0.09375
r7284 n5067 n5068 0.1875
r7285 n5010 n5069 0.1875
r7286 n5068 n5069 0.1875
r7287 n5011 n5070 0.1875
r7288 n5069 n5070 0.125
r7289 n5012 n5071 0.1875
r7290 n5070 n5071 0.125
r7291 n5013 n5072 0.046875
r7292 n5071 n5072 0.3125
r7293 n5014 n5073 0.037499999999999999
r7294 n5072 n5073 0.5625
r7295 n5015 n5074 0.1875
r7296 n5073 n5074 0.375
r7297 n5016 n5075 0.018749999999999999
r7298 n5074 n5075 0.6875
r7299 n5017 n5076 0.037499999999999999
r7300 n5018 n5077 0.03125
r7301 n5076 n5077 0.6875
r7302 n5019 n5078 0.09375
r7303 n5077 n5078 0.5
r7304 n5020 n5079 0.011029411764705883
r7305 n5078 n5079 1.1875
r7306 n5021 n5080 0.014423076923076924
r7307 n5079 n5080 1.875
r7308 n5022 n5081 0.09375
r7309 n5080 n5081 0.9375
r7310 n5023 n5082 0.09375
r7311 n5081 n5082 0.25
r7312 n5024 n5083 0.046875
r7313 n5082 n5083 0.375
r7314 n5025 n5084 0.037499999999999999
r7315 n5083 n5084 0.5625
r7316 n5026 n5085 0.018749999999999999
r7317 n5027 n5086 0.0074999999999999997
r7318 n5085 n5086 2.1875
r7319 n5028 n5087 0.1875
r7320 n5086 n5087 1.625
r7321 n5029 n5088 0.0066964285714285711
r7322 n5087 n5088 1.8125
r7323 n5030 n5089 0.1875
r7324 n5088 n5089 1.8125
r7325 n5031 n5090 0.0074999999999999997
r7326 n5089 n5090 1.625
r7327 n5032 n5091 0.018749999999999999
r7328 n5090 n5091 2.1875
r7329 n5033 n5092 0.00946969696969697
r7330 n5034 n5093 0.15625
r7331 n5092 n5093 0.546875
r7332 n5035 n5094 0.010416666666666666
r7333 n5093 n5094 0.5
r7334 n5036 n5095 0.15625
r7335 n5094 n5095 0.5
r7336 n5037 n5096 0.00946969696969697
r7337 n5095 n5096 0.546875
r7338 n5038 n5097 0.03125
r7339 n5096 n5097 0.671875
r7340 n5039 n5098 0.007621951219512195
r7341 n5097 n5098 0.796875
r7342 n5040 n5099 0.007621951219512195
r7343 n5098 n5099 1.28125
r7344 n5041 n5100 0.007621951219512195
r7345 n5099 n5100 1.28125
r7346 n5042 n5101 0.0091911764705882356
r7347 n5100 n5101 1.171875
r7348 n5043 n5102 0.011405109489051095
r7349 n5101 n5102 0.95937499999999998
r7350 n5044 n5103 0.011322463768115942
r7351 n5102 n5103 0.859375
r7352 n5045 n5104 0.0091911764705882356
r7353 n5103 n5104 0.96250000000000002
r7354 n5046 n5105 0.02403846153846154
r7355 n5104 n5105 0.734375
r7356 n5047 n5106 0.0078125
r7357 n5105 n5106 0.828125
r7358 n5048 n5107 0.3125
r7359 n5106 n5107 0.640625
r7360 n5049 n5108 0.00946969696969697
r7361 n5107 n5108 0.53125
r7362 n5050 n5109 0.3125
r7363 n5108 n5109 0.53125
r7364 n5051 n5110 0.01358695652173913
r7365 n5109 n5110 0.375
r7366 n5052 n5111 0.078125
r7367 n5110 n5111 0.421875
r7368 n5053 n5112 0.052083333333333336
r7369 n5111 n5112 0.15625
r7370 n5054 n5113 0.0625
r7371 n5112 n5113 0.171875
r7372 n5055 n5114 0.3125
r7373 n5113 n5114 0.09375
r7374 n5056 n5115 0.02403846153846154
r7375 n5114 n5115 0.21875
r7376 n5057 n5116 0.03125
r7377 n5115 n5116 0.359375
r7378 n5058 n5117 0.0625
r7379 n5116 n5117 0.234375
r7380 n5059 n5118 0.0625
r7381 n5117 n5118 0.15625
r7382 n5060 n5119 0.3125
r7383 n5118 n5119 0.09375
r7384 n5061 n5120 0.10416666666666667
r7385 n5119 n5120 0.0625
r7386 n5062 n5121 0.3125
r7387 n5120 n5121 0.0625
r7388 n5063 n5122 0.034722222222222224
r7389 n5121 n5122 0.15625
r7390 n5064 n5123 0.03125
r7391 n5122 n5123 0.296875
r7392 n5065 n5124 0.0625
r7393 n5123 n5124 0.234375
r7394 n5066 n5125 0.0625
r7395 n5124 n5125 0.15625
r7396 n5067 n5126 0.3125
r7397 n5125 n5126 0.09375
r7398 n5068 n5127 0.15625
r7399 n5126 n5127 0.046875
r7400 n5069 n5128 0.3125
r7401 n5127 n5128 0.046875
r7402 n5070 n5129 0.3125
r7403 n5128 n5129 0.03125
r7404 n5071 n5130 0.3125
r7405 n5129 n5130 0.03125
r7406 n5072 n5131 0.078125
r7407 n5130 n5131 0.078125
r7408 n5073 n5132 0.0625
r7409 n5131 n5132 0.140625
r7410 n5074 n5133 0.3125
r7411 n5132 n5133 0.09375
r7412 n5075 n5134 0.03125
r7413 n5133 n5134 0.171875
r7414 n5135 n5136 0.1875
r7415 n5076 n5137 0.0625
r7416 n5136 n5137 0.203125
r7417 n5077 n5138 0.052083333333333336
r7418 n5137 n5138 0.171875
r7419 n5078 n5139 0.15625
r7420 n5138 n5139 0.125
r7421 n5079 n5140 0.018382352941176471
r7422 n5139 n5140 0.296875
r7423 n5080 n5141 0.02403846153846154
r7424 n5140 n5141 0.46875
r7425 n5081 n5142 0.15625
r7426 n5141 n5142 0.234375
r7427 n5082 n5143 0.15625
r7428 n5142 n5143 0.0625
r7429 n5083 n5144 0.078125
r7430 n5143 n5144 0.09375
r7431 n5084 n5145 0.0625
r7432 n5144 n5145 0.140625
r7433 n5145 n5146 0.203125
r7434 n5146 n5147 0.1875
r7435 n5085 n5148 0.03125
r7436 n5086 n5149 0.012500000000000001
r7437 n5148 n5149 0.546875
r7438 n5087 n5150 0.3125
r7439 n5149 n5150 0.40625
r7440 n5088 n5151 0.011160714285714286
r7441 n5150 n5151 0.453125
r7442 n5089 n5152 0.3125
r7443 n5151 n5152 0.453125
r7444 n5090 n5153 0.012500000000000001
r7445 n5152 n5153 0.40625
r7446 n5091 n5154 0.03125
r7447 n5153 n5154 0.546875
r7448 n5092 n5155 0.011363636363636364
r7449 n5093 n5156 0.1875
r7450 n5155 n5156 1.09375
r7451 n5094 n5157 0.012500000000000001
r7452 n5156 n5157 1
r7453 n5095 n5158 0.1875
r7454 n5157 n5158 1
r7455 n5096 n5159 0.011363636363636364
r7456 n5158 n5159 1.09375
r7457 n5116 n5160 0.037499999999999999
r7458 n5117 n5161 0.074999999999999997
r7459 n5160 n5161 0.46875
r7460 n5118 n5162 0.074999999999999997
r7461 n5161 n5162 0.3125
r7462 n5119 n5163 0.375
r7463 n5162 n5163 0.1875
r7464 n5120 n5164 0.125
r7465 n5163 n5164 0.125
r7466 n5121 n5165 0.375
r7467 n5164 n5165 0.125
r7468 n5122 n5166 0.041666666666666664
r7469 n5165 n5166 0.3125
r7470 n5123 n5167 0.037499999999999999
r7471 n5166 n5167 0.59375
r7472 n5124 n5168 0.074999999999999997
r7473 n5167 n5168 0.46875
r7474 n5125 n5169 0.074999999999999997
r7475 n5168 n5169 0.3125
r7476 n5126 n5170 0.375
r7477 n5169 n5170 0.1875
r7478 n5127 n5171 0.1875
r7479 n5170 n5171 0.09375
r7480 n5128 n5172 0.375
r7481 n5171 n5172 0.09375
r7482 n5129 n5173 0.375
r7483 n5172 n5173 0.0625
r7484 n5130 n5174 0.375
r7485 n5173 n5174 0.0625
r7486 n5131 n5175 0.09375
r7487 n5174 n5175 0.15625
r7488 n5132 n5176 0.074999999999999997
r7489 n5175 n5176 0.28125
r7490 n5133 n5177 0.375
r7491 n5176 n5177 0.1875
r7492 n5134 n5178 0.037499999999999999
r7493 n5177 n5178 0.34375
r7494 n5135 n5179 0.09375
r7495 n5136 n5180 0.046875
r7496 n5179 n5180 0.375
r7497 n5137 n5181 0.074999999999999997
r7498 n5180 n5181 0.40625
r7499 n5138 n5182 0.0625
r7500 n5181 n5182 0.34375
r7501 n5139 n5183 0.1875
r7502 n5182 n5183 0.25
r7503 n5140 n5184 0.022058823529411766
r7504 n5183 n5184 0.59375
r7505 n5141 n5185 0.028846153846153848
r7506 n5184 n5185 0.9375
r7507 n5142 n5186 0.1875
r7508 n5185 n5186 0.46875
r7509 n5143 n5187 0.1875
r7510 n5186 n5187 0.125
r7511 n5144 n5188 0.09375
r7512 n5187 n5188 0.1875
r7513 n5145 n5189 0.074999999999999997
r7514 n5188 n5189 0.28125
r7515 n5146 n5190 0.046875
r7516 n5189 n5190 0.40625
r7517 n5147 n5191 0.09375
r7518 n5190 n5191 0.375
r7519 n5148 n5192 0.037499999999999999
r7520 n5149 n5193 0.014999999999999999
r7521 n5192 n5193 1.09375
r7522 n5150 n5194 0.375
r7523 n5193 n5194 0.8125
r7524 n5151 n5195 0.013392857142857142
r7525 n5194 n5195 0.90625
r7526 n5152 n5196 0.375
r7527 n5195 n5196 0.90625
r7528 n5153 n5197 0.014999999999999999
r7529 n5196 n5197 0.8125
r7530 n5154 n5198 0.037499999999999999
r7531 n5197 n5198 1.09375
r7532 n5155 n5199 0.013257575757575758
r7533 n5156 n5200 0.21875
r7534 n5199 n5200 0.4375
r7535 n5157 n5201 0.014583333333333334
r7536 n5200 n5201 0.40000000000000002
r7537 n5158 n5202 0.21875
r7538 n5201 n5202 0.40000000000000002
r7539 n5159 n5203 0.013257575757575758
r7540 n5202 n5203 0.4375
r7541 n5179 n5204 0.109375
r7542 n5180 n5205 0.0546875
r7543 n5204 n5205 0.14999999999999999
r7544 n5181 n5206 0.087499999999999994
r7545 n5205 n5206 0.16250000000000001
r7546 n5182 n5207 0.072916666666666671
r7547 n5206 n5207 0.13750000000000001
r7548 n5183 n5208 0.21875
r7549 n5207 n5208 0.10000000000000001
r7550 n5184 n5209 0.025735294117647058
r7551 n5208 n5209 0.23749999999999999
r7552 n5185 n5210 0.033653846153846152
r7553 n5209 n5210 0.375
r7554 n5186 n5211 0.21875
r7555 n5210 n5211 0.1875
r7556 n5187 n5212 0.21875
r7557 n5211 n5212 0.050000000000000003
r7558 n5188 n5213 0.109375
r7559 n5212 n5213 0.074999999999999997
r7560 n5189 n5214 0.087499999999999994
r7561 n5213 n5214 0.1125
r7562 n5190 n5215 0.0546875
r7563 n5214 n5215 0.16250000000000001
r7564 n5191 n5216 0.109375
r7565 n5215 n5216 0.14999999999999999
r7566 n5192 n5217 0.043749999999999997
r7567 n5193 n5218 0.017500000000000002
r7568 n5217 n5218 0.4375
r7569 n5194 n5219 0.4375
r7570 n5218 n5219 0.32500000000000001
r7571 n5195 n5220 0.015625
r7572 n5219 n5220 0.36249999999999999
r7573 n5196 n5221 0.4375
r7574 n5220 n5221 0.36249999999999999
r7575 n5197 n5222 0.017500000000000002
r7576 n5221 n5222 0.32500000000000001
r7577 n5198 n5223 0.043749999999999997
r7578 n5222 n5223 0.4375
r7579 n5199 n5224 0.013257575757575758
r7580 n5200 n5225 0.21875
r7581 n5224 n5225 1.09375
r7582 n5201 n5226 0.014583333333333334
r7583 n5225 n5226 1
r7584 n5202 n5227 0.21875
r7585 n5226 n5227 1
r7586 n5203 n5228 0.013257575757575758
r7587 n5227 n5228 1.09375
r7588 n5204 n5229 0.109375
r7589 n5205 n5230 0.0546875
r7590 n5229 n5230 0.375
r7591 n5206 n5231 0.087499999999999994
r7592 n5230 n5231 0.40625
r7593 n5207 n5232 0.072916666666666671
r7594 n5231 n5232 0.34375
r7595 n5208 n5233 0.21875
r7596 n5232 n5233 0.25
r7597 n5209 n5234 0.025735294117647058
r7598 n5233 n5234 0.59375
r7599 n5210 n5235 0.033653846153846152
r7600 n5234 n5235 0.9375
r7601 n5211 n5236 0.21875
r7602 n5235 n5236 0.46875
r7603 n5212 n5237 0.21875
r7604 n5236 n5237 0.125
r7605 n5213 n5238 0.109375
r7606 n5237 n5238 0.1875
r7607 n5214 n5239 0.087499999999999994
r7608 n5238 n5239 0.28125
r7609 n5215 n5240 0.0546875
r7610 n5239 n5240 0.40625
r7611 n5216 n5241 0.109375
r7612 n5240 n5241 0.375
r7613 n5217 n5242 0.043749999999999997
r7614 n5218 n5243 0.017500000000000002
r7615 n5242 n5243 1.09375
r7616 n5219 n5244 0.4375
r7617 n5243 n5244 0.8125
r7618 n5220 n5245 0.015625
r7619 n5244 n5245 0.90625
r7620 n5221 n5246 0.4375
r7621 n5245 n5246 0.90625
r7622 n5222 n5247 0.017500000000000002
r7623 n5246 n5247 0.8125
r7624 n5223 n5248 0.043749999999999997
r7625 n5247 n5248 1.09375
r7626 n5224 n5249 0.007575757575757576
r7627 n5225 n5250 0.125
r7628 n5249 n5250 1.09375
r7629 n5226 n5251 0.0083333333333333332
r7630 n5250 n5251 1
r7631 n5227 n5252 0.125
r7632 n5251 n5252 1
r7633 n5228 n5253 0.007575757575757576
r7634 n5252 n5253 1.09375
r7635 n5229 n5254 0.0625
r7636 n5230 n5255 0.03125
r7637 n5254 n5255 0.375
r7638 n5231 n5256 0.050000000000000003
r7639 n5255 n5256 0.40625
r7640 n5232 n5257 0.041666666666666664
r7641 n5256 n5257 0.34375
r7642 n5233 n5258 0.125
r7643 n5257 n5258 0.25
r7644 n5234 n5259 0.014705882352941176
r7645 n5258 n5259 0.59375
r7646 n5235 n5260 0.019230769230769232
r7647 n5259 n5260 0.9375
r7648 n5236 n5261 0.125
r7649 n5260 n5261 0.46875
r7650 n5237 n5262 0.125
r7651 n5261 n5262 0.125
r7652 n5238 n5263 0.0625
r7653 n5262 n5263 0.1875
r7654 n5239 n5264 0.050000000000000003
r7655 n5263 n5264 0.28125
r7656 n5240 n5265 0.03125
r7657 n5264 n5265 0.40625
r7658 n5241 n5266 0.0625
r7659 n5265 n5266 0.375
r7660 n5242 n5267 0.025000000000000001
r7661 n5243 n5268 0.01
r7662 n5267 n5268 1.09375
r7663 n5244 n5269 0.25
r7664 n5268 n5269 0.8125
r7665 n5245 n5270 0.0089285714285714281
r7666 n5269 n5270 0.90625
r7667 n5246 n5271 0.25
r7668 n5270 n5271 0.90625
r7669 n5247 n5272 0.01
r7670 n5271 n5272 0.8125
r7671 n5248 n5273 0.025000000000000001
r7672 n5272 n5273 1.09375
r7673 n5249 n5274 0.056818181818181816
r7674 n5250 n5275 0.9375
r7675 n5274 n5275 0.078125
r7676 n5251 n5276 0.0625
r7677 n5275 n5276 0.071428571428571425
r7678 n5252 n5277 0.9375
r7679 n5276 n5277 0.071428571428571425
r7680 n5253 n5278 0.056818181818181816
r7681 n5277 n5278 0.078125
r7682 n5254 n5279 0.46875
r7683 n5255 n5280 0.234375
r7684 n5279 n5280 0.026785714285714284
r7685 n5256 n5281 0.375
r7686 n5280 n5281 0.029017857142857144
r7687 n5257 n5282 0.3125
r7688 n5281 n5282 0.024553571428571428
r7689 n5258 n5283 0.9375
r7690 n5282 n5283 0.017857142857142856
r7691 n5259 n5284 0.11029411764705882
r7692 n5283 n5284 0.042410714285714288
r7693 n5260 n5285 0.14423076923076922
r7694 n5284 n5285 0.066964285714285712
r7695 n5261 n5286 0.9375
r7696 n5285 n5286 0.033482142857142856
r7697 n5262 n5287 0.9375
r7698 n5286 n5287 0.0089285714285714281
r7699 n5263 n5288 0.46875
r7700 n5287 n5288 0.013392857142857142
r7701 n5264 n5289 0.375
r7702 n5288 n5289 0.020089285714285716
r7703 n5265 n5290 0.234375
r7704 n5289 n5290 0.029017857142857144
r7705 n5266 n5291 0.46875
r7706 n5290 n5291 0.026785714285714284
r7707 n5267 n5292 0.1875
r7708 n5268 n5293 0.074999999999999997
r7709 n5292 n5293 0.078125
r7710 n5269 n5294 1.875
r7711 n5293 n5294 0.058035714285714288
r7712 n5270 n5295 0.066964285714285712
r7713 n5294 n5295 0.064732142857142863
r7714 n5271 n5296 1.875
r7715 n5295 n5296 0.064732142857142863
r7716 n5272 n5297 0.074999999999999997
r7717 n5296 n5297 0.058035714285714288
r7718 n5273 n5298 0.1875
r7719 n5297 n5298 0.078125
r7720 n5274 n5299 0.056818181818181816
r7721 n5275 n5300 0.9375
r7722 n5299 n5300 1.09375
r7723 n5276 n5301 0.0625
r7724 n5300 n5301 1
r7725 n5277 n5302 0.9375
r7726 n5301 n5302 1
r7727 n5278 n5303 0.056818181818181816
r7728 n5302 n5303 1.09375
r7729 n5304 n5305 0.46875
r7730 n5305 n5306 0.3125
r7731 n5306 n5307 0.1875
r7732 n5307 n5308 0.125
r7733 n5308 n5309 0.125
r7734 n5309 n5310 0.3125
r7735 n5310 n5311 0.59375
r7736 n5311 n5312 0.46875
r7737 n5312 n5313 0.3125
r7738 n5313 n5314 0.1875
r7739 n5314 n5315 0.09375
r7740 n5315 n5316 0.09375
r7741 n5316 n5317 0.0625
r7742 n5317 n5318 0.0625
r7743 n5318 n5319 0.15625
r7744 n5319 n5320 0.28125
r7745 n5320 n5321 0.1875
r7746 n5321 n5322 0.34375
r7747 n5279 n5323 0.46875
r7748 n5280 n5324 0.234375
r7749 n5323 n5324 0.375
r7750 n5281 n5325 0.375
r7751 n5324 n5325 0.40625
r7752 n5282 n5326 0.3125
r7753 n5325 n5326 0.34375
r7754 n5283 n5327 0.9375
r7755 n5326 n5327 0.25
r7756 n5284 n5328 0.11029411764705882
r7757 n5327 n5328 0.59375
r7758 n5285 n5329 0.14423076923076922
r7759 n5328 n5329 0.9375
r7760 n5286 n5330 0.9375
r7761 n5329 n5330 0.46875
r7762 n5287 n5331 0.9375
r7763 n5330 n5331 0.125
r7764 n5288 n5332 0.46875
r7765 n5331 n5332 0.1875
r7766 n5289 n5333 0.375
r7767 n5332 n5333 0.28125
r7768 n5290 n5334 0.234375
r7769 n5333 n5334 0.40625
r7770 n5291 n5335 0.46875
r7771 n5334 n5335 0.375
r7772 n5292 n5336 0.1875
r7773 n5293 n5337 0.074999999999999997
r7774 n5336 n5337 1.09375
r7775 n5294 n5338 1.875
r7776 n5337 n5338 0.8125
r7777 n5295 n5339 0.066964285714285712
r7778 n5338 n5339 0.90625
r7779 n5296 n5340 1.875
r7780 n5339 n5340 0.90625
r7781 n5297 n5341 0.074999999999999997
r7782 n5340 n5341 0.8125
r7783 n5298 n5342 0.1875
r7784 n5341 n5342 1.09375
r7785 n5299 n5343 0.007575757575757576
r7786 n5300 n5344 0.125
r7787 n5343 n5344 1.09375
r7788 n5301 n5345 0.0083333333333333332
r7789 n5344 n5345 1
r7790 n5302 n5346 0.125
r7791 n5345 n5346 1
r7792 n5303 n5347 0.007575757575757576
r7793 n5346 n5347 1.09375
r7794 n5304 n5348 0.025000000000000001
r7795 n5305 n5349 0.050000000000000003
r7796 n5348 n5349 0.46875
r7797 n5306 n5350 0.050000000000000003
r7798 n5349 n5350 0.3125
r7799 n5307 n5351 0.25
r7800 n5350 n5351 0.1875
r7801 n5308 n5352 0.083333333333333329
r7802 n5351 n5352 0.125
r7803 n5309 n5353 0.25
r7804 n5352 n5353 0.125
r7805 n5310 n5354 0.027777777777777776
r7806 n5353 n5354 0.3125
r7807 n5311 n5355 0.025000000000000001
r7808 n5354 n5355 0.59375
r7809 n5312 n5356 0.050000000000000003
r7810 n5355 n5356 0.46875
r7811 n5313 n5357 0.050000000000000003
r7812 n5356 n5357 0.3125
r7813 n5314 n5358 0.25
r7814 n5357 n5358 0.1875
r7815 n5315 n5359 0.125
r7816 n5358 n5359 0.09375
r7817 n5316 n5360 0.25
r7818 n5359 n5360 0.09375
r7819 n5317 n5361 0.25
r7820 n5360 n5361 0.0625
r7821 n5318 n5362 0.25
r7822 n5361 n5362 0.0625
r7823 n5319 n5363 0.0625
r7824 n5362 n5363 0.15625
r7825 n5320 n5364 0.050000000000000003
r7826 n5363 n5364 0.28125
r7827 n5321 n5365 0.25
r7828 n5364 n5365 0.1875
r7829 n5322 n5366 0.025000000000000001
r7830 n5365 n5366 0.34375
r7831 n5323 n5367 0.0625
r7832 n5324 n5368 0.03125
r7833 n5367 n5368 0.375
r7834 n5325 n5369 0.050000000000000003
r7835 n5368 n5369 0.40625
r7836 n5326 n5370 0.041666666666666664
r7837 n5369 n5370 0.34375
r7838 n5327 n5371 0.125
r7839 n5370 n5371 0.25
r7840 n5328 n5372 0.014705882352941176
r7841 n5371 n5372 0.59375
r7842 n5329 n5373 0.019230769230769232
r7843 n5372 n5373 0.9375
r7844 n5330 n5374 0.125
r7845 n5373 n5374 0.46875
r7846 n5331 n5375 0.125
r7847 n5374 n5375 0.125
r7848 n5332 n5376 0.0625
r7849 n5375 n5376 0.1875
r7850 n5333 n5377 0.050000000000000003
r7851 n5376 n5377 0.28125
r7852 n5334 n5378 0.03125
r7853 n5377 n5378 0.40625
r7854 n5335 n5379 0.0625
r7855 n5378 n5379 0.375
r7856 n5336 n5380 0.025000000000000001
r7857 n5337 n5381 0.01
r7858 n5380 n5381 1.09375
r7859 n5338 n5382 0.25
r7860 n5381 n5382 0.8125
r7861 n5339 n5383 0.0089285714285714281
r7862 n5382 n5383 0.90625
r7863 n5340 n5384 0.25
r7864 n5383 n5384 0.90625
r7865 n5341 n5385 0.01
r7866 n5384 n5385 0.8125
r7867 n5342 n5386 0.025000000000000001
r7868 n5385 n5386 1.09375
r7869 n5343 n5387 0.007575757575757576
r7870 n5344 n5388 0.125
r7871 n5387 n5388 1.09375
r7872 n5345 n5389 0.0083333333333333332
r7873 n5388 n5389 1
r7874 n5346 n5390 0.125
r7875 n5389 n5390 1
r7876 n5347 n5391 0.007575757575757576
r7877 n5390 n5391 1.09375
r7878 n5348 n5392 0.025000000000000001
r7879 n5349 n5393 0.050000000000000003
r7880 n5392 n5393 0.46875
r7881 n5350 n5394 0.050000000000000003
r7882 n5393 n5394 0.3125
r7883 n5351 n5395 0.25
r7884 n5394 n5395 0.1875
r7885 n5352 n5396 0.083333333333333329
r7886 n5395 n5396 0.125
r7887 n5353 n5397 0.25
r7888 n5396 n5397 0.125
r7889 n5354 n5398 0.027777777777777776
r7890 n5397 n5398 0.3125
r7891 n5355 n5399 0.025000000000000001
r7892 n5398 n5399 0.59375
r7893 n5356 n5400 0.050000000000000003
r7894 n5399 n5400 0.46875
r7895 n5357 n5401 0.050000000000000003
r7896 n5400 n5401 0.3125
r7897 n5358 n5402 0.25
r7898 n5401 n5402 0.1875
r7899 n5359 n5403 0.125
r7900 n5402 n5403 0.09375
r7901 n5360 n5404 0.25
r7902 n5403 n5404 0.09375
r7903 n5361 n5405 0.25
r7904 n5404 n5405 0.0625
r7905 n5362 n5406 0.25
r7906 n5405 n5406 0.0625
r7907 n5363 n5407 0.0625
r7908 n5406 n5407 0.15625
r7909 n5364 n5408 0.050000000000000003
r7910 n5407 n5408 0.28125
r7911 n5365 n5409 0.25
r7912 n5408 n5409 0.1875
r7913 n5366 n5410 0.025000000000000001
r7914 n5409 n5410 0.34375
r7915 n5367 n5411 0.0625
r7916 n5368 n5412 0.03125
r7917 n5411 n5412 0.375
r7918 n5369 n5413 0.050000000000000003
r7919 n5412 n5413 0.40625
r7920 n5370 n5414 0.041666666666666664
r7921 n5413 n5414 0.34375
r7922 n5371 n5415 0.125
r7923 n5414 n5415 0.25
r7924 n5372 n5416 0.014705882352941176
r7925 n5415 n5416 0.59375
r7926 n5373 n5417 0.019230769230769232
r7927 n5416 n5417 0.9375
r7928 n5374 n5418 0.125
r7929 n5417 n5418 0.46875
r7930 n5375 n5419 0.125
r7931 n5418 n5419 0.125
r7932 n5376 n5420 0.0625
r7933 n5419 n5420 0.1875
r7934 n5377 n5421 0.050000000000000003
r7935 n5420 n5421 0.28125
r7936 n5378 n5422 0.03125
r7937 n5421 n5422 0.40625
r7938 n5379 n5423 0.0625
r7939 n5422 n5423 0.375
r7940 n5380 n5424 0.025000000000000001
r7941 n5381 n5425 0.01
r7942 n5424 n5425 1.09375
r7943 n5382 n5426 0.25
r7944 n5425 n5426 0.8125
r7945 n5383 n5427 0.0089285714285714281
r7946 n5426 n5427 0.90625
r7947 n5384 n5428 0.25
r7948 n5427 n5428 0.90625
r7949 n5385 n5429 0.01
r7950 n5428 n5429 0.8125
r7951 n5386 n5430 0.025000000000000001
r7952 n5429 n5430 1.09375
r7953 n5387 n5431 0.011363636363636364
r7954 n5388 n5432 0.1875
r7955 n5431 n5432 0.546875
r7956 n5389 n5433 0.012500000000000001
r7957 n5432 n5433 0.5
r7958 n5390 n5434 0.1875
r7959 n5433 n5434 0.5
r7960 n5391 n5435 0.011363636363636364
r7961 n5434 n5435 0.546875
r7962 n5392 n5436 0.037499999999999999
r7963 n5393 n5437 0.074999999999999997
r7964 n5436 n5437 0.234375
r7965 n5394 n5438 0.074999999999999997
r7966 n5437 n5438 0.15625
r7967 n5395 n5439 0.375
r7968 n5438 n5439 0.09375
r7969 n5396 n5440 0.125
r7970 n5439 n5440 0.0625
r7971 n5397 n5441 0.375
r7972 n5440 n5441 0.0625
r7973 n5398 n5442 0.041666666666666664
r7974 n5441 n5442 0.15625
r7975 n5399 n5443 0.037499999999999999
r7976 n5442 n5443 0.296875
r7977 n5400 n5444 0.074999999999999997
r7978 n5443 n5444 0.234375
r7979 n5401 n5445 0.074999999999999997
r7980 n5444 n5445 0.15625
r7981 n5402 n5446 0.375
r7982 n5445 n5446 0.09375
r7983 n5403 n5447 0.1875
r7984 n5446 n5447 0.046875
r7985 n5404 n5448 0.375
r7986 n5447 n5448 0.046875
r7987 n5405 n5449 0.375
r7988 n5448 n5449 0.03125
r7989 n5406 n5450 0.375
r7990 n5449 n5450 0.03125
r7991 n5407 n5451 0.09375
r7992 n5450 n5451 0.078125
r7993 n5408 n5452 0.074999999999999997
r7994 n5451 n5452 0.140625
r7995 n5409 n5453 0.375
r7996 n5452 n5453 0.09375
r7997 n5410 n5454 0.037499999999999999
r7998 n5453 n5454 0.171875
r7999 n5411 n5455 0.09375
r8000 n5412 n5456 0.046875
r8001 n5455 n5456 0.1875
r8002 n5413 n5457 0.074999999999999997
r8003 n5456 n5457 0.203125
r8004 n5414 n5458 0.0625
r8005 n5457 n5458 0.171875
r8006 n5415 n5459 0.1875
r8007 n5458 n5459 0.125
r8008 n5416 n5460 0.022058823529411766
r8009 n5459 n5460 0.296875
r8010 n5417 n5461 0.028846153846153848
r8011 n5460 n5461 0.46875
r8012 n5418 n5462 0.1875
r8013 n5461 n5462 0.234375
r8014 n5419 n5463 0.1875
r8015 n5462 n5463 0.0625
r8016 n5420 n5464 0.09375
r8017 n5463 n5464 0.09375
r8018 n5421 n5465 0.074999999999999997
r8019 n5464 n5465 0.140625
r8020 n5422 n5466 0.046875
r8021 n5465 n5466 0.203125
r8022 n5423 n5467 0.09375
r8023 n5466 n5467 0.1875
r8024 n5424 n5468 0.037499999999999999
r8025 n5425 n5469 0.014999999999999999
r8026 n5468 n5469 0.546875
r8027 n5426 n5470 0.375
r8028 n5469 n5470 0.40625
r8029 n5427 n5471 0.013392857142857142
r8030 n5470 n5471 0.453125
r8031 n5428 n5472 0.375
r8032 n5471 n5472 0.453125
r8033 n5429 n5473 0.014999999999999999
r8034 n5472 n5473 0.40625
r8035 n5430 n5474 0.037499999999999999
r8036 n5473 n5474 0.546875
r8037 n5431 n5475 0.020833333333333332
r8038 n5432 n5476 0.34375
r8039 n5475 n5476 0.3125
r8040 n5433 n5477 0.022916666666666665
r8041 n5476 n5477 0.2857142857142857
r8042 n5434 n5478 0.34375
r8043 n5477 n5478 0.2857142857142857
r8044 n5435 n5479 0.020833333333333332
r8045 n5478 n5479 0.3125
r8046 n5436 n5480 0.068750000000000006
r8047 n5437 n5481 0.13750000000000001
r8048 n5480 n5481 0.13392857142857142
r8049 n5438 n5482 0.13750000000000001
r8050 n5481 n5482 0.089285714285714288
r8051 n5439 n5483 0.6875
r8052 n5482 n5483 0.053571428571428568
r8053 n5440 n5484 0.22916666666666666
r8054 n5483 n5484 0.035714285714285712
r8055 n5441 n5485 0.6875
r8056 n5484 n5485 0.035714285714285712
r8057 n5442 n5486 0.076388888888888895
r8058 n5485 n5486 0.089285714285714288
r8059 n5443 n5487 0.068750000000000006
r8060 n5486 n5487 0.16964285714285715
r8061 n5444 n5488 0.13750000000000001
r8062 n5487 n5488 0.13392857142857142
r8063 n5445 n5489 0.13750000000000001
r8064 n5488 n5489 0.089285714285714288
r8065 n5446 n5490 0.6875
r8066 n5489 n5490 0.053571428571428568
r8067 n5447 n5491 0.34375
r8068 n5490 n5491 0.026785714285714284
r8069 n5448 n5492 0.6875
r8070 n5491 n5492 0.026785714285714284
r8071 n5449 n5493 0.6875
r8072 n5492 n5493 0.017857142857142856
r8073 n5450 n5494 0.6875
r8074 n5493 n5494 0.017857142857142856
r8075 n5451 n5495 0.171875
r8076 n5494 n5495 0.044642857142857144
r8077 n5452 n5496 0.13750000000000001
r8078 n5495 n5496 0.080357142857142863
r8079 n5453 n5497 0.6875
r8080 n5496 n5497 0.053571428571428568
r8081 n5454 n5498 0.068750000000000006
r8082 n5497 n5498 0.098214285714285712
r8083 n5455 n5499 0.171875
r8084 n5456 n5500 0.0859375
r8085 n5499 n5500 0.10714285714285714
r8086 n5457 n5501 0.13750000000000001
r8087 n5500 n5501 0.11607142857142858
r8088 n5458 n5502 0.11458333333333333
r8089 n5501 n5502 0.098214285714285712
r8090 n5459 n5503 0.34375
r8091 n5502 n5503 0.071428571428571425
r8092 n5460 n5504 0.040441176470588237
r8093 n5503 n5504 0.16964285714285715
r8094 n5461 n5505 0.052884615384615384
r8095 n5504 n5505 0.26785714285714285
r8096 n5462 n5506 0.34375
r8097 n5505 n5506 0.13392857142857142
r8098 n5463 n5507 0.34375
r8099 n5506 n5507 0.035714285714285712
r8100 n5464 n5508 0.171875
r8101 n5507 n5508 0.053571428571428568
r8102 n5465 n5509 0.13750000000000001
r8103 n5508 n5509 0.080357142857142863
r8104 n5466 n5510 0.0859375
r8105 n5509 n5510 0.11607142857142858
r8106 n5467 n5511 0.171875
r8107 n5510 n5511 0.10714285714285714
r8108 n5468 n5512 0.068750000000000006
r8109 n5469 n5513 0.0275
r8110 n5512 n5513 0.3125
r8111 n5470 n5514 0.6875
r8112 n5513 n5514 0.23214285714285715
r8113 n5471 n5515 0.024553571428571428
r8114 n5514 n5515 0.25892857142857145
r8115 n5472 n5516 0.6875
r8116 n5515 n5516 0.25892857142857145
r8117 n5473 n5517 0.0275
r8118 n5516 n5517 0.23214285714285715
r8119 n5474 n5518 0.068750000000000006
r8120 n5517 n5518 0.3125
r8121 n5475 n5519 0.01893939393939394
r8122 n5476 n5520 0.3125
r8123 n5519 n5520 0.72916666666666663
r8124 n5477 n5521 0.020833333333333332
r8125 n5520 n5521 0.66666666666666663
r8126 n5478 n5522 0.3125
r8127 n5521 n5522 0.66666666666666663
r8128 n5479 n5523 0.01893939393939394
r8129 n5522 n5523 0.72916666666666663
r8130 n5480 n5524 0.0625
r8131 n5481 n5525 0.125
r8132 n5524 n5525 0.3125
r8133 n5482 n5526 0.125
r8134 n5525 n5526 0.20833333333333334
r8135 n5483 n5527 0.625
r8136 n5526 n5527 0.125
r8137 n5484 n5528 0.20833333333333334
r8138 n5527 n5528 0.083333333333333329
r8139 n5485 n5529 0.625
r8140 n5528 n5529 0.083333333333333329
r8141 n5486 n5530 0.069444444444444448
r8142 n5529 n5530 0.20833333333333334
r8143 n5487 n5531 0.0625
r8144 n5530 n5531 0.39583333333333331
r8145 n5488 n5532 0.125
r8146 n5531 n5532 0.3125
r8147 n5489 n5533 0.125
r8148 n5532 n5533 0.20833333333333334
r8149 n5490 n5534 0.625
r8150 n5533 n5534 0.125
r8151 n5491 n5535 0.3125
r8152 n5534 n5535 0.0625
r8153 n5492 n5536 0.625
r8154 n5535 n5536 0.0625
r8155 n5493 n5537 0.625
r8156 n5536 n5537 0.041666666666666664
r8157 n5494 n5538 0.625
r8158 n5537 n5538 0.041666666666666664
r8159 n5495 n5539 0.15625
r8160 n5538 n5539 0.10416666666666667
r8161 n5496 n5540 0.125
r8162 n5539 n5540 0.1875
r8163 n5497 n5541 0.625
r8164 n5540 n5541 0.125
r8165 n5498 n5542 0.0625
r8166 n5541 n5542 0.22916666666666666
r8167 n5512 n5543 0.0625
r8168 n5513 n5544 0.025000000000000001
r8169 n5543 n5544 0.72916666666666663
r8170 n5514 n5545 0.625
r8171 n5544 n5545 0.54166666666666663
r8172 n5515 n5546 0.022321428571428572
r8173 n5545 n5546 0.60416666666666663
r8174 n5516 n5547 0.625
r8175 n5546 n5547 0.60416666666666663
r8176 n5517 n5548 0.025000000000000001
r8177 n5547 n5548 0.54166666666666663
r8178 n5518 n5549 0.0625
r8179 n5548 n5549 0.72916666666666663
r8180 n5519 n5550 0.011363636363636364
r8181 n5520 n5551 0.1875
r8182 n5550 n5551 0.72916666666666663
r8183 n5521 n5552 0.012500000000000001
r8184 n5551 n5552 0.66666666666666663
r8185 n5522 n5553 0.1875
r8186 n5552 n5553 0.66666666666666663
r8187 n5523 n5554 0.011363636363636364
r8188 n5553 n5554 0.72916666666666663
r8189 n5524 n5555 0.037499999999999999
r8190 n5525 n5556 0.074999999999999997
r8191 n5555 n5556 0.3125
r8192 n5526 n5557 0.074999999999999997
r8193 n5556 n5557 0.20833333333333334
r8194 n5527 n5558 0.375
r8195 n5557 n5558 0.125
r8196 n5528 n5559 0.125
r8197 n5558 n5559 0.083333333333333329
r8198 n5529 n5560 0.375
r8199 n5559 n5560 0.083333333333333329
r8200 n5530 n5561 0.041666666666666664
r8201 n5560 n5561 0.20833333333333334
r8202 n5531 n5562 0.037499999999999999
r8203 n5561 n5562 0.39583333333333331
r8204 n5532 n5563 0.074999999999999997
r8205 n5562 n5563 0.3125
r8206 n5533 n5564 0.074999999999999997
r8207 n5563 n5564 0.20833333333333334
r8208 n5534 n5565 0.375
r8209 n5564 n5565 0.125
r8210 n5535 n5566 0.1875
r8211 n5565 n5566 0.0625
r8212 n5536 n5567 0.375
r8213 n5566 n5567 0.0625
r8214 n5537 n5568 0.375
r8215 n5567 n5568 0.041666666666666664
r8216 n5538 n5569 0.375
r8217 n5568 n5569 0.041666666666666664
r8218 n5539 n5570 0.09375
r8219 n5569 n5570 0.10416666666666667
r8220 n5540 n5571 0.074999999999999997
r8221 n5570 n5571 0.1875
r8222 n5541 n5572 0.375
r8223 n5571 n5572 0.125
r8224 n5542 n5573 0.037499999999999999
r8225 n5572 n5573 0.22916666666666666
r8226 n5543 n5574 0.037499999999999999
r8227 n5544 n5575 0.014999999999999999
r8228 n5574 n5575 0.72916666666666663
r8229 n5545 n5576 0.375
r8230 n5575 n5576 0.54166666666666663
r8231 n5546 n5577 0.013392857142857142
r8232 n5576 n5577 0.60416666666666663
r8233 n5547 n5578 0.375
r8234 n5577 n5578 0.60416666666666663
r8235 n5548 n5579 0.014999999999999999
r8236 n5578 n5579 0.54166666666666663
r8237 n5549 n5580 0.037499999999999999
r8238 n5579 n5580 0.72916666666666663
r8239 n5550 n5581 0.00946969696969697
r8240 n5551 n5582 0.15625
r8241 n5581 n5582 1.09375
r8242 n5552 n5583 0.010416666666666666
r8243 n5582 n5583 1
r8244 n5553 n5584 0.15625
r8245 n5583 n5584 1
r8246 n5554 n5585 0.00946969696969697
r8247 n5584 n5585 1.09375
r8248 n5555 n5586 0.03125
r8249 n5556 n5587 0.0625
r8250 n5586 n5587 0.46875
r8251 n5557 n5588 0.0625
r8252 n5587 n5588 0.3125
r8253 n5558 n5589 0.3125
r8254 n5588 n5589 0.1875
r8255 n5559 n5590 0.10416666666666667
r8256 n5589 n5590 0.125
r8257 n5560 n5591 0.3125
r8258 n5590 n5591 0.125
r8259 n5561 n5592 0.034722222222222224
r8260 n5591 n5592 0.3125
r8261 n5562 n5593 0.03125
r8262 n5592 n5593 0.59375
r8263 n5563 n5594 0.0625
r8264 n5593 n5594 0.46875
r8265 n5564 n5595 0.0625
r8266 n5594 n5595 0.3125
r8267 n5565 n5596 0.3125
r8268 n5595 n5596 0.1875
r8269 n5566 n5597 0.15625
r8270 n5596 n5597 0.09375
r8271 n5567 n5598 0.3125
r8272 n5597 n5598 0.09375
r8273 n5568 n5599 0.3125
r8274 n5598 n5599 0.0625
r8275 n5569 n5600 0.3125
r8276 n5599 n5600 0.0625
r8277 n5570 n5601 0.078125
r8278 n5600 n5601 0.15625
r8279 n5571 n5602 0.0625
r8280 n5601 n5602 0.28125
r8281 n5572 n5603 0.3125
r8282 n5602 n5603 0.1875
r8283 n5573 n5604 0.03125
r8284 n5603 n5604 0.34375
r8285 n5574 n5605 0.03125
r8286 n5575 n5606 0.012500000000000001
r8287 n5605 n5606 1.09375
r8288 n5576 n5607 0.3125
r8289 n5606 n5607 0.8125
r8290 n5577 n5608 0.011160714285714286
r8291 n5607 n5608 0.90625
r8292 n5578 n5609 0.3125
r8293 n5608 n5609 0.90625
r8294 n5579 n5610 0.012500000000000001
r8295 n5609 n5610 0.8125
r8296 n5580 n5611 0.03125
r8297 n5610 n5611 1.09375
r8298 n5581 n5612 0.032196969696969696
r8299 n5582 n5613 0.53125
r8300 n5612 n5613 0.14583333333333334
r8301 n5583 n5614 0.035416666666666666
r8302 n5613 n5614 0.13333333333333333
r8303 n5584 n5615 0.53125
r8304 n5614 n5615 0.13333333333333333
r8305 n5585 n5616 0.032196969696969696
r8306 n5615 n5616 0.14583333333333334
r8307 n5586 n5617 0.10625
r8308 n5587 n5618 0.21249999999999999
r8309 n5617 n5618 0.0625
r8310 n5588 n5619 0.21249999999999999
r8311 n5618 n5619 0.041666666666666664
r8312 n5589 n5620 1.0625
r8313 n5619 n5620 0.025000000000000001
r8314 n5590 n5621 0.35416666666666669
r8315 n5620 n5621 0.016666666666666666
r8316 n5591 n5622 1.0625
r8317 n5621 n5622 0.016666666666666666
r8318 n5592 n5623 0.11805555555555555
r8319 n5622 n5623 0.041666666666666664
r8320 n5593 n5624 0.10625
r8321 n5623 n5624 0.079166666666666663
r8322 n5594 n5625 0.21249999999999999
r8323 n5624 n5625 0.0625
r8324 n5595 n5626 0.21249999999999999
r8325 n5625 n5626 0.041666666666666664
r8326 n5596 n5627 1.0625
r8327 n5626 n5627 0.025000000000000001
r8328 n5597 n5628 0.53125
r8329 n5627 n5628 0.012500000000000001
r8330 n5598 n5629 1.0625
r8331 n5628 n5629 0.012500000000000001
r8332 n5599 n5630 1.0625
r8333 n5629 n5630 0.0083333333333333332
r8334 n5600 n5631 1.0625
r8335 n5630 n5631 0.0083333333333333332
r8336 n5601 n5632 0.265625
r8337 n5631 n5632 0.020833333333333332
r8338 n5602 n5633 0.21249999999999999
r8339 n5632 n5633 0.037499999999999999
r8340 n5603 n5634 1.0625
r8341 n5633 n5634 0.025000000000000001
r8342 n5604 n5635 0.10625
r8343 n5634 n5635 0.04583333333333333
r8344 n5605 n5636 0.10625
r8345 n5606 n5637 0.042500000000000003
r8346 n5636 n5637 0.14583333333333334
r8347 n5607 n5638 1.0625
r8348 n5637 n5638 0.10833333333333334
r8349 n5608 n5639 0.037946428571428568
r8350 n5638 n5639 0.12083333333333333
r8351 n5609 n5640 1.0625
r8352 n5639 n5640 0.12083333333333333
r8353 n5610 n5641 0.042500000000000003
r8354 n5640 n5641 0.10833333333333334
r8355 n5611 n5642 0.10625
r8356 n5641 n5642 0.14583333333333334
r8357 n5612 n5643 0.056818181818181816
r8358 n5613 n5644 0.9375
r8359 n5643 n5644 0.14583333333333334
r8360 n5614 n5645 0.0625
r8361 n5644 n5645 0.13333333333333333
r8362 n5615 n5646 0.9375
r8363 n5645 n5646 0.13333333333333333
r8364 n5616 n5647 0.056818181818181816
r8365 n5646 n5647 0.14583333333333334
r8366 n5617 n5648 0.1875
r8367 n5618 n5649 0.375
r8368 n5648 n5649 0.0625
r8369 n5619 n5650 0.375
r8370 n5649 n5650 0.041666666666666664
r8371 n5620 n5651 1.875
r8372 n5650 n5651 0.025000000000000001
r8373 n5621 n5652 0.625
r8374 n5651 n5652 0.016666666666666666
r8375 n5622 n5653 1.875
r8376 n5652 n5653 0.016666666666666666
r8377 n5623 n5654 0.20833333333333334
r8378 n5653 n5654 0.041666666666666664
r8379 n5624 n5655 0.1875
r8380 n5654 n5655 0.079166666666666663
r8381 n5625 n5656 0.375
r8382 n5655 n5656 0.0625
r8383 n5626 n5657 0.375
r8384 n5656 n5657 0.041666666666666664
r8385 n5627 n5658 1.875
r8386 n5657 n5658 0.025000000000000001
r8387 n5628 n5659 0.9375
r8388 n5658 n5659 0.012500000000000001
r8389 n5629 n5660 1.875
r8390 n5659 n5660 0.012500000000000001
r8391 n5630 n5661 1.875
r8392 n5660 n5661 0.0083333333333333332
r8393 n5631 n5662 1.875
r8394 n5661 n5662 0.0083333333333333332
r8395 n5632 n5663 0.46875
r8396 n5662 n5663 0.020833333333333332
r8397 n5633 n5664 0.375
r8398 n5663 n5664 0.037499999999999999
r8399 n5634 n5665 1.875
r8400 n5664 n5665 0.025000000000000001
r8401 n5635 n5666 0.1875
r8402 n5665 n5666 0.04583333333333333
r8403 n5636 n5667 0.1875
r8404 n5637 n5668 0.074999999999999997
r8405 n5667 n5668 0.14583333333333334
r8406 n5638 n5669 1.875
r8407 n5668 n5669 0.10833333333333334
r8408 n5639 n5670 0.066964285714285712
r8409 n5669 n5670 0.12083333333333333
r8410 n5640 n5671 1.875
r8411 n5670 n5671 0.12083333333333333
r8412 n5641 n5672 0.074999999999999997
r8413 n5671 n5672 0.10833333333333334
r8414 n5642 n5673 0.1875
r8415 n5672 n5673 0.14583333333333334
r8416 n5643 n5674 0.032196969696969696
r8417 n5644 n5675 0.53125
r8418 n5674 n5675 1.09375
r8419 n5645 n5676 0.035416666666666666
r8420 n5675 n5676 1
r8421 n5646 n5677 0.53125
r8422 n5676 n5677 1
r8423 n5647 n5678 0.032196969696969696
r8424 n5677 n5678 1.09375
r8425 n5648 n5679 0.10625
r8426 n5649 n5680 0.21249999999999999
r8427 n5679 n5680 0.46875
r8428 n5650 n5681 0.21249999999999999
r8429 n5680 n5681 0.3125
r8430 n5651 n5682 1.0625
r8431 n5681 n5682 0.1875
r8432 n5652 n5683 0.35416666666666669
r8433 n5682 n5683 0.125
r8434 n5653 n5684 1.0625
r8435 n5683 n5684 0.125
r8436 n5654 n5685 0.11805555555555555
r8437 n5684 n5685 0.3125
r8438 n5655 n5686 0.10625
r8439 n5685 n5686 0.59375
r8440 n5656 n5687 0.21249999999999999
r8441 n5686 n5687 0.46875
r8442 n5657 n5688 0.21249999999999999
r8443 n5687 n5688 0.3125
r8444 n5658 n5689 1.0625
r8445 n5688 n5689 0.1875
r8446 n5659 n5690 0.53125
r8447 n5689 n5690 0.09375
r8448 n5660 n5691 1.0625
r8449 n5690 n5691 0.09375
r8450 n5661 n5692 1.0625
r8451 n5691 n5692 0.0625
r8452 n5662 n5693 1.0625
r8453 n5692 n5693 0.0625
r8454 n5663 n5694 0.265625
r8455 n5693 n5694 0.15625
r8456 n5664 n5695 0.21249999999999999
r8457 n5694 n5695 0.28125
r8458 n5665 n5696 1.0625
r8459 n5695 n5696 0.1875
r8460 n5666 n5697 0.10625
r8461 n5696 n5697 0.34375
r8462 n5667 n5698 0.10625
r8463 n5668 n5699 0.042500000000000003
r8464 n5698 n5699 1.09375
r8465 n5669 n5700 1.0625
r8466 n5699 n5700 0.8125
r8467 n5670 n5701 0.037946428571428568
r8468 n5700 n5701 0.90625
r8469 n5671 n5702 1.0625
r8470 n5701 n5702 0.90625
r8471 n5672 n5703 0.042500000000000003
r8472 n5702 n5703 0.8125
r8473 n5673 n5704 0.10625
r8474 n5703 n5704 1.09375
r8475 n5674 n5705 0.00946969696969697
r8476 n5675 n5706 0.15625
r8477 n5705 n5706 0.72916666666666663
r8478 n5676 n5707 0.010416666666666666
r8479 n5706 n5707 0.66666666666666663
r8480 n5677 n5708 0.15625
r8481 n5707 n5708 0.66666666666666663
r8482 n5678 n5709 0.00946969696969697
r8483 n5708 n5709 0.72916666666666663
r8484 n5679 n5710 0.03125
r8485 n5680 n5711 0.0625
r8486 n5710 n5711 0.3125
r8487 n5681 n5712 0.0625
r8488 n5711 n5712 0.20833333333333334
r8489 n5682 n5713 0.3125
r8490 n5712 n5713 0.125
r8491 n5683 n5714 0.10416666666666667
r8492 n5713 n5714 0.083333333333333329
r8493 n5684 n5715 0.3125
r8494 n5714 n5715 0.083333333333333329
r8495 n5685 n5716 0.034722222222222224
r8496 n5715 n5716 0.20833333333333334
r8497 n5686 n5717 0.03125
r8498 n5716 n5717 0.39583333333333331
r8499 n5687 n5718 0.0625
r8500 n5717 n5718 0.3125
r8501 n5688 n5719 0.0625
r8502 n5718 n5719 0.20833333333333334
r8503 n5689 n5720 0.3125
r8504 n5719 n5720 0.125
r8505 n5690 n5721 0.15625
r8506 n5720 n5721 0.0625
r8507 n5691 n5722 0.3125
r8508 n5721 n5722 0.0625
r8509 n5692 n5723 0.3125
r8510 n5722 n5723 0.041666666666666664
r8511 n5693 n5724 0.3125
r8512 n5723 n5724 0.041666666666666664
r8513 n5694 n5725 0.078125
r8514 n5724 n5725 0.10416666666666667
r8515 n5695 n5726 0.0625
r8516 n5725 n5726 0.1875
r8517 n5696 n5727 0.3125
r8518 n5726 n5727 0.125
r8519 n5697 n5728 0.03125
r8520 n5727 n5728 0.22916666666666666
r8521 n5698 n5729 0.03125
r8522 n5699 n5730 0.012500000000000001
r8523 n5729 n5730 0.72916666666666663
r8524 n5700 n5731 0.3125
r8525 n5730 n5731 0.54166666666666663
r8526 n5701 n5732 0.011160714285714286
r8527 n5731 n5732 0.60416666666666663
r8528 n5702 n5733 0.3125
r8529 n5732 n5733 0.60416666666666663
r8530 n5703 n5734 0.012500000000000001
r8531 n5733 n5734 0.54166666666666663
r8532 n5704 n5735 0.03125
r8533 n5734 n5735 0.72916666666666663
r8534 n5705 n5736 0.011363636363636364
r8535 n5706 n5737 0.1875
r8536 n5736 n5737 0.72916666666666663
r8537 n5707 n5738 0.012500000000000001
r8538 n5737 n5738 0.66666666666666663
r8539 n5708 n5739 0.1875
r8540 n5738 n5739 0.66666666666666663
r8541 n5709 n5740 0.011363636363636364
r8542 n5739 n5740 0.72916666666666663
r8543 n5710 n5741 0.037499999999999999
r8544 n5711 n5742 0.074999999999999997
r8545 n5741 n5742 0.3125
r8546 n5712 n5743 0.074999999999999997
r8547 n5742 n5743 0.20833333333333334
r8548 n5713 n5744 0.375
r8549 n5743 n5744 0.125
r8550 n5714 n5745 0.125
r8551 n5744 n5745 0.083333333333333329
r8552 n5715 n5746 0.375
r8553 n5745 n5746 0.083333333333333329
r8554 n5716 n5747 0.041666666666666664
r8555 n5746 n5747 0.20833333333333334
r8556 n5717 n5748 0.037499999999999999
r8557 n5747 n5748 0.39583333333333331
r8558 n5718 n5749 0.074999999999999997
r8559 n5748 n5749 0.3125
r8560 n5719 n5750 0.074999999999999997
r8561 n5749 n5750 0.20833333333333334
r8562 n5720 n5751 0.375
r8563 n5750 n5751 0.125
r8564 n5721 n5752 0.1875
r8565 n5751 n5752 0.0625
r8566 n5722 n5753 0.375
r8567 n5752 n5753 0.0625
r8568 n5723 n5754 0.375
r8569 n5753 n5754 0.041666666666666664
r8570 n5724 n5755 0.375
r8571 n5754 n5755 0.041666666666666664
r8572 n5725 n5756 0.09375
r8573 n5755 n5756 0.10416666666666667
r8574 n5726 n5757 0.074999999999999997
r8575 n5756 n5757 0.1875
r8576 n5727 n5758 0.375
r8577 n5757 n5758 0.125
r8578 n5728 n5759 0.037499999999999999
r8579 n5758 n5759 0.22916666666666666
r8580 n5729 n5760 0.037499999999999999
r8581 n5730 n5761 0.014999999999999999
r8582 n5760 n5761 0.72916666666666663
r8583 n5731 n5762 0.375
r8584 n5761 n5762 0.54166666666666663
r8585 n5732 n5763 0.013392857142857142
r8586 n5762 n5763 0.60416666666666663
r8587 n5733 n5764 0.375
r8588 n5763 n5764 0.60416666666666663
r8589 n5734 n5765 0.014999999999999999
r8590 n5764 n5765 0.54166666666666663
r8591 n5735 n5766 0.037499999999999999
r8592 n5765 n5766 0.72916666666666663
r8593 n5736 n5767 0.01893939393939394
r8594 n5737 n5768 0.3125
r8595 n5767 n5768 0.3125
r8596 n5738 n5769 0.020833333333333332
r8597 n5768 n5769 0.2857142857142857
r8598 n5739 n5770 0.3125
r8599 n5769 n5770 0.2857142857142857
r8600 n5740 n5771 0.01893939393939394
r8601 n5770 n5771 0.3125
r8602 n5741 n5772 0.0625
r8603 n5742 n5773 0.125
r8604 n5772 n5773 0.13392857142857142
r8605 n5743 n5774 0.125
r8606 n5773 n5774 0.089285714285714288
r8607 n5744 n5775 0.625
r8608 n5774 n5775 0.053571428571428568
r8609 n5745 n5776 0.20833333333333334
r8610 n5775 n5776 0.035714285714285712
r8611 n5746 n5777 0.625
r8612 n5776 n5777 0.035714285714285712
r8613 n5747 n5778 0.069444444444444448
r8614 n5777 n5778 0.089285714285714288
r8615 n5748 n5779 0.0625
r8616 n5778 n5779 0.16964285714285715
r8617 n5749 n5780 0.125
r8618 n5779 n5780 0.13392857142857142
r8619 n5750 n5781 0.125
r8620 n5780 n5781 0.089285714285714288
r8621 n5751 n5782 0.625
r8622 n5781 n5782 0.053571428571428568
r8623 n5752 n5783 0.3125
r8624 n5782 n5783 0.026785714285714284
r8625 n5753 n5784 0.625
r8626 n5783 n5784 0.026785714285714284
r8627 n5754 n5785 0.625
r8628 n5784 n5785 0.017857142857142856
r8629 n5755 n5786 0.625
r8630 n5785 n5786 0.017857142857142856
r8631 n5756 n5787 0.15625
r8632 n5786 n5787 0.044642857142857144
r8633 n5757 n5788 0.125
r8634 n5787 n5788 0.080357142857142863
r8635 n5758 n5789 0.625
r8636 n5788 n5789 0.053571428571428568
r8637 n5759 n5790 0.0625
r8638 n5789 n5790 0.098214285714285712
r8639 n5760 n5791 0.0625
r8640 n5761 n5792 0.025000000000000001
r8641 n5791 n5792 0.3125
r8642 n5762 n5793 0.625
r8643 n5792 n5793 0.23214285714285715
r8644 n5763 n5794 0.022321428571428572
r8645 n5793 n5794 0.25892857142857145
r8646 n5764 n5795 0.625
r8647 n5794 n5795 0.25892857142857145
r8648 n5765 n5796 0.025000000000000001
r8649 n5795 n5796 0.23214285714285715
r8650 n5766 n5797 0.0625
r8651 n5796 n5797 0.3125
r8652 n5767 n5798 0.028409090909090908
r8653 n5768 n5799 0.46875
r8654 n5798 n5799 0.2734375
r8655 n5769 n5800 0.03125
r8656 n5799 n5800 0.25
r8657 n5770 n5801 0.46875
r8658 n5800 n5801 0.25
r8659 n5771 n5802 0.028409090909090908
r8660 n5801 n5802 0.2734375
r8661 n5772 n5803 0.09375
r8662 n5773 n5804 0.1875
r8663 n5803 n5804 0.1171875
r8664 n5774 n5805 0.1875
r8665 n5804 n5805 0.078125
r8666 n5775 n5806 0.9375
r8667 n5805 n5806 0.046875
r8668 n5776 n5807 0.3125
r8669 n5806 n5807 0.03125
r8670 n5777 n5808 0.9375
r8671 n5807 n5808 0.03125
r8672 n5778 n5809 0.10416666666666667
r8673 n5808 n5809 0.078125
r8674 n5779 n5810 0.09375
r8675 n5809 n5810 0.1484375
r8676 n5780 n5811 0.1875
r8677 n5810 n5811 0.1171875
r8678 n5781 n5812 0.1875
r8679 n5811 n5812 0.078125
r8680 n5782 n5813 0.9375
r8681 n5812 n5813 0.046875
r8682 n5783 n5814 0.46875
r8683 n5813 n5814 0.0234375
r8684 n5784 n5815 0.9375
r8685 n5814 n5815 0.0234375
r8686 n5785 n5816 0.9375
r8687 n5815 n5816 0.015625
r8688 n5786 n5817 0.9375
r8689 n5816 n5817 0.015625
r8690 n5787 n5818 0.234375
r8691 n5817 n5818 0.0390625
r8692 n5788 n5819 0.1875
r8693 n5818 n5819 0.0703125
r8694 n5789 n5820 0.9375
r8695 n5819 n5820 0.046875
r8696 n5790 n5821 0.09375
r8697 n5820 n5821 0.0859375
r8698 n5791 n5822 0.09375
r8699 n5792 n5823 0.037499999999999999
r8700 n5822 n5823 0.2734375
r8701 n5793 n5824 0.9375
r8702 n5823 n5824 0.203125
r8703 n5794 n5825 0.033482142857142856
r8704 n5824 n5825 0.2265625
r8705 n5795 n5826 0.9375
r8706 n5825 n5826 0.2265625
r8707 n5796 n5827 0.037499999999999999
r8708 n5826 n5827 0.203125
r8709 n5797 n5828 0.09375
r8710 n5827 n5828 0.2734375
r8711 n5798 n5829 0.01893939393939394
r8712 n5799 n5830 0.3125
r8713 n5829 n5830 1.09375
r8714 n5800 n5831 0.020833333333333332
r8715 n5830 n5831 1
r8716 n5801 n5832 0.3125
r8717 n5831 n5832 1
r8718 n5802 n5833 0.01893939393939394
r8719 n5832 n5833 1.09375
r8720 n5803 n5834 0.0625
r8721 n5804 n5835 0.125
r8722 n5834 n5835 0.46875
r8723 n5805 n5836 0.125
r8724 n5835 n5836 0.3125
r8725 n5806 n5837 0.625
r8726 n5836 n5837 0.1875
r8727 n5807 n5838 0.20833333333333334
r8728 n5837 n5838 0.125
r8729 n5808 n5839 0.625
r8730 n5838 n5839 0.125
r8731 n5809 n5840 0.069444444444444448
r8732 n5839 n5840 0.3125
r8733 n5810 n5841 0.0625
r8734 n5840 n5841 0.59375
r8735 n5811 n5842 0.125
r8736 n5841 n5842 0.46875
r8737 n5812 n5843 0.125
r8738 n5842 n5843 0.3125
r8739 n5813 n5844 0.625
r8740 n5843 n5844 0.1875
r8741 n5814 n5845 0.3125
r8742 n5844 n5845 0.09375
r8743 n5815 n5846 0.625
r8744 n5845 n5846 0.09375
r8745 n5816 n5847 0.625
r8746 n5846 n5847 0.0625
r8747 n5817 n5848 0.625
r8748 n5847 n5848 0.0625
r8749 n5818 n5849 0.15625
r8750 n5848 n5849 0.15625
r8751 n5819 n5850 0.125
r8752 n5849 n5850 0.28125
r8753 n5820 n5851 0.625
r8754 n5850 n5851 0.1875
r8755 n5821 n5852 0.0625
r8756 n5851 n5852 0.34375
r8757 n5822 n5853 0.0625
r8758 n5823 n5854 0.025000000000000001
r8759 n5853 n5854 1.09375
r8760 n5824 n5855 0.625
r8761 n5854 n5855 0.8125
r8762 n5825 n5856 0.022321428571428572
r8763 n5855 n5856 0.90625
r8764 n5826 n5857 0.625
r8765 n5856 n5857 0.90625
r8766 n5827 n5858 0.025000000000000001
r8767 n5857 n5858 0.8125
r8768 n5828 n5859 0.0625
r8769 n5858 n5859 1.09375
r8770 n5829 n5860 0.064393939393939392
r8771 n5830 n5861 1.0625
r8772 n5860 n5861 0.068359375
r8773 n5831 n5862 0.070833333333333331
r8774 n5861 n5862 0.0625
r8775 n5832 n5863 1.0625
r8776 n5862 n5863 0.0625
r8777 n5833 n5864 0.064393939393939392
r8778 n5863 n5864 0.068359375
r8779 n5853 n5865 0.21249999999999999
r8780 n5854 n5866 0.085000000000000006
r8781 n5865 n5866 0.068359375
r8782 n5855 n5867 2.125
r8783 n5866 n5867 0.05078125
r8784 n5856 n5868 0.075892857142857137
r8785 n5867 n5868 0.056640625
r8786 n5857 n5869 2.125
r8787 n5868 n5869 0.056640625
r8788 n5858 n5870 0.085000000000000006
r8789 n5869 n5870 0.05078125
r8790 n5859 n5871 0.21249999999999999
r8791 n5870 n5871 0.068359375
r8792 n5860 n5872 0.14962121212121213
r8793 n5861 n5873 2.46875
r8794 n5872 n5873 0.046542553191489359
r8795 n5862 n5874 0.16458333333333333
r8796 n5873 n5874 0.042553191489361701
r8797 n5863 n5875 2.46875
r8798 n5874 n5875 0.042553191489361701
r8799 n5864 n5876 0.14962121212121213
r8800 n5875 n5876 0.046542553191489359
r8801 n5865 n5877 0.49375000000000002
r8802 n5866 n5878 0.19750000000000001
r8803 n5877 n5878 0.046542553191489359
r8804 n5867 n5879 4.9375
r8805 n5878 n5879 0.034574468085106384
r8806 n5868 n5880 0.17633928571428573
r8807 n5879 n5880 0.038563829787234043
r8808 n5869 n5881 4.9375
r8809 n5880 n5881 0.038563829787234043
r8810 n5870 n5882 0.19750000000000001
r8811 n5881 n5882 0.034574468085106384
r8812 n5871 n5883 0.49375000000000002
r8813 n5882 n5883 0.046542553191489359
r8814 n5872 n5884 0.15340909090909091
r8815 n5873 n5885 2.53125
r8816 n5884 n5885 0.064338235294117641
r8817 n5874 n5886 0.16875000000000001
r8818 n5885 n5886 0.058823529411764705
r8819 n5875 n5887 2.53125
r8820 n5886 n5887 0.058823529411764705
r8821 n5876 n5888 0.15340909090909091
r8822 n5887 n5888 0.064338235294117641
r8823 n5877 n5889 0.50624999999999998
r8824 n5878 n5890 0.20250000000000001
r8825 n5889 n5890 0.064338235294117641
r8826 n5879 n5891 5.0625
r8827 n5890 n5891 0.04779411764705882
r8828 n5880 n5892 0.18080357142857142
r8829 n5891 n5892 0.053308823529411763
r8830 n5881 n5893 5.0625
r8831 n5892 n5893 0.053308823529411763
r8832 n5882 n5894 0.20250000000000001
r8833 n5893 n5894 0.04779411764705882
r8834 n5883 n5895 0.50624999999999998
r8835 n5894 n5895 0.064338235294117641
r8836 n5884 n5896 0.15643939393939393
r8837 n5885 n5897 2.5812499999999998
r8838 n5896 n5897 0.045010288065843625
r8839 n5886 n5898 0.17208333333333334
r8840 n5897 n5898 0.041152263374485597
r8841 n5887 n5899 2.5812499999999998
r8842 n5898 n5899 0.041152263374485597
r8843 n5888 n5900 0.15643939393939393
r8844 n5899 n5900 0.045010288065843625
r8845 n5889 n5901 0.51624999999999999
r8846 n5890 n5902 0.20649999999999999
r8847 n5901 n5902 0.045010288065843625
r8848 n5891 n5903 5.1624999999999996
r8849 n5902 n5903 0.033436213991769548
r8850 n5892 n5904 0.18437500000000001
r8851 n5903 n5904 0.037294238683127569
r8852 n5893 n5905 5.1624999999999996
r8853 n5904 n5905 0.037294238683127569
r8854 n5894 n5906 0.20649999999999999
r8855 n5905 n5906 0.033436213991769548
r8856 n5895 n5907 0.51624999999999999
r8857 n5906 n5907 0.045010288065843625
r8858 n5896 n5908 0.18446969696969698
r8859 n5897 n5909 3.0437500000000002
r8860 n5908 n5909 0.044825819672131145
r8861 n5898 n5910 0.20291666666666666
r8862 n5909 n5910 0.040983606557377046
r8863 n5899 n5911 3.0437500000000002
r8864 n5910 n5911 0.040983606557377046
r8865 n5900 n5912 0.18446969696969698
r8866 n5911 n5912 0.044825819672131145
r8867 n5901 n5913 0.60875000000000001
r8868 n5902 n5914 0.24349999999999999
r8869 n5913 n5914 0.044825819672131145
r8870 n5903 n5915 6.0875000000000004
r8871 n5914 n5915 0.033299180327868855
r8872 n5904 n5916 0.21741071428571429
r8873 n5915 n5916 0.037141393442622954
r8874 n5905 n5917 6.0875000000000004
r8875 n5916 n5917 0.037141393442622954
r8876 n5906 n5918 0.24349999999999999
r8877 n5917 n5918 0.033299180327868855
r8878 n5907 n5919 0.60875000000000001
r8879 n5918 n5919 0.044825819672131145
r8880 n5908 n5920 0.18446969696969698
r8881 n5909 n5921 3.0437500000000002
r8882 n5920 n5921 0.045010288065843625
r8883 n5910 n5922 0.20291666666666666
r8884 n5921 n5922 0.041152263374485597
r8885 n5911 n5923 3.0437500000000002
r8886 n5922 n5923 0.041152263374485597
r8887 n5912 n5924 0.18446969696969698
r8888 n5923 n5924 0.045010288065843625
r8889 n5913 n5925 0.60875000000000001
r8890 n5914 n5926 0.24349999999999999
r8891 n5925 n5926 0.045010288065843625
r8892 n5915 n5927 6.0875000000000004
r8893 n5926 n5927 0.033436213991769548
r8894 n5916 n5928 0.21741071428571429
r8895 n5927 n5928 0.037294238683127569
r8896 n5917 n5929 6.0875000000000004
r8897 n5928 n5929 0.037294238683127569
r8898 n5918 n5930 0.24349999999999999
r8899 n5929 n5930 0.033436213991769548
r8900 n5919 n5931 0.60875000000000001
r8901 n5930 n5931 0.045010288065843625
r8902 n5920 n5932 0.18409090909090908
r8903 n5921 n5933 3.0375000000000001
r8904 n5932 n5933 0.045010288065843625
r8905 n5922 n5934 0.20250000000000001
r8906 n5933 n5934 0.041152263374485597
r8907 n5923 n5935 3.0375000000000001
r8908 n5934 n5935 0.041152263374485597
r8909 n5924 n5936 0.18409090909090908
r8910 n5935 n5936 0.045010288065843625
r8911 n5925 n5937 0.60750000000000004
r8912 n5926 n5938 0.24299999999999999
r8913 n5937 n5938 0.045010288065843625
r8914 n5927 n5939 6.0750000000000002
r8915 n5938 n5939 0.033436213991769548
r8916 n5928 n5940 0.21696428571428572
r8917 n5939 n5940 0.037294238683127569
r8918 n5929 n5941 6.0750000000000002
r8919 n5940 n5941 0.037294238683127569
r8920 n5930 n5942 0.24299999999999999
r8921 n5941 n5942 0.033436213991769548
r8922 n5931 n5943 0.60750000000000004
r8923 n5942 n5943 0.045010288065843625
r8924 n5932 n5944 0.18446969696969698
r8925 n5933 n5945 3.0437500000000002
r8926 n5944 n5945 0.044825819672131145
r8927 n5934 n5946 0.20291666666666666
r8928 n5945 n5946 0.040983606557377046
r8929 n5935 n5947 3.0437500000000002
r8930 n5946 n5947 0.040983606557377046
r8931 n5936 n5948 0.18446969696969698
r8932 n5947 n5948 0.044825819672131145
r8933 n5937 n5949 0.60875000000000001
r8934 n5938 n5950 0.24349999999999999
r8935 n5949 n5950 0.044825819672131145
r8936 n5939 n5951 6.0875000000000004
r8937 n5950 n5951 0.033299180327868855
r8938 n5940 n5952 0.21741071428571429
r8939 n5951 n5952 0.037141393442622954
r8940 n5941 n5953 6.0875000000000004
r8941 n5952 n5953 0.037141393442622954
r8942 n5942 n5954 0.24349999999999999
r8943 n5953 n5954 0.033299180327868855
r8944 n5943 n5955 0.60875000000000001
r8945 n5954 n5955 0.044825819672131145
r8946 n5944 n5956 0.18446969696969698
r8947 n5945 n5957 3.0437500000000002
r8948 n5956 n5957 0.045010288065843625
r8949 n5946 n5958 0.20291666666666666
r8950 n5957 n5958 0.041152263374485597
r8951 n5947 n5959 3.0437500000000002
r8952 n5958 n5959 0.041152263374485597
r8953 n5948 n5960 0.18446969696969698
r8954 n5959 n5960 0.045010288065843625
r8955 n5949 n5961 0.60875000000000001
r8956 n5950 n5962 0.24349999999999999
r8957 n5961 n5962 0.045010288065843625
r8958 n5951 n5963 6.0875000000000004
r8959 n5962 n5963 0.033436213991769548
r8960 n5952 n5964 0.21741071428571429
r8961 n5963 n5964 0.037294238683127569
r8962 n5953 n5965 6.0875000000000004
r8963 n5964 n5965 0.037294238683127569
r8964 n5954 n5966 0.24349999999999999
r8965 n5965 n5966 0.033436213991769548
r8966 n5955 n5967 0.60875000000000001
r8967 n5966 n5967 0.045010288065843625
r8968 n5956 n5968 0.09583333333333334
r8969 n5957 n5969 1.58125
r8970 n5968 n5969 1.09375
r8971 n5958 n5970 0.10541666666666667
r8972 n5969 n5970 1
r8973 n5959 n5971 1.58125
r8974 n5970 n5971 1
r8975 n5960 n5972 0.09583333333333334
r8976 n5971 n5972 1.09375
r8977 n5973 n5974 0.78125
r8978 n5974 n5975 1
r8979 n5975 n5976 1
r8980 n5976 n5977 0.78125
r8981 n5961 n5978 0.31624999999999998
r8982 n5962 n5979 0.1265
r8983 n5978 n5979 1.09375
r8984 n5963 n5980 3.1625000000000001
r8985 n5979 n5980 0.8125
r8986 n5964 n5981 0.11294642857142857
r8987 n5980 n5981 0.90625
r8988 n5965 n5982 3.1625000000000001
r8989 n5981 n5982 0.90625
r8990 n5966 n5983 0.1265
r8991 n5982 n5983 0.8125
r8992 n5967 n5984 0.31624999999999998
r8993 n5983 n5984 1.09375
r8994 n5968 n5985 0.02462121212121212
r8995 n5969 n5986 0.40625
r8996 n5985 n5986 0.19886363636363635
r8997 n5970 n5987 0.027083333333333334
r8998 n5986 n5987 0.18181818181818182
r8999 n5971 n5988 0.40625
r9000 n5987 n5988 0.18181818181818182
r9001 n5972 n5989 0.02462121212121212
r9002 n5988 n5989 0.19886363636363635
r9003 n5989 n5990 0.24431818181818182
r9004 n5990 n5991 0.28977272727272729
r9005 n5991 n5992 0.46590909090909088
r9006 n5992 n5993 0.46590909090909088
r9007 n5993 n5994 0.42613636363636365
r9008 n5994 n5995 0.34886363636363638
r9009 n5995 n5996 0.3125
r9010 n5996 n5997 0.34999999999999998
r9011 n5997 n5998 0.26704545454545453
r9012 n5998 n5999 0.30113636363636365
r9013 n5999 n6000 0.23295454545454544
r9014 n6000 n6001 0.19318181818181818
r9015 n6001 n6002 0.19318181818181818
r9016 n6002 n6003 0.13636363636363635
r9017 n6003 n6004 0.15340909090909091
r9018 n6004 n6005 0.056818181818181816
r9019 n6005 n6006 0.0625
r9020 n6006 n6007 0.034090909090909088
r9021 n6007 n6008 0.079545454545454544
r9022 n6008 n6009 0.13068181818181818
r9023 n6009 n6010 0.085227272727272721
r9024 n6010 n6011 0.056818181818181816
r9025 n6011 n6012 0.034090909090909088
r9026 n6012 n6013 0.022727272727272728
r9027 n6013 n6014 0.022727272727272728
r9028 n6014 n6015 0.056818181818181816
r9029 n6015 n6016 0.10795454545454546
r9030 n6016 n6017 0.085227272727272721
r9031 n6017 n6018 0.056818181818181816
r9032 n6018 n6019 0.034090909090909088
r9033 n6019 n6020 0.017045454545454544
r9034 n6020 n6021 0.017045454545454544
r9035 n6021 n6022 0.011363636363636364
r9036 n6022 n6023 0.011363636363636364
r9037 n6023 n6024 0.028409090909090908
r9038 n6024 n6025 0.05113636363636364
r9039 n6025 n6026 0.034090909090909088
r9040 n6026 n6027 0.0625
r9041 n6027 n6028 0.073863636363636367
r9042 n6028 n6029 0.05113636363636364
r9043 n6029 n6030 0.045454545454545456
r9044 n6030 n6031 0.017045454545454544
r9045 n6031 n6032 0.011363636363636364
r9046 n6032 n6033 0.039772727272727272
r9047 n6033 n6034 0.0625
r9048 n6034 n6035 0.034090909090909088
r9049 n6035 n6036 0.028409090909090908
r9050 n6036 n6037 0.05113636363636364
r9051 n6037 n6038 0.045454545454545456
r9052 n6038 n6039 0.056818181818181816
r9053 n6039 n6040 0.073863636363636367
r9054 n6040 n6041 0.090909090909090912
r9055 n6041 n6042 0.079545454545454544
r9056 n6042 n6043 0.0625
r9057 n6043 n6044 0.090909090909090912
r9058 n6044 n6045 0.073863636363636367
r9059 n6045 n6046 0.068181818181818177
r9060 n6046 n6047 0.073863636363636367
r9061 n6047 n6048 0.0625
r9062 n6048 n6049 0.045454545454545456
r9063 n6049 n6050 0.10795454545454546
r9064 n6050 n6051 0.17045454545454544
r9065 n6051 n6052 0.085227272727272721
r9066 n6052 n6053 0.022727272727272728
r9067 n6053 n6054 0.034090909090909088
r9068 n6054 n6055 0.05113636363636364
r9069 n6055 n6056 0.073863636363636367
r9070 n6056 n6057 0.068181818181818177
r9071 n6057 n6058 0.096590909090909088
r9072 n6058 n6059 0.11363636363636363
r9073 n6059 n6060 0.19318181818181818
r9074 n6060 n6061 0.16477272727272727
r9075 n6061 n6062 0.039772727272727272
r9076 n6062 n6063 0.18181818181818182
r9077 n6063 n6064 0.16477272727272727
r9078 n6064 n6065 0.19318181818181818
r9079 n6065 n6066 0.375
r9080 n6066 n6067 0.38636363636363635
r9081 n6067 n6068 0.38636363636363635
r9082 n6068 n6069 0.38636363636363635
r9083 n6069 n6070 0.38636363636363635
r9084 n6070 n6071 0.38636363636363635
r9085 n6071 n6072 0.38636363636363635
r9086 n6072 n6073 0.38636363636363635
r9087 n6073 n6074 0.38636363636363635
r9088 n6074 n6075 0.38636363636363635
r9089 n6075 n6076 0.38636363636363635
r9090 n6076 n6077 0.38636363636363635
r9091 n6077 n6078 0.38636363636363635
r9092 n6078 n6079 0.38636363636363635
r9093 n6079 n6080 0.38636363636363635
r9094 n6080 n6081 0.38636363636363635
r9095 n6081 n6082 0.38636363636363635
r9096 n6082 n6083 0.38636363636363635
r9097 n6083 n6084 0.38636363636363635
r9098 n6084 n6085 0.38636363636363635
r9099 n6085 n6086 0.38636363636363635
r9100 n6086 n6087 0.38636363636363635
r9101 n6087 n6088 0.25568181818181818
r9102 n5973 n6089 0.035326086956521736
r9103 n6088 n6089 0.19318181818181818
r9104 n5974 n6090 0.40625
r9105 n6089 n6090 0.14204545454545456
r9106 n5975 n6091 0.027083333333333334
r9107 n6090 n6091 0.18181818181818182
r9108 n5976 n6092 0.40625
r9109 n6091 n6092 0.18181818181818182
r9110 n5977 n6093 0.035326086956521736
r9111 n6092 n6093 0.14204545454545456
r9112 n5978 n6094 0.081250000000000003
r9113 n5979 n6095 0.032500000000000001
r9114 n6094 n6095 0.19886363636363635
r9115 n5980 n6096 0.8125
r9116 n6095 n6096 0.14772727272727273
r9117 n5981 n6097 0.029017857142857144
r9118 n6096 n6097 0.16477272727272727
r9119 n5982 n6098 0.8125
r9120 n6097 n6098 0.16477272727272727
r9121 n5983 n6099 0.032500000000000001
r9122 n6098 n6099 0.14772727272727273
r9123 n5984 n6100 0.081250000000000003
r9124 n6099 n6100 0.19886363636363635
r9125 n5985 n6101 0.02462121212121212
r9126 n5986 n6102 0.40625
r9127 n6101 n6102 1.09375
r9128 n5987 n6103 0.027083333333333334
r9129 n6102 n6103 1
r9130 n5988 n6104 0.40625
r9131 n6103 n6104 1
r9132 n5989 n6105 0.02462121212121212
r9133 n6104 n6105 1.09375
r9134 n5990 n6106 0.081250000000000003
r9135 n6105 n6106 1.34375
r9136 n5991 n6107 0.019817073170731708
r9137 n6106 n6107 1.59375
r9138 n5992 n6108 0.019817073170731708
r9139 n6107 n6108 2.5625
r9140 n5993 n6109 0.019817073170731708
r9141 n6108 n6109 2.5625
r9142 n5994 n6110 0.02389705882352941
r9143 n6109 n6110 2.34375
r9144 n5995 n6111 0.029653284671532845
r9145 n6110 n6111 1.91875
r9146 n5996 n6112 0.029438405797101448
r9147 n6111 n6112 1.71875
r9148 n5997 n6113 0.02389705882352941
r9149 n6112 n6113 1.925
r9150 n5998 n6114 0.0625
r9151 n6113 n6114 1.46875
r9152 n5999 n6115 0.020312500000000001
r9153 n6114 n6115 1.65625
r9154 n6000 n6116 0.8125
r9155 n6115 n6116 1.28125
r9156 n6001 n6117 0.02462121212121212
r9157 n6116 n6117 1.0625
r9158 n6002 n6118 0.8125
r9159 n6117 n6118 1.0625
r9160 n6003 n6119 0.035326086956521736
r9161 n6118 n6119 0.75
r9162 n6004 n6120 0.203125
r9163 n6119 n6120 0.84375
r9164 n6005 n6121 0.13541666666666666
r9165 n6120 n6121 0.3125
r9166 n6006 n6122 0.16250000000000001
r9167 n6121 n6122 0.34375
r9168 n6007 n6123 0.8125
r9169 n6122 n6123 0.1875
r9170 n6008 n6124 0.0625
r9171 n6123 n6124 0.4375
r9172 n6009 n6125 0.081250000000000003
r9173 n6124 n6125 0.71875
r9174 n6010 n6126 0.16250000000000001
r9175 n6125 n6126 0.46875
r9176 n6011 n6127 0.16250000000000001
r9177 n6126 n6127 0.3125
r9178 n6012 n6128 0.8125
r9179 n6127 n6128 0.1875
r9180 n6013 n6129 0.27083333333333331
r9181 n6128 n6129 0.125
r9182 n6014 n6130 0.8125
r9183 n6129 n6130 0.125
r9184 n6015 n6131 0.090277777777777776
r9185 n6130 n6131 0.3125
r9186 n6016 n6132 0.081250000000000003
r9187 n6131 n6132 0.59375
r9188 n6017 n6133 0.16250000000000001
r9189 n6132 n6133 0.46875
r9190 n6018 n6134 0.16250000000000001
r9191 n6133 n6134 0.3125
r9192 n6019 n6135 0.8125
r9193 n6134 n6135 0.1875
r9194 n6020 n6136 0.40625
r9195 n6135 n6136 0.09375
r9196 n6021 n6137 0.8125
r9197 n6136 n6137 0.09375
r9198 n6022 n6138 0.8125
r9199 n6137 n6138 0.0625
r9200 n6023 n6139 0.8125
r9201 n6138 n6139 0.0625
r9202 n6024 n6140 0.203125
r9203 n6139 n6140 0.15625
r9204 n6025 n6141 0.16250000000000001
r9205 n6140 n6141 0.28125
r9206 n6026 n6142 0.8125
r9207 n6141 n6142 0.1875
r9208 n6027 n6143 0.081250000000000003
r9209 n6142 n6143 0.34375
r9210 n6028 n6144 0.27083333333333331
r9211 n6143 n6144 0.40625
r9212 n6029 n6145 0.13541666666666666
r9213 n6144 n6145 0.28125
r9214 n6030 n6146 0.40625
r9215 n6145 n6146 0.25
r9216 n6031 n6147 0.8125
r9217 n6146 n6147 0.09375
r9218 n6032 n6148 0.8125
r9219 n6147 n6148 0.0625
r9220 n6033 n6149 0.13541666666666666
r9221 n6148 n6149 0.21875
r9222 n6034 n6150 0.16250000000000001
r9223 n6149 n6150 0.34375
r9224 n6035 n6151 0.8125
r9225 n6150 n6151 0.1875
r9226 n6036 n6152 0.203125
r9227 n6151 n6152 0.15625
r9228 n6037 n6153 0.16250000000000001
r9229 n6152 n6153 0.28125
r9230 n6038 n6154 0.27083333333333331
r9231 n6153 n6154 0.25
r9232 n6039 n6155 0.11607142857142858
r9233 n6154 n6155 0.3125
r9234 n6040 n6156 0.13541666666666666
r9235 n6155 n6156 0.40625
r9236 n6041 n6157 0.081250000000000003
r9237 n6156 n6157 0.5
r9238 n6042 n6158 0.203125
r9239 n6157 n6158 0.4375
r9240 n6043 n6159 0.11607142857142858
r9241 n6158 n6159 0.34375
r9242 n6044 n6160 0.090277777777777776
r9243 n6159 n6160 0.5
r9244 n6045 n6161 0.203125
r9245 n6160 n6161 0.40625
r9246 n6046 n6162 0.1015625
r9247 n6161 n6162 0.375
r9248 n6047 n6163 0.16250000000000001
r9249 n6162 n6163 0.40625
r9250 n6048 n6164 0.13541666666666666
r9251 n6163 n6164 0.34375
r9252 n6049 n6165 0.40625
r9253 n6164 n6165 0.25
r9254 n6050 n6166 0.04779411764705882
r9255 n6165 n6166 0.59375
r9256 n6051 n6167 0.0625
r9257 n6166 n6167 0.9375
r9258 n6052 n6168 0.40625
r9259 n6167 n6168 0.46875
r9260 n6053 n6169 0.40625
r9261 n6168 n6169 0.125
r9262 n6054 n6170 0.203125
r9263 n6169 n6170 0.1875
r9264 n6055 n6171 0.16250000000000001
r9265 n6170 n6171 0.28125
r9266 n6056 n6172 0.1015625
r9267 n6171 n6172 0.40625
r9268 n6057 n6173 0.203125
r9269 n6172 n6173 0.375
r9270 n6058 n6174 0.0625
r9271 n6173 n6174 0.53125
r9272 n6059 n6175 0.11607142857142858
r9273 n6174 n6175 0.625
r9274 n6060 n6176 0.030092592592592591
r9275 n6175 n6176 1.0625
r9276 n6061 n6177 0.40625
r9277 n6176 n6177 0.90625
r9278 n6062 n6178 0.16250000000000001
r9279 n6177 n6178 0.21875
r9280 n6063 n6179 0.030092592592592591
r9281 n6178 n6179 1
r9282 n6064 n6180 0.40625
r9283 n6179 n6180 0.90625
r9284 n6065 n6181 0.025390625
r9285 n6180 n6181 1.0625
r9286 n6066 n6182 0.02389705882352941
r9287 n6181 n6182 2.0625
r9288 n6067 n6183 0.02389705882352941
r9289 n6182 n6183 2.125
r9290 n6068 n6184 0.02389705882352941
r9291 n6183 n6184 2.125
r9292 n6069 n6185 0.02389705882352941
r9293 n6184 n6185 2.125
r9294 n6070 n6186 0.02389705882352941
r9295 n6185 n6186 2.125
r9296 n6071 n6187 0.02389705882352941
r9297 n6186 n6187 2.125
r9298 n6072 n6188 0.02389705882352941
r9299 n6187 n6188 2.125
r9300 n6073 n6189 0.02389705882352941
r9301 n6188 n6189 2.125
r9302 n6074 n6190 0.02389705882352941
r9303 n6189 n6190 2.125
r9304 n6075 n6191 0.02389705882352941
r9305 n6190 n6191 2.125
r9306 n6076 n6192 0.02389705882352941
r9307 n6191 n6192 2.125
r9308 n6077 n6193 0.02389705882352941
r9309 n6192 n6193 2.125
r9310 n6078 n6194 0.02389705882352941
r9311 n6193 n6194 2.125
r9312 n6079 n6195 0.02389705882352941
r9313 n6194 n6195 2.125
r9314 n6080 n6196 0.02389705882352941
r9315 n6195 n6196 2.125
r9316 n6081 n6197 0.02389705882352941
r9317 n6196 n6197 2.125
r9318 n6082 n6198 0.02389705882352941
r9319 n6197 n6198 2.125
r9320 n6083 n6199 0.02389705882352941
r9321 n6198 n6199 2.125
r9322 n6084 n6200 0.02389705882352941
r9323 n6199 n6200 2.125
r9324 n6085 n6201 0.02389705882352941
r9325 n6200 n6201 2.125
r9326 n6086 n6202 0.02389705882352941
r9327 n6201 n6202 2.125
r9328 n6087 n6203 0.02389705882352941
r9329 n6202 n6203 2.125
r9330 n6088 n6204 0.073863636363636367
r9331 n6203 n6204 1.40625
r9332 n6089 n6205 0.035326086956521736
r9333 n6204 n6205 1.0625
r9334 n6090 n6206 0.40625
r9335 n6205 n6206 0.78125
r9336 n6091 n6207 0.027083333333333334
r9337 n6206 n6207 1
r9338 n6092 n6208 0.40625
r9339 n6207 n6208 1
r9340 n6093 n6209 0.035326086956521736
r9341 n6208 n6209 0.78125
r9342 n6094 n6210 0.081250000000000003
r9343 n6095 n6211 0.032500000000000001
r9344 n6210 n6211 1.09375
r9345 n6096 n6212 0.8125
r9346 n6211 n6212 0.8125
r9347 n6097 n6213 0.029017857142857144
r9348 n6212 n6213 0.90625
r9349 n6098 n6214 0.8125
r9350 n6213 n6214 0.90625
r9351 n6099 n6215 0.032500000000000001
r9352 n6214 n6215 0.8125
r9353 n6100 n6216 0.081250000000000003
r9354 n6215 n6216 1.09375
r9355 n6101 n6217 0.060606060606060608
r9356 n6102 n6218 1
r9357 n6217 n6218 0.072916666666666671
r9358 n6103 n6219 0.066666666666666666
r9359 n6218 n6219 0.066666666666666666
r9360 n6104 n6220 1
r9361 n6219 n6220 0.066666666666666666
r9362 n6105 n6221 0.060606060606060608
r9363 n6220 n6221 0.072916666666666671
r9364 n6106 n6222 0.20000000000000001
r9365 n6221 n6222 0.089583333333333334
r9366 n6107 n6223 0.04878048780487805
r9367 n6222 n6223 0.10625
r9368 n6108 n6224 0.04878048780487805
r9369 n6223 n6224 0.17083333333333334
r9370 n6109 n6225 0.04878048780487805
r9371 n6224 n6225 0.17083333333333334
r9372 n6110 n6226 0.058823529411764705
r9373 n6225 n6226 0.15625
r9374 n6111 n6227 0.072992700729927001
r9375 n6226 n6227 0.12791666666666668
r9376 n6112 n6228 0.072463768115942032
r9377 n6227 n6228 0.11458333333333333
r9378 n6113 n6229 0.058823529411764705
r9379 n6228 n6229 0.12833333333333333
r9380 n6114 n6230 0.15384615384615385
r9381 n6229 n6230 0.097916666666666666
r9382 n6115 n6231 0.050000000000000003
r9383 n6230 n6231 0.11041666666666666
r9384 n6116 n6232 2
r9385 n6231 n6232 0.085416666666666669
r9386 n6117 n6233 0.060606060606060608
r9387 n6232 n6233 0.070833333333333331
r9388 n6118 n6234 2
r9389 n6233 n6234 0.070833333333333331
r9390 n6119 n6235 0.086956521739130432
r9391 n6234 n6235 0.050000000000000003
r9392 n6120 n6236 0.5
r9393 n6235 n6236 0.056250000000000001
r9394 n6121 n6237 0.33333333333333331
r9395 n6236 n6237 0.020833333333333332
r9396 n6122 n6238 0.40000000000000002
r9397 n6237 n6238 0.022916666666666665
r9398 n6123 n6239 2
r9399 n6238 n6239 0.012500000000000001
r9400 n6124 n6240 0.15384615384615385
r9401 n6239 n6240 0.029166666666666667
r9402 n6125 n6241 0.20000000000000001
r9403 n6240 n6241 0.04791666666666667
r9404 n6126 n6242 0.40000000000000002
r9405 n6241 n6242 0.03125
r9406 n6127 n6243 0.40000000000000002
r9407 n6242 n6243 0.020833333333333332
r9408 n6128 n6244 2
r9409 n6243 n6244 0.012500000000000001
r9410 n6129 n6245 0.66666666666666663
r9411 n6244 n6245 0.0083333333333333332
r9412 n6130 n6246 2
r9413 n6245 n6246 0.0083333333333333332
r9414 n6131 n6247 0.22222222222222221
r9415 n6246 n6247 0.020833333333333332
r9416 n6132 n6248 0.20000000000000001
r9417 n6247 n6248 0.039583333333333331
r9418 n6133 n6249 0.40000000000000002
r9419 n6248 n6249 0.03125
r9420 n6134 n6250 0.40000000000000002
r9421 n6249 n6250 0.020833333333333332
r9422 n6135 n6251 2
r9423 n6250 n6251 0.012500000000000001
r9424 n6136 n6252 1
r9425 n6251 n6252 0.0062500000000000003
r9426 n6137 n6253 2
r9427 n6252 n6253 0.0062500000000000003
r9428 n6138 n6254 2
r9429 n6253 n6254 0.0041666666666666666
r9430 n6139 n6255 2
r9431 n6254 n6255 0.0041666666666666666
r9432 n6140 n6256 0.5
r9433 n6255 n6256 0.010416666666666666
r9434 n6141 n6257 0.40000000000000002
r9435 n6256 n6257 0.018749999999999999
r9436 n6142 n6258 2
r9437 n6257 n6258 0.012500000000000001
r9438 n6143 n6259 0.20000000000000001
r9439 n6258 n6259 0.022916666666666665
r9440 n6144 n6260 0.66666666666666663
r9441 n6259 n6260 0.027083333333333334
r9442 n6145 n6261 0.33333333333333331
r9443 n6260 n6261 0.018749999999999999
r9444 n6146 n6262 1
r9445 n6261 n6262 0.016666666666666666
r9446 n6147 n6263 2
r9447 n6262 n6263 0.0062500000000000003
r9448 n6148 n6264 2
r9449 n6263 n6264 0.0041666666666666666
r9450 n6149 n6265 0.33333333333333331
r9451 n6264 n6265 0.014583333333333334
r9452 n6150 n6266 0.40000000000000002
r9453 n6265 n6266 0.022916666666666665
r9454 n6151 n6267 2
r9455 n6266 n6267 0.012500000000000001
r9456 n6152 n6268 0.5
r9457 n6267 n6268 0.010416666666666666
r9458 n6153 n6269 0.40000000000000002
r9459 n6268 n6269 0.018749999999999999
r9460 n6154 n6270 0.66666666666666663
r9461 n6269 n6270 0.016666666666666666
r9462 n6155 n6271 0.2857142857142857
r9463 n6270 n6271 0.020833333333333332
r9464 n6156 n6272 0.33333333333333331
r9465 n6271 n6272 0.027083333333333334
r9466 n6157 n6273 0.20000000000000001
r9467 n6272 n6273 0.033333333333333333
r9468 n6158 n6274 0.5
r9469 n6273 n6274 0.029166666666666667
r9470 n6159 n6275 0.2857142857142857
r9471 n6274 n6275 0.022916666666666665
r9472 n6160 n6276 0.22222222222222221
r9473 n6275 n6276 0.033333333333333333
r9474 n6161 n6277 0.5
r9475 n6276 n6277 0.027083333333333334
r9476 n6162 n6278 0.25
r9477 n6277 n6278 0.025000000000000001
r9478 n6163 n6279 0.40000000000000002
r9479 n6278 n6279 0.027083333333333334
r9480 n6164 n6280 0.33333333333333331
r9481 n6279 n6280 0.022916666666666665
r9482 n6165 n6281 1
r9483 n6280 n6281 0.016666666666666666
r9484 n6166 n6282 0.11764705882352941
r9485 n6281 n6282 0.039583333333333331
r9486 n6167 n6283 0.15384615384615385
r9487 n6282 n6283 0.0625
r9488 n6168 n6284 1
r9489 n6283 n6284 0.03125
r9490 n6169 n6285 1
r9491 n6284 n6285 0.0083333333333333332
r9492 n6170 n6286 0.5
r9493 n6285 n6286 0.012500000000000001
r9494 n6171 n6287 0.40000000000000002
r9495 n6286 n6287 0.018749999999999999
r9496 n6172 n6288 0.25
r9497 n6287 n6288 0.027083333333333334
r9498 n6173 n6289 0.5
r9499 n6288 n6289 0.025000000000000001
r9500 n6174 n6290 0.15384615384615385
r9501 n6289 n6290 0.035416666666666666
r9502 n6175 n6291 0.2857142857142857
r9503 n6290 n6291 0.041666666666666664
r9504 n6176 n6292 0.07407407407407407
r9505 n6291 n6292 0.070833333333333331
r9506 n6177 n6293 1
r9507 n6292 n6293 0.060416666666666667
r9508 n6178 n6294 0.40000000000000002
r9509 n6293 n6294 0.014583333333333334
r9510 n6179 n6295 0.07407407407407407
r9511 n6294 n6295 0.066666666666666666
r9512 n6180 n6296 1
r9513 n6295 n6296 0.060416666666666667
r9514 n6181 n6297 0.0625
r9515 n6296 n6297 0.070833333333333331
r9516 n6182 n6298 0.058823529411764705
r9517 n6297 n6298 0.13750000000000001
r9518 n6183 n6299 0.058823529411764705
r9519 n6298 n6299 0.14166666666666666
r9520 n6184 n6300 0.058823529411764705
r9521 n6299 n6300 0.14166666666666666
r9522 n6185 n6301 0.058823529411764705
r9523 n6300 n6301 0.14166666666666666
r9524 n6186 n6302 0.058823529411764705
r9525 n6301 n6302 0.14166666666666666
r9526 n6187 n6303 0.058823529411764705
r9527 n6302 n6303 0.14166666666666666
r9528 n6188 n6304 0.058823529411764705
r9529 n6303 n6304 0.14166666666666666
r9530 n6189 n6305 0.058823529411764705
r9531 n6304 n6305 0.14166666666666666
r9532 n6190 n6306 0.058823529411764705
r9533 n6305 n6306 0.14166666666666666
r9534 n6191 n6307 0.058823529411764705
r9535 n6306 n6307 0.14166666666666666
r9536 n6192 n6308 0.058823529411764705
r9537 n6307 n6308 0.14166666666666666
r9538 n6193 n6309 0.058823529411764705
r9539 n6308 n6309 0.14166666666666666
r9540 n6194 n6310 0.058823529411764705
r9541 n6309 n6310 0.14166666666666666
r9542 n6195 n6311 0.058823529411764705
r9543 n6310 n6311 0.14166666666666666
r9544 n6196 n6312 0.058823529411764705
r9545 n6311 n6312 0.14166666666666666
r9546 n6197 n6313 0.058823529411764705
r9547 n6312 n6313 0.14166666666666666
r9548 n6198 n6314 0.058823529411764705
r9549 n6313 n6314 0.14166666666666666
r9550 n6199 n6315 0.058823529411764705
r9551 n6314 n6315 0.14166666666666666
r9552 n6200 n6316 0.058823529411764705
r9553 n6315 n6316 0.14166666666666666
r9554 n6201 n6317 0.058823529411764705
r9555 n6316 n6317 0.14166666666666666
r9556 n6202 n6318 0.058823529411764705
r9557 n6317 n6318 0.14166666666666666
r9558 n6203 n6319 0.058823529411764705
r9559 n6318 n6319 0.14166666666666666
r9560 n6204 n6320 0.18181818181818182
r9561 n6319 n6320 0.09375
r9562 n6205 n6321 0.086956521739130432
r9563 n6320 n6321 0.070833333333333331
r9564 n6206 n6322 1
r9565 n6321 n6322 0.052083333333333336
r9566 n6207 n6323 0.066666666666666666
r9567 n6322 n6323 0.066666666666666666
r9568 n6208 n6324 1
r9569 n6323 n6324 0.066666666666666666
r9570 n6209 n6325 0.086956521739130432
r9571 n6324 n6325 0.052083333333333336
r9572 n6210 n6326 0.20000000000000001
r9573 n6211 n6327 0.080000000000000002
r9574 n6326 n6327 0.072916666666666671
r9575 n6212 n6328 2
r9576 n6327 n6328 0.054166666666666669
r9577 n6213 n6329 0.071428571428571425
r9578 n6328 n6329 0.060416666666666667
r9579 n6214 n6330 2
r9580 n6329 n6330 0.060416666666666667
r9581 n6215 n6331 0.080000000000000002
r9582 n6330 n6331 0.054166666666666669
r9583 n6216 n6332 0.20000000000000001
r9584 n6331 n6332 0.072916666666666671
r9585 n6217 n6333 0.060606060606060608
r9586 n6218 n6334 1
r9587 n6333 n6334 1.09375
r9588 n6219 n6335 0.066666666666666666
r9589 n6334 n6335 1
r9590 n6220 n6336 1
r9591 n6335 n6336 1
r9592 n6221 n6337 0.060606060606060608
r9593 n6336 n6337 1.09375
r9594 n6222 n6338 0.20000000000000001
r9595 n6337 n6338 1.34375
r9596 n6223 n6339 0.04878048780487805
r9597 n6338 n6339 1.59375
r9598 n6224 n6340 0.04878048780487805
r9599 n6339 n6340 2.5625
r9600 n6225 n6341 0.04878048780487805
r9601 n6340 n6341 2.5625
r9602 n6226 n6342 0.058823529411764705
r9603 n6341 n6342 2.34375
r9604 n6227 n6343 0.072992700729927001
r9605 n6342 n6343 1.91875
r9606 n6228 n6344 0.072463768115942032
r9607 n6343 n6344 1.71875
r9608 n6229 n6345 0.058823529411764705
r9609 n6344 n6345 1.925
r9610 n6230 n6346 0.15384615384615385
r9611 n6345 n6346 1.46875
r9612 n6231 n6347 0.050000000000000003
r9613 n6346 n6347 1.65625
r9614 n6232 n6348 2
r9615 n6347 n6348 1.28125
r9616 n6233 n6349 0.060606060606060608
r9617 n6348 n6349 1.0625
r9618 n6234 n6350 2
r9619 n6349 n6350 1.0625
r9620 n6235 n6351 0.086956521739130432
r9621 n6350 n6351 0.75
r9622 n6236 n6352 0.5
r9623 n6351 n6352 0.84375
r9624 n6237 n6353 0.33333333333333331
r9625 n6352 n6353 0.3125
r9626 n6238 n6354 0.40000000000000002
r9627 n6353 n6354 0.34375
r9628 n6239 n6355 2
r9629 n6354 n6355 0.1875
r9630 n6240 n6356 0.15384615384615385
r9631 n6355 n6356 0.4375
r9632 n6241 n6357 0.20000000000000001
r9633 n6356 n6357 0.71875
r9634 n6242 n6358 0.40000000000000002
r9635 n6357 n6358 0.46875
r9636 n6243 n6359 0.40000000000000002
r9637 n6358 n6359 0.3125
r9638 n6244 n6360 2
r9639 n6359 n6360 0.1875
r9640 n6245 n6361 0.66666666666666663
r9641 n6360 n6361 0.125
r9642 n6246 n6362 2
r9643 n6361 n6362 0.125
r9644 n6247 n6363 0.22222222222222221
r9645 n6362 n6363 0.3125
r9646 n6248 n6364 0.20000000000000001
r9647 n6363 n6364 0.59375
r9648 n6249 n6365 0.40000000000000002
r9649 n6364 n6365 0.46875
r9650 n6250 n6366 0.40000000000000002
r9651 n6365 n6366 0.3125
r9652 n6251 n6367 2
r9653 n6366 n6367 0.1875
r9654 n6252 n6368 1
r9655 n6367 n6368 0.09375
r9656 n6253 n6369 2
r9657 n6368 n6369 0.09375
r9658 n6254 n6370 2
r9659 n6369 n6370 0.0625
r9660 n6255 n6371 2
r9661 n6370 n6371 0.0625
r9662 n6256 n6372 0.5
r9663 n6371 n6372 0.15625
r9664 n6257 n6373 0.40000000000000002
r9665 n6372 n6373 0.28125
r9666 n6258 n6374 2
r9667 n6373 n6374 0.1875
r9668 n6259 n6375 0.20000000000000001
r9669 n6374 n6375 0.34375
r9670 n6260 n6376 0.66666666666666663
r9671 n6375 n6376 0.40625
r9672 n6261 n6377 0.33333333333333331
r9673 n6376 n6377 0.28125
r9674 n6262 n6378 1
r9675 n6377 n6378 0.25
r9676 n6263 n6379 2
r9677 n6378 n6379 0.09375
r9678 n6264 n6380 2
r9679 n6379 n6380 0.0625
r9680 n6265 n6381 0.33333333333333331
r9681 n6380 n6381 0.21875
r9682 n6266 n6382 0.40000000000000002
r9683 n6381 n6382 0.34375
r9684 n6267 n6383 2
r9685 n6382 n6383 0.1875
r9686 n6268 n6384 0.5
r9687 n6383 n6384 0.15625
r9688 n6269 n6385 0.40000000000000002
r9689 n6384 n6385 0.28125
r9690 n6270 n6386 0.66666666666666663
r9691 n6385 n6386 0.25
r9692 n6271 n6387 0.2857142857142857
r9693 n6386 n6387 0.3125
r9694 n6272 n6388 0.33333333333333331
r9695 n6387 n6388 0.40625
r9696 n6273 n6389 0.20000000000000001
r9697 n6388 n6389 0.5
r9698 n6274 n6390 0.5
r9699 n6389 n6390 0.4375
r9700 n6275 n6391 0.2857142857142857
r9701 n6390 n6391 0.34375
r9702 n6276 n6392 0.22222222222222221
r9703 n6391 n6392 0.5
r9704 n6277 n6393 0.5
r9705 n6392 n6393 0.40625
r9706 n6278 n6394 0.25
r9707 n6393 n6394 0.375
r9708 n6279 n6395 0.40000000000000002
r9709 n6394 n6395 0.40625
r9710 n6280 n6396 0.33333333333333331
r9711 n6395 n6396 0.34375
r9712 n6281 n6397 1
r9713 n6396 n6397 0.25
r9714 n6282 n6398 0.11764705882352941
r9715 n6397 n6398 0.59375
r9716 n6283 n6399 0.15384615384615385
r9717 n6398 n6399 0.9375
r9718 n6284 n6400 1
r9719 n6399 n6400 0.46875
r9720 n6285 n6401 1
r9721 n6400 n6401 0.125
r9722 n6286 n6402 0.5
r9723 n6401 n6402 0.1875
r9724 n6287 n6403 0.40000000000000002
r9725 n6402 n6403 0.28125
r9726 n6288 n6404 0.25
r9727 n6403 n6404 0.40625
r9728 n6289 n6405 0.5
r9729 n6404 n6405 0.375
r9730 n6290 n6406 0.15384615384615385
r9731 n6405 n6406 0.53125
r9732 n6291 n6407 0.2857142857142857
r9733 n6406 n6407 0.625
r9734 n6292 n6408 0.07407407407407407
r9735 n6407 n6408 1.0625
r9736 n6293 n6409 1
r9737 n6408 n6409 0.90625
r9738 n6294 n6410 0.40000000000000002
r9739 n6409 n6410 0.21875
r9740 n6295 n6411 0.07407407407407407
r9741 n6410 n6411 1
r9742 n6296 n6412 1
r9743 n6411 n6412 0.90625
r9744 n6297 n6413 0.0625
r9745 n6412 n6413 1.0625
r9746 n6298 n6414 0.058823529411764705
r9747 n6413 n6414 2.0625
r9748 n6299 n6415 0.058823529411764705
r9749 n6414 n6415 2.125
r9750 n6300 n6416 0.058823529411764705
r9751 n6415 n6416 2.125
r9752 n6301 n6417 0.058823529411764705
r9753 n6416 n6417 2.125
r9754 n6302 n6418 0.058823529411764705
r9755 n6417 n6418 2.125
r9756 n6303 n6419 0.058823529411764705
r9757 n6418 n6419 2.125
r9758 n6304 n6420 0.058823529411764705
r9759 n6419 n6420 2.125
r9760 n6305 n6421 0.058823529411764705
r9761 n6420 n6421 2.125
r9762 n6306 n6422 0.058823529411764705
r9763 n6421 n6422 2.125
r9764 n6307 n6423 0.058823529411764705
r9765 n6422 n6423 2.125
r9766 n6308 n6424 0.058823529411764705
r9767 n6423 n6424 2.125
r9768 n6309 n6425 0.058823529411764705
r9769 n6424 n6425 2.125
r9770 n6310 n6426 0.058823529411764705
r9771 n6425 n6426 2.125
r9772 n6311 n6427 0.058823529411764705
r9773 n6426 n6427 2.125
r9774 n6312 n6428 0.058823529411764705
r9775 n6427 n6428 2.125
r9776 n6313 n6429 0.058823529411764705
r9777 n6428 n6429 2.125
r9778 n6314 n6430 0.058823529411764705
r9779 n6429 n6430 2.125
r9780 n6315 n6431 0.058823529411764705
r9781 n6430 n6431 2.125
r9782 n6316 n6432 0.058823529411764705
r9783 n6431 n6432 2.125
r9784 n6317 n6433 0.058823529411764705
r9785 n6432 n6433 2.125
r9786 n6318 n6434 0.058823529411764705
r9787 n6433 n6434 2.125
r9788 n6319 n6435 0.058823529411764705
r9789 n6434 n6435 2.125
r9790 n6320 n6436 0.18181818181818182
r9791 n6435 n6436 1.40625
r9792 n6321 n6437 0.086956521739130432
r9793 n6436 n6437 1.0625
r9794 n6322 n6438 1
r9795 n6437 n6438 0.78125
r9796 n6323 n6439 0.066666666666666666
r9797 n6438 n6439 1
r9798 n6324 n6440 1
r9799 n6439 n6440 1
r9800 n6325 n6441 0.086956521739130432
r9801 n6440 n6441 0.78125
r9802 n6326 n6442 0.20000000000000001
r9803 n6327 n6443 0.080000000000000002
r9804 n6442 n6443 1.09375
r9805 n6328 n6444 2
r9806 n6443 n6444 0.8125
r9807 n6329 n6445 0.071428571428571425
r9808 n6444 n6445 0.90625
r9809 n6330 n6446 2
r9810 n6445 n6446 0.90625
r9811 n6331 n6447 0.080000000000000002
r9812 n6446 n6447 0.8125
r9813 n6332 n6448 0.20000000000000001
r9814 n6447 n6448 1.09375
r9815 n6333 n6449 0.02462121212121212
r9816 n6334 n6450 0.40625
r9817 n6449 n6450 0.19886363636363635
r9818 n6335 n6451 0.027083333333333334
r9819 n6450 n6451 0.18181818181818182
r9820 n6336 n6452 0.40625
r9821 n6451 n6452 0.18181818181818182
r9822 n6337 n6453 0.02462121212121212
r9823 n6452 n6453 0.19886363636363635
r9824 n6338 n6454 0.081250000000000003
r9825 n6453 n6454 0.24431818181818182
r9826 n6339 n6455 0.019817073170731708
r9827 n6454 n6455 0.28977272727272729
r9828 n6340 n6456 0.019817073170731708
r9829 n6455 n6456 0.46590909090909088
r9830 n6341 n6457 0.019817073170731708
r9831 n6456 n6457 0.46590909090909088
r9832 n6342 n6458 0.02389705882352941
r9833 n6457 n6458 0.42613636363636365
r9834 n6343 n6459 0.029653284671532845
r9835 n6458 n6459 0.34886363636363638
r9836 n6344 n6460 0.029438405797101448
r9837 n6459 n6460 0.3125
r9838 n6345 n6461 0.02389705882352941
r9839 n6460 n6461 0.34999999999999998
r9840 n6346 n6462 0.0625
r9841 n6461 n6462 0.26704545454545453
r9842 n6347 n6463 0.020312500000000001
r9843 n6462 n6463 0.30113636363636365
r9844 n6348 n6464 0.8125
r9845 n6463 n6464 0.23295454545454544
r9846 n6349 n6465 0.02462121212121212
r9847 n6464 n6465 0.19318181818181818
r9848 n6350 n6466 0.8125
r9849 n6465 n6466 0.19318181818181818
r9850 n6351 n6467 0.035326086956521736
r9851 n6466 n6467 0.13636363636363635
r9852 n6352 n6468 0.203125
r9853 n6467 n6468 0.15340909090909091
r9854 n6353 n6469 0.13541666666666666
r9855 n6468 n6469 0.056818181818181816
r9856 n6354 n6470 0.16250000000000001
r9857 n6469 n6470 0.0625
r9858 n6355 n6471 0.8125
r9859 n6470 n6471 0.034090909090909088
r9860 n6356 n6472 0.0625
r9861 n6471 n6472 0.079545454545454544
r9862 n6357 n6473 0.081250000000000003
r9863 n6472 n6473 0.13068181818181818
r9864 n6358 n6474 0.16250000000000001
r9865 n6473 n6474 0.085227272727272721
r9866 n6359 n6475 0.16250000000000001
r9867 n6474 n6475 0.056818181818181816
r9868 n6360 n6476 0.8125
r9869 n6475 n6476 0.034090909090909088
r9870 n6361 n6477 0.27083333333333331
r9871 n6476 n6477 0.022727272727272728
r9872 n6362 n6478 0.8125
r9873 n6477 n6478 0.022727272727272728
r9874 n6363 n6479 0.090277777777777776
r9875 n6478 n6479 0.056818181818181816
r9876 n6364 n6480 0.081250000000000003
r9877 n6479 n6480 0.10795454545454546
r9878 n6365 n6481 0.16250000000000001
r9879 n6480 n6481 0.085227272727272721
r9880 n6366 n6482 0.16250000000000001
r9881 n6481 n6482 0.056818181818181816
r9882 n6367 n6483 0.8125
r9883 n6482 n6483 0.034090909090909088
r9884 n6368 n6484 0.40625
r9885 n6483 n6484 0.017045454545454544
r9886 n6369 n6485 0.8125
r9887 n6484 n6485 0.017045454545454544
r9888 n6370 n6486 0.8125
r9889 n6485 n6486 0.011363636363636364
r9890 n6371 n6487 0.8125
r9891 n6486 n6487 0.011363636363636364
r9892 n6372 n6488 0.203125
r9893 n6487 n6488 0.028409090909090908
r9894 n6373 n6489 0.16250000000000001
r9895 n6488 n6489 0.05113636363636364
r9896 n6374 n6490 0.8125
r9897 n6489 n6490 0.034090909090909088
r9898 n6375 n6491 0.081250000000000003
r9899 n6490 n6491 0.0625
r9900 n6376 n6492 0.27083333333333331
r9901 n6491 n6492 0.073863636363636367
r9902 n6377 n6493 0.13541666666666666
r9903 n6492 n6493 0.05113636363636364
r9904 n6378 n6494 0.40625
r9905 n6493 n6494 0.045454545454545456
r9906 n6379 n6495 0.8125
r9907 n6494 n6495 0.017045454545454544
r9908 n6380 n6496 0.8125
r9909 n6495 n6496 0.011363636363636364
r9910 n6381 n6497 0.13541666666666666
r9911 n6496 n6497 0.039772727272727272
r9912 n6382 n6498 0.16250000000000001
r9913 n6497 n6498 0.0625
r9914 n6383 n6499 0.8125
r9915 n6498 n6499 0.034090909090909088
r9916 n6384 n6500 0.203125
r9917 n6499 n6500 0.028409090909090908
r9918 n6385 n6501 0.16250000000000001
r9919 n6500 n6501 0.05113636363636364
r9920 n6386 n6502 0.27083333333333331
r9921 n6501 n6502 0.045454545454545456
r9922 n6387 n6503 0.11607142857142858
r9923 n6502 n6503 0.056818181818181816
r9924 n6388 n6504 0.13541666666666666
r9925 n6503 n6504 0.073863636363636367
r9926 n6389 n6505 0.081250000000000003
r9927 n6504 n6505 0.090909090909090912
r9928 n6390 n6506 0.203125
r9929 n6505 n6506 0.079545454545454544
r9930 n6391 n6507 0.11607142857142858
r9931 n6506 n6507 0.0625
r9932 n6392 n6508 0.090277777777777776
r9933 n6507 n6508 0.090909090909090912
r9934 n6393 n6509 0.203125
r9935 n6508 n6509 0.073863636363636367
r9936 n6394 n6510 0.1015625
r9937 n6509 n6510 0.068181818181818177
r9938 n6395 n6511 0.16250000000000001
r9939 n6510 n6511 0.073863636363636367
r9940 n6396 n6512 0.13541666666666666
r9941 n6511 n6512 0.0625
r9942 n6397 n6513 0.40625
r9943 n6512 n6513 0.045454545454545456
r9944 n6398 n6514 0.04779411764705882
r9945 n6513 n6514 0.10795454545454546
r9946 n6399 n6515 0.0625
r9947 n6514 n6515 0.17045454545454544
r9948 n6400 n6516 0.40625
r9949 n6515 n6516 0.085227272727272721
r9950 n6401 n6517 0.40625
r9951 n6516 n6517 0.022727272727272728
r9952 n6402 n6518 0.203125
r9953 n6517 n6518 0.034090909090909088
r9954 n6403 n6519 0.16250000000000001
r9955 n6518 n6519 0.05113636363636364
r9956 n6404 n6520 0.1015625
r9957 n6519 n6520 0.073863636363636367
r9958 n6405 n6521 0.203125
r9959 n6520 n6521 0.068181818181818177
r9960 n6406 n6522 0.0625
r9961 n6521 n6522 0.096590909090909088
r9962 n6407 n6523 0.11607142857142858
r9963 n6522 n6523 0.11363636363636363
r9964 n6408 n6524 0.030092592592592591
r9965 n6523 n6524 0.19318181818181818
r9966 n6409 n6525 0.40625
r9967 n6524 n6525 0.16477272727272727
r9968 n6410 n6526 0.16250000000000001
r9969 n6525 n6526 0.039772727272727272
r9970 n6411 n6527 0.030092592592592591
r9971 n6526 n6527 0.18181818181818182
r9972 n6412 n6528 0.40625
r9973 n6527 n6528 0.16477272727272727
r9974 n6413 n6529 0.025390625
r9975 n6528 n6529 0.19318181818181818
r9976 n6414 n6530 0.02389705882352941
r9977 n6529 n6530 0.375
r9978 n6415 n6531 0.02389705882352941
r9979 n6530 n6531 0.38636363636363635
r9980 n6416 n6532 0.02389705882352941
r9981 n6531 n6532 0.38636363636363635
r9982 n6417 n6533 0.02389705882352941
r9983 n6532 n6533 0.38636363636363635
r9984 n6418 n6534 0.02389705882352941
r9985 n6533 n6534 0.38636363636363635
r9986 n6419 n6535 0.02389705882352941
r9987 n6534 n6535 0.38636363636363635
r9988 n6420 n6536 0.02389705882352941
r9989 n6535 n6536 0.38636363636363635
r9990 n6421 n6537 0.02389705882352941
r9991 n6536 n6537 0.38636363636363635
r9992 n6422 n6538 0.02389705882352941
r9993 n6537 n6538 0.38636363636363635
r9994 n6423 n6539 0.02389705882352941
r9995 n6538 n6539 0.38636363636363635
r9996 n6424 n6540 0.02389705882352941
r9997 n6539 n6540 0.38636363636363635
r9998 n6425 n6541 0.02389705882352941
r9999 n6540 n6541 0.38636363636363635
r10000 n6426 n6542 0.02389705882352941
r10001 n6541 n6542 0.38636363636363635
r10002 n6427 n6543 0.02389705882352941
r10003 n6542 n6543 0.38636363636363635
r10004 n6428 n6544 0.02389705882352941
r10005 n6543 n6544 0.38636363636363635
r10006 n6429 n6545 0.02389705882352941
r10007 n6544 n6545 0.38636363636363635
r10008 n6430 n6546 0.02389705882352941
r10009 n6545 n6546 0.38636363636363635
r10010 n6431 n6547 0.02389705882352941
r10011 n6546 n6547 0.38636363636363635
r10012 n6432 n6548 0.02389705882352941
r10013 n6547 n6548 0.38636363636363635
r10014 n6433 n6549 0.02389705882352941
r10015 n6548 n6549 0.38636363636363635
r10016 n6434 n6550 0.02389705882352941
r10017 n6549 n6550 0.38636363636363635
r10018 n6435 n6551 0.02389705882352941
r10019 n6550 n6551 0.38636363636363635
r10020 n6436 n6552 0.073863636363636367
r10021 n6551 n6552 0.25568181818181818
r10022 n6437 n6553 0.035326086956521736
r10023 n6552 n6553 0.19318181818181818
r10024 n6438 n6554 0.40625
r10025 n6553 n6554 0.14204545454545456
r10026 n6439 n6555 0.027083333333333334
r10027 n6554 n6555 0.18181818181818182
r10028 n6440 n6556 0.40625
r10029 n6555 n6556 0.18181818181818182
r10030 n6441 n6557 0.035326086956521736
r10031 n6556 n6557 0.14204545454545456
r10032 n6442 n6558 0.081250000000000003
r10033 n6443 n6559 0.032500000000000001
r10034 n6558 n6559 0.19886363636363635
r10035 n6444 n6560 0.8125
r10036 n6559 n6560 0.14772727272727273
r10037 n6445 n6561 0.029017857142857144
r10038 n6560 n6561 0.16477272727272727
r10039 n6446 n6562 0.8125
r10040 n6561 n6562 0.16477272727272727
r10041 n6447 n6563 0.032500000000000001
r10042 n6562 n6563 0.14772727272727273
r10043 n6448 n6564 0.081250000000000003
r10044 n6563 n6564 0.19886363636363635
r10045 n6449 n6565 0.02462121212121212
r10046 n6450 n6566 0.40625
r10047 n6565 n6566 1.09375
r10048 n6451 n6567 0.027083333333333334
r10049 n6566 n6567 1
r10050 n6452 n6568 0.40625
r10051 n6567 n6568 1
r10052 n6453 n6569 0.02462121212121212
r10053 n6568 n6569 1.09375
r10054 n6553 n6570 0.035326086956521736
r10055 n6554 n6571 0.40625
r10056 n6570 n6571 0.78125
r10057 n6555 n6572 0.027083333333333334
r10058 n6571 n6572 1
r10059 n6556 n6573 0.40625
r10060 n6572 n6573 1
r10061 n6557 n6574 0.035326086956521736
r10062 n6573 n6574 0.78125
r10063 n6558 n6575 0.081250000000000003
r10064 n6559 n6576 0.032500000000000001
r10065 n6575 n6576 1.09375
r10066 n6560 n6577 0.8125
r10067 n6576 n6577 0.8125
r10068 n6561 n6578 0.029017857142857144
r10069 n6577 n6578 0.90625
r10070 n6562 n6579 0.8125
r10071 n6578 n6579 0.90625
r10072 n6563 n6580 0.032500000000000001
r10073 n6579 n6580 0.8125
r10074 n6564 n6581 0.081250000000000003
r10075 n6580 n6581 1.09375
r10076 n6565 n6582 0.067424242424242428
r10077 n6566 n6583 1.1125
r10078 n6582 n6583 0.065104166666666671
r10079 n6567 n6584 0.074166666666666672
r10080 n6583 n6584 0.059523809523809521
r10081 n6568 n6585 1.1125
r10082 n6584 n6585 0.059523809523809521
r10083 n6569 n6586 0.067424242424242428
r10084 n6585 n6586 0.065104166666666671
r10085 n6575 n6587 0.2225
r10086 n6576 n6588 0.088999999999999996
r10087 n6587 n6588 0.065104166666666671
r10088 n6577 n6589 2.2250000000000001
r10089 n6588 n6589 0.04836309523809524
r10090 n6578 n6590 0.07946428571428571
r10091 n6589 n6590 0.053943452380952384
r10092 n6579 n6591 2.2250000000000001
r10093 n6590 n6591 0.053943452380952384
r10094 n6580 n6592 0.088999999999999996
r10095 n6591 n6592 0.04836309523809524
r10096 n6581 n6593 0.2225
r10097 n6592 n6593 0.065104166666666671
r10098 n6582 n6594 0.12689393939393939
r10099 n6583 n6595 2.09375
r10100 n6594 n6595 0.0654940119760479
r10101 n6584 n6596 0.13958333333333334
r10102 n6595 n6596 0.059880239520958084
r10103 n6585 n6597 2.09375
r10104 n6596 n6597 0.059880239520958084
r10105 n6586 n6598 0.12689393939393939
r10106 n6597 n6598 0.0654940119760479
r10107 n6587 n6599 0.41875000000000001
r10108 n6588 n6600 0.16750000000000001
r10109 n6599 n6600 0.0654940119760479
r10110 n6589 n6601 4.1875
r10111 n6600 n6601 0.048652694610778445
r10112 n6590 n6602 0.14955357142857142
r10113 n6601 n6602 0.054266467065868261
r10114 n6591 n6603 4.1875
r10115 n6602 n6603 0.054266467065868261
r10116 n6592 n6604 0.16750000000000001
r10117 n6603 n6604 0.048652694610778445
r10118 n6593 n6605 0.41875000000000001
r10119 n6604 n6605 0.0654940119760479
r10120 n6594 n6606 0.084090909090909091
r10121 n6595 n6607 1.3875
r10122 n6606 n6607 0.19886363636363635
r10123 n6596 n6608 0.092499999999999999
r10124 n6607 n6608 0.18181818181818182
r10125 n6597 n6609 1.3875
r10126 n6608 n6609 0.18181818181818182
r10127 n6598 n6610 0.084090909090909091
r10128 n6609 n6610 0.19886363636363635
r10129 n6599 n6611 0.27750000000000002
r10130 n6600 n6612 0.111
r10131 n6611 n6612 0.19886363636363635
r10132 n6601 n6613 2.7749999999999999
r10133 n6612 n6613 0.14772727272727273
r10134 n6602 n6614 0.099107142857142852
r10135 n6613 n6614 0.16477272727272727
r10136 n6603 n6615 2.7749999999999999
r10137 n6614 n6615 0.16477272727272727
r10138 n6604 n6616 0.111
r10139 n6615 n6616 0.14772727272727273
r10140 n6605 n6617 0.27750000000000002
r10141 n6616 n6617 0.19886363636363635
r10142 n6606 n6618 0.039772727272727272
r10143 n6607 n6619 0.65625
r10144 n6618 n6619 0.21875
r10145 n6608 n6620 0.043749999999999997
r10146 n6619 n6620 0.20000000000000001
r10147 n6609 n6621 0.65625
r10148 n6620 n6621 0.20000000000000001
r10149 n6610 n6622 0.039772727272727272
r10150 n6621 n6622 0.21875
r10151 n6623 n6624 0.0625
r10152 n6624 n6625 0.037499999999999999
r10153 n6625 n6626 0.018749999999999999
r10154 n6626 n6627 0.018749999999999999
r10155 n6627 n6628 0.012500000000000001
r10156 n6628 n6629 0.012500000000000001
r10157 n6629 n6630 0.03125
r10158 n6630 n6631 0.056250000000000001
r10159 n6631 n6632 0.037499999999999999
r10160 n6632 n6633 0.068750000000000006
r10161 n6633 n6634 0.081250000000000003
r10162 n6634 n6635 0.056250000000000001
r10163 n6635 n6636 0.050000000000000003
r10164 n6636 n6637 0.018749999999999999
r10165 n6637 n6638 0.012500000000000001
r10166 n6638 n6639 0.043749999999999997
r10167 n6639 n6640 0.068750000000000006
r10168 n6640 n6641 0.037499999999999999
r10169 n6641 n6642 0.03125
r10170 n6642 n6643 0.056250000000000001
r10171 n6643 n6644 0.050000000000000003
r10172 n6644 n6645 0.0625
r10173 n6611 n6646 0.13125000000000001
r10174 n6612 n6647 0.052499999999999998
r10175 n6646 n6647 0.21875
r10176 n6613 n6648 1.3125
r10177 n6647 n6648 0.16250000000000001
r10178 n6614 n6649 0.046875
r10179 n6648 n6649 0.18124999999999999
r10180 n6615 n6650 1.3125
r10181 n6649 n6650 0.18124999999999999
r10182 n6616 n6651 0.052499999999999998
r10183 n6650 n6651 0.16250000000000001
r10184 n6617 n6652 0.13125000000000001
r10185 n6651 n6652 0.21875
r10186 n6618 n6653 0.022727272727272728
r10187 n6619 n6654 0.375
r10188 n6653 n6654 1.09375
r10189 n6620 n6655 0.025000000000000001
r10190 n6654 n6655 1
r10191 n6621 n6656 0.375
r10192 n6655 n6656 1
r10193 n6622 n6657 0.022727272727272728
r10194 n6656 n6657 1.09375
r10195 n6623 n6658 0.14999999999999999
r10196 n6624 n6659 0.14999999999999999
r10197 n6658 n6659 0.3125
r10198 n6625 n6660 0.75
r10199 n6659 n6660 0.1875
r10200 n6626 n6661 0.375
r10201 n6660 n6661 0.09375
r10202 n6627 n6662 0.75
r10203 n6661 n6662 0.09375
r10204 n6628 n6663 0.75
r10205 n6662 n6663 0.0625
r10206 n6629 n6664 0.75
r10207 n6663 n6664 0.0625
r10208 n6630 n6665 0.1875
r10209 n6664 n6665 0.15625
r10210 n6631 n6666 0.14999999999999999
r10211 n6665 n6666 0.28125
r10212 n6632 n6667 0.75
r10213 n6666 n6667 0.1875
r10214 n6633 n6668 0.074999999999999997
r10215 n6667 n6668 0.34375
r10216 n6634 n6669 0.25
r10217 n6668 n6669 0.40625
r10218 n6635 n6670 0.125
r10219 n6669 n6670 0.28125
r10220 n6636 n6671 0.375
r10221 n6670 n6671 0.25
r10222 n6637 n6672 0.75
r10223 n6671 n6672 0.09375
r10224 n6638 n6673 0.75
r10225 n6672 n6673 0.0625
r10226 n6639 n6674 0.125
r10227 n6673 n6674 0.21875
r10228 n6640 n6675 0.14999999999999999
r10229 n6674 n6675 0.34375
r10230 n6641 n6676 0.75
r10231 n6675 n6676 0.1875
r10232 n6642 n6677 0.1875
r10233 n6676 n6677 0.15625
r10234 n6643 n6678 0.14999999999999999
r10235 n6677 n6678 0.28125
r10236 n6644 n6679 0.25
r10237 n6678 n6679 0.25
r10238 n6645 n6680 0.10714285714285714
r10239 n6679 n6680 0.3125
r10240 n6681 n6682 0.78125
r10241 n6682 n6683 1.0625
r10242 n6683 n6684 0.9375
r10243 n6684 n6685 1.0625
r10244 n6685 n6686 0.78125
r10245 n6646 n6687 0.074999999999999997
r10246 n6647 n6688 0.029999999999999999
r10247 n6687 n6688 1.09375
r10248 n6648 n6689 0.75
r10249 n6688 n6689 0.8125
r10250 n6649 n6690 0.026785714285714284
r10251 n6689 n6690 0.90625
r10252 n6650 n6691 0.75
r10253 n6690 n6691 0.90625
r10254 n6651 n6692 0.029999999999999999
r10255 n6691 n6692 0.8125
r10256 n6652 n6693 0.074999999999999997
r10257 n6692 n6693 1.09375
r10258 n6653 n6694 0.00946969696969697
r10259 n6654 n6695 0.15625
r10260 n6694 n6695 0.72916666666666663
r10261 n6655 n6696 0.010416666666666666
r10262 n6695 n6696 0.66666666666666663
r10263 n6656 n6697 0.15625
r10264 n6696 n6697 0.66666666666666663
r10265 n6657 n6698 0.00946969696969697
r10266 n6697 n6698 0.72916666666666663
r10267 n6658 n6699 0.0625
r10268 n6659 n6700 0.0625
r10269 n6699 n6700 0.20833333333333334
r10270 n6660 n6701 0.3125
r10271 n6700 n6701 0.125
r10272 n6661 n6702 0.15625
r10273 n6701 n6702 0.0625
r10274 n6662 n6703 0.3125
r10275 n6702 n6703 0.0625
r10276 n6663 n6704 0.3125
r10277 n6703 n6704 0.041666666666666664
r10278 n6664 n6705 0.3125
r10279 n6704 n6705 0.041666666666666664
r10280 n6665 n6706 0.078125
r10281 n6705 n6706 0.10416666666666667
r10282 n6666 n6707 0.0625
r10283 n6706 n6707 0.1875
r10284 n6667 n6708 0.3125
r10285 n6707 n6708 0.125
r10286 n6668 n6709 0.03125
r10287 n6708 n6709 0.22916666666666666
r10288 n6669 n6710 0.10416666666666667
r10289 n6709 n6710 0.27083333333333331
r10290 n6670 n6711 0.052083333333333336
r10291 n6710 n6711 0.1875
r10292 n6671 n6712 0.15625
r10293 n6711 n6712 0.16666666666666666
r10294 n6672 n6713 0.3125
r10295 n6712 n6713 0.0625
r10296 n6673 n6714 0.3125
r10297 n6713 n6714 0.041666666666666664
r10298 n6674 n6715 0.052083333333333336
r10299 n6714 n6715 0.14583333333333334
r10300 n6675 n6716 0.0625
r10301 n6715 n6716 0.22916666666666666
r10302 n6676 n6717 0.3125
r10303 n6716 n6717 0.125
r10304 n6677 n6718 0.078125
r10305 n6717 n6718 0.10416666666666667
r10306 n6678 n6719 0.0625
r10307 n6718 n6719 0.1875
r10308 n6679 n6720 0.10416666666666667
r10309 n6719 n6720 0.16666666666666666
r10310 n6680 n6721 0.044642857142857144
r10311 n6720 n6721 0.20833333333333334
r10312 n6681 n6722 0.044642857142857144
r10313 n6682 n6723 0.017361111111111112
r10314 n6722 n6723 0.52083333333333337
r10315 n6683 n6724 0.01953125
r10316 n6723 n6724 0.70833333333333337
r10317 n6684 n6725 0.022321428571428572
r10318 n6724 n6725 0.625
r10319 n6685 n6726 0.015625
r10320 n6725 n6726 0.70833333333333337
r10321 n6686 n6727 0.0625
r10322 n6726 n6727 0.52083333333333337
r10323 n6727 n6728 0.70833333333333337
r10324 n6728 n6729 1.3125
r10325 n6729 n6730 1.4166666666666667
r10326 n6730 n6731 1.4166666666666667
r10327 n6731 n6732 1.5416666666666667
r10328 n6732 n6733 1.5416666666666667
r10329 n6733 n6734 1.4166666666666667
r10330 n6734 n6735 1.4166666666666667
r10331 n6735 n6736 1.0625
r10332 n6736 n6737 0.70833333333333337
r10333 n6737 n6738 1.2083333333333333
r10334 n6738 n6739 1.7083333333333333
r10335 n6739 n6740 1.7083333333333333
r10336 n6740 n6741 1.0625
r10337 n6687 n6742 0.03125
r10338 n6741 n6742 0.41666666666666669
r10339 n6688 n6743 0.012500000000000001
r10340 n6742 n6743 0.72916666666666663
r10341 n6689 n6744 0.3125
r10342 n6743 n6744 0.54166666666666663
r10343 n6690 n6745 0.011160714285714286
r10344 n6744 n6745 0.60416666666666663
r10345 n6691 n6746 0.3125
r10346 n6745 n6746 0.60416666666666663
r10347 n6692 n6747 0.012500000000000001
r10348 n6746 n6747 0.54166666666666663
r10349 n6693 n6748 0.03125
r10350 n6747 n6748 0.72916666666666663
r10351 n6694 n6749 0.015151515151515152
r10352 n6695 n6750 0.25
r10353 n6749 n6750 0.4375
r10354 n6696 n6751 0.016666666666666666
r10355 n6750 n6751 0.40000000000000002
r10356 n6697 n6752 0.25
r10357 n6751 n6752 0.40000000000000002
r10358 n6698 n6753 0.015151515151515152
r10359 n6752 n6753 0.4375
r10360 n6699 n6754 0.10000000000000001
r10361 n6700 n6755 0.10000000000000001
r10362 n6754 n6755 0.125
r10363 n6701 n6756 0.5
r10364 n6755 n6756 0.074999999999999997
r10365 n6702 n6757 0.25
r10366 n6756 n6757 0.037499999999999999
r10367 n6703 n6758 0.5
r10368 n6757 n6758 0.037499999999999999
r10369 n6704 n6759 0.5
r10370 n6758 n6759 0.025000000000000001
r10371 n6705 n6760 0.5
r10372 n6759 n6760 0.025000000000000001
r10373 n6706 n6761 0.125
r10374 n6760 n6761 0.0625
r10375 n6707 n6762 0.10000000000000001
r10376 n6761 n6762 0.1125
r10377 n6708 n6763 0.5
r10378 n6762 n6763 0.074999999999999997
r10379 n6709 n6764 0.050000000000000003
r10380 n6763 n6764 0.13750000000000001
r10381 n6710 n6765 0.16666666666666666
r10382 n6764 n6765 0.16250000000000001
r10383 n6711 n6766 0.083333333333333329
r10384 n6765 n6766 0.1125
r10385 n6712 n6767 0.25
r10386 n6766 n6767 0.10000000000000001
r10387 n6713 n6768 0.5
r10388 n6767 n6768 0.037499999999999999
r10389 n6714 n6769 0.5
r10390 n6768 n6769 0.025000000000000001
r10391 n6715 n6770 0.083333333333333329
r10392 n6769 n6770 0.087499999999999994
r10393 n6716 n6771 0.10000000000000001
r10394 n6770 n6771 0.13750000000000001
r10395 n6717 n6772 0.5
r10396 n6771 n6772 0.074999999999999997
r10397 n6718 n6773 0.125
r10398 n6772 n6773 0.0625
r10399 n6719 n6774 0.10000000000000001
r10400 n6773 n6774 0.1125
r10401 n6720 n6775 0.16666666666666666
r10402 n6774 n6775 0.10000000000000001
r10403 n6721 n6776 0.071428571428571425
r10404 n6775 n6776 0.125
r10405 n6722 n6777 0.071428571428571425
r10406 n6723 n6778 0.027777777777777776
r10407 n6777 n6778 0.3125
r10408 n6724 n6779 0.03125
r10409 n6778 n6779 0.42499999999999999
r10410 n6725 n6780 0.035714285714285712
r10411 n6779 n6780 0.375
r10412 n6726 n6781 0.025000000000000001
r10413 n6780 n6781 0.42499999999999999
r10414 n6727 n6782 0.10000000000000001
r10415 n6781 n6782 0.3125
r10416 n6728 n6783 0.017241379310344827
r10417 n6782 n6783 0.42499999999999999
r10418 n6729 n6784 0.014705882352941176
r10419 n6783 n6784 0.78749999999999998
r10420 n6730 n6785 0.014705882352941176
r10421 n6784 n6785 0.84999999999999998
r10422 n6731 n6786 0.014705882352941176
r10423 n6785 n6786 0.84999999999999998
r10424 n6732 n6787 0.012500000000000001
r10425 n6786 n6787 0.92500000000000004
r10426 n6733 n6788 0.014705882352941176
r10427 n6787 n6788 0.92500000000000004
r10428 n6734 n6789 0.014705882352941176
r10429 n6788 n6789 0.84999999999999998
r10430 n6735 n6790 0.014705882352941176
r10431 n6789 n6790 0.84999999999999998
r10432 n6736 n6791 0.029411764705882353
r10433 n6790 n6791 0.63749999999999996
r10434 n6737 n6792 0.029411764705882353
r10435 n6791 n6792 0.42499999999999999
r10436 n6738 n6793 0.012195121951219513
r10437 n6792 n6793 0.72499999999999998
r10438 n6739 n6794 0.012195121951219513
r10439 n6793 n6794 1.0249999999999999
r10440 n6740 n6795 0.012195121951219513
r10441 n6794 n6795 1.0249999999999999
r10442 n6741 n6796 0.050000000000000003
r10443 n6795 n6796 0.63749999999999996
r10444 n6742 n6797 0.050000000000000003
r10445 n6796 n6797 0.25
r10446 n6743 n6798 0.02
r10447 n6797 n6798 0.4375
r10448 n6744 n6799 0.5
r10449 n6798 n6799 0.32500000000000001
r10450 n6745 n6800 0.017857142857142856
r10451 n6799 n6800 0.36249999999999999
r10452 n6746 n6801 0.5
r10453 n6800 n6801 0.36249999999999999
r10454 n6747 n6802 0.02
r10455 n6801 n6802 0.32500000000000001
r10456 n6748 n6803 0.050000000000000003
r10457 n6802 n6803 0.4375
r10458 n6749 n6804 0.015151515151515152
r10459 n6750 n6805 0.25
r10460 n6804 n6805 0.72916666666666663
r10461 n6751 n6806 0.016666666666666666
r10462 n6805 n6806 0.66666666666666663
r10463 n6752 n6807 0.25
r10464 n6806 n6807 0.66666666666666663
r10465 n6753 n6808 0.015151515151515152
r10466 n6807 n6808 0.72916666666666663
r10467 n6754 n6809 0.10000000000000001
r10468 n6755 n6810 0.10000000000000001
r10469 n6809 n6810 0.20833333333333334
r10470 n6756 n6811 0.5
r10471 n6810 n6811 0.125
r10472 n6757 n6812 0.25
r10473 n6811 n6812 0.0625
r10474 n6758 n6813 0.5
r10475 n6812 n6813 0.0625
r10476 n6759 n6814 0.5
r10477 n6813 n6814 0.041666666666666664
r10478 n6760 n6815 0.5
r10479 n6814 n6815 0.041666666666666664
r10480 n6761 n6816 0.125
r10481 n6815 n6816 0.10416666666666667
r10482 n6762 n6817 0.10000000000000001
r10483 n6816 n6817 0.1875
r10484 n6763 n6818 0.5
r10485 n6817 n6818 0.125
r10486 n6764 n6819 0.050000000000000003
r10487 n6818 n6819 0.22916666666666666
r10488 n6765 n6820 0.16666666666666666
r10489 n6819 n6820 0.27083333333333331
r10490 n6766 n6821 0.083333333333333329
r10491 n6820 n6821 0.1875
r10492 n6767 n6822 0.25
r10493 n6821 n6822 0.16666666666666666
r10494 n6768 n6823 0.5
r10495 n6822 n6823 0.0625
r10496 n6769 n6824 0.5
r10497 n6823 n6824 0.041666666666666664
r10498 n6770 n6825 0.083333333333333329
r10499 n6824 n6825 0.14583333333333334
r10500 n6771 n6826 0.10000000000000001
r10501 n6825 n6826 0.22916666666666666
r10502 n6772 n6827 0.5
r10503 n6826 n6827 0.125
r10504 n6773 n6828 0.125
r10505 n6827 n6828 0.10416666666666667
r10506 n6774 n6829 0.10000000000000001
r10507 n6828 n6829 0.1875
r10508 n6775 n6830 0.16666666666666666
r10509 n6829 n6830 0.16666666666666666
r10510 n6776 n6831 0.071428571428571425
r10511 n6830 n6831 0.20833333333333334
r10512 n6777 n6832 0.071428571428571425
r10513 n6778 n6833 0.027777777777777776
r10514 n6832 n6833 0.52083333333333337
r10515 n6779 n6834 0.03125
r10516 n6833 n6834 0.70833333333333337
r10517 n6780 n6835 0.035714285714285712
r10518 n6834 n6835 0.625
r10519 n6781 n6836 0.025000000000000001
r10520 n6835 n6836 0.70833333333333337
r10521 n6782 n6837 0.10000000000000001
r10522 n6836 n6837 0.52083333333333337
r10523 n6783 n6838 0.017241379310344827
r10524 n6837 n6838 0.70833333333333337
r10525 n6784 n6839 0.014705882352941176
r10526 n6838 n6839 1.3125
r10527 n6785 n6840 0.014705882352941176
r10528 n6839 n6840 1.4166666666666667
r10529 n6786 n6841 0.014705882352941176
r10530 n6840 n6841 1.4166666666666667
r10531 n6787 n6842 0.012500000000000001
r10532 n6841 n6842 1.5416666666666667
r10533 n6788 n6843 0.014705882352941176
r10534 n6842 n6843 1.5416666666666667
r10535 n6789 n6844 0.014705882352941176
r10536 n6843 n6844 1.4166666666666667
r10537 n6790 n6845 0.014705882352941176
r10538 n6844 n6845 1.4166666666666667
r10539 n6791 n6846 0.029411764705882353
r10540 n6845 n6846 1.0625
r10541 n6792 n6847 0.029411764705882353
r10542 n6846 n6847 0.70833333333333337
r10543 n6793 n6848 0.012195121951219513
r10544 n6847 n6848 1.2083333333333333
r10545 n6794 n6849 0.012195121951219513
r10546 n6848 n6849 1.7083333333333333
r10547 n6795 n6850 0.012195121951219513
r10548 n6849 n6850 1.7083333333333333
r10549 n6796 n6851 0.050000000000000003
r10550 n6850 n6851 1.0625
r10551 n6797 n6852 0.050000000000000003
r10552 n6851 n6852 0.41666666666666669
r10553 n6798 n6853 0.02
r10554 n6852 n6853 0.72916666666666663
r10555 n6799 n6854 0.5
r10556 n6853 n6854 0.54166666666666663
r10557 n6800 n6855 0.017857142857142856
r10558 n6854 n6855 0.60416666666666663
r10559 n6801 n6856 0.5
r10560 n6855 n6856 0.60416666666666663
r10561 n6802 n6857 0.02
r10562 n6856 n6857 0.54166666666666663
r10563 n6803 n6858 0.050000000000000003
r10564 n6857 n6858 0.72916666666666663
r10565 n6804 n6859 0.00946969696969697
r10566 n6805 n6860 0.15625
r10567 n6859 n6860 1.09375
r10568 n6806 n6861 0.010416666666666666
r10569 n6860 n6861 1
r10570 n6807 n6862 0.15625
r10571 n6861 n6862 1
r10572 n6808 n6863 0.00946969696969697
r10573 n6862 n6863 1.09375
r10574 n6809 n6864 0.0625
r10575 n6810 n6865 0.0625
r10576 n6864 n6865 0.3125
r10577 n6811 n6866 0.3125
r10578 n6865 n6866 0.1875
r10579 n6812 n6867 0.15625
r10580 n6866 n6867 0.09375
r10581 n6813 n6868 0.3125
r10582 n6867 n6868 0.09375
r10583 n6814 n6869 0.3125
r10584 n6868 n6869 0.0625
r10585 n6815 n6870 0.3125
r10586 n6869 n6870 0.0625
r10587 n6816 n6871 0.078125
r10588 n6870 n6871 0.15625
r10589 n6817 n6872 0.0625
r10590 n6871 n6872 0.28125
r10591 n6818 n6873 0.3125
r10592 n6872 n6873 0.1875
r10593 n6819 n6874 0.03125
r10594 n6873 n6874 0.34375
r10595 n6820 n6875 0.10416666666666667
r10596 n6874 n6875 0.40625
r10597 n6821 n6876 0.052083333333333336
r10598 n6875 n6876 0.28125
r10599 n6822 n6877 0.15625
r10600 n6876 n6877 0.25
r10601 n6823 n6878 0.3125
r10602 n6877 n6878 0.09375
r10603 n6824 n6879 0.3125
r10604 n6878 n6879 0.0625
r10605 n6825 n6880 0.052083333333333336
r10606 n6879 n6880 0.21875
r10607 n6826 n6881 0.0625
r10608 n6880 n6881 0.34375
r10609 n6827 n6882 0.3125
r10610 n6881 n6882 0.1875
r10611 n6828 n6883 0.078125
r10612 n6882 n6883 0.15625
r10613 n6829 n6884 0.0625
r10614 n6883 n6884 0.28125
r10615 n6830 n6885 0.10416666666666667
r10616 n6884 n6885 0.25
r10617 n6831 n6886 0.044642857142857144
r10618 n6885 n6886 0.3125
r10619 n6832 n6887 0.044642857142857144
r10620 n6833 n6888 0.017361111111111112
r10621 n6887 n6888 0.78125
r10622 n6834 n6889 0.01953125
r10623 n6888 n6889 1.0625
r10624 n6835 n6890 0.022321428571428572
r10625 n6889 n6890 0.9375
r10626 n6836 n6891 0.015625
r10627 n6890 n6891 1.0625
r10628 n6837 n6892 0.0625
r10629 n6891 n6892 0.78125
r10630 n6838 n6893 0.010775862068965518
r10631 n6892 n6893 1.0625
r10632 n6839 n6894 0.0091911764705882356
r10633 n6893 n6894 1.96875
r10634 n6840 n6895 0.0091911764705882356
r10635 n6894 n6895 2.125
r10636 n6841 n6896 0.0091911764705882356
r10637 n6895 n6896 2.125
r10638 n6842 n6897 0.0078125
r10639 n6896 n6897 2.3125
r10640 n6843 n6898 0.0091911764705882356
r10641 n6897 n6898 2.3125
r10642 n6844 n6899 0.0091911764705882356
r10643 n6898 n6899 2.125
r10644 n6845 n6900 0.0091911764705882356
r10645 n6899 n6900 2.125
r10646 n6846 n6901 0.018382352941176471
r10647 n6900 n6901 1.59375
r10648 n6847 n6902 0.018382352941176471
r10649 n6901 n6902 1.0625
r10650 n6848 n6903 0.007621951219512195
r10651 n6902 n6903 1.8125
r10652 n6849 n6904 0.007621951219512195
r10653 n6903 n6904 2.5625
r10654 n6850 n6905 0.007621951219512195
r10655 n6904 n6905 2.5625
r10656 n6851 n6906 0.03125
r10657 n6905 n6906 1.59375
r10658 n6852 n6907 0.03125
r10659 n6906 n6907 0.625
r10660 n6853 n6908 0.012500000000000001
r10661 n6907 n6908 1.09375
r10662 n6854 n6909 0.3125
r10663 n6908 n6909 0.8125
r10664 n6855 n6910 0.011160714285714286
r10665 n6909 n6910 0.90625
r10666 n6856 n6911 0.3125
r10667 n6910 n6911 0.90625
r10668 n6857 n6912 0.012500000000000001
r10669 n6911 n6912 0.8125
r10670 n6858 n6913 0.03125
r10671 n6912 n6913 1.09375
r10672 n6859 n6914 0.060606060606060608
r10673 n6860 n6915 1
r10674 n6914 n6915 0.072916666666666671
r10675 n6861 n6916 0.066666666666666666
r10676 n6915 n6916 0.066666666666666666
r10677 n6862 n6917 1
r10678 n6916 n6917 0.066666666666666666
r10679 n6863 n6918 0.060606060606060608
r10680 n6917 n6918 0.072916666666666671
r10681 n6864 n6919 0.40000000000000002
r10682 n6865 n6920 0.40000000000000002
r10683 n6919 n6920 0.020833333333333332
r10684 n6866 n6921 2
r10685 n6920 n6921 0.012500000000000001
r10686 n6867 n6922 1
r10687 n6921 n6922 0.0062500000000000003
r10688 n6868 n6923 2
r10689 n6922 n6923 0.0062500000000000003
r10690 n6869 n6924 2
r10691 n6923 n6924 0.0041666666666666666
r10692 n6870 n6925 2
r10693 n6924 n6925 0.0041666666666666666
r10694 n6871 n6926 0.5
r10695 n6925 n6926 0.010416666666666666
r10696 n6872 n6927 0.40000000000000002
r10697 n6926 n6927 0.018749999999999999
r10698 n6873 n6928 2
r10699 n6927 n6928 0.012500000000000001
r10700 n6874 n6929 0.20000000000000001
r10701 n6928 n6929 0.022916666666666665
r10702 n6875 n6930 0.66666666666666663
r10703 n6929 n6930 0.027083333333333334
r10704 n6876 n6931 0.33333333333333331
r10705 n6930 n6931 0.018749999999999999
r10706 n6877 n6932 1
r10707 n6931 n6932 0.016666666666666666
r10708 n6878 n6933 2
r10709 n6932 n6933 0.0062500000000000003
r10710 n6879 n6934 2
r10711 n6933 n6934 0.0041666666666666666
r10712 n6880 n6935 0.33333333333333331
r10713 n6934 n6935 0.014583333333333334
r10714 n6881 n6936 0.40000000000000002
r10715 n6935 n6936 0.022916666666666665
r10716 n6882 n6937 2
r10717 n6936 n6937 0.012500000000000001
r10718 n6883 n6938 0.5
r10719 n6937 n6938 0.010416666666666666
r10720 n6884 n6939 0.40000000000000002
r10721 n6938 n6939 0.018749999999999999
r10722 n6885 n6940 0.66666666666666663
r10723 n6939 n6940 0.016666666666666666
r10724 n6886 n6941 0.2857142857142857
r10725 n6940 n6941 0.020833333333333332
r10726 n6887 n6942 0.2857142857142857
r10727 n6888 n6943 0.1111111111111111
r10728 n6942 n6943 0.052083333333333336
r10729 n6889 n6944 0.125
r10730 n6943 n6944 0.070833333333333331
r10731 n6890 n6945 0.14285714285714285
r10732 n6944 n6945 0.0625
r10733 n6891 n6946 0.10000000000000001
r10734 n6945 n6946 0.070833333333333331
r10735 n6892 n6947 0.40000000000000002
r10736 n6946 n6947 0.052083333333333336
r10737 n6893 n6948 0.068965517241379309
r10738 n6947 n6948 0.070833333333333331
r10739 n6894 n6949 0.058823529411764705
r10740 n6948 n6949 0.13125000000000001
r10741 n6895 n6950 0.058823529411764705
r10742 n6949 n6950 0.14166666666666666
r10743 n6896 n6951 0.058823529411764705
r10744 n6950 n6951 0.14166666666666666
r10745 n6897 n6952 0.050000000000000003
r10746 n6951 n6952 0.15416666666666667
r10747 n6898 n6953 0.058823529411764705
r10748 n6952 n6953 0.15416666666666667
r10749 n6899 n6954 0.058823529411764705
r10750 n6953 n6954 0.14166666666666666
r10751 n6900 n6955 0.058823529411764705
r10752 n6954 n6955 0.14166666666666666
r10753 n6901 n6956 0.11764705882352941
r10754 n6955 n6956 0.10625
r10755 n6902 n6957 0.11764705882352941
r10756 n6956 n6957 0.070833333333333331
r10757 n6903 n6958 0.04878048780487805
r10758 n6957 n6958 0.12083333333333333
r10759 n6904 n6959 0.04878048780487805
r10760 n6958 n6959 0.17083333333333334
r10761 n6905 n6960 0.04878048780487805
r10762 n6959 n6960 0.17083333333333334
r10763 n6906 n6961 0.20000000000000001
r10764 n6960 n6961 0.10625
r10765 n6907 n6962 0.20000000000000001
r10766 n6961 n6962 0.041666666666666664
r10767 n6908 n6963 0.080000000000000002
r10768 n6962 n6963 0.072916666666666671
r10769 n6909 n6964 2
r10770 n6963 n6964 0.054166666666666669
r10771 n6910 n6965 0.071428571428571425
r10772 n6964 n6965 0.060416666666666667
r10773 n6911 n6966 2
r10774 n6965 n6966 0.060416666666666667
r10775 n6912 n6967 0.080000000000000002
r10776 n6966 n6967 0.054166666666666669
r10777 n6913 n6968 0.20000000000000001
r10778 n6967 n6968 0.072916666666666671
r10779 n6914 n6969 0.060606060606060608
r10780 n6915 n6970 1
r10781 n6969 n6970 1.09375
r10782 n6916 n6971 0.066666666666666666
r10783 n6970 n6971 1
r10784 n6917 n6972 1
r10785 n6971 n6972 1
r10786 n6918 n6973 0.060606060606060608
r10787 n6972 n6973 1.09375
r10788 n6919 n6974 0.40000000000000002
r10789 n6920 n6975 0.40000000000000002
r10790 n6974 n6975 0.3125
r10791 n6921 n6976 2
r10792 n6975 n6976 0.1875
r10793 n6922 n6977 1
r10794 n6976 n6977 0.09375
r10795 n6923 n6978 2
r10796 n6977 n6978 0.09375
r10797 n6924 n6979 2
r10798 n6978 n6979 0.0625
r10799 n6925 n6980 2
r10800 n6979 n6980 0.0625
r10801 n6926 n6981 0.5
r10802 n6980 n6981 0.15625
r10803 n6927 n6982 0.40000000000000002
r10804 n6981 n6982 0.28125
r10805 n6928 n6983 2
r10806 n6982 n6983 0.1875
r10807 n6929 n6984 0.20000000000000001
r10808 n6983 n6984 0.34375
r10809 n6930 n6985 0.66666666666666663
r10810 n6984 n6985 0.40625
r10811 n6931 n6986 0.33333333333333331
r10812 n6985 n6986 0.28125
r10813 n6932 n6987 1
r10814 n6986 n6987 0.25
r10815 n6933 n6988 2
r10816 n6987 n6988 0.09375
r10817 n6934 n6989 2
r10818 n6988 n6989 0.0625
r10819 n6935 n6990 0.33333333333333331
r10820 n6989 n6990 0.21875
r10821 n6936 n6991 0.40000000000000002
r10822 n6990 n6991 0.34375
r10823 n6937 n6992 2
r10824 n6991 n6992 0.1875
r10825 n6938 n6993 0.5
r10826 n6992 n6993 0.15625
r10827 n6939 n6994 0.40000000000000002
r10828 n6993 n6994 0.28125
r10829 n6940 n6995 0.66666666666666663
r10830 n6994 n6995 0.25
r10831 n6941 n6996 0.2857142857142857
r10832 n6995 n6996 0.3125
r10833 n6942 n6997 0.2857142857142857
r10834 n6943 n6998 0.1111111111111111
r10835 n6997 n6998 0.78125
r10836 n6944 n6999 0.125
r10837 n6998 n6999 1.0625
r10838 n6945 n7000 0.14285714285714285
r10839 n6999 n7000 0.9375
r10840 n6946 n7001 0.10000000000000001
r10841 n7000 n7001 1.0625
r10842 n6947 n7002 0.40000000000000002
r10843 n7001 n7002 0.78125
r10844 n6948 n7003 0.068965517241379309
r10845 n7002 n7003 1.0625
r10846 n6949 n7004 0.058823529411764705
r10847 n7003 n7004 1.96875
r10848 n6950 n7005 0.058823529411764705
r10849 n7004 n7005 2.125
r10850 n6951 n7006 0.058823529411764705
r10851 n7005 n7006 2.125
r10852 n6952 n7007 0.050000000000000003
r10853 n7006 n7007 2.3125
r10854 n6953 n7008 0.058823529411764705
r10855 n7007 n7008 2.3125
r10856 n6954 n7009 0.058823529411764705
r10857 n7008 n7009 2.125
r10858 n6955 n7010 0.058823529411764705
r10859 n7009 n7010 2.125
r10860 n6956 n7011 0.11764705882352941
r10861 n7010 n7011 1.59375
r10862 n6957 n7012 0.11764705882352941
r10863 n7011 n7012 1.0625
r10864 n6958 n7013 0.04878048780487805
r10865 n7012 n7013 1.8125
r10866 n6959 n7014 0.04878048780487805
r10867 n7013 n7014 2.5625
r10868 n6960 n7015 0.04878048780487805
r10869 n7014 n7015 2.5625
r10870 n6961 n7016 0.20000000000000001
r10871 n7015 n7016 1.59375
r10872 n6962 n7017 0.20000000000000001
r10873 n7016 n7017 0.625
r10874 n6963 n7018 0.080000000000000002
r10875 n7017 n7018 1.09375
r10876 n6964 n7019 2
r10877 n7018 n7019 0.8125
r10878 n6965 n7020 0.071428571428571425
r10879 n7019 n7020 0.90625
r10880 n6966 n7021 2
r10881 n7020 n7021 0.90625
r10882 n6967 n7022 0.080000000000000002
r10883 n7021 n7022 0.8125
r10884 n6968 n7023 0.20000000000000001
r10885 n7022 n7023 1.09375
r10886 n6969 n7024 0.00946969696969697
r10887 n6970 n7025 0.15625
r10888 n7024 n7025 0.72916666666666663
r10889 n6971 n7026 0.010416666666666666
r10890 n7025 n7026 0.66666666666666663
r10891 n6972 n7027 0.15625
r10892 n7026 n7027 0.66666666666666663
r10893 n6973 n7028 0.00946969696969697
r10894 n7027 n7028 0.72916666666666663
r10895 n6974 n7029 0.0625
r10896 n6975 n7030 0.0625
r10897 n7029 n7030 0.20833333333333334
r10898 n6976 n7031 0.3125
r10899 n7030 n7031 0.125
r10900 n6977 n7032 0.15625
r10901 n7031 n7032 0.0625
r10902 n6978 n7033 0.3125
r10903 n7032 n7033 0.0625
r10904 n6979 n7034 0.3125
r10905 n7033 n7034 0.041666666666666664
r10906 n6980 n7035 0.3125
r10907 n7034 n7035 0.041666666666666664
r10908 n6981 n7036 0.078125
r10909 n7035 n7036 0.10416666666666667
r10910 n6982 n7037 0.0625
r10911 n7036 n7037 0.1875
r10912 n6983 n7038 0.3125
r10913 n7037 n7038 0.125
r10914 n6984 n7039 0.03125
r10915 n7038 n7039 0.22916666666666666
r10916 n6985 n7040 0.10416666666666667
r10917 n7039 n7040 0.27083333333333331
r10918 n6986 n7041 0.052083333333333336
r10919 n7040 n7041 0.1875
r10920 n6987 n7042 0.15625
r10921 n7041 n7042 0.16666666666666666
r10922 n6988 n7043 0.3125
r10923 n7042 n7043 0.0625
r10924 n6989 n7044 0.3125
r10925 n7043 n7044 0.041666666666666664
r10926 n6990 n7045 0.052083333333333336
r10927 n7044 n7045 0.14583333333333334
r10928 n6991 n7046 0.0625
r10929 n7045 n7046 0.22916666666666666
r10930 n6992 n7047 0.3125
r10931 n7046 n7047 0.125
r10932 n6993 n7048 0.078125
r10933 n7047 n7048 0.10416666666666667
r10934 n6994 n7049 0.0625
r10935 n7048 n7049 0.1875
r10936 n6995 n7050 0.10416666666666667
r10937 n7049 n7050 0.16666666666666666
r10938 n6996 n7051 0.044642857142857144
r10939 n7050 n7051 0.20833333333333334
r10940 n6997 n7052 0.044642857142857144
r10941 n6998 n7053 0.017361111111111112
r10942 n7052 n7053 0.52083333333333337
r10943 n6999 n7054 0.01953125
r10944 n7053 n7054 0.70833333333333337
r10945 n7000 n7055 0.022321428571428572
r10946 n7054 n7055 0.625
r10947 n7001 n7056 0.015625
r10948 n7055 n7056 0.70833333333333337
r10949 n7002 n7057 0.0625
r10950 n7056 n7057 0.52083333333333337
r10951 n7003 n7058 0.010775862068965518
r10952 n7057 n7058 0.70833333333333337
r10953 n7004 n7059 0.0091911764705882356
r10954 n7058 n7059 1.3125
r10955 n7005 n7060 0.0091911764705882356
r10956 n7059 n7060 1.4166666666666667
r10957 n7006 n7061 0.0091911764705882356
r10958 n7060 n7061 1.4166666666666667
r10959 n7007 n7062 0.0078125
r10960 n7061 n7062 1.5416666666666667
r10961 n7008 n7063 0.0091911764705882356
r10962 n7062 n7063 1.5416666666666667
r10963 n7009 n7064 0.0091911764705882356
r10964 n7063 n7064 1.4166666666666667
r10965 n7010 n7065 0.0091911764705882356
r10966 n7064 n7065 1.4166666666666667
r10967 n7011 n7066 0.018382352941176471
r10968 n7065 n7066 1.0625
r10969 n7012 n7067 0.018382352941176471
r10970 n7066 n7067 0.70833333333333337
r10971 n7013 n7068 0.007621951219512195
r10972 n7067 n7068 1.2083333333333333
r10973 n7014 n7069 0.007621951219512195
r10974 n7068 n7069 1.7083333333333333
r10975 n7015 n7070 0.007621951219512195
r10976 n7069 n7070 1.7083333333333333
r10977 n7016 n7071 0.03125
r10978 n7070 n7071 1.0625
r10979 n7017 n7072 0.03125
r10980 n7071 n7072 0.41666666666666669
r10981 n7018 n7073 0.012500000000000001
r10982 n7072 n7073 0.72916666666666663
r10983 n7019 n7074 0.3125
r10984 n7073 n7074 0.54166666666666663
r10985 n7020 n7075 0.011160714285714286
r10986 n7074 n7075 0.60416666666666663
r10987 n7021 n7076 0.3125
r10988 n7075 n7076 0.60416666666666663
r10989 n7022 n7077 0.012500000000000001
r10990 n7076 n7077 0.54166666666666663
r10991 n7023 n7078 0.03125
r10992 n7077 n7078 0.72916666666666663
r10993 n7024 n7079 0.015151515151515152
r10994 n7025 n7080 0.25
r10995 n7079 n7080 0.4375
r10996 n7026 n7081 0.016666666666666666
r10997 n7080 n7081 0.40000000000000002
r10998 n7027 n7082 0.25
r10999 n7081 n7082 0.40000000000000002
r11000 n7028 n7083 0.015151515151515152
r11001 n7082 n7083 0.4375
r11002 n7029 n7084 0.10000000000000001
r11003 n7030 n7085 0.10000000000000001
r11004 n7084 n7085 0.125
r11005 n7031 n7086 0.5
r11006 n7085 n7086 0.074999999999999997
r11007 n7032 n7087 0.25
r11008 n7086 n7087 0.037499999999999999
r11009 n7033 n7088 0.5
r11010 n7087 n7088 0.037499999999999999
r11011 n7034 n7089 0.5
r11012 n7088 n7089 0.025000000000000001
r11013 n7035 n7090 0.5
r11014 n7089 n7090 0.025000000000000001
r11015 n7036 n7091 0.125
r11016 n7090 n7091 0.0625
r11017 n7037 n7092 0.10000000000000001
r11018 n7091 n7092 0.1125
r11019 n7038 n7093 0.5
r11020 n7092 n7093 0.074999999999999997
r11021 n7039 n7094 0.050000000000000003
r11022 n7093 n7094 0.13750000000000001
r11023 n7040 n7095 0.16666666666666666
r11024 n7094 n7095 0.16250000000000001
r11025 n7041 n7096 0.083333333333333329
r11026 n7095 n7096 0.1125
r11027 n7042 n7097 0.25
r11028 n7096 n7097 0.10000000000000001
r11029 n7043 n7098 0.5
r11030 n7097 n7098 0.037499999999999999
r11031 n7044 n7099 0.5
r11032 n7098 n7099 0.025000000000000001
r11033 n7045 n7100 0.083333333333333329
r11034 n7099 n7100 0.087499999999999994
r11035 n7046 n7101 0.10000000000000001
r11036 n7100 n7101 0.13750000000000001
r11037 n7047 n7102 0.5
r11038 n7101 n7102 0.074999999999999997
r11039 n7048 n7103 0.125
r11040 n7102 n7103 0.0625
r11041 n7049 n7104 0.10000000000000001
r11042 n7103 n7104 0.1125
r11043 n7050 n7105 0.16666666666666666
r11044 n7104 n7105 0.10000000000000001
r11045 n7051 n7106 0.071428571428571425
r11046 n7105 n7106 0.125
r11047 n7052 n7107 0.071428571428571425
r11048 n7053 n7108 0.027777777777777776
r11049 n7107 n7108 0.3125
r11050 n7054 n7109 0.03125
r11051 n7108 n7109 0.42499999999999999
r11052 n7055 n7110 0.035714285714285712
r11053 n7109 n7110 0.375
r11054 n7056 n7111 0.025000000000000001
r11055 n7110 n7111 0.42499999999999999
r11056 n7057 n7112 0.10000000000000001
r11057 n7111 n7112 0.3125
r11058 n7058 n7113 0.017241379310344827
r11059 n7112 n7113 0.42499999999999999
r11060 n7059 n7114 0.014705882352941176
r11061 n7113 n7114 0.78749999999999998
r11062 n7060 n7115 0.014705882352941176
r11063 n7114 n7115 0.84999999999999998
r11064 n7061 n7116 0.014705882352941176
r11065 n7115 n7116 0.84999999999999998
r11066 n7062 n7117 0.012500000000000001
r11067 n7116 n7117 0.92500000000000004
r11068 n7063 n7118 0.014705882352941176
r11069 n7117 n7118 0.92500000000000004
r11070 n7064 n7119 0.014705882352941176
r11071 n7118 n7119 0.84999999999999998
r11072 n7065 n7120 0.014705882352941176
r11073 n7119 n7120 0.84999999999999998
r11074 n7066 n7121 0.029411764705882353
r11075 n7120 n7121 0.63749999999999996
r11076 n7067 n7122 0.029411764705882353
r11077 n7121 n7122 0.42499999999999999
r11078 n7068 n7123 0.012195121951219513
r11079 n7122 n7123 0.72499999999999998
r11080 n7069 n7124 0.012195121951219513
r11081 n7123 n7124 1.0249999999999999
r11082 n7070 n7125 0.012195121951219513
r11083 n7124 n7125 1.0249999999999999
r11084 n7071 n7126 0.050000000000000003
r11085 n7125 n7126 0.63749999999999996
r11086 n7072 n7127 0.050000000000000003
r11087 n7126 n7127 0.25
r11088 n7073 n7128 0.02
r11089 n7127 n7128 0.4375
r11090 n7074 n7129 0.5
r11091 n7128 n7129 0.32500000000000001
r11092 n7075 n7130 0.017857142857142856
r11093 n7129 n7130 0.36249999999999999
r11094 n7076 n7131 0.5
r11095 n7130 n7131 0.36249999999999999
r11096 n7077 n7132 0.02
r11097 n7131 n7132 0.32500000000000001
r11098 n7078 n7133 0.050000000000000003
r11099 n7132 n7133 0.4375
r11100 n7079 n7134 0.015151515151515152
r11101 n7080 n7135 0.25
r11102 n7134 n7135 0.72916666666666663
r11103 n7081 n7136 0.016666666666666666
r11104 n7135 n7136 0.66666666666666663
r11105 n7082 n7137 0.25
r11106 n7136 n7137 0.66666666666666663
r11107 n7083 n7138 0.015151515151515152
r11108 n7137 n7138 0.72916666666666663
r11109 n7084 n7139 0.10000000000000001
r11110 n7085 n7140 0.10000000000000001
r11111 n7139 n7140 0.20833333333333334
r11112 n7086 n7141 0.5
r11113 n7140 n7141 0.125
r11114 n7087 n7142 0.25
r11115 n7141 n7142 0.0625
r11116 n7088 n7143 0.5
r11117 n7142 n7143 0.0625
r11118 n7089 n7144 0.5
r11119 n7143 n7144 0.041666666666666664
r11120 n7090 n7145 0.5
r11121 n7144 n7145 0.041666666666666664
r11122 n7091 n7146 0.125
r11123 n7145 n7146 0.10416666666666667
r11124 n7092 n7147 0.10000000000000001
r11125 n7146 n7147 0.1875
r11126 n7093 n7148 0.5
r11127 n7147 n7148 0.125
r11128 n7094 n7149 0.050000000000000003
r11129 n7148 n7149 0.22916666666666666
r11130 n7095 n7150 0.16666666666666666
r11131 n7149 n7150 0.27083333333333331
r11132 n7096 n7151 0.083333333333333329
r11133 n7150 n7151 0.1875
r11134 n7097 n7152 0.25
r11135 n7151 n7152 0.16666666666666666
r11136 n7098 n7153 0.5
r11137 n7152 n7153 0.0625
r11138 n7099 n7154 0.5
r11139 n7153 n7154 0.041666666666666664
r11140 n7100 n7155 0.083333333333333329
r11141 n7154 n7155 0.14583333333333334
r11142 n7101 n7156 0.10000000000000001
r11143 n7155 n7156 0.22916666666666666
r11144 n7102 n7157 0.5
r11145 n7156 n7157 0.125
r11146 n7103 n7158 0.125
r11147 n7157 n7158 0.10416666666666667
r11148 n7104 n7159 0.10000000000000001
r11149 n7158 n7159 0.1875
r11150 n7105 n7160 0.16666666666666666
r11151 n7159 n7160 0.16666666666666666
r11152 n7106 n7161 0.071428571428571425
r11153 n7160 n7161 0.20833333333333334
r11154 n7107 n7162 0.071428571428571425
r11155 n7108 n7163 0.027777777777777776
r11156 n7162 n7163 0.52083333333333337
r11157 n7109 n7164 0.03125
r11158 n7163 n7164 0.70833333333333337
r11159 n7110 n7165 0.035714285714285712
r11160 n7164 n7165 0.625
r11161 n7111 n7166 0.025000000000000001
r11162 n7165 n7166 0.70833333333333337
r11163 n7112 n7167 0.10000000000000001
r11164 n7166 n7167 0.52083333333333337
r11165 n7113 n7168 0.017241379310344827
r11166 n7167 n7168 0.70833333333333337
r11167 n7114 n7169 0.014705882352941176
r11168 n7168 n7169 1.3125
r11169 n7115 n7170 0.014705882352941176
r11170 n7169 n7170 1.4166666666666667
r11171 n7116 n7171 0.014705882352941176
r11172 n7170 n7171 1.4166666666666667
r11173 n7117 n7172 0.012500000000000001
r11174 n7171 n7172 1.5416666666666667
r11175 n7118 n7173 0.014705882352941176
r11176 n7172 n7173 1.5416666666666667
r11177 n7119 n7174 0.014705882352941176
r11178 n7173 n7174 1.4166666666666667
r11179 n7120 n7175 0.014705882352941176
r11180 n7174 n7175 1.4166666666666667
r11181 n7121 n7176 0.029411764705882353
r11182 n7175 n7176 1.0625
r11183 n7122 n7177 0.029411764705882353
r11184 n7176 n7177 0.70833333333333337
r11185 n7123 n7178 0.012195121951219513
r11186 n7177 n7178 1.2083333333333333
r11187 n7124 n7179 0.012195121951219513
r11188 n7178 n7179 1.7083333333333333
r11189 n7125 n7180 0.012195121951219513
r11190 n7179 n7180 1.7083333333333333
r11191 n7126 n7181 0.050000000000000003
r11192 n7180 n7181 1.0625
r11193 n7127 n7182 0.050000000000000003
r11194 n7181 n7182 0.41666666666666669
r11195 n7128 n7183 0.02
r11196 n7182 n7183 0.72916666666666663
r11197 n7129 n7184 0.5
r11198 n7183 n7184 0.54166666666666663
r11199 n7130 n7185 0.017857142857142856
r11200 n7184 n7185 0.60416666666666663
r11201 n7131 n7186 0.5
r11202 n7185 n7186 0.60416666666666663
r11203 n7132 n7187 0.02
r11204 n7186 n7187 0.54166666666666663
r11205 n7133 n7188 0.050000000000000003
r11206 n7187 n7188 0.72916666666666663
r11207 n7134 n7189 0.00946969696969697
r11208 n7135 n7190 0.15625
r11209 n7189 n7190 1.09375
r11210 n7136 n7191 0.010416666666666666
r11211 n7190 n7191 1
r11212 n7137 n7192 0.15625
r11213 n7191 n7192 1
r11214 n7138 n7193 0.00946969696969697
r11215 n7192 n7193 1.09375
r11216 n7139 n7194 0.0625
r11217 n7140 n7195 0.0625
r11218 n7194 n7195 0.3125
r11219 n7141 n7196 0.3125
r11220 n7195 n7196 0.1875
r11221 n7142 n7197 0.15625
r11222 n7196 n7197 0.09375
r11223 n7143 n7198 0.3125
r11224 n7197 n7198 0.09375
r11225 n7144 n7199 0.3125
r11226 n7198 n7199 0.0625
r11227 n7145 n7200 0.3125
r11228 n7199 n7200 0.0625
r11229 n7146 n7201 0.078125
r11230 n7200 n7201 0.15625
r11231 n7147 n7202 0.0625
r11232 n7201 n7202 0.28125
r11233 n7148 n7203 0.3125
r11234 n7202 n7203 0.1875
r11235 n7149 n7204 0.03125
r11236 n7203 n7204 0.34375
r11237 n7150 n7205 0.10416666666666667
r11238 n7204 n7205 0.40625
r11239 n7151 n7206 0.052083333333333336
r11240 n7205 n7206 0.28125
r11241 n7152 n7207 0.15625
r11242 n7206 n7207 0.25
r11243 n7153 n7208 0.3125
r11244 n7207 n7208 0.09375
r11245 n7154 n7209 0.3125
r11246 n7208 n7209 0.0625
r11247 n7155 n7210 0.052083333333333336
r11248 n7209 n7210 0.21875
r11249 n7156 n7211 0.0625
r11250 n7210 n7211 0.34375
r11251 n7157 n7212 0.3125
r11252 n7211 n7212 0.1875
r11253 n7158 n7213 0.078125
r11254 n7212 n7213 0.15625
r11255 n7159 n7214 0.0625
r11256 n7213 n7214 0.28125
r11257 n7160 n7215 0.10416666666666667
r11258 n7214 n7215 0.25
r11259 n7161 n7216 0.044642857142857144
r11260 n7215 n7216 0.3125
r11261 n7162 n7217 0.044642857142857144
r11262 n7163 n7218 0.017361111111111112
r11263 n7217 n7218 0.78125
r11264 n7164 n7219 0.01953125
r11265 n7218 n7219 1.0625
r11266 n7165 n7220 0.022321428571428572
r11267 n7219 n7220 0.9375
r11268 n7166 n7221 0.015625
r11269 n7220 n7221 1.0625
r11270 n7167 n7222 0.0625
r11271 n7221 n7222 0.78125
r11272 n7182 n7223 0.03125
r11273 n7183 n7224 0.012500000000000001
r11274 n7223 n7224 1.09375
r11275 n7184 n7225 0.3125
r11276 n7224 n7225 0.8125
r11277 n7185 n7226 0.011160714285714286
r11278 n7225 n7226 0.90625
r11279 n7186 n7227 0.3125
r11280 n7226 n7227 0.90625
r11281 n7187 n7228 0.012500000000000001
r11282 n7227 n7228 0.8125
r11283 n7188 n7229 0.03125
r11284 n7228 n7229 1.09375
r11285 n7189 n7230 0.022727272727272728
r11286 n7190 n7231 0.375
r11287 n7230 n7231 0.21875
r11288 n7191 n7232 0.025000000000000001
r11289 n7231 n7232 0.20000000000000001
r11290 n7192 n7233 0.375
r11291 n7232 n7233 0.20000000000000001
r11292 n7193 n7234 0.022727272727272728
r11293 n7233 n7234 0.21875
r11294 n7194 n7235 0.14999999999999999
r11295 n7195 n7236 0.14999999999999999
r11296 n7235 n7236 0.0625
r11297 n7196 n7237 0.75
r11298 n7236 n7237 0.037499999999999999
r11299 n7197 n7238 0.375
r11300 n7237 n7238 0.018749999999999999
r11301 n7198 n7239 0.75
r11302 n7238 n7239 0.018749999999999999
r11303 n7199 n7240 0.75
r11304 n7239 n7240 0.012500000000000001
r11305 n7200 n7241 0.75
r11306 n7240 n7241 0.012500000000000001
r11307 n7201 n7242 0.1875
r11308 n7241 n7242 0.03125
r11309 n7202 n7243 0.14999999999999999
r11310 n7242 n7243 0.056250000000000001
r11311 n7203 n7244 0.75
r11312 n7243 n7244 0.037499999999999999
r11313 n7204 n7245 0.074999999999999997
r11314 n7244 n7245 0.068750000000000006
r11315 n7205 n7246 0.25
r11316 n7245 n7246 0.081250000000000003
r11317 n7206 n7247 0.125
r11318 n7246 n7247 0.056250000000000001
r11319 n7207 n7248 0.375
r11320 n7247 n7248 0.050000000000000003
r11321 n7208 n7249 0.75
r11322 n7248 n7249 0.018749999999999999
r11323 n7209 n7250 0.75
r11324 n7249 n7250 0.012500000000000001
r11325 n7210 n7251 0.125
r11326 n7250 n7251 0.043749999999999997
r11327 n7211 n7252 0.14999999999999999
r11328 n7251 n7252 0.068750000000000006
r11329 n7212 n7253 0.75
r11330 n7252 n7253 0.037499999999999999
r11331 n7213 n7254 0.1875
r11332 n7253 n7254 0.03125
r11333 n7214 n7255 0.14999999999999999
r11334 n7254 n7255 0.056250000000000001
r11335 n7215 n7256 0.25
r11336 n7255 n7256 0.050000000000000003
r11337 n7216 n7257 0.10714285714285714
r11338 n7256 n7257 0.0625
r11339 n7223 n7258 0.074999999999999997
r11340 n7224 n7259 0.029999999999999999
r11341 n7258 n7259 0.21875
r11342 n7225 n7260 0.75
r11343 n7259 n7260 0.16250000000000001
r11344 n7226 n7261 0.026785714285714284
r11345 n7260 n7261 0.18124999999999999
r11346 n7227 n7262 0.75
r11347 n7261 n7262 0.18124999999999999
r11348 n7228 n7263 0.029999999999999999
r11349 n7262 n7263 0.16250000000000001
r11350 n7229 n7264 0.074999999999999997
r11351 n7263 n7264 0.21875
r11352 n7230 n7265 0.039772727272727272
r11353 n7231 n7266 0.65625
r11354 n7265 n7266 0.19886363636363635
r11355 n7232 n7267 0.043749999999999997
r11356 n7266 n7267 0.18181818181818182
r11357 n7233 n7268 0.65625
r11358 n7267 n7268 0.18181818181818182
r11359 n7234 n7269 0.039772727272727272
r11360 n7268 n7269 0.19886363636363635
r11361 n7258 n7270 0.13125000000000001
r11362 n7259 n7271 0.052499999999999998
r11363 n7270 n7271 0.19886363636363635
r11364 n7260 n7272 1.3125
r11365 n7271 n7272 0.14772727272727273
r11366 n7261 n7273 0.046875
r11367 n7272 n7273 0.16477272727272727
r11368 n7262 n7274 1.3125
r11369 n7273 n7274 0.16477272727272727
r11370 n7263 n7275 0.052499999999999998
r11371 n7274 n7275 0.14772727272727273
r11372 n7264 n7276 0.13125000000000001
r11373 n7275 n7276 0.19886363636363635
r11374 n7265 n7277 0.096590909090909088
r11375 n7266 n7278 1.59375
r11376 n7277 n7278 0.0546875
r11377 n7267 n7279 0.10625
r11378 n7278 n7279 0.050000000000000003
r11379 n7268 n7280 1.59375
r11380 n7279 n7280 0.050000000000000003
r11381 n7269 n7281 0.096590909090909088
r11382 n7280 n7281 0.0546875
r11383 n7270 n7282 0.31874999999999998
r11384 n7271 n7283 0.1275
r11385 n7282 n7283 0.0546875
r11386 n7272 n7284 3.1875
r11387 n7283 n7284 0.040625000000000001
r11388 n7273 n7285 0.11383928571428571
r11389 n7284 n7285 0.045312499999999999
r11390 n7274 n7286 3.1875
r11391 n7285 n7286 0.045312499999999999
r11392 n7275 n7287 0.1275
r11393 n7286 n7287 0.040625000000000001
r11394 n7276 n7288 0.31874999999999998
r11395 n7287 n7288 0.0546875
r11396 n7277 n7289 0.15151515151515152
r11397 n7278 n7290 2.5
r11398 n7289 n7290 0.0546875
r11399 n7279 n7291 0.16666666666666666
r11400 n7290 n7291 0.050000000000000003
r11401 n7280 n7292 2.5
r11402 n7291 n7292 0.050000000000000003
r11403 n7281 n7293 0.15151515151515152
r11404 n7292 n7293 0.0546875
r11405 n7282 n7294 0.5
r11406 n7283 n7295 0.20000000000000001
r11407 n7294 n7295 0.0546875
r11408 n7284 n7296 5
r11409 n7295 n7296 0.040625000000000001
r11410 n7285 n7297 0.17857142857142858
r11411 n7296 n7297 0.045312499999999999
r11412 n7286 n7298 5
r11413 n7297 n7298 0.045312499999999999
r11414 n7287 n7299 0.20000000000000001
r11415 n7298 n7299 0.040625000000000001
r11416 n7288 n7300 0.5
r11417 n7299 n7300 0.0546875
r11418 n7289 n7301 0.14015151515151514
r11419 n7290 n7302 2.3125
r11420 n7301 n7302 0.064338235294117641
r11421 n7291 n7303 0.15416666666666667
r11422 n7302 n7303 0.058823529411764705
r11423 n7292 n7304 2.3125
r11424 n7303 n7304 0.058823529411764705
r11425 n7293 n7305 0.14015151515151514
r11426 n7304 n7305 0.064338235294117641
r11427 n7294 n7306 0.46250000000000002
r11428 n7295 n7307 0.185
r11429 n7306 n7307 0.064338235294117641
r11430 n7296 n7308 4.625
r11431 n7307 n7308 0.04779411764705882
r11432 n7297 n7309 0.16517857142857142
r11433 n7308 n7309 0.053308823529411763
r11434 n7298 n7310 4.625
r11435 n7309 n7310 0.053308823529411763
r11436 n7299 n7311 0.185
r11437 n7310 n7311 0.04779411764705882
r11438 n7300 n7312 0.46250000000000002
r11439 n7311 n7312 0.064338235294117641
r11440 n7301 n7313 0.14734848484848484
r11441 n7302 n7314 2.4312499999999999
r11442 n7313 n7314 0.049942922374429224
r11443 n7303 n7315 0.16208333333333333
r11444 n7314 n7315 0.045662100456621002
r11445 n7304 n7316 2.4312499999999999
r11446 n7315 n7316 0.045662100456621002
r11447 n7305 n7317 0.14734848484848484
r11448 n7316 n7317 0.049942922374429224
r11449 n7306 n7318 0.48625000000000002
r11450 n7307 n7319 0.19450000000000001
r11451 n7318 n7319 0.049942922374429224
r11452 n7308 n7320 4.8624999999999998
r11453 n7319 n7320 0.037100456621004564
r11454 n7309 n7321 0.17366071428571428
r11455 n7320 n7321 0.041381278538812787
r11456 n7310 n7322 4.8624999999999998
r11457 n7321 n7322 0.041381278538812787
r11458 n7311 n7323 0.19450000000000001
r11459 n7322 n7323 0.037100456621004564
r11460 n7312 n7324 0.48625000000000002
r11461 n7323 n7324 0.049942922374429224
r11462 n7313 n7325 0.16553030303030303
r11463 n7314 n7326 2.7312500000000002
r11464 n7325 n7326 0.050172018348623851
r11465 n7315 n7327 0.18208333333333335
r11466 n7326 n7327 0.045871559633027525
r11467 n7316 n7328 2.7312500000000002
r11468 n7327 n7328 0.045871559633027525
r11469 n7317 n7329 0.16553030303030303
r11470 n7328 n7329 0.050172018348623851
r11471 n7318 n7330 0.54625000000000001
r11472 n7319 n7331 0.2185
r11473 n7330 n7331 0.050172018348623851
r11474 n7320 n7332 5.4625000000000004
r11475 n7331 n7332 0.037270642201834861
r11476 n7321 n7333 0.19508928571428572
r11477 n7332 n7333 0.041571100917431193
r11478 n7322 n7334 5.4625000000000004
r11479 n7333 n7334 0.041571100917431193
r11480 n7323 n7335 0.2185
r11481 n7334 n7335 0.037270642201834861
r11482 n7324 n7336 0.54625000000000001
r11483 n7335 n7336 0.050172018348623851
r11484 n7325 n7337 0.16553030303030303
r11485 n7326 n7338 2.7312500000000002
r11486 n7337 n7338 0.049942922374429224
r11487 n7327 n7339 0.18208333333333335
r11488 n7338 n7339 0.045662100456621002
r11489 n7328 n7340 2.7312500000000002
r11490 n7339 n7340 0.045662100456621002
r11491 n7329 n7341 0.16553030303030303
r11492 n7340 n7341 0.049942922374429224
r11493 n7330 n7342 0.54625000000000001
r11494 n7331 n7343 0.2185
r11495 n7342 n7343 0.049942922374429224
r11496 n7332 n7344 5.4625000000000004
r11497 n7343 n7344 0.037100456621004564
r11498 n7333 n7345 0.19508928571428572
r11499 n7344 n7345 0.041381278538812787
r11500 n7334 n7346 5.4625000000000004
r11501 n7345 n7346 0.041381278538812787
r11502 n7335 n7347 0.2185
r11503 n7346 n7347 0.037100456621004564
r11504 n7336 n7348 0.54625000000000001
r11505 n7347 n7348 0.049942922374429224
r11506 n7337 n7349 0.16590909090909092
r11507 n7338 n7350 2.7374999999999998
r11508 n7349 n7350 0.049942922374429224
r11509 n7339 n7351 0.1825
r11510 n7350 n7351 0.045662100456621002
r11511 n7340 n7352 2.7374999999999998
r11512 n7351 n7352 0.045662100456621002
r11513 n7341 n7353 0.16590909090909092
r11514 n7352 n7353 0.049942922374429224
r11515 n7342 n7354 0.54749999999999999
r11516 n7343 n7355 0.219
r11517 n7354 n7355 0.049942922374429224
r11518 n7344 n7356 5.4749999999999996
r11519 n7355 n7356 0.037100456621004564
r11520 n7345 n7357 0.19553571428571428
r11521 n7356 n7357 0.041381278538812787
r11522 n7346 n7358 5.4749999999999996
r11523 n7357 n7358 0.041381278538812787
r11524 n7347 n7359 0.219
r11525 n7358 n7359 0.037100456621004564
r11526 n7348 n7360 0.54749999999999999
r11527 n7359 n7360 0.049942922374429224
r11528 n7349 n7361 0.15227272727272728
r11529 n7350 n7362 2.5125000000000002
r11530 n7361 n7362 0.059767759562841527
r11531 n7351 n7363 0.16750000000000001
r11532 n7362 n7363 0.054644808743169397
r11533 n7352 n7364 2.5125000000000002
r11534 n7363 n7364 0.054644808743169397
r11535 n7353 n7365 0.15227272727272728
r11536 n7364 n7365 0.059767759562841527
r11537 n7354 n7366 0.50249999999999995
r11538 n7355 n7367 0.20100000000000001
r11539 n7366 n7367 0.059767759562841527
r11540 n7356 n7368 5.0250000000000004
r11541 n7367 n7368 0.044398907103825137
r11542 n7357 n7369 0.17946428571428572
r11543 n7368 n7369 0.049521857923497267
r11544 n7358 n7370 5.0250000000000004
r11545 n7369 n7370 0.049521857923497267
r11546 n7359 n7371 0.20100000000000001
r11547 n7370 n7371 0.044398907103825137
r11548 n7360 n7372 0.50249999999999995
r11549 n7371 n7372 0.059767759562841527
r11550 n7361 n7373 0.13901515151515151
r11551 n7362 n7374 2.2937500000000002
r11552 n7373 n7374 0.059442934782608696
r11553 n7363 n7375 0.15291666666666667
r11554 n7374 n7375 0.05434782608695652
r11555 n7364 n7376 2.2937500000000002
r11556 n7375 n7376 0.05434782608695652
r11557 n7365 n7377 0.13901515151515151
r11558 n7376 n7377 0.059442934782608696
r11559 n7366 n7378 0.45874999999999999
r11560 n7367 n7379 0.1835
r11561 n7378 n7379 0.059442934782608696
r11562 n7368 n7380 4.5875000000000004
r11563 n7379 n7380 0.044157608695652176
r11564 n7369 n7381 0.16383928571428572
r11565 n7380 n7381 0.049252717391304345
r11566 n7370 n7382 4.5875000000000004
r11567 n7381 n7382 0.049252717391304345
r11568 n7371 n7383 0.1835
r11569 n7382 n7383 0.044157608695652176
r11570 n7372 n7384 0.45874999999999999
r11571 n7383 n7384 0.059442934782608696
r11572 n7373 n7385 0.13901515151515151
r11573 n7374 n7386 2.2937500000000002
r11574 n7385 n7386 0.059767759562841527
r11575 n7375 n7387 0.15291666666666667
r11576 n7386 n7387 0.054644808743169397
r11577 n7376 n7388 2.2937500000000002
r11578 n7387 n7388 0.054644808743169397
r11579 n7377 n7389 0.13901515151515151
r11580 n7388 n7389 0.059767759562841527
r11581 n7378 n7390 0.45874999999999999
r11582 n7379 n7391 0.1835
r11583 n7390 n7391 0.059767759562841527
r11584 n7380 n7392 4.5875000000000004
r11585 n7391 n7392 0.044398907103825137
r11586 n7381 n7393 0.16383928571428572
r11587 n7392 n7393 0.049521857923497267
r11588 n7382 n7394 4.5875000000000004
r11589 n7393 n7394 0.049521857923497267
r11590 n7383 n7395 0.1835
r11591 n7394 n7395 0.044398907103825137
r11592 n7384 n7396 0.45874999999999999
r11593 n7395 n7396 0.059767759562841527
r11594 n7397 n7398 0.17624999999999999
r11595 n7398 n7399 0.11750000000000001
r11596 n7399 n7400 0.070499999999999993
r11597 n7400 n7401 0.047
r11598 n7401 n7402 0.047
r11599 n7402 n7403 0.11750000000000001
r11600 n7403 n7404 0.22325
r11601 n7404 n7405 0.17624999999999999
r11602 n7405 n7406 0.11750000000000001
r11603 n7406 n7407 0.070499999999999993
r11604 n7407 n7408 0.035249999999999997
r11605 n7408 n7409 0.035249999999999997
r11606 n7409 n7410 0.0235
r11607 n7410 n7411 0.0235
r11608 n7411 n7412 0.058750000000000004
r11609 n7412 n7413 0.10575000000000001
r11610 n7413 n7414 0.070499999999999993
r11611 n7414 n7415 0.12925
r11612 n7397 n7416 0.0093999999999999986
r11613 n7398 n7417 0.018799999999999997
r11614 n7416 n7417 0.17624999999999999
r11615 n7399 n7418 0.018799999999999997
r11616 n7417 n7418 0.11750000000000001
r11617 n7400 n7419 0.094
r11618 n7418 n7419 0.070499999999999993
r11619 n7401 n7420 0.031333333333333331
r11620 n7419 n7420 0.047
r11621 n7402 n7421 0.094
r11622 n7420 n7421 0.047
r11623 n7403 n7422 0.010444444444444444
r11624 n7421 n7422 0.11750000000000001
r11625 n7404 n7423 0.0093999999999999986
r11626 n7422 n7423 0.22325
r11627 n7405 n7424 0.018799999999999997
r11628 n7423 n7424 0.17624999999999999
r11629 n7406 n7425 0.018799999999999997
r11630 n7424 n7425 0.11750000000000001
r11631 n7407 n7426 0.094
r11632 n7425 n7426 0.070499999999999993
r11633 n7408 n7427 0.047
r11634 n7426 n7427 0.035249999999999997
r11635 n7409 n7428 0.094
r11636 n7427 n7428 0.035249999999999997
r11637 n7410 n7429 0.094
r11638 n7428 n7429 0.0235
r11639 n7411 n7430 0.094
r11640 n7429 n7430 0.0235
r11641 n7412 n7431 0.0235
r11642 n7430 n7431 0.058750000000000004
r11643 n7413 n7432 0.018799999999999997
r11644 n7431 n7432 0.10575000000000001
r11645 n7414 n7433 0.094
r11646 n7432 n7433 0.070499999999999993
r11647 n7415 n7434 0.0093999999999999986
r11648 n7433 n7434 0.12925
r11649 n7416 n7435 0.0093999999999999986
r11650 n7417 n7436 0.018799999999999997
r11651 n7435 n7436 0.17624999999999999
r11652 n7418 n7437 0.018799999999999997
r11653 n7436 n7437 0.11750000000000001
r11654 n7419 n7438 0.094
r11655 n7437 n7438 0.070499999999999993
r11656 n7420 n7439 0.031333333333333331
r11657 n7438 n7439 0.047
r11658 n7421 n7440 0.094
r11659 n7439 n7440 0.047
r11660 n7422 n7441 0.010444444444444444
r11661 n7440 n7441 0.11750000000000001
r11662 n7423 n7442 0.0093999999999999986
r11663 n7441 n7442 0.22325
r11664 n7424 n7443 0.018799999999999997
r11665 n7442 n7443 0.17624999999999999
r11666 n7425 n7444 0.018799999999999997
r11667 n7443 n7444 0.11750000000000001
r11668 n7426 n7445 0.094
r11669 n7444 n7445 0.070499999999999993
r11670 n7427 n7446 0.047
r11671 n7445 n7446 0.035249999999999997
r11672 n7428 n7447 0.094
r11673 n7446 n7447 0.035249999999999997
r11674 n7429 n7448 0.094
r11675 n7447 n7448 0.0235
r11676 n7430 n7449 0.094
r11677 n7448 n7449 0.0235
r11678 n7431 n7450 0.0235
r11679 n7449 n7450 0.058750000000000004
r11680 n7432 n7451 0.018799999999999997
r11681 n7450 n7451 0.10575000000000001
r11682 n7433 n7452 0.094
r11683 n7451 n7452 0.070499999999999993
r11684 n7434 n7453 0.0093999999999999986
r11685 n7452 n7453 0.12925
r11686 n7435 n7454 0.0141
r11687 n7436 n7455 0.028199999999999999
r11688 n7454 n7455 0.088124999999999995
r11689 n7437 n7456 0.028199999999999999
r11690 n7455 n7456 0.058750000000000004
r11691 n7438 n7457 0.14099999999999999
r11692 n7456 n7457 0.035249999999999997
r11693 n7439 n7458 0.047
r11694 n7457 n7458 0.0235
r11695 n7440 n7459 0.14099999999999999
r11696 n7458 n7459 0.0235
r11697 n7441 n7460 0.015666666666666666
r11698 n7459 n7460 0.058750000000000004
r11699 n7442 n7461 0.0141
r11700 n7460 n7461 0.111625
r11701 n7443 n7462 0.028199999999999999
r11702 n7461 n7462 0.088124999999999995
r11703 n7444 n7463 0.028199999999999999
r11704 n7462 n7463 0.058750000000000004
r11705 n7445 n7464 0.14099999999999999
r11706 n7463 n7464 0.035249999999999997
r11707 n7446 n7465 0.070499999999999993
r11708 n7464 n7465 0.017624999999999998
r11709 n7447 n7466 0.14099999999999999
r11710 n7465 n7466 0.017624999999999998
r11711 n7448 n7467 0.14099999999999999
r11712 n7466 n7467 0.01175
r11713 n7449 n7468 0.14099999999999999
r11714 n7467 n7468 0.01175
r11715 n7450 n7469 0.035249999999999997
r11716 n7468 n7469 0.029375000000000002
r11717 n7451 n7470 0.028199999999999999
r11718 n7469 n7470 0.052875000000000005
r11719 n7452 n7471 0.14099999999999999
r11720 n7470 n7471 0.035249999999999997
r11721 n7453 n7472 0.0141
r11722 n7471 n7472 0.064625000000000002
r11723 n7454 n7473 0.025849999999999998
r11724 n7455 n7474 0.051699999999999996
r11725 n7473 n7474 0.050357142857142857
r11726 n7456 n7475 0.051699999999999996
r11727 n7474 n7475 0.033571428571428572
r11728 n7457 n7476 0.25850000000000001
r11729 n7475 n7476 0.020142857142857143
r11730 n7458 n7477 0.086166666666666669
r11731 n7476 n7477 0.013428571428571429
r11732 n7459 n7478 0.25850000000000001
r11733 n7477 n7478 0.013428571428571429
r11734 n7460 n7479 0.028722222222222222
r11735 n7478 n7479 0.033571428571428572
r11736 n7461 n7480 0.025849999999999998
r11737 n7479 n7480 0.063785714285714279
r11738 n7462 n7481 0.051699999999999996
r11739 n7480 n7481 0.050357142857142857
r11740 n7463 n7482 0.051699999999999996
r11741 n7481 n7482 0.033571428571428572
r11742 n7464 n7483 0.25850000000000001
r11743 n7482 n7483 0.020142857142857143
r11744 n7465 n7484 0.12925
r11745 n7483 n7484 0.010071428571428571
r11746 n7466 n7485 0.25850000000000001
r11747 n7484 n7485 0.010071428571428571
r11748 n7467 n7486 0.25850000000000001
r11749 n7485 n7486 0.0067142857142857143
r11750 n7468 n7487 0.25850000000000001
r11751 n7486 n7487 0.0067142857142857143
r11752 n7469 n7488 0.064625000000000002
r11753 n7487 n7488 0.016785714285714286
r11754 n7470 n7489 0.051699999999999996
r11755 n7488 n7489 0.030214285714285718
r11756 n7471 n7490 0.25850000000000001
r11757 n7489 n7490 0.020142857142857143
r11758 n7472 n7491 0.025849999999999998
r11759 n7490 n7491 0.036928571428571429
r11760 n7473 n7492 0.0235
r11761 n7474 n7493 0.047
r11762 n7492 n7493 0.11749999999999999
r11763 n7475 n7494 0.047
r11764 n7493 n7494 0.078333333333333338
r11765 n7476 n7495 0.23500000000000001
r11766 n7494 n7495 0.047
r11767 n7477 n7496 0.078333333333333338
r11768 n7495 n7496 0.031333333333333331
r11769 n7478 n7497 0.23500000000000001
r11770 n7496 n7497 0.031333333333333331
r11771 n7479 n7498 0.026111111111111113
r11772 n7497 n7498 0.078333333333333338
r11773 n7480 n7499 0.0235
r11774 n7498 n7499 0.14883333333333332
r11775 n7481 n7500 0.047
r11776 n7499 n7500 0.11749999999999999
r11777 n7482 n7501 0.047
r11778 n7500 n7501 0.078333333333333338
r11779 n7483 n7502 0.23500000000000001
r11780 n7501 n7502 0.047
r11781 n7484 n7503 0.11750000000000001
r11782 n7502 n7503 0.0235
r11783 n7485 n7504 0.23500000000000001
r11784 n7503 n7504 0.0235
r11785 n7486 n7505 0.23500000000000001
r11786 n7504 n7505 0.015666666666666666
r11787 n7487 n7506 0.23500000000000001
r11788 n7505 n7506 0.015666666666666666
r11789 n7488 n7507 0.058750000000000004
r11790 n7506 n7507 0.039166666666666669
r11791 n7489 n7508 0.047
r11792 n7507 n7508 0.070500000000000007
r11793 n7490 n7509 0.23500000000000001
r11794 n7508 n7509 0.047
r11795 n7491 n7510 0.0235
r11796 n7509 n7510 0.086166666666666669
r11797 n7492 n7511 0.0141
r11798 n7493 n7512 0.028199999999999999
r11799 n7511 n7512 0.11749999999999999
r11800 n7494 n7513 0.028199999999999999
r11801 n7512 n7513 0.078333333333333338
r11802 n7495 n7514 0.14099999999999999
r11803 n7513 n7514 0.047
r11804 n7496 n7515 0.047
r11805 n7514 n7515 0.031333333333333331
r11806 n7497 n7516 0.14099999999999999
r11807 n7515 n7516 0.031333333333333331
r11808 n7498 n7517 0.015666666666666666
r11809 n7516 n7517 0.078333333333333338
r11810 n7499 n7518 0.0141
r11811 n7517 n7518 0.14883333333333332
r11812 n7500 n7519 0.028199999999999999
r11813 n7518 n7519 0.11749999999999999
r11814 n7501 n7520 0.028199999999999999
r11815 n7519 n7520 0.078333333333333338
r11816 n7502 n7521 0.14099999999999999
r11817 n7520 n7521 0.047
r11818 n7503 n7522 0.070499999999999993
r11819 n7521 n7522 0.0235
r11820 n7504 n7523 0.14099999999999999
r11821 n7522 n7523 0.0235
r11822 n7505 n7524 0.14099999999999999
r11823 n7523 n7524 0.015666666666666666
r11824 n7506 n7525 0.14099999999999999
r11825 n7524 n7525 0.015666666666666666
r11826 n7507 n7526 0.035249999999999997
r11827 n7525 n7526 0.039166666666666669
r11828 n7508 n7527 0.028199999999999999
r11829 n7526 n7527 0.070500000000000007
r11830 n7509 n7528 0.14099999999999999
r11831 n7527 n7528 0.047
r11832 n7510 n7529 0.0141
r11833 n7528 n7529 0.086166666666666669
r11834 n7511 n7530 0.01175
r11835 n7512 n7531 0.0235
r11836 n7530 n7531 0.17624999999999999
r11837 n7513 n7532 0.0235
r11838 n7531 n7532 0.11750000000000001
r11839 n7514 n7533 0.11750000000000001
r11840 n7532 n7533 0.070499999999999993
r11841 n7515 n7534 0.039166666666666669
r11842 n7533 n7534 0.047
r11843 n7516 n7535 0.11750000000000001
r11844 n7534 n7535 0.047
r11845 n7517 n7536 0.013055555555555556
r11846 n7535 n7536 0.11750000000000001
r11847 n7518 n7537 0.01175
r11848 n7536 n7537 0.22325
r11849 n7519 n7538 0.0235
r11850 n7537 n7538 0.17624999999999999
r11851 n7520 n7539 0.0235
r11852 n7538 n7539 0.11750000000000001
r11853 n7521 n7540 0.11750000000000001
r11854 n7539 n7540 0.070499999999999993
r11855 n7522 n7541 0.058750000000000004
r11856 n7540 n7541 0.035249999999999997
r11857 n7523 n7542 0.11750000000000001
r11858 n7541 n7542 0.035249999999999997
r11859 n7524 n7543 0.11750000000000001
r11860 n7542 n7543 0.0235
r11861 n7525 n7544 0.11750000000000001
r11862 n7543 n7544 0.0235
r11863 n7526 n7545 0.029375000000000002
r11864 n7544 n7545 0.058750000000000004
r11865 n7527 n7546 0.0235
r11866 n7545 n7546 0.10575000000000001
r11867 n7528 n7547 0.11750000000000001
r11868 n7546 n7547 0.070499999999999993
r11869 n7529 n7548 0.01175
r11870 n7547 n7548 0.12925
r11871 n7530 n7549 0.039949999999999999
r11872 n7531 n7550 0.079899999999999999
r11873 n7549 n7550 0.0235
r11874 n7532 n7551 0.079899999999999999
r11875 n7550 n7551 0.015666666666666666
r11876 n7533 n7552 0.39950000000000002
r11877 n7551 n7552 0.0093999999999999986
r11878 n7534 n7553 0.13316666666666668
r11879 n7552 n7553 0.006266666666666666
r11880 n7535 n7554 0.39950000000000002
r11881 n7553 n7554 0.006266666666666666
r11882 n7536 n7555 0.044388888888888887
r11883 n7554 n7555 0.015666666666666666
r11884 n7537 n7556 0.039949999999999999
r11885 n7555 n7556 0.029766666666666667
r11886 n7538 n7557 0.079899999999999999
r11887 n7556 n7557 0.0235
r11888 n7539 n7558 0.079899999999999999
r11889 n7557 n7558 0.015666666666666666
r11890 n7540 n7559 0.39950000000000002
r11891 n7558 n7559 0.0093999999999999986
r11892 n7541 n7560 0.19975000000000001
r11893 n7559 n7560 0.0046999999999999993
r11894 n7542 n7561 0.39950000000000002
r11895 n7560 n7561 0.0046999999999999993
r11896 n7543 n7562 0.39950000000000002
r11897 n7561 n7562 0.003133333333333333
r11898 n7544 n7563 0.39950000000000002
r11899 n7562 n7563 0.003133333333333333
r11900 n7545 n7564 0.099875000000000005
r11901 n7563 n7564 0.0078333333333333328
r11902 n7546 n7565 0.079899999999999999
r11903 n7564 n7565 0.014100000000000001
r11904 n7547 n7566 0.39950000000000002
r11905 n7565 n7566 0.0093999999999999986
r11906 n7548 n7567 0.039949999999999999
r11907 n7566 n7567 0.017233333333333333
r11908 n7549 n7568 0.070499999999999993
r11909 n7550 n7569 0.14099999999999999
r11910 n7568 n7569 0.0235
r11911 n7551 n7570 0.14099999999999999
r11912 n7569 n7570 0.015666666666666666
r11913 n7552 n7571 0.70499999999999996
r11914 n7570 n7571 0.0093999999999999986
r11915 n7553 n7572 0.23499999999999999
r11916 n7571 n7572 0.006266666666666666
r11917 n7554 n7573 0.70499999999999996
r11918 n7572 n7573 0.006266666666666666
r11919 n7555 n7574 0.078333333333333338
r11920 n7573 n7574 0.015666666666666666
r11921 n7556 n7575 0.070499999999999993
r11922 n7574 n7575 0.029766666666666667
r11923 n7557 n7576 0.14099999999999999
r11924 n7575 n7576 0.0235
r11925 n7558 n7577 0.14099999999999999
r11926 n7576 n7577 0.015666666666666666
r11927 n7559 n7578 0.70499999999999996
r11928 n7577 n7578 0.0093999999999999986
r11929 n7560 n7579 0.35249999999999998
r11930 n7578 n7579 0.0046999999999999993
r11931 n7561 n7580 0.70499999999999996
r11932 n7579 n7580 0.0046999999999999993
r11933 n7562 n7581 0.70499999999999996
r11934 n7580 n7581 0.003133333333333333
r11935 n7563 n7582 0.70499999999999996
r11936 n7581 n7582 0.003133333333333333
r11937 n7564 n7583 0.17624999999999999
r11938 n7582 n7583 0.0078333333333333328
r11939 n7565 n7584 0.14099999999999999
r11940 n7583 n7584 0.014100000000000001
r11941 n7566 n7585 0.70499999999999996
r11942 n7584 n7585 0.0093999999999999986
r11943 n7567 n7586 0.070499999999999993
r11944 n7585 n7586 0.017233333333333333
r11945 n7568 n7587 0.039949999999999999
r11946 n7569 n7588 0.079899999999999999
r11947 n7587 n7588 0.17624999999999999
r11948 n7570 n7589 0.079899999999999999
r11949 n7588 n7589 0.11750000000000001
r11950 n7571 n7590 0.39950000000000002
r11951 n7589 n7590 0.070499999999999993
r11952 n7572 n7591 0.13316666666666668
r11953 n7590 n7591 0.047
r11954 n7573 n7592 0.39950000000000002
r11955 n7591 n7592 0.047
r11956 n7574 n7593 0.044388888888888887
r11957 n7592 n7593 0.11750000000000001
r11958 n7575 n7594 0.039949999999999999
r11959 n7593 n7594 0.22325
r11960 n7576 n7595 0.079899999999999999
r11961 n7594 n7595 0.17624999999999999
r11962 n7577 n7596 0.079899999999999999
r11963 n7595 n7596 0.11750000000000001
r11964 n7578 n7597 0.39950000000000002
r11965 n7596 n7597 0.070499999999999993
r11966 n7579 n7598 0.19975000000000001
r11967 n7597 n7598 0.035249999999999997
r11968 n7580 n7599 0.39950000000000002
r11969 n7598 n7599 0.035249999999999997
r11970 n7581 n7600 0.39950000000000002
r11971 n7599 n7600 0.0235
r11972 n7582 n7601 0.39950000000000002
r11973 n7600 n7601 0.0235
r11974 n7583 n7602 0.099875000000000005
r11975 n7601 n7602 0.058750000000000004
r11976 n7584 n7603 0.079899999999999999
r11977 n7602 n7603 0.10575000000000001
r11978 n7585 n7604 0.39950000000000002
r11979 n7603 n7604 0.070499999999999993
r11980 n7586 n7605 0.039949999999999999
r11981 n7604 n7605 0.12925
r11982 n7587 n7606 0.01175
r11983 n7588 n7607 0.0235
r11984 n7606 n7607 0.11749999999999999
r11985 n7589 n7608 0.0235
r11986 n7607 n7608 0.078333333333333338
r11987 n7590 n7609 0.11750000000000001
r11988 n7608 n7609 0.047
r11989 n7591 n7610 0.039166666666666669
r11990 n7609 n7610 0.031333333333333331
r11991 n7592 n7611 0.11750000000000001
r11992 n7610 n7611 0.031333333333333331
r11993 n7593 n7612 0.013055555555555556
r11994 n7611 n7612 0.078333333333333338
r11995 n7594 n7613 0.01175
r11996 n7612 n7613 0.14883333333333332
r11997 n7595 n7614 0.0235
r11998 n7613 n7614 0.11749999999999999
r11999 n7596 n7615 0.0235
r12000 n7614 n7615 0.078333333333333338
r12001 n7597 n7616 0.11750000000000001
r12002 n7615 n7616 0.047
r12003 n7598 n7617 0.058750000000000004
r12004 n7616 n7617 0.0235
r12005 n7599 n7618 0.11750000000000001
r12006 n7617 n7618 0.0235
r12007 n7600 n7619 0.11750000000000001
r12008 n7618 n7619 0.015666666666666666
r12009 n7601 n7620 0.11750000000000001
r12010 n7619 n7620 0.015666666666666666
r12011 n7602 n7621 0.029375000000000002
r12012 n7620 n7621 0.039166666666666669
r12013 n7603 n7622 0.0235
r12014 n7621 n7622 0.070500000000000007
r12015 n7604 n7623 0.11750000000000001
r12016 n7622 n7623 0.047
r12017 n7605 n7624 0.01175
r12018 n7623 n7624 0.086166666666666669
r12019 n7606 n7625 0.0141
r12020 n7607 n7626 0.028199999999999999
r12021 n7625 n7626 0.11749999999999999
r12022 n7608 n7627 0.028199999999999999
r12023 n7626 n7627 0.078333333333333338
r12024 n7609 n7628 0.14099999999999999
r12025 n7627 n7628 0.047
r12026 n7610 n7629 0.047
r12027 n7628 n7629 0.031333333333333331
r12028 n7611 n7630 0.14099999999999999
r12029 n7629 n7630 0.031333333333333331
r12030 n7612 n7631 0.015666666666666666
r12031 n7630 n7631 0.078333333333333338
r12032 n7613 n7632 0.0141
r12033 n7631 n7632 0.14883333333333332
r12034 n7614 n7633 0.028199999999999999
r12035 n7632 n7633 0.11749999999999999
r12036 n7615 n7634 0.028199999999999999
r12037 n7633 n7634 0.078333333333333338
r12038 n7616 n7635 0.14099999999999999
r12039 n7634 n7635 0.047
r12040 n7617 n7636 0.070499999999999993
r12041 n7635 n7636 0.0235
r12042 n7618 n7637 0.14099999999999999
r12043 n7636 n7637 0.0235
r12044 n7619 n7638 0.14099999999999999
r12045 n7637 n7638 0.015666666666666666
r12046 n7620 n7639 0.14099999999999999
r12047 n7638 n7639 0.015666666666666666
r12048 n7621 n7640 0.035249999999999997
r12049 n7639 n7640 0.039166666666666669
r12050 n7622 n7641 0.028199999999999999
r12051 n7640 n7641 0.070500000000000007
r12052 n7623 n7642 0.14099999999999999
r12053 n7641 n7642 0.047
r12054 n7624 n7643 0.0141
r12055 n7642 n7643 0.086166666666666669
r12056 n7625 n7644 0.0235
r12057 n7626 n7645 0.047
r12058 n7644 n7645 0.050357142857142857
r12059 n7627 n7646 0.047
r12060 n7645 n7646 0.033571428571428572
r12061 n7628 n7647 0.23500000000000001
r12062 n7646 n7647 0.020142857142857143
r12063 n7629 n7648 0.078333333333333338
r12064 n7647 n7648 0.013428571428571429
r12065 n7630 n7649 0.23500000000000001
r12066 n7648 n7649 0.013428571428571429
r12067 n7631 n7650 0.026111111111111113
r12068 n7649 n7650 0.033571428571428572
r12069 n7632 n7651 0.0235
r12070 n7650 n7651 0.063785714285714279
r12071 n7633 n7652 0.047
r12072 n7651 n7652 0.050357142857142857
r12073 n7634 n7653 0.047
r12074 n7652 n7653 0.033571428571428572
r12075 n7635 n7654 0.23500000000000001
r12076 n7653 n7654 0.020142857142857143
r12077 n7636 n7655 0.11750000000000001
r12078 n7654 n7655 0.010071428571428571
r12079 n7637 n7656 0.23500000000000001
r12080 n7655 n7656 0.010071428571428571
r12081 n7638 n7657 0.23500000000000001
r12082 n7656 n7657 0.0067142857142857143
r12083 n7639 n7658 0.23500000000000001
r12084 n7657 n7658 0.0067142857142857143
r12085 n7640 n7659 0.058750000000000004
r12086 n7658 n7659 0.016785714285714286
r12087 n7641 n7660 0.047
r12088 n7659 n7660 0.030214285714285718
r12089 n7642 n7661 0.23500000000000001
r12090 n7660 n7661 0.020142857142857143
r12091 n7643 n7662 0.0235
r12092 n7661 n7662 0.036928571428571429
r12093 n7644 n7663 0.035249999999999997
r12094 n7645 n7664 0.070499999999999993
r12095 n7663 n7664 0.044062499999999998
r12096 n7646 n7665 0.070499999999999993
r12097 n7664 n7665 0.029375000000000002
r12098 n7647 n7666 0.35249999999999998
r12099 n7665 n7666 0.017624999999999998
r12100 n7648 n7667 0.11749999999999999
r12101 n7666 n7667 0.01175
r12102 n7649 n7668 0.35249999999999998
r12103 n7667 n7668 0.01175
r12104 n7650 n7669 0.039166666666666669
r12105 n7668 n7669 0.029375000000000002
r12106 n7651 n7670 0.035249999999999997
r12107 n7669 n7670 0.055812500000000001
r12108 n7652 n7671 0.070499999999999993
r12109 n7670 n7671 0.044062499999999998
r12110 n7653 n7672 0.070499999999999993
r12111 n7671 n7672 0.029375000000000002
r12112 n7654 n7673 0.35249999999999998
r12113 n7672 n7673 0.017624999999999998
r12114 n7655 n7674 0.17624999999999999
r12115 n7673 n7674 0.0088124999999999992
r12116 n7656 n7675 0.35249999999999998
r12117 n7674 n7675 0.0088124999999999992
r12118 n7657 n7676 0.35249999999999998
r12119 n7675 n7676 0.005875
r12120 n7658 n7677 0.35249999999999998
r12121 n7676 n7677 0.005875
r12122 n7659 n7678 0.088124999999999995
r12123 n7677 n7678 0.014687500000000001
r12124 n7660 n7679 0.070499999999999993
r12125 n7678 n7679 0.026437500000000003
r12126 n7661 n7680 0.35249999999999998
r12127 n7679 n7680 0.017624999999999998
r12128 n7662 n7681 0.035249999999999997
r12129 n7680 n7681 0.032312500000000001
r12130 n7663 n7682 0.0235
r12131 n7664 n7683 0.047
r12132 n7682 n7683 0.17624999999999999
r12133 n7665 n7684 0.047
r12134 n7683 n7684 0.11750000000000001
r12135 n7666 n7685 0.23500000000000001
r12136 n7684 n7685 0.070499999999999993
r12137 n7667 n7686 0.078333333333333338
r12138 n7685 n7686 0.047
r12139 n7668 n7687 0.23500000000000001
r12140 n7686 n7687 0.047
r12141 n7669 n7688 0.026111111111111113
r12142 n7687 n7688 0.11750000000000001
r12143 n7670 n7689 0.0235
r12144 n7688 n7689 0.22325
r12145 n7671 n7690 0.047
r12146 n7689 n7690 0.17624999999999999
r12147 n7672 n7691 0.047
r12148 n7690 n7691 0.11750000000000001
r12149 n7673 n7692 0.23500000000000001
r12150 n7691 n7692 0.070499999999999993
r12151 n7674 n7693 0.11750000000000001
r12152 n7692 n7693 0.035249999999999997
r12153 n7675 n7694 0.23500000000000001
r12154 n7693 n7694 0.035249999999999997
r12155 n7676 n7695 0.23500000000000001
r12156 n7694 n7695 0.0235
r12157 n7677 n7696 0.23500000000000001
r12158 n7695 n7696 0.0235
r12159 n7678 n7697 0.058750000000000004
r12160 n7696 n7697 0.058750000000000004
r12161 n7679 n7698 0.047
r12162 n7697 n7698 0.10575000000000001
r12163 n7680 n7699 0.23500000000000001
r12164 n7698 n7699 0.070499999999999993
r12165 n7681 n7700 0.0235
r12166 n7699 n7700 0.12925
r12167 n7683 n7701 0.1598
r12168 n7684 n7702 0.1598
r12169 n7701 n7702 0.0073437500000000005
r12170 n7685 n7703 0.79900000000000004
r12171 n7702 n7703 0.0044062499999999996
r12172 n7686 n7704 0.26633333333333337
r12173 n7703 n7704 0.0029375
r12174 n7687 n7705 0.79900000000000004
r12175 n7704 n7705 0.0029375
r12176 n7688 n7706 0.088777777777777775
r12177 n7705 n7706 0.0073437500000000005
r12178 n7689 n7707 0.079899999999999999
r12179 n7706 n7707 0.013953125
r12180 n7690 n7708 0.1598
r12181 n7707 n7708 0.011015624999999999
r12182 n7691 n7709 0.1598
r12183 n7708 n7709 0.0073437500000000005
r12184 n7692 n7710 0.79900000000000004
r12185 n7709 n7710 0.0044062499999999996
r12186 n7693 n7711 0.39950000000000002
r12187 n7710 n7711 0.0022031249999999998
r12188 n7694 n7712 0.79900000000000004
r12189 n7711 n7712 0.0022031249999999998
r12190 n7695 n7713 0.79900000000000004
r12191 n7712 n7713 0.00146875
r12192 n7696 n7714 0.79900000000000004
r12193 n7713 n7714 0.00146875
r12194 n7697 n7715 0.19975000000000001
r12195 n7714 n7715 0.0036718750000000002
r12196 n7698 n7716 0.1598
r12197 n7715 n7716 0.0066093750000000007
r12198 n7699 n7717 0.79900000000000004
r12199 n7716 n7717 0.0044062499999999996
r12200 n7701 n7718 0.37130000000000002
r12201 n7702 n7719 0.37130000000000002
r12202 n7718 n7719 0.0050000000000000001
r12203 n7703 n7720 1.8565
r12204 n7719 n7720 0.0029999999999999996
r12205 n7704 n7721 0.61883333333333335
r12206 n7720 n7721 0.002
r12207 n7705 n7722 1.8565
r12208 n7721 n7722 0.002
r12209 n7706 n7723 0.20627777777777778
r12210 n7722 n7723 0.0050000000000000001
r12211 n7707 n7724 0.18565000000000001
r12212 n7723 n7724 0.0094999999999999998
r12213 n7708 n7725 0.37130000000000002
r12214 n7724 n7725 0.0074999999999999997
r12215 n7709 n7726 0.37130000000000002
r12216 n7725 n7726 0.0050000000000000001
r12217 n7710 n7727 1.8565
r12218 n7726 n7727 0.0029999999999999996
r12219 n7711 n7728 0.92825000000000002
r12220 n7727 n7728 0.0014999999999999998
r12221 n7712 n7729 1.8565
r12222 n7728 n7729 0.0014999999999999998
r12223 n7713 n7730 1.8565
r12224 n7729 n7730 0.001
r12225 n7714 n7731 1.8565
r12226 n7730 n7731 0.001
r12227 n7715 n7732 0.46412500000000001
r12228 n7731 n7732 0.0025000000000000001
r12229 n7716 n7733 0.37130000000000002
r12230 n7732 n7733 0.0045000000000000005
r12231 n7717 n7734 1.8565
r12232 n7733 n7734 0.0029999999999999996
r12233 n7718 n7735 0.38069999999999998
r12234 n7719 n7736 0.38069999999999998
r12235 n7735 n7736 0.0069117647058823534
r12236 n7720 n7737 1.9035
r12237 n7736 n7737 0.0041470588235294117
r12238 n7721 n7738 0.63449999999999995
r12239 n7737 n7738 0.0027647058823529408
r12240 n7722 n7739 1.9035
r12241 n7738 n7739 0.0027647058823529408
r12242 n7723 n7740 0.21149999999999999
r12243 n7739 n7740 0.0069117647058823534
r12244 n7724 n7741 0.19034999999999999
r12245 n7740 n7741 0.01313235294117647
r12246 n7725 n7742 0.38069999999999998
r12247 n7741 n7742 0.010367647058823528
r12248 n7726 n7743 0.38069999999999998
r12249 n7742 n7743 0.0069117647058823534
r12250 n7727 n7744 1.9035
r12251 n7743 n7744 0.0041470588235294117
r12252 n7728 n7745 0.95174999999999998
r12253 n7744 n7745 0.0020735294117647058
r12254 n7729 n7746 1.9035
r12255 n7745 n7746 0.0020735294117647058
r12256 n7730 n7747 1.9035
r12257 n7746 n7747 0.0013823529411764704
r12258 n7731 n7748 1.9035
r12259 n7747 n7748 0.0013823529411764704
r12260 n7732 n7749 0.47587499999999999
r12261 n7748 n7749 0.0034558823529411767
r12262 n7733 n7750 0.38069999999999998
r12263 n7749 n7750 0.0062205882352941184
r12264 n7734 n7751 1.9035
r12265 n7750 n7751 0.0041470588235294117
r12266 n7735 n7752 0.38822000000000001
r12267 n7736 n7753 0.38822000000000001
r12268 n7752 n7753 0.0048353909465020575
r12269 n7737 n7754 1.9411
r12270 n7753 n7754 0.0029012345679012342
r12271 n7738 n7755 0.64703333333333335
r12272 n7754 n7755 0.001934156378600823
r12273 n7739 n7756 1.9411
r12274 n7755 n7756 0.001934156378600823
r12275 n7740 n7757 0.2156777777777778
r12276 n7756 n7757 0.0048353909465020575
r12277 n7741 n7758 0.19411
r12278 n7757 n7758 0.009187242798353909
r12279 n7742 n7759 0.38822000000000001
r12280 n7758 n7759 0.0072530864197530862
r12281 n7743 n7760 0.38822000000000001
r12282 n7759 n7760 0.0048353909465020575
r12283 n7744 n7761 1.9411
r12284 n7760 n7761 0.0029012345679012342
r12285 n7745 n7762 0.97055000000000002
r12286 n7761 n7762 0.0014506172839506171
r12287 n7746 n7763 1.9411
r12288 n7762 n7763 0.0014506172839506171
r12289 n7747 n7764 1.9411
r12290 n7763 n7764 0.00096707818930041151
r12291 n7748 n7765 1.9411
r12292 n7764 n7765 0.00096707818930041151
r12293 n7749 n7766 0.48527500000000001
r12294 n7765 n7766 0.0024176954732510287
r12295 n7750 n7767 0.38822000000000001
r12296 n7766 n7767 0.0043518518518518524
r12297 n7751 n7768 1.9411
r12298 n7767 n7768 0.0029012345679012342
r12299 n7752 n7769 0.45777999999999996
r12300 n7753 n7770 0.45777999999999996
r12301 n7769 n7770 0.0048155737704918032
r12302 n7754 n7771 2.2888999999999999
r12303 n7770 n7771 0.0028893442622950818
r12304 n7755 n7772 0.76296666666666668
r12305 n7771 n7772 0.0019262295081967213
r12306 n7756 n7773 2.2888999999999999
r12307 n7772 n7773 0.0019262295081967213
r12308 n7757 n7774 0.25432222222222223
r12309 n7773 n7774 0.0048155737704918032
r12310 n7758 n7775 0.22888999999999998
r12311 n7774 n7775 0.0091495901639344259
r12312 n7759 n7776 0.45777999999999996
r12313 n7775 n7776 0.0072233606557377044
r12314 n7760 n7777 0.45777999999999996
r12315 n7776 n7777 0.0048155737704918032
r12316 n7761 n7778 2.2888999999999999
r12317 n7777 n7778 0.0028893442622950818
r12318 n7762 n7779 1.14445
r12319 n7778 n7779 0.0014446721311475409
r12320 n7763 n7780 2.2888999999999999
r12321 n7779 n7780 0.0014446721311475409
r12322 n7764 n7781 2.2888999999999999
r12323 n7780 n7781 0.00096311475409836063
r12324 n7765 n7782 2.2888999999999999
r12325 n7781 n7782 0.00096311475409836063
r12326 n7766 n7783 0.57222499999999998
r12327 n7782 n7783 0.0024077868852459016
r12328 n7767 n7784 0.45777999999999996
r12329 n7783 n7784 0.0043340163934426235
r12330 n7768 n7785 2.2888999999999999
r12331 n7784 n7785 0.0028893442622950818
r12332 n7769 n7786 0.45777999999999996
r12333 n7770 n7787 0.45777999999999996
r12334 n7786 n7787 0.0048353909465020575
r12335 n7771 n7788 2.2888999999999999
r12336 n7787 n7788 0.0029012345679012342
r12337 n7772 n7789 0.76296666666666668
r12338 n7788 n7789 0.001934156378600823
r12339 n7773 n7790 2.2888999999999999
r12340 n7789 n7790 0.001934156378600823
r12341 n7774 n7791 0.25432222222222223
r12342 n7790 n7791 0.0048353909465020575
r12343 n7775 n7792 0.22888999999999998
r12344 n7791 n7792 0.009187242798353909
r12345 n7776 n7793 0.45777999999999996
r12346 n7792 n7793 0.0072530864197530862
r12347 n7777 n7794 0.45777999999999996
r12348 n7793 n7794 0.0048353909465020575
r12349 n7778 n7795 2.2888999999999999
r12350 n7794 n7795 0.0029012345679012342
r12351 n7779 n7796 1.14445
r12352 n7795 n7796 0.0014506172839506171
r12353 n7780 n7797 2.2888999999999999
r12354 n7796 n7797 0.0014506172839506171
r12355 n7781 n7798 2.2888999999999999
r12356 n7797 n7798 0.00096707818930041151
r12357 n7782 n7799 2.2888999999999999
r12358 n7798 n7799 0.00096707818930041151
r12359 n7783 n7800 0.57222499999999998
r12360 n7799 n7800 0.0024176954732510287
r12361 n7784 n7801 0.45777999999999996
r12362 n7800 n7801 0.0043518518518518524
r12363 n7785 n7802 2.2888999999999999
r12364 n7801 n7802 0.0029012345679012342
r12365 n7786 n7803 0.45683999999999997
r12366 n7787 n7804 0.45683999999999997
r12367 n7803 n7804 0.0048353909465020575
r12368 n7788 n7805 2.2841999999999998
r12369 n7804 n7805 0.0029012345679012342
r12370 n7789 n7806 0.76139999999999997
r12371 n7805 n7806 0.001934156378600823
r12372 n7790 n7807 2.2841999999999998
r12373 n7806 n7807 0.001934156378600823
r12374 n7791 n7808 0.25379999999999997
r12375 n7807 n7808 0.0048353909465020575
r12376 n7792 n7809 0.22841999999999998
r12377 n7808 n7809 0.009187242798353909
r12378 n7793 n7810 0.45683999999999997
r12379 n7809 n7810 0.0072530864197530862
r12380 n7794 n7811 0.45683999999999997
r12381 n7810 n7811 0.0048353909465020575
r12382 n7795 n7812 2.2841999999999998
r12383 n7811 n7812 0.0029012345679012342
r12384 n7796 n7813 1.1420999999999999
r12385 n7812 n7813 0.0014506172839506171
r12386 n7797 n7814 2.2841999999999998
r12387 n7813 n7814 0.0014506172839506171
r12388 n7798 n7815 2.2841999999999998
r12389 n7814 n7815 0.00096707818930041151
r12390 n7799 n7816 2.2841999999999998
r12391 n7815 n7816 0.00096707818930041151
r12392 n7800 n7817 0.57104999999999995
r12393 n7816 n7817 0.0024176954732510287
r12394 n7801 n7818 0.45683999999999997
r12395 n7817 n7818 0.0043518518518518524
r12396 n7802 n7819 2.2841999999999998
r12397 n7818 n7819 0.0029012345679012342
r12398 n7803 n7820 0.45777999999999996
r12399 n7804 n7821 0.45777999999999996
r12400 n7820 n7821 0.0048155737704918032
r12401 n7805 n7822 2.2888999999999999
r12402 n7821 n7822 0.0028893442622950818
r12403 n7806 n7823 0.76296666666666668
r12404 n7822 n7823 0.0019262295081967213
r12405 n7807 n7824 2.2888999999999999
r12406 n7823 n7824 0.0019262295081967213
r12407 n7808 n7825 0.25432222222222223
r12408 n7824 n7825 0.0048155737704918032
r12409 n7809 n7826 0.22888999999999998
r12410 n7825 n7826 0.0091495901639344259
r12411 n7810 n7827 0.45777999999999996
r12412 n7826 n7827 0.0072233606557377044
r12413 n7811 n7828 0.45777999999999996
r12414 n7827 n7828 0.0048155737704918032
r12415 n7812 n7829 2.2888999999999999
r12416 n7828 n7829 0.0028893442622950818
r12417 n7813 n7830 1.14445
r12418 n7829 n7830 0.0014446721311475409
r12419 n7814 n7831 2.2888999999999999
r12420 n7830 n7831 0.0014446721311475409
r12421 n7815 n7832 2.2888999999999999
r12422 n7831 n7832 0.00096311475409836063
r12423 n7816 n7833 2.2888999999999999
r12424 n7832 n7833 0.00096311475409836063
r12425 n7817 n7834 0.57222499999999998
r12426 n7833 n7834 0.0024077868852459016
r12427 n7818 n7835 0.45777999999999996
r12428 n7834 n7835 0.0043340163934426235
r12429 n7819 n7836 2.2888999999999999
r12430 n7835 n7836 0.0028893442622950818
r12431 n7820 n7837 0.45777999999999996
r12432 n7821 n7838 0.45777999999999996
r12433 n7837 n7838 0.0048353909465020575
r12434 n7822 n7839 2.2888999999999999
r12435 n7838 n7839 0.0029012345679012342
r12436 n7823 n7840 0.76296666666666668
r12437 n7839 n7840 0.001934156378600823
r12438 n7824 n7841 2.2888999999999999
r12439 n7840 n7841 0.001934156378600823
r12440 n7825 n7842 0.25432222222222223
r12441 n7841 n7842 0.0048353909465020575
r12442 n7826 n7843 0.22888999999999998
r12443 n7842 n7843 0.009187242798353909
r12444 n7827 n7844 0.45777999999999996
r12445 n7843 n7844 0.0072530864197530862
r12446 n7828 n7845 0.45777999999999996
r12447 n7844 n7845 0.0048353909465020575
r12448 n7829 n7846 2.2888999999999999
r12449 n7845 n7846 0.0029012345679012342
r12450 n7830 n7847 1.14445
r12451 n7846 n7847 0.0014506172839506171
r12452 n7831 n7848 2.2888999999999999
r12453 n7847 n7848 0.0014506172839506171
r12454 n7832 n7849 2.2888999999999999
r12455 n7848 n7849 0.00096707818930041151
r12456 n7833 n7850 2.2888999999999999
r12457 n7849 n7850 0.00096707818930041151
r12458 n7834 n7851 0.57222499999999998
r12459 n7850 n7851 0.0024176954732510287
r12460 n7835 n7852 0.45777999999999996
r12461 n7851 n7852 0.0043518518518518524
r12462 n7836 n7853 2.2888999999999999
r12463 n7852 n7853 0.0029012345679012342
r12464 n7837 n7854 0.23782
r12465 n7838 n7855 0.23782
r12466 n7854 n7855 0.11750000000000001
r12467 n7839 n7856 1.1891
r12468 n7855 n7856 0.070499999999999993
r12469 n7840 n7857 0.39636666666666664
r12470 n7856 n7857 0.047
r12471 n7841 n7858 1.1891
r12472 n7857 n7858 0.047
r12473 n7842 n7859 0.13212222222222222
r12474 n7858 n7859 0.11750000000000001
r12475 n7843 n7860 0.11891
r12476 n7859 n7860 0.22325
r12477 n7844 n7861 0.23782
r12478 n7860 n7861 0.17624999999999999
r12479 n7845 n7862 0.23782
r12480 n7861 n7862 0.11750000000000001
r12481 n7846 n7863 1.1891
r12482 n7862 n7863 0.070499999999999993
r12483 n7847 n7864 0.59455000000000002
r12484 n7863 n7864 0.035249999999999997
r12485 n7848 n7865 1.1891
r12486 n7864 n7865 0.035249999999999997
r12487 n7849 n7866 1.1891
r12488 n7865 n7866 0.0235
r12489 n7850 n7867 1.1891
r12490 n7866 n7867 0.0235
r12491 n7851 n7868 0.29727500000000001
r12492 n7867 n7868 0.058750000000000004
r12493 n7852 n7869 0.23782
r12494 n7868 n7869 0.10575000000000001
r12495 n7853 n7870 1.1891
r12496 n7869 n7870 0.070499999999999993
r12497 n7854 n7871 0.061100000000000002
r12498 n7855 n7872 0.061100000000000002
r12499 n7871 n7872 0.021363636363636366
r12500 n7856 n7873 0.30549999999999999
r12501 n7872 n7873 0.012818181818181817
r12502 n7857 n7874 0.10183333333333335
r12503 n7873 n7874 0.0085454545454545453
r12504 n7858 n7875 0.30549999999999999
r12505 n7874 n7875 0.0085454545454545453
r12506 n7859 n7876 0.033944444444444444
r12507 n7875 n7876 0.021363636363636366
r12508 n7860 n7877 0.030550000000000001
r12509 n7876 n7877 0.040590909090909087
r12510 n7861 n7878 0.061100000000000002
r12511 n7877 n7878 0.032045454545454544
r12512 n7862 n7879 0.061100000000000002
r12513 n7878 n7879 0.021363636363636366
r12514 n7863 n7880 0.30549999999999999
r12515 n7879 n7880 0.012818181818181817
r12516 n7864 n7881 0.15275
r12517 n7880 n7881 0.0064090909090909086
r12518 n7865 n7882 0.30549999999999999
r12519 n7881 n7882 0.0064090909090909086
r12520 n7866 n7883 0.30549999999999999
r12521 n7882 n7883 0.0042727272727272727
r12522 n7867 n7884 0.30549999999999999
r12523 n7883 n7884 0.0042727272727272727
r12524 n7868 n7885 0.076374999999999998
r12525 n7884 n7885 0.010681818181818183
r12526 n7869 n7886 0.061100000000000002
r12527 n7885 n7886 0.019227272727272728
r12528 n7870 n7887 0.30549999999999999
r12529 n7886 n7887 0.012818181818181817
r12530 n7871 n7888 0.061100000000000002
r12531 n7872 n7889 0.061100000000000002
r12532 n7888 n7889 0.11750000000000001
r12533 n7873 n7890 0.30549999999999999
r12534 n7889 n7890 0.070499999999999993
r12535 n7874 n7891 0.10183333333333335
r12536 n7890 n7891 0.047
r12537 n7875 n7892 0.30549999999999999
r12538 n7891 n7892 0.047
r12539 n7876 n7893 0.033944444444444444
r12540 n7892 n7893 0.11750000000000001
r12541 n7877 n7894 0.030550000000000001
r12542 n7893 n7894 0.22325
r12543 n7878 n7895 0.061100000000000002
r12544 n7894 n7895 0.17624999999999999
r12545 n7879 n7896 0.061100000000000002
r12546 n7895 n7896 0.11750000000000001
r12547 n7880 n7897 0.30549999999999999
r12548 n7896 n7897 0.070499999999999993
r12549 n7881 n7898 0.15275
r12550 n7897 n7898 0.035249999999999997
r12551 n7882 n7899 0.30549999999999999
r12552 n7898 n7899 0.035249999999999997
r12553 n7883 n7900 0.30549999999999999
r12554 n7899 n7900 0.0235
r12555 n7884 n7901 0.30549999999999999
r12556 n7900 n7901 0.0235
r12557 n7885 n7902 0.076374999999999998
r12558 n7901 n7902 0.058750000000000004
r12559 n7886 n7903 0.061100000000000002
r12560 n7902 n7903 0.10575000000000001
r12561 n7887 n7904 0.30549999999999999
r12562 n7903 n7904 0.070499999999999993
r12563 n7888 n7905 0.15039999999999998
r12564 n7889 n7906 0.15039999999999998
r12565 n7905 n7906 0.0078333333333333328
r12566 n7890 n7907 0.752
r12567 n7906 n7907 0.0046999999999999993
r12568 n7891 n7908 0.25066666666666665
r12569 n7907 n7908 0.003133333333333333
r12570 n7892 n7909 0.752
r12571 n7908 n7909 0.003133333333333333
r12572 n7893 n7910 0.08355555555555555
r12573 n7909 n7910 0.0078333333333333328
r12574 n7894 n7911 0.075199999999999989
r12575 n7910 n7911 0.014883333333333333
r12576 n7895 n7912 0.15039999999999998
r12577 n7911 n7912 0.01175
r12578 n7896 n7913 0.15039999999999998
r12579 n7912 n7913 0.0078333333333333328
r12580 n7897 n7914 0.752
r12581 n7913 n7914 0.0046999999999999993
r12582 n7898 n7915 0.376
r12583 n7914 n7915 0.0023499999999999997
r12584 n7899 n7916 0.752
r12585 n7915 n7916 0.0023499999999999997
r12586 n7900 n7917 0.752
r12587 n7916 n7917 0.0015666666666666665
r12588 n7901 n7918 0.752
r12589 n7917 n7918 0.0015666666666666665
r12590 n7902 n7919 0.188
r12591 n7918 n7919 0.0039166666666666664
r12592 n7903 n7920 0.15039999999999998
r12593 n7919 n7920 0.0070500000000000007
r12594 n7904 n7921 0.752
r12595 n7920 n7921 0.0046999999999999993
r12596 n7905 n7922 0.15039999999999998
r12597 n7906 n7923 0.15039999999999998
r12598 n7922 n7923 0.11750000000000001
r12599 n7907 n7924 0.752
r12600 n7923 n7924 0.070499999999999993
r12601 n7908 n7925 0.25066666666666665
r12602 n7924 n7925 0.047
r12603 n7909 n7926 0.752
r12604 n7925 n7926 0.047
r12605 n7910 n7927 0.08355555555555555
r12606 n7926 n7927 0.11750000000000001
r12607 n7911 n7928 0.075199999999999989
r12608 n7927 n7928 0.22325
r12609 n7912 n7929 0.15039999999999998
r12610 n7928 n7929 0.17624999999999999
r12611 n7913 n7930 0.15039999999999998
r12612 n7929 n7930 0.11750000000000001
r12613 n7914 n7931 0.752
r12614 n7930 n7931 0.070499999999999993
r12615 n7915 n7932 0.376
r12616 n7931 n7932 0.035249999999999997
r12617 n7916 n7933 0.752
r12618 n7932 n7933 0.035249999999999997
r12619 n7917 n7934 0.752
r12620 n7933 n7934 0.0235
r12621 n7918 n7935 0.752
r12622 n7934 n7935 0.0235
r12623 n7919 n7936 0.188
r12624 n7935 n7936 0.058750000000000004
r12625 n7920 n7937 0.15039999999999998
r12626 n7936 n7937 0.10575000000000001
r12627 n7921 n7938 0.752
r12628 n7937 n7938 0.070499999999999993
r12629 n7922 n7939 0.061100000000000002
r12630 n7923 n7940 0.061100000000000002
r12631 n7939 n7940 0.021363636363636366
r12632 n7924 n7941 0.30549999999999999
r12633 n7940 n7941 0.012818181818181817
r12634 n7925 n7942 0.10183333333333335
r12635 n7941 n7942 0.0085454545454545453
r12636 n7926 n7943 0.30549999999999999
r12637 n7942 n7943 0.0085454545454545453
r12638 n7927 n7944 0.033944444444444444
r12639 n7943 n7944 0.021363636363636366
r12640 n7928 n7945 0.030550000000000001
r12641 n7944 n7945 0.040590909090909087
r12642 n7929 n7946 0.061100000000000002
r12643 n7945 n7946 0.032045454545454544
r12644 n7930 n7947 0.061100000000000002
r12645 n7946 n7947 0.021363636363636366
r12646 n7931 n7948 0.30549999999999999
r12647 n7947 n7948 0.012818181818181817
r12648 n7932 n7949 0.15275
r12649 n7948 n7949 0.0064090909090909086
r12650 n7933 n7950 0.30549999999999999
r12651 n7949 n7950 0.0064090909090909086
r12652 n7934 n7951 0.30549999999999999
r12653 n7950 n7951 0.0042727272727272727
r12654 n7935 n7952 0.30549999999999999
r12655 n7951 n7952 0.0042727272727272727
r12656 n7936 n7953 0.076374999999999998
r12657 n7952 n7953 0.010681818181818183
r12658 n7937 n7954 0.061100000000000002
r12659 n7953 n7954 0.019227272727272728
r12660 n7938 n7955 0.30549999999999999
r12661 n7954 n7955 0.012818181818181817
r12662 n7939 n7956 0.061100000000000002
r12663 n7940 n7957 0.061100000000000002
r12664 n7956 n7957 0.11750000000000001
r12665 n7941 n7958 0.30549999999999999
r12666 n7957 n7958 0.070499999999999993
r12667 n7942 n7959 0.10183333333333335
r12668 n7958 n7959 0.047
r12669 n7943 n7960 0.30549999999999999
r12670 n7959 n7960 0.047
r12671 n7944 n7961 0.033944444444444444
r12672 n7960 n7961 0.11750000000000001
r12673 n7945 n7962 0.030550000000000001
r12674 n7961 n7962 0.22325
r12675 n7946 n7963 0.061100000000000002
r12676 n7962 n7963 0.17624999999999999
r12677 n7947 n7964 0.061100000000000002
r12678 n7963 n7964 0.11750000000000001
r12679 n7948 n7965 0.30549999999999999
r12680 n7964 n7965 0.070499999999999993
r12681 n7949 n7966 0.15275
r12682 n7965 n7966 0.035249999999999997
r12683 n7950 n7967 0.30549999999999999
r12684 n7966 n7967 0.035249999999999997
r12685 n7951 n7968 0.30549999999999999
r12686 n7967 n7968 0.0235
r12687 n7952 n7969 0.30549999999999999
r12688 n7968 n7969 0.0235
r12689 n7953 n7970 0.076374999999999998
r12690 n7969 n7970 0.058750000000000004
r12691 n7954 n7971 0.061100000000000002
r12692 n7970 n7971 0.10575000000000001
r12693 n7955 n7972 0.30549999999999999
r12694 n7971 n7972 0.070499999999999993
r12695 n7956 n7973 0.16732
r12696 n7957 n7974 0.16732
r12697 n7973 n7974 0.0069940476190476194
r12698 n7958 n7975 0.83660000000000001
r12699 n7974 n7975 0.0041964285714285714
r12700 n7959 n7976 0.27886666666666665
r12701 n7975 n7976 0.0027976190476190475
r12702 n7960 n7977 0.83660000000000001
r12703 n7976 n7977 0.0027976190476190475
r12704 n7961 n7978 0.092955555555555555
r12705 n7977 n7978 0.0069940476190476194
r12706 n7962 n7979 0.083659999999999998
r12707 n7978 n7979 0.013288690476190477
r12708 n7963 n7980 0.16732
r12709 n7979 n7980 0.010491071428571428
r12710 n7964 n7981 0.16732
r12711 n7980 n7981 0.0069940476190476194
r12712 n7965 n7982 0.83660000000000001
r12713 n7981 n7982 0.0041964285714285714
r12714 n7966 n7983 0.41830000000000001
r12715 n7982 n7983 0.0020982142857142857
r12716 n7967 n7984 0.83660000000000001
r12717 n7983 n7984 0.0020982142857142857
r12718 n7968 n7985 0.83660000000000001
r12719 n7984 n7985 0.0013988095238095237
r12720 n7969 n7986 0.83660000000000001
r12721 n7985 n7986 0.0013988095238095237
r12722 n7970 n7987 0.20915
r12723 n7986 n7987 0.0034970238095238097
r12724 n7971 n7988 0.16732
r12725 n7987 n7988 0.006294642857142858
r12726 n7972 n7989 0.83660000000000001
r12727 n7988 n7989 0.0041964285714285714
r12728 n7973 n7990 0.31489999999999996
r12729 n7974 n7991 0.31489999999999996
r12730 n7990 n7991 0.0070359281437125751
r12731 n7975 n7992 1.5745
r12732 n7991 n7992 0.0042215568862275449
r12733 n7976 n7993 0.52483333333333326
r12734 n7992 n7993 0.0028143712574850298
r12735 n7977 n7994 1.5745
r12736 n7993 n7994 0.0028143712574850298
r12737 n7978 n7995 0.17494444444444443
r12738 n7994 n7995 0.0070359281437125751
r12739 n7979 n7996 0.15744999999999998
r12740 n7995 n7996 0.013368263473053891
r12741 n7980 n7997 0.31489999999999996
r12742 n7996 n7997 0.010553892215568862
r12743 n7981 n7998 0.31489999999999996
r12744 n7997 n7998 0.0070359281437125751
r12745 n7982 n7999 1.5745
r12746 n7998 n7999 0.0042215568862275449
r12747 n7983 n8000 0.78725000000000001
r12748 n7999 n8000 0.0021107784431137725
r12749 n7984 n8001 1.5745
r12750 n8000 n8001 0.0021107784431137725
r12751 n7985 n8002 1.5745
r12752 n8001 n8002 0.0014071856287425149
r12753 n7986 n8003 1.5745
r12754 n8002 n8003 0.0014071856287425149
r12755 n7987 n8004 0.393625
r12756 n8003 n8004 0.0035179640718562876
r12757 n7988 n8005 0.31489999999999996
r12758 n8004 n8005 0.0063323353293413178
r12759 n7989 n8006 1.5745
r12760 n8005 n8006 0.0042215568862275449
r12761 n7990 n8007 0.20867999999999998
r12762 n7991 n8008 0.20867999999999998
r12763 n8007 n8008 0.021363636363636366
r12764 n7992 n8009 1.0433999999999999
r12765 n8008 n8009 0.012818181818181817
r12766 n7993 n8010 0.3478
r12767 n8009 n8010 0.0085454545454545453
r12768 n7994 n8011 1.0433999999999999
r12769 n8010 n8011 0.0085454545454545453
r12770 n7995 n8012 0.11593333333333332
r12771 n8011 n8012 0.021363636363636366
r12772 n7996 n8013 0.10433999999999999
r12773 n8012 n8013 0.040590909090909087
r12774 n7997 n8014 0.20867999999999998
r12775 n8013 n8014 0.032045454545454544
r12776 n7998 n8015 0.20867999999999998
r12777 n8014 n8015 0.021363636363636366
r12778 n7999 n8016 1.0433999999999999
r12779 n8015 n8016 0.012818181818181817
r12780 n8000 n8017 0.52169999999999994
r12781 n8016 n8017 0.0064090909090909086
r12782 n8001 n8018 1.0433999999999999
r12783 n8017 n8018 0.0064090909090909086
r12784 n8002 n8019 1.0433999999999999
r12785 n8018 n8019 0.0042727272727272727
r12786 n8003 n8020 1.0433999999999999
r12787 n8019 n8020 0.0042727272727272727
r12788 n8004 n8021 0.26084999999999997
r12789 n8020 n8021 0.010681818181818183
r12790 n8005 n8022 0.20867999999999998
r12791 n8021 n8022 0.019227272727272728
r12792 n8006 n8023 1.0433999999999999
r12793 n8022 n8023 0.012818181818181817
r12794 n8007 n8024 0.098699999999999996
r12795 n8008 n8025 0.098699999999999996
r12796 n8024 n8025 0.0235
r12797 n8009 n8026 0.49349999999999994
r12798 n8025 n8026 0.0141
r12799 n8010 n8027 0.16449999999999998
r12800 n8026 n8027 0.0093999999999999986
r12801 n8011 n8028 0.49349999999999994
r12802 n8027 n8028 0.0093999999999999986
r12803 n8012 n8029 0.054833333333333331
r12804 n8028 n8029 0.0235
r12805 n8013 n8030 0.049349999999999998
r12806 n8029 n8030 0.044649999999999995
r12807 n8014 n8031 0.098699999999999996
r12808 n8030 n8031 0.035249999999999997
r12809 n8015 n8032 0.098699999999999996
r12810 n8031 n8032 0.0235
r12811 n8016 n8033 0.49349999999999994
r12812 n8032 n8033 0.0141
r12813 n8017 n8034 0.24674999999999997
r12814 n8033 n8034 0.0070499999999999998
r12815 n8018 n8035 0.49349999999999994
r12816 n8034 n8035 0.0070499999999999998
r12817 n8019 n8036 0.49349999999999994
r12818 n8035 n8036 0.0046999999999999993
r12819 n8020 n8037 0.49349999999999994
r12820 n8036 n8037 0.0046999999999999993
r12821 n8021 n8038 0.12337499999999998
r12822 n8037 n8038 0.01175
r12823 n8022 n8039 0.098699999999999996
r12824 n8038 n8039 0.021150000000000002
r12825 n8023 n8040 0.49349999999999994
r12826 n8039 n8040 0.0141
r12827 n8040 n8041 0.025849999999999998
r12828 n8041 n8042 0.030550000000000001
r12829 n8042 n8043 0.021150000000000002
r12830 n8043 n8044 0.018799999999999997
r12831 n8044 n8045 0.0070499999999999998
r12832 n8045 n8046 0.0046999999999999993
r12833 n8046 n8047 0.016449999999999999
r12834 n8047 n8048 0.025849999999999998
r12835 n8048 n8049 0.0141
r12836 n8049 n8050 0.01175
r12837 n8050 n8051 0.021150000000000002
r12838 n8051 n8052 0.018799999999999997
r12839 n8052 n8053 0.0235
r12840 n8024 n8054 0.056399999999999999
r12841 n8025 n8055 0.056399999999999999
r12842 n8054 n8055 0.11750000000000001
r12843 n8026 n8056 0.28199999999999997
r12844 n8055 n8056 0.070499999999999993
r12845 n8027 n8057 0.094
r12846 n8056 n8057 0.047
r12847 n8028 n8058 0.28199999999999997
r12848 n8057 n8058 0.047
r12849 n8029 n8059 0.031333333333333331
r12850 n8058 n8059 0.11750000000000001
r12851 n8030 n8060 0.028199999999999999
r12852 n8059 n8060 0.22325
r12853 n8031 n8061 0.056399999999999999
r12854 n8060 n8061 0.17624999999999999
r12855 n8032 n8062 0.056399999999999999
r12856 n8061 n8062 0.11750000000000001
r12857 n8033 n8063 0.28199999999999997
r12858 n8062 n8063 0.070499999999999993
r12859 n8034 n8064 0.14099999999999999
r12860 n8063 n8064 0.035249999999999997
r12861 n8035 n8065 0.28199999999999997
r12862 n8064 n8065 0.035249999999999997
r12863 n8036 n8066 0.28199999999999997
r12864 n8065 n8066 0.0235
r12865 n8037 n8067 0.28199999999999997
r12866 n8066 n8067 0.0235
r12867 n8038 n8068 0.070499999999999993
r12868 n8067 n8068 0.058750000000000004
r12869 n8039 n8069 0.056399999999999999
r12870 n8068 n8069 0.10575000000000001
r12871 n8040 n8070 0.28199999999999997
r12872 n8069 n8070 0.070499999999999993
r12873 n8041 n8071 0.028199999999999999
r12874 n8070 n8071 0.12925
r12875 n8042 n8072 0.094
r12876 n8071 n8072 0.15275
r12877 n8043 n8073 0.047
r12878 n8072 n8073 0.10575000000000001
r12879 n8044 n8074 0.14099999999999999
r12880 n8073 n8074 0.094
r12881 n8045 n8075 0.28199999999999997
r12882 n8074 n8075 0.035249999999999997
r12883 n8046 n8076 0.28199999999999997
r12884 n8075 n8076 0.0235
r12885 n8047 n8077 0.047
r12886 n8076 n8077 0.082250000000000004
r12887 n8048 n8078 0.056399999999999999
r12888 n8077 n8078 0.12925
r12889 n8049 n8079 0.28199999999999997
r12890 n8078 n8079 0.070499999999999993
r12891 n8050 n8080 0.070499999999999993
r12892 n8079 n8080 0.058750000000000004
r12893 n8051 n8081 0.056399999999999999
r12894 n8080 n8081 0.10575000000000001
r12895 n8052 n8082 0.094
r12896 n8081 n8082 0.094
r12897 n8053 n8083 0.040285714285714286
r12898 n8082 n8083 0.11750000000000001
r12899 n8054 n8084 0.0235
r12900 n8055 n8085 0.0235
r12901 n8084 n8085 0.078333333333333338
r12902 n8056 n8086 0.11750000000000001
r12903 n8085 n8086 0.047
r12904 n8057 n8087 0.039166666666666669
r12905 n8086 n8087 0.031333333333333331
r12906 n8058 n8088 0.11750000000000001
r12907 n8087 n8088 0.031333333333333331
r12908 n8059 n8089 0.013055555555555556
r12909 n8088 n8089 0.078333333333333338
r12910 n8060 n8090 0.01175
r12911 n8089 n8090 0.14883333333333332
r12912 n8061 n8091 0.0235
r12913 n8090 n8091 0.11749999999999999
r12914 n8062 n8092 0.0235
r12915 n8091 n8092 0.078333333333333338
r12916 n8063 n8093 0.11750000000000001
r12917 n8092 n8093 0.047
r12918 n8064 n8094 0.058750000000000004
r12919 n8093 n8094 0.0235
r12920 n8065 n8095 0.11750000000000001
r12921 n8094 n8095 0.0235
r12922 n8066 n8096 0.11750000000000001
r12923 n8095 n8096 0.015666666666666666
r12924 n8067 n8097 0.11750000000000001
r12925 n8096 n8097 0.015666666666666666
r12926 n8068 n8098 0.029375000000000002
r12927 n8097 n8098 0.039166666666666669
r12928 n8069 n8099 0.0235
r12929 n8098 n8099 0.070500000000000007
r12930 n8070 n8100 0.11750000000000001
r12931 n8099 n8100 0.047
r12932 n8071 n8101 0.01175
r12933 n8100 n8101 0.086166666666666669
r12934 n8072 n8102 0.039166666666666669
r12935 n8101 n8102 0.10183333333333335
r12936 n8073 n8103 0.019583333333333335
r12937 n8102 n8103 0.070500000000000007
r12938 n8074 n8104 0.058750000000000004
r12939 n8103 n8104 0.062666666666666662
r12940 n8075 n8105 0.11750000000000001
r12941 n8104 n8105 0.0235
r12942 n8076 n8106 0.11750000000000001
r12943 n8105 n8106 0.015666666666666666
r12944 n8077 n8107 0.019583333333333335
r12945 n8106 n8107 0.054833333333333331
r12946 n8078 n8108 0.0235
r12947 n8107 n8108 0.086166666666666669
r12948 n8079 n8109 0.11750000000000001
r12949 n8108 n8109 0.047
r12950 n8080 n8110 0.029375000000000002
r12951 n8109 n8110 0.039166666666666669
r12952 n8081 n8111 0.0235
r12953 n8110 n8111 0.070500000000000007
r12954 n8082 n8112 0.039166666666666669
r12955 n8111 n8112 0.062666666666666662
r12956 n8083 n8113 0.016785714285714286
r12957 n8112 n8113 0.078333333333333338
r12958 n8084 n8114 0.037599999999999995
r12959 n8085 n8115 0.037599999999999995
r12960 n8114 n8115 0.047
r12961 n8086 n8116 0.188
r12962 n8115 n8116 0.028199999999999999
r12963 n8087 n8117 0.062666666666666662
r12964 n8116 n8117 0.018799999999999997
r12965 n8088 n8118 0.188
r12966 n8117 n8118 0.018799999999999997
r12967 n8089 n8119 0.020888888888888887
r12968 n8118 n8119 0.047
r12969 n8090 n8120 0.018799999999999997
r12970 n8119 n8120 0.08929999999999999
r12971 n8091 n8121 0.037599999999999995
r12972 n8120 n8121 0.070499999999999993
r12973 n8092 n8122 0.037599999999999995
r12974 n8121 n8122 0.047
r12975 n8093 n8123 0.188
r12976 n8122 n8123 0.028199999999999999
r12977 n8094 n8124 0.094
r12978 n8123 n8124 0.0141
r12979 n8095 n8125 0.188
r12980 n8124 n8125 0.0141
r12981 n8096 n8126 0.188
r12982 n8125 n8126 0.0093999999999999986
r12983 n8097 n8127 0.188
r12984 n8126 n8127 0.0093999999999999986
r12985 n8098 n8128 0.047
r12986 n8127 n8128 0.0235
r12987 n8099 n8129 0.037599999999999995
r12988 n8128 n8129 0.042300000000000004
r12989 n8100 n8130 0.188
r12990 n8129 n8130 0.028199999999999999
r12991 n8101 n8131 0.018799999999999997
r12992 n8130 n8131 0.051699999999999996
r12993 n8102 n8132 0.062666666666666662
r12994 n8131 n8132 0.061100000000000002
r12995 n8103 n8133 0.031333333333333331
r12996 n8132 n8133 0.042300000000000004
r12997 n8104 n8134 0.094
r12998 n8133 n8134 0.037599999999999995
r12999 n8105 n8135 0.188
r13000 n8134 n8135 0.0141
r13001 n8106 n8136 0.188
r13002 n8135 n8136 0.0093999999999999986
r13003 n8107 n8137 0.031333333333333331
r13004 n8136 n8137 0.032899999999999999
r13005 n8108 n8138 0.037599999999999995
r13006 n8137 n8138 0.051699999999999996
r13007 n8109 n8139 0.188
r13008 n8138 n8139 0.028199999999999999
r13009 n8110 n8140 0.047
r13010 n8139 n8140 0.0235
r13011 n8111 n8141 0.037599999999999995
r13012 n8140 n8141 0.042300000000000004
r13013 n8112 n8142 0.062666666666666662
r13014 n8141 n8142 0.037599999999999995
r13015 n8113 n8143 0.026857142857142857
r13016 n8142 n8143 0.047
r13017 n8114 n8144 0.037599999999999995
r13018 n8115 n8145 0.037599999999999995
r13019 n8144 n8145 0.078333333333333338
r13020 n8116 n8146 0.188
r13021 n8145 n8146 0.047
r13022 n8117 n8147 0.062666666666666662
r13023 n8146 n8147 0.031333333333333331
r13024 n8118 n8148 0.188
r13025 n8147 n8148 0.031333333333333331
r13026 n8119 n8149 0.020888888888888887
r13027 n8148 n8149 0.078333333333333338
r13028 n8120 n8150 0.018799999999999997
r13029 n8149 n8150 0.14883333333333332
r13030 n8121 n8151 0.037599999999999995
r13031 n8150 n8151 0.11749999999999999
r13032 n8122 n8152 0.037599999999999995
r13033 n8151 n8152 0.078333333333333338
r13034 n8123 n8153 0.188
r13035 n8152 n8153 0.047
r13036 n8124 n8154 0.094
r13037 n8153 n8154 0.0235
r13038 n8125 n8155 0.188
r13039 n8154 n8155 0.0235
r13040 n8126 n8156 0.188
r13041 n8155 n8156 0.015666666666666666
r13042 n8127 n8157 0.188
r13043 n8156 n8157 0.015666666666666666
r13044 n8128 n8158 0.047
r13045 n8157 n8158 0.039166666666666669
r13046 n8129 n8159 0.037599999999999995
r13047 n8158 n8159 0.070500000000000007
r13048 n8130 n8160 0.188
r13049 n8159 n8160 0.047
r13050 n8131 n8161 0.018799999999999997
r13051 n8160 n8161 0.086166666666666669
r13052 n8132 n8162 0.062666666666666662
r13053 n8161 n8162 0.10183333333333335
r13054 n8133 n8163 0.031333333333333331
r13055 n8162 n8163 0.070500000000000007
r13056 n8134 n8164 0.094
r13057 n8163 n8164 0.062666666666666662
r13058 n8135 n8165 0.188
r13059 n8164 n8165 0.0235
r13060 n8136 n8166 0.188
r13061 n8165 n8166 0.015666666666666666
r13062 n8137 n8167 0.031333333333333331
r13063 n8166 n8167 0.054833333333333331
r13064 n8138 n8168 0.037599999999999995
r13065 n8167 n8168 0.086166666666666669
r13066 n8139 n8169 0.188
r13067 n8168 n8169 0.047
r13068 n8140 n8170 0.047
r13069 n8169 n8170 0.039166666666666669
r13070 n8141 n8171 0.037599999999999995
r13071 n8170 n8171 0.070500000000000007
r13072 n8142 n8172 0.062666666666666662
r13073 n8171 n8172 0.062666666666666662
r13074 n8143 n8173 0.026857142857142857
r13075 n8172 n8173 0.078333333333333338
r13076 n8144 n8174 0.0235
r13077 n8145 n8175 0.0235
r13078 n8174 n8175 0.11750000000000001
r13079 n8146 n8176 0.11750000000000001
r13080 n8175 n8176 0.070499999999999993
r13081 n8147 n8177 0.039166666666666669
r13082 n8176 n8177 0.047
r13083 n8148 n8178 0.11750000000000001
r13084 n8177 n8178 0.047
r13085 n8149 n8179 0.013055555555555556
r13086 n8178 n8179 0.11750000000000001
r13087 n8150 n8180 0.01175
r13088 n8179 n8180 0.22325
r13089 n8151 n8181 0.0235
r13090 n8180 n8181 0.17624999999999999
r13091 n8152 n8182 0.0235
r13092 n8181 n8182 0.11750000000000001
r13093 n8153 n8183 0.11750000000000001
r13094 n8182 n8183 0.070499999999999993
r13095 n8154 n8184 0.058750000000000004
r13096 n8183 n8184 0.035249999999999997
r13097 n8155 n8185 0.11750000000000001
r13098 n8184 n8185 0.035249999999999997
r13099 n8156 n8186 0.11750000000000001
r13100 n8185 n8186 0.0235
r13101 n8157 n8187 0.11750000000000001
r13102 n8186 n8187 0.0235
r13103 n8158 n8188 0.029375000000000002
r13104 n8187 n8188 0.058750000000000004
r13105 n8159 n8189 0.0235
r13106 n8188 n8189 0.10575000000000001
r13107 n8160 n8190 0.11750000000000001
r13108 n8189 n8190 0.070499999999999993
r13109 n8161 n8191 0.01175
r13110 n8190 n8191 0.12925
r13111 n8162 n8192 0.039166666666666669
r13112 n8191 n8192 0.15275
r13113 n8163 n8193 0.019583333333333335
r13114 n8192 n8193 0.10575000000000001
r13115 n8164 n8194 0.058750000000000004
r13116 n8193 n8194 0.094
r13117 n8165 n8195 0.11750000000000001
r13118 n8194 n8195 0.035249999999999997
r13119 n8166 n8196 0.11750000000000001
r13120 n8195 n8196 0.0235
r13121 n8167 n8197 0.019583333333333335
r13122 n8196 n8197 0.082250000000000004
r13123 n8168 n8198 0.0235
r13124 n8197 n8198 0.12925
r13125 n8169 n8199 0.11750000000000001
r13126 n8198 n8199 0.070499999999999993
r13127 n8170 n8200 0.029375000000000002
r13128 n8199 n8200 0.058750000000000004
r13129 n8171 n8201 0.0235
r13130 n8200 n8201 0.10575000000000001
r13131 n8172 n8202 0.039166666666666669
r13132 n8201 n8202 0.094
r13133 n8173 n8203 0.016785714285714286
r13134 n8202 n8203 0.11750000000000001
r13135 n8174 n8204 0.15039999999999998
r13136 n8175 n8205 0.15039999999999998
r13137 n8204 n8205 0.0078333333333333328
r13138 n8176 n8206 0.752
r13139 n8205 n8206 0.0046999999999999993
r13140 n8177 n8207 0.25066666666666665
r13141 n8206 n8207 0.003133333333333333
r13142 n8178 n8208 0.752
r13143 n8207 n8208 0.003133333333333333
r13144 n8179 n8209 0.08355555555555555
r13145 n8208 n8209 0.0078333333333333328
r13146 n8180 n8210 0.075199999999999989
r13147 n8209 n8210 0.014883333333333333
r13148 n8181 n8211 0.15039999999999998
r13149 n8210 n8211 0.01175
r13150 n8182 n8212 0.15039999999999998
r13151 n8211 n8212 0.0078333333333333328
r13152 n8183 n8213 0.752
r13153 n8212 n8213 0.0046999999999999993
r13154 n8184 n8214 0.376
r13155 n8213 n8214 0.0023499999999999997
r13156 n8185 n8215 0.752
r13157 n8214 n8215 0.0023499999999999997
r13158 n8186 n8216 0.752
r13159 n8215 n8216 0.0015666666666666665
r13160 n8187 n8217 0.752
r13161 n8216 n8217 0.0015666666666666665
r13162 n8188 n8218 0.188
r13163 n8217 n8218 0.0039166666666666664
r13164 n8189 n8219 0.15039999999999998
r13165 n8218 n8219 0.0070500000000000007
r13166 n8190 n8220 0.752
r13167 n8219 n8220 0.0046999999999999993
r13168 n8191 n8221 0.075199999999999989
r13169 n8220 n8221 0.0086166666666666666
r13170 n8192 n8222 0.25066666666666665
r13171 n8221 n8222 0.010183333333333334
r13172 n8193 n8223 0.12533333333333332
r13173 n8222 n8223 0.0070500000000000007
r13174 n8194 n8224 0.376
r13175 n8223 n8224 0.006266666666666666
r13176 n8195 n8225 0.752
r13177 n8224 n8225 0.0023499999999999997
r13178 n8196 n8226 0.752
r13179 n8225 n8226 0.0015666666666666665
r13180 n8197 n8227 0.12533333333333332
r13181 n8226 n8227 0.0054833333333333331
r13182 n8198 n8228 0.15039999999999998
r13183 n8227 n8228 0.0086166666666666666
r13184 n8199 n8229 0.752
r13185 n8228 n8229 0.0046999999999999993
r13186 n8200 n8230 0.188
r13187 n8229 n8230 0.0039166666666666664
r13188 n8201 n8231 0.15039999999999998
r13189 n8230 n8231 0.0070500000000000007
r13190 n8202 n8232 0.25066666666666665
r13191 n8231 n8232 0.006266666666666666
r13192 n8203 n8233 0.10742857142857143
r13193 n8232 n8233 0.0078333333333333328
r13194 n8204 n8234 0.15039999999999998
r13195 n8205 n8235 0.15039999999999998
r13196 n8234 n8235 0.11750000000000001
r13197 n8206 n8236 0.752
r13198 n8235 n8236 0.070499999999999993
r13199 n8207 n8237 0.25066666666666665
r13200 n8236 n8237 0.047
r13201 n8208 n8238 0.752
r13202 n8237 n8238 0.047
r13203 n8209 n8239 0.08355555555555555
r13204 n8238 n8239 0.11750000000000001
r13205 n8210 n8240 0.075199999999999989
r13206 n8239 n8240 0.22325
r13207 n8211 n8241 0.15039999999999998
r13208 n8240 n8241 0.17624999999999999
r13209 n8212 n8242 0.15039999999999998
r13210 n8241 n8242 0.11750000000000001
r13211 n8213 n8243 0.752
r13212 n8242 n8243 0.070499999999999993
r13213 n8214 n8244 0.376
r13214 n8243 n8244 0.035249999999999997
r13215 n8215 n8245 0.752
r13216 n8244 n8245 0.035249999999999997
r13217 n8216 n8246 0.752
r13218 n8245 n8246 0.0235
r13219 n8217 n8247 0.752
r13220 n8246 n8247 0.0235
r13221 n8218 n8248 0.188
r13222 n8247 n8248 0.058750000000000004
r13223 n8219 n8249 0.15039999999999998
r13224 n8248 n8249 0.10575000000000001
r13225 n8220 n8250 0.752
r13226 n8249 n8250 0.070499999999999993
r13227 n8221 n8251 0.075199999999999989
r13228 n8250 n8251 0.12925
r13229 n8222 n8252 0.25066666666666665
r13230 n8251 n8252 0.15275
r13231 n8223 n8253 0.12533333333333332
r13232 n8252 n8253 0.10575000000000001
r13233 n8224 n8254 0.376
r13234 n8253 n8254 0.094
r13235 n8225 n8255 0.752
r13236 n8254 n8255 0.035249999999999997
r13237 n8226 n8256 0.752
r13238 n8255 n8256 0.0235
r13239 n8227 n8257 0.12533333333333332
r13240 n8256 n8257 0.082250000000000004
r13241 n8228 n8258 0.15039999999999998
r13242 n8257 n8258 0.12925
r13243 n8229 n8259 0.752
r13244 n8258 n8259 0.070499999999999993
r13245 n8230 n8260 0.188
r13246 n8259 n8260 0.058750000000000004
r13247 n8231 n8261 0.15039999999999998
r13248 n8260 n8261 0.10575000000000001
r13249 n8232 n8262 0.25066666666666665
r13250 n8261 n8262 0.094
r13251 n8233 n8263 0.10742857142857143
r13252 n8262 n8263 0.11750000000000001
r13253 n8234 n8264 0.0235
r13254 n8235 n8265 0.0235
r13255 n8264 n8265 0.078333333333333338
r13256 n8236 n8266 0.11750000000000001
r13257 n8265 n8266 0.047
r13258 n8237 n8267 0.039166666666666669
r13259 n8266 n8267 0.031333333333333331
r13260 n8238 n8268 0.11750000000000001
r13261 n8267 n8268 0.031333333333333331
r13262 n8239 n8269 0.013055555555555556
r13263 n8268 n8269 0.078333333333333338
r13264 n8240 n8270 0.01175
r13265 n8269 n8270 0.14883333333333332
r13266 n8241 n8271 0.0235
r13267 n8270 n8271 0.11749999999999999
r13268 n8242 n8272 0.0235
r13269 n8271 n8272 0.078333333333333338
r13270 n8243 n8273 0.11750000000000001
r13271 n8272 n8273 0.047
r13272 n8244 n8274 0.058750000000000004
r13273 n8273 n8274 0.0235
r13274 n8245 n8275 0.11750000000000001
r13275 n8274 n8275 0.0235
r13276 n8246 n8276 0.11750000000000001
r13277 n8275 n8276 0.015666666666666666
r13278 n8247 n8277 0.11750000000000001
r13279 n8276 n8277 0.015666666666666666
r13280 n8248 n8278 0.029375000000000002
r13281 n8277 n8278 0.039166666666666669
r13282 n8249 n8279 0.0235
r13283 n8278 n8279 0.070500000000000007
r13284 n8250 n8280 0.11750000000000001
r13285 n8279 n8280 0.047
r13286 n8251 n8281 0.01175
r13287 n8280 n8281 0.086166666666666669
r13288 n8252 n8282 0.039166666666666669
r13289 n8281 n8282 0.10183333333333335
r13290 n8253 n8283 0.019583333333333335
r13291 n8282 n8283 0.070500000000000007
r13292 n8254 n8284 0.058750000000000004
r13293 n8283 n8284 0.062666666666666662
r13294 n8255 n8285 0.11750000000000001
r13295 n8284 n8285 0.0235
r13296 n8256 n8286 0.11750000000000001
r13297 n8285 n8286 0.015666666666666666
r13298 n8257 n8287 0.019583333333333335
r13299 n8286 n8287 0.054833333333333331
r13300 n8258 n8288 0.0235
r13301 n8287 n8288 0.086166666666666669
r13302 n8259 n8289 0.11750000000000001
r13303 n8288 n8289 0.047
r13304 n8260 n8290 0.029375000000000002
r13305 n8289 n8290 0.039166666666666669
r13306 n8261 n8291 0.0235
r13307 n8290 n8291 0.070500000000000007
r13308 n8262 n8292 0.039166666666666669
r13309 n8291 n8292 0.062666666666666662
r13310 n8263 n8293 0.016785714285714286
r13311 n8292 n8293 0.078333333333333338
r13312 n8264 n8294 0.037599999999999995
r13313 n8265 n8295 0.037599999999999995
r13314 n8294 n8295 0.047
r13315 n8266 n8296 0.188
r13316 n8295 n8296 0.028199999999999999
r13317 n8267 n8297 0.062666666666666662
r13318 n8296 n8297 0.018799999999999997
r13319 n8268 n8298 0.188
r13320 n8297 n8298 0.018799999999999997
r13321 n8269 n8299 0.020888888888888887
r13322 n8298 n8299 0.047
r13323 n8270 n8300 0.018799999999999997
r13324 n8299 n8300 0.08929999999999999
r13325 n8271 n8301 0.037599999999999995
r13326 n8300 n8301 0.070499999999999993
r13327 n8272 n8302 0.037599999999999995
r13328 n8301 n8302 0.047
r13329 n8273 n8303 0.188
r13330 n8302 n8303 0.028199999999999999
r13331 n8274 n8304 0.094
r13332 n8303 n8304 0.0141
r13333 n8275 n8305 0.188
r13334 n8304 n8305 0.0141
r13335 n8276 n8306 0.188
r13336 n8305 n8306 0.0093999999999999986
r13337 n8277 n8307 0.188
r13338 n8306 n8307 0.0093999999999999986
r13339 n8278 n8308 0.047
r13340 n8307 n8308 0.0235
r13341 n8279 n8309 0.037599999999999995
r13342 n8308 n8309 0.042300000000000004
r13343 n8280 n8310 0.188
r13344 n8309 n8310 0.028199999999999999
r13345 n8281 n8311 0.018799999999999997
r13346 n8310 n8311 0.051699999999999996
r13347 n8282 n8312 0.062666666666666662
r13348 n8311 n8312 0.061100000000000002
r13349 n8283 n8313 0.031333333333333331
r13350 n8312 n8313 0.042300000000000004
r13351 n8284 n8314 0.094
r13352 n8313 n8314 0.037599999999999995
r13353 n8285 n8315 0.188
r13354 n8314 n8315 0.0141
r13355 n8286 n8316 0.188
r13356 n8315 n8316 0.0093999999999999986
r13357 n8287 n8317 0.031333333333333331
r13358 n8316 n8317 0.032899999999999999
r13359 n8288 n8318 0.037599999999999995
r13360 n8317 n8318 0.051699999999999996
r13361 n8289 n8319 0.188
r13362 n8318 n8319 0.028199999999999999
r13363 n8290 n8320 0.047
r13364 n8319 n8320 0.0235
r13365 n8291 n8321 0.037599999999999995
r13366 n8320 n8321 0.042300000000000004
r13367 n8292 n8322 0.062666666666666662
r13368 n8321 n8322 0.037599999999999995
r13369 n8293 n8323 0.026857142857142857
r13370 n8322 n8323 0.047
r13371 n8294 n8324 0.037599999999999995
r13372 n8295 n8325 0.037599999999999995
r13373 n8324 n8325 0.078333333333333338
r13374 n8296 n8326 0.188
r13375 n8325 n8326 0.047
r13376 n8297 n8327 0.062666666666666662
r13377 n8326 n8327 0.031333333333333331
r13378 n8298 n8328 0.188
r13379 n8327 n8328 0.031333333333333331
r13380 n8299 n8329 0.020888888888888887
r13381 n8328 n8329 0.078333333333333338
r13382 n8300 n8330 0.018799999999999997
r13383 n8329 n8330 0.14883333333333332
r13384 n8301 n8331 0.037599999999999995
r13385 n8330 n8331 0.11749999999999999
r13386 n8302 n8332 0.037599999999999995
r13387 n8331 n8332 0.078333333333333338
r13388 n8303 n8333 0.188
r13389 n8332 n8333 0.047
r13390 n8304 n8334 0.094
r13391 n8333 n8334 0.0235
r13392 n8305 n8335 0.188
r13393 n8334 n8335 0.0235
r13394 n8306 n8336 0.188
r13395 n8335 n8336 0.015666666666666666
r13396 n8307 n8337 0.188
r13397 n8336 n8337 0.015666666666666666
r13398 n8308 n8338 0.047
r13399 n8337 n8338 0.039166666666666669
r13400 n8309 n8339 0.037599999999999995
r13401 n8338 n8339 0.070500000000000007
r13402 n8310 n8340 0.188
r13403 n8339 n8340 0.047
r13404 n8311 n8341 0.018799999999999997
r13405 n8340 n8341 0.086166666666666669
r13406 n8312 n8342 0.062666666666666662
r13407 n8341 n8342 0.10183333333333335
r13408 n8313 n8343 0.031333333333333331
r13409 n8342 n8343 0.070500000000000007
r13410 n8314 n8344 0.094
r13411 n8343 n8344 0.062666666666666662
r13412 n8315 n8345 0.188
r13413 n8344 n8345 0.0235
r13414 n8316 n8346 0.188
r13415 n8345 n8346 0.015666666666666666
r13416 n8317 n8347 0.031333333333333331
r13417 n8346 n8347 0.054833333333333331
r13418 n8318 n8348 0.037599999999999995
r13419 n8347 n8348 0.086166666666666669
r13420 n8319 n8349 0.188
r13421 n8348 n8349 0.047
r13422 n8320 n8350 0.047
r13423 n8349 n8350 0.039166666666666669
r13424 n8321 n8351 0.037599999999999995
r13425 n8350 n8351 0.070500000000000007
r13426 n8322 n8352 0.062666666666666662
r13427 n8351 n8352 0.062666666666666662
r13428 n8323 n8353 0.026857142857142857
r13429 n8352 n8353 0.078333333333333338
r13430 n8324 n8354 0.0235
r13431 n8325 n8355 0.0235
r13432 n8354 n8355 0.11750000000000001
r13433 n8326 n8356 0.11750000000000001
r13434 n8355 n8356 0.070499999999999993
r13435 n8327 n8357 0.039166666666666669
r13436 n8356 n8357 0.047
r13437 n8328 n8358 0.11750000000000001
r13438 n8357 n8358 0.047
r13439 n8329 n8359 0.013055555555555556
r13440 n8358 n8359 0.11750000000000001
r13441 n8330 n8360 0.01175
r13442 n8359 n8360 0.22325
r13443 n8331 n8361 0.0235
r13444 n8360 n8361 0.17624999999999999
r13445 n8332 n8362 0.0235
r13446 n8361 n8362 0.11750000000000001
r13447 n8333 n8363 0.11750000000000001
r13448 n8362 n8363 0.070499999999999993
r13449 n8334 n8364 0.058750000000000004
r13450 n8363 n8364 0.035249999999999997
r13451 n8335 n8365 0.11750000000000001
r13452 n8364 n8365 0.035249999999999997
r13453 n8336 n8366 0.11750000000000001
r13454 n8365 n8366 0.0235
r13455 n8337 n8367 0.11750000000000001
r13456 n8366 n8367 0.0235
r13457 n8338 n8368 0.029375000000000002
r13458 n8367 n8368 0.058750000000000004
r13459 n8339 n8369 0.0235
r13460 n8368 n8369 0.10575000000000001
r13461 n8340 n8370 0.11750000000000001
r13462 n8369 n8370 0.070499999999999993
r13463 n8341 n8371 0.01175
r13464 n8370 n8371 0.12925
r13465 n8342 n8372 0.039166666666666669
r13466 n8371 n8372 0.15275
r13467 n8343 n8373 0.019583333333333335
r13468 n8372 n8373 0.10575000000000001
r13469 n8344 n8374 0.058750000000000004
r13470 n8373 n8374 0.094
r13471 n8345 n8375 0.11750000000000001
r13472 n8374 n8375 0.035249999999999997
r13473 n8346 n8376 0.11750000000000001
r13474 n8375 n8376 0.0235
r13475 n8347 n8377 0.019583333333333335
r13476 n8376 n8377 0.082250000000000004
r13477 n8348 n8378 0.0235
r13478 n8377 n8378 0.12925
r13479 n8349 n8379 0.11750000000000001
r13480 n8378 n8379 0.070499999999999993
r13481 n8350 n8380 0.029375000000000002
r13482 n8379 n8380 0.058750000000000004
r13483 n8351 n8381 0.0235
r13484 n8380 n8381 0.10575000000000001
r13485 n8352 n8382 0.039166666666666669
r13486 n8381 n8382 0.094
r13487 n8353 n8383 0.016785714285714286
r13488 n8382 n8383 0.11750000000000001
r13489 n8361 n8384 0.056399999999999999
r13490 n8362 n8385 0.056399999999999999
r13491 n8384 n8385 0.0235
r13492 n8363 n8386 0.28199999999999997
r13493 n8385 n8386 0.0141
r13494 n8364 n8387 0.14099999999999999
r13495 n8386 n8387 0.0070499999999999998
r13496 n8365 n8388 0.28199999999999997
r13497 n8387 n8388 0.0070499999999999998
r13498 n8366 n8389 0.28199999999999997
r13499 n8388 n8389 0.0046999999999999993
r13500 n8367 n8390 0.28199999999999997
r13501 n8389 n8390 0.0046999999999999993
r13502 n8368 n8391 0.070499999999999993
r13503 n8390 n8391 0.01175
r13504 n8369 n8392 0.056399999999999999
r13505 n8391 n8392 0.021150000000000002
r13506 n8370 n8393 0.28199999999999997
r13507 n8392 n8393 0.0141
r13508 n8371 n8394 0.028199999999999999
r13509 n8393 n8394 0.025849999999999998
r13510 n8372 n8395 0.094
r13511 n8394 n8395 0.030550000000000001
r13512 n8373 n8396 0.047
r13513 n8395 n8396 0.021150000000000002
r13514 n8374 n8397 0.14099999999999999
r13515 n8396 n8397 0.018799999999999997
r13516 n8375 n8398 0.28199999999999997
r13517 n8397 n8398 0.0070499999999999998
r13518 n8376 n8399 0.28199999999999997
r13519 n8398 n8399 0.0046999999999999993
r13520 n8377 n8400 0.047
r13521 n8399 n8400 0.016449999999999999
r13522 n8378 n8401 0.056399999999999999
r13523 n8400 n8401 0.025849999999999998
r13524 n8379 n8402 0.28199999999999997
r13525 n8401 n8402 0.0141
r13526 n8380 n8403 0.070499999999999993
r13527 n8402 n8403 0.01175
r13528 n8381 n8404 0.056399999999999999
r13529 n8403 n8404 0.021150000000000002
r13530 n8382 n8405 0.094
r13531 n8404 n8405 0.018799999999999997
r13532 n8383 n8406 0.040285714285714286
r13533 n8405 n8406 0.0235
r13534 n8386 n8407 0.49349999999999994
r13535 n8387 n8408 0.24674999999999997
r13536 n8407 n8408 0.0064090909090909086
r13537 n8388 n8409 0.49349999999999994
r13538 n8408 n8409 0.0064090909090909086
r13539 n8389 n8410 0.49349999999999994
r13540 n8409 n8410 0.0042727272727272727
r13541 n8390 n8411 0.49349999999999994
r13542 n8410 n8411 0.0042727272727272727
r13543 n8391 n8412 0.12337499999999998
r13544 n8411 n8412 0.010681818181818183
r13545 n8392 n8413 0.098699999999999996
r13546 n8412 n8413 0.019227272727272728
r13547 n8393 n8414 0.49349999999999994
r13548 n8413 n8414 0.012818181818181817
r13549 n8394 n8415 0.049349999999999998
r13550 n8414 n8415 0.0235
r13551 n8395 n8416 0.16449999999999998
r13552 n8415 n8416 0.027772727272727275
r13553 n8396 n8417 0.08224999999999999
r13554 n8416 n8417 0.019227272727272728
r13555 n8397 n8418 0.24674999999999997
r13556 n8417 n8418 0.017090909090909091
r13557 n8398 n8419 0.49349999999999994
r13558 n8418 n8419 0.0064090909090909086
r13559 n8399 n8420 0.49349999999999994
r13560 n8419 n8420 0.0042727272727272727
r13561 n8400 n8421 0.08224999999999999
r13562 n8420 n8421 0.014954545454545455
r13563 n8401 n8422 0.098699999999999996
r13564 n8421 n8422 0.0235
r13565 n8402 n8423 0.49349999999999994
r13566 n8422 n8423 0.012818181818181817
r13567 n8403 n8424 0.12337499999999998
r13568 n8423 n8424 0.010681818181818183
r13569 n8404 n8425 0.098699999999999996
r13570 n8424 n8425 0.019227272727272728
r13571 n8407 n8426 1.1984999999999999
r13572 n8408 n8427 0.59924999999999995
r13573 n8426 n8427 0.0017625
r13574 n8409 n8428 1.1984999999999999
r13575 n8427 n8428 0.0017625
r13576 n8410 n8429 1.1984999999999999
r13577 n8428 n8429 0.0011749999999999998
r13578 n8411 n8430 1.1984999999999999
r13579 n8429 n8430 0.0011749999999999998
r13580 n8412 n8431 0.29962499999999997
r13581 n8430 n8431 0.0029375
r13582 n8413 n8432 0.2397
r13583 n8431 n8432 0.0052875000000000005
r13584 n8414 n8433 1.1984999999999999
r13585 n8432 n8433 0.0035249999999999999
r13586 n8415 n8434 0.11985
r13587 n8433 n8434 0.0064624999999999995
r13588 n8416 n8435 0.39949999999999997
r13589 n8434 n8435 0.0076375000000000002
r13590 n8417 n8436 0.19974999999999998
r13591 n8435 n8436 0.0052875000000000005
r13592 n8418 n8437 0.59924999999999995
r13593 n8436 n8437 0.0046999999999999993
r13594 n8419 n8438 1.1984999999999999
r13595 n8437 n8438 0.0017625
r13596 n8420 n8439 1.1984999999999999
r13597 n8438 n8439 0.0011749999999999998
r13598 n8421 n8440 0.19974999999999998
r13599 n8439 n8440 0.0041124999999999998
r13600 n8422 n8441 0.2397
r13601 n8440 n8441 0.0064624999999999995
r13602 n8423 n8442 1.1984999999999999
r13603 n8441 n8442 0.0035249999999999999
r13604 n8424 n8443 0.29962499999999997
r13605 n8442 n8443 0.0029375
r13606 n8425 n8444 0.2397
r13607 n8443 n8444 0.0052875000000000005
r13608 n8426 n8445 1.8800000000000001
r13609 n8427 n8446 0.94000000000000006
r13610 n8445 n8446 0.0017625
r13611 n8428 n8447 1.8800000000000001
r13612 n8446 n8447 0.0017625
r13613 n8429 n8448 1.8800000000000001
r13614 n8447 n8448 0.0011749999999999998
r13615 n8430 n8449 1.8800000000000001
r13616 n8448 n8449 0.0011749999999999998
r13617 n8431 n8450 0.47000000000000003
r13618 n8449 n8450 0.0029375
r13619 n8432 n8451 0.376
r13620 n8450 n8451 0.0052875000000000005
r13621 n8433 n8452 1.8800000000000001
r13622 n8451 n8452 0.0035249999999999999
r13623 n8434 n8453 0.188
r13624 n8452 n8453 0.0064624999999999995
r13625 n8435 n8454 0.62666666666666671
r13626 n8453 n8454 0.0076375000000000002
r13627 n8436 n8455 0.31333333333333335
r13628 n8454 n8455 0.0052875000000000005
r13629 n8437 n8456 0.94000000000000006
r13630 n8455 n8456 0.0046999999999999993
r13631 n8438 n8457 1.8800000000000001
r13632 n8456 n8457 0.0017625
r13633 n8439 n8458 1.8800000000000001
r13634 n8457 n8458 0.0011749999999999998
r13635 n8440 n8459 0.31333333333333335
r13636 n8458 n8459 0.0041124999999999998
r13637 n8441 n8460 0.376
r13638 n8459 n8460 0.0064624999999999995
r13639 n8442 n8461 1.8800000000000001
r13640 n8460 n8461 0.0035249999999999999
r13641 n8443 n8462 0.47000000000000003
r13642 n8461 n8462 0.0029375
r13643 n8444 n8463 0.376
r13644 n8462 n8463 0.0052875000000000005
r13645 n8445 n8464 1.7390000000000001
r13646 n8446 n8465 0.86950000000000005
r13647 n8464 n8465 0.0020735294117647058
r13648 n8447 n8466 1.7390000000000001
r13649 n8465 n8466 0.0020735294117647058
r13650 n8448 n8467 1.7390000000000001
r13651 n8466 n8467 0.0013823529411764704
r13652 n8449 n8468 1.7390000000000001
r13653 n8467 n8468 0.0013823529411764704
r13654 n8450 n8469 0.43475000000000003
r13655 n8468 n8469 0.0034558823529411767
r13656 n8451 n8470 0.3478
r13657 n8469 n8470 0.0062205882352941184
r13658 n8452 n8471 1.7390000000000001
r13659 n8470 n8471 0.0041470588235294117
r13660 n8453 n8472 0.1739
r13661 n8471 n8472 0.0076029411764705884
r13662 n8454 n8473 0.57966666666666666
r13663 n8472 n8473 0.0089852941176470601
r13664 n8455 n8474 0.28983333333333333
r13665 n8473 n8474 0.0062205882352941184
r13666 n8456 n8475 0.86950000000000005
r13667 n8474 n8475 0.0055294117647058817
r13668 n8457 n8476 1.7390000000000001
r13669 n8475 n8476 0.0020735294117647058
r13670 n8458 n8477 1.7390000000000001
r13671 n8476 n8477 0.0013823529411764704
r13672 n8459 n8478 0.28983333333333333
r13673 n8477 n8478 0.0048382352941176475
r13674 n8460 n8479 0.3478
r13675 n8478 n8479 0.0076029411764705884
r13676 n8461 n8480 1.7390000000000001
r13677 n8479 n8480 0.0041470588235294117
r13678 n8462 n8481 0.43475000000000003
r13679 n8480 n8481 0.0034558823529411767
r13680 n8463 n8482 0.3478
r13681 n8481 n8482 0.0062205882352941184
r13682 n8464 n8483 1.8283
r13683 n8465 n8484 0.91415000000000002
r13684 n8483 n8484 0.0016095890410958904
r13685 n8466 n8485 1.8283
r13686 n8484 n8485 0.0016095890410958904
r13687 n8467 n8486 1.8283
r13688 n8485 n8486 0.0010730593607305935
r13689 n8468 n8487 1.8283
r13690 n8486 n8487 0.0010730593607305935
r13691 n8469 n8488 0.45707500000000001
r13692 n8487 n8488 0.0026826484018264841
r13693 n8470 n8489 0.36566000000000004
r13694 n8488 n8489 0.004828767123287672
r13695 n8471 n8490 1.8283
r13696 n8489 n8490 0.0032191780821917808
r13697 n8472 n8491 0.18283000000000002
r13698 n8490 n8491 0.0059018264840182645
r13699 n8473 n8492 0.60943333333333338
r13700 n8491 n8492 0.0069748858447488587
r13701 n8474 n8493 0.30471666666666669
r13702 n8492 n8493 0.004828767123287672
r13703 n8475 n8494 0.91415000000000002
r13704 n8493 n8494 0.0042922374429223741
r13705 n8476 n8495 1.8283
r13706 n8494 n8495 0.0016095890410958904
r13707 n8477 n8496 1.8283
r13708 n8495 n8496 0.0010730593607305935
r13709 n8478 n8497 0.30471666666666669
r13710 n8496 n8497 0.0037557077625570779
r13711 n8479 n8498 0.36566000000000004
r13712 n8497 n8498 0.0059018264840182645
r13713 n8480 n8499 1.8283
r13714 n8498 n8499 0.0032191780821917808
r13715 n8481 n8500 0.45707500000000001
r13716 n8499 n8500 0.0026826484018264841
r13717 n8482 n8501 0.36566000000000004
r13718 n8500 n8501 0.004828767123287672
r13719 n8483 n8502 2.0539000000000001
r13720 n8484 n8503 1.02695
r13721 n8502 n8503 0.0016169724770642201
r13722 n8485 n8504 2.0539000000000001
r13723 n8503 n8504 0.0016169724770642201
r13724 n8486 n8505 2.0539000000000001
r13725 n8504 n8505 0.0010779816513761468
r13726 n8487 n8506 2.0539000000000001
r13727 n8505 n8506 0.0010779816513761468
r13728 n8488 n8507 0.51347500000000001
r13729 n8506 n8507 0.0026949541284403671
r13730 n8489 n8508 0.41078000000000003
r13731 n8507 n8508 0.0048509174311926612
r13732 n8490 n8509 2.0539000000000001
r13733 n8508 n8509 0.0032339449541284402
r13734 n8491 n8510 0.20539000000000002
r13735 n8509 n8510 0.0059288990825688073
r13736 n8492 n8511 0.68463333333333343
r13737 n8510 n8511 0.0070068807339449543
r13738 n8493 n8512 0.34231666666666671
r13739 n8511 n8512 0.0048509174311926612
r13740 n8494 n8513 1.02695
r13741 n8512 n8513 0.0043119266055045872
r13742 n8495 n8514 2.0539000000000001
r13743 n8513 n8514 0.0016169724770642201
r13744 n8496 n8515 2.0539000000000001
r13745 n8514 n8515 0.0010779816513761468
r13746 n8497 n8516 0.34231666666666671
r13747 n8515 n8516 0.0037729357798165137
r13748 n8498 n8517 0.41078000000000003
r13749 n8516 n8517 0.0059288990825688073
r13750 n8499 n8518 2.0539000000000001
r13751 n8517 n8518 0.0032339449541284402
r13752 n8500 n8519 0.51347500000000001
r13753 n8518 n8519 0.0026949541284403671
r13754 n8501 n8520 0.41078000000000003
r13755 n8519 n8520 0.0048509174311926612
r13756 n8502 n8521 2.0539000000000001
r13757 n8503 n8522 1.02695
r13758 n8521 n8522 0.0016095890410958904
r13759 n8504 n8523 2.0539000000000001
r13760 n8522 n8523 0.0016095890410958904
r13761 n8505 n8524 2.0539000000000001
r13762 n8523 n8524 0.0010730593607305935
r13763 n8506 n8525 2.0539000000000001
r13764 n8524 n8525 0.0010730593607305935
r13765 n8507 n8526 0.51347500000000001
r13766 n8525 n8526 0.0026826484018264841
r13767 n8508 n8527 0.41078000000000003
r13768 n8526 n8527 0.004828767123287672
r13769 n8509 n8528 2.0539000000000001
r13770 n8527 n8528 0.0032191780821917808
r13771 n8510 n8529 0.20539000000000002
r13772 n8528 n8529 0.0059018264840182645
r13773 n8511 n8530 0.68463333333333343
r13774 n8529 n8530 0.0069748858447488587
r13775 n8512 n8531 0.34231666666666671
r13776 n8530 n8531 0.004828767123287672
r13777 n8513 n8532 1.02695
r13778 n8531 n8532 0.0042922374429223741
r13779 n8514 n8533 2.0539000000000001
r13780 n8532 n8533 0.0016095890410958904
r13781 n8515 n8534 2.0539000000000001
r13782 n8533 n8534 0.0010730593607305935
r13783 n8516 n8535 0.34231666666666671
r13784 n8534 n8535 0.0037557077625570779
r13785 n8517 n8536 0.41078000000000003
r13786 n8535 n8536 0.0059018264840182645
r13787 n8518 n8537 2.0539000000000001
r13788 n8536 n8537 0.0032191780821917808
r13789 n8519 n8538 0.51347500000000001
r13790 n8537 n8538 0.0026826484018264841
r13791 n8520 n8539 0.41078000000000003
r13792 n8538 n8539 0.004828767123287672
r13793 n8521 n8540 2.0585999999999998
r13794 n8522 n8541 1.0292999999999999
r13795 n8540 n8541 0.0016095890410958904
r13796 n8523 n8542 2.0585999999999998
r13797 n8541 n8542 0.0016095890410958904
r13798 n8524 n8543 2.0585999999999998
r13799 n8542 n8543 0.0010730593607305935
r13800 n8525 n8544 2.0585999999999998
r13801 n8543 n8544 0.0010730593607305935
r13802 n8526 n8545 0.51464999999999994
r13803 n8544 n8545 0.0026826484018264841
r13804 n8527 n8546 0.41171999999999997
r13805 n8545 n8546 0.004828767123287672
r13806 n8528 n8547 2.0585999999999998
r13807 n8546 n8547 0.0032191780821917808
r13808 n8529 n8548 0.20585999999999999
r13809 n8547 n8548 0.0059018264840182645
r13810 n8530 n8549 0.68619999999999992
r13811 n8548 n8549 0.0069748858447488587
r13812 n8531 n8550 0.34309999999999996
r13813 n8549 n8550 0.004828767123287672
r13814 n8532 n8551 1.0292999999999999
r13815 n8550 n8551 0.0042922374429223741
r13816 n8533 n8552 2.0585999999999998
r13817 n8551 n8552 0.0016095890410958904
r13818 n8534 n8553 2.0585999999999998
r13819 n8552 n8553 0.0010730593607305935
r13820 n8535 n8554 0.34309999999999996
r13821 n8553 n8554 0.0037557077625570779
r13822 n8536 n8555 0.41171999999999997
r13823 n8554 n8555 0.0059018264840182645
r13824 n8537 n8556 2.0585999999999998
r13825 n8555 n8556 0.0032191780821917808
r13826 n8538 n8557 0.51464999999999994
r13827 n8556 n8557 0.0026826484018264841
r13828 n8539 n8558 0.41171999999999997
r13829 n8557 n8558 0.004828767123287672
r13830 n8540 out 1.8893999999999997
r13831 n8541 out 0.94469999999999987
r13832 n8542 out 1.8893999999999997
r13833 n8543 out 1.8893999999999997
r13834 n8544 out 1.8893999999999997
r13835 n8545 out 0.47234999999999994
r13836 n8546 out 0.37787999999999999
r13837 n8547 out 1.8893999999999997
r13838 n8548 out 0.18894
r13839 n8549 out 0.62979999999999992
r13840 n8550 out 0.31489999999999996
r13841 n8551 out 0.94469999999999987
r13842 n8552 out 1.8893999999999997
r13843 n8553 out 1.8893999999999997
r13844 n8554 out 0.31489999999999996
r13845 n8555 out 0.37787999999999999
r13846 n8556 out 1.8893999999999997
r13847 n8557 out 0.47234999999999994
r13848 n8558 out 0.37787999999999999
r13849 n9 0 158.10000000000002
r13850 n10 0 10.540000000000001
r13851 n11 0 158.10000000000002
r13852 n193 n2025 2687.7000000000003
r13853 n194 n2026 179.18000000000004
r13854 n195 n2027 2687.7000000000003
r13855 n200 n2037 179.18000000000004
r13856 n201 n2038 11.945333333333334
r13857 n202 n2039 179.18000000000004
r13858 n207 n2049 2687.7000000000003
r13859 n208 n2050 179.18000000000004
r13860 n209 n2051 2687.7000000000003
r13861 n467 n2304 413.49230769230769
r13862 n468 n2305 537.53999999999996
r13863 n469 n2306 1075.0799999999999
r13864 n470 n2307 1075.0799999999999
r13865 n471 n2308 5375.4000000000005
r13866 n504 n2335 51.686538461538461
r13867 n505 n2336 67.192499999999995
r13868 n506 n2337 134.38499999999999
r13869 n507 n2338 134.38499999999999
r13870 n508 n2339 671.92500000000007
r13871 n541 n2366 59.070329670329677
r13872 n542 n2367 76.791428571428582
r13873 n543 n2368 153.58285714285716
r13874 n544 n2369 153.58285714285716
r13875 n545 n2370 767.91428571428582
r13876 n578 n2397 413.49230769230769
r13877 n579 n2398 537.53999999999996
r13878 n580 n2399 1075.0799999999999
r13879 n581 n2400 1075.0799999999999
r13880 n582 n2401 5375.4000000000005
r13881 n735 n2806 413.49230769230769
r13882 n736 n2807 537.53999999999996
r13883 n737 n2808 1075.0799999999999
r13884 n738 n2809 1075.0799999999999
r13885 n739 n2810 5375.4000000000005
r13886 n772 n2837 55.132307692307698
r13887 n773 n2838 71.672000000000011
r13888 n774 n2839 143.34400000000002
r13889 n775 n2840 143.34400000000002
r13890 n776 n2841 716.72000000000014
r13891 n809 n2868 55.132307692307698
r13892 n810 n2869 71.672000000000011
r13893 n811 n2870 143.34400000000002
r13894 n812 n2871 143.34400000000002
r13895 n813 n2872 716.72000000000014
r13896 n846 n2899 413.49230769230769
r13897 n847 n2900 537.53999999999996
r13898 n848 n2901 1075.0799999999999
r13899 n849 n2902 1075.0799999999999
r13900 n850 n2903 5375.4000000000005
r13901 n250 n2127 5375.4000000000005
r13902 n251 n2128 5375.4000000000005
r13903 n252 n2129 5375.4000000000005
r13904 n253 n2130 1343.8500000000001
r13905 n254 n2131 1075.0799999999999
r13906 n255 n2132 5375.4000000000005
r13907 n256 n2133 537.53999999999996
r13908 n257 n2134 1791.8000000000002
r13909 n258 n2135 895.90000000000009
r13910 n259 n2136 2687.7000000000003
r13911 n318 n2149 358.36000000000007
r13912 n319 n2150 358.36000000000007
r13913 n320 n2151 358.36000000000007
r13914 n321 n2152 89.590000000000018
r13915 n322 n2153 71.672000000000011
r13916 n323 n2154 358.36000000000007
r13917 n324 n2155 35.836000000000006
r13918 n325 n2156 119.45333333333335
r13919 n326 n2157 59.726666666666674
r13920 n327 n2158 179.18000000000004
r13921 n386 n2171 5375.4000000000005
r13922 n387 n2172 5375.4000000000005
r13923 n388 n2173 5375.4000000000005
r13924 n389 n2174 1343.8500000000001
r13925 n390 n2175 1075.0799999999999
r13926 n391 n2176 5375.4000000000005
r13927 n392 n2177 537.53999999999996
r13928 n393 n2178 1791.8000000000002
r13929 n394 n2179 895.90000000000009
r13930 n395 n2180 2687.7000000000003
r13931 n482 n2319 5375.4000000000005
r13932 n483 n2320 1343.8500000000001
r13933 n484 n2321 1075.0799999999999
r13934 n485 n2322 5375.4000000000005
r13935 n486 n2323 537.53999999999996
r13936 n487 n2324 1791.8000000000002
r13937 n488 n2325 895.90000000000009
r13938 n489 n2326 2687.7000000000003
r13939 n490 n2327 5375.4000000000005
r13940 n491 n2328 5375.4000000000005
r13941 n519 n2350 671.92500000000007
r13942 n520 n2351 167.98125000000002
r13943 n521 n2352 134.38499999999999
r13944 n522 n2353 671.92500000000007
r13945 n523 n2354 67.192499999999995
r13946 n524 n2355 223.97500000000002
r13947 n525 n2356 111.98750000000001
r13948 n526 n2357 335.96250000000003
r13949 n527 n2358 671.92500000000007
r13950 n528 n2359 671.92500000000007
r13951 n556 n2381 767.91428571428582
r13952 n557 n2382 191.97857142857146
r13953 n558 n2383 153.58285714285716
r13954 n559 n2384 767.91428571428582
r13955 n560 n2385 76.791428571428582
r13956 n561 n2386 255.97142857142859
r13957 n562 n2387 127.98571428571429
r13958 n563 n2388 383.95714285714291
r13959 n564 n2389 767.91428571428582
r13960 n565 n2390 767.91428571428582
r13961 n593 n2412 5375.4000000000005
r13962 n594 n2413 1343.8500000000001
r13963 n595 n2414 1075.0799999999999
r13964 n596 n2415 5375.4000000000005
r13965 n597 n2416 537.53999999999996
r13966 n598 n2417 1791.8000000000002
r13967 n599 n2418 895.90000000000009
r13968 n600 n2419 2687.7000000000003
r13969 n601 n2420 5375.4000000000005
r13970 n602 n2421 5375.4000000000005
r13971 n750 n2821 5375.4000000000005
r13972 n751 n2822 1343.8500000000001
r13973 n752 n2823 1075.0799999999999
r13974 n753 n2824 5375.4000000000005
r13975 n754 n2825 537.53999999999996
r13976 n755 n2826 1791.8000000000002
r13977 n756 n2827 895.90000000000009
r13978 n757 n2828 2687.7000000000003
r13979 n758 n2829 5375.4000000000005
r13980 n759 n2830 5375.4000000000005
r13981 n787 n2852 716.72000000000014
r13982 n788 n2853 179.18000000000004
r13983 n789 n2854 143.34400000000002
r13984 n790 n2855 716.72000000000014
r13985 n791 n2856 71.672000000000011
r13986 n792 n2857 238.90666666666669
r13987 n793 n2858 119.45333333333335
r13988 n794 n2859 358.36000000000007
r13989 n795 n2860 716.72000000000014
r13990 n796 n2861 716.72000000000014
r13991 n824 n2883 716.72000000000014
r13992 n825 n2884 179.18000000000004
r13993 n826 n2885 143.34400000000002
r13994 n827 n2886 716.72000000000014
r13995 n828 n2887 71.672000000000011
r13996 n829 n2888 238.90666666666669
r13997 n830 n2889 119.45333333333335
r13998 n831 n2890 358.36000000000007
r13999 n832 n2891 716.72000000000014
r14000 n833 n2892 716.72000000000014
r14001 n861 n2914 5375.4000000000005
r14002 n862 n2915 1343.8500000000001
r14003 n863 n2916 1075.0799999999999
r14004 n864 n2917 5375.4000000000005
r14005 n865 n2918 537.53999999999996
r14006 n866 n2919 1791.8000000000002
r14007 n867 n2920 895.90000000000009
r14008 n868 n2921 2687.7000000000003
r14009 n869 n2922 5375.4000000000005
r14010 n870 n2923 5375.4000000000005
r14011 n663 n2621 2687.7000000000003
r14012 n664 n2622 316.20000000000005
r14013 n665 n2623 413.49230769230769
r14014 n666 n2624 2687.7000000000003
r14015 n671 n2634 191.97857142857146
r14016 n672 n2635 22.585714285714289
r14017 n673 n2636 29.535164835164839
r14018 n674 n2637 191.97857142857146
r14019 n679 n2647 2687.7000000000003
r14020 n680 n2648 316.20000000000005
r14021 n681 n2649 413.49230769230769
r14022 n682 n2650 2687.7000000000003
r14023 n687 n2660 2687.7000000000003
r14024 n688 n2661 316.20000000000005
r14025 n689 n2662 413.49230769230769
r14026 n690 n2663 2687.7000000000003
r14027 n1070 n3019 2687.7000000000003
r14028 n1071 n3020 179.18000000000004
r14029 n1072 n3021 2687.7000000000003
r14030 n1217 n3024 179.18000000000004
r14031 n1218 n3025 11.945333333333334
r14032 n1219 n3026 179.18000000000004
r14033 n1364 n3029 2687.7000000000003
r14034 n1365 n3030 179.18000000000004
r14035 n1366 n3031 2687.7000000000003
r14036 n2038 n3831 4.5
r14037 n2342 n4768 28.125
r14038 n2343 n4769 25.3125
r14039 n2344 n4770 50.625
r14040 n2345 n4771 50.625
r14041 n2346 n4772 253.125
r14042 n2373 n4827 32.142857142857139
r14043 n2374 n4828 28.928571428571427
r14044 n2375 n4829 57.857142857142854
r14045 n2376 n4830 57.857142857142854
r14046 n2377 n4831 289.28571428571428
r14047 n2844 n5623 30
r14048 n2845 n5624 27
r14049 n2846 n5625 54
r14050 n2847 n5626 54
r14051 n2848 n5627 270
r14052 n2875 n5654 30
r14053 n2876 n5655 27
r14054 n2877 n5656 54
r14055 n2878 n5657 54
r14056 n2879 n5658 270
r14057 n2151 n4246 135
r14058 n2152 n4247 33.75
r14059 n2153 n4248 27
r14060 n2154 n4249 135
r14061 n2155 n4250 13.5
r14062 n2156 n4251 45
r14063 n2157 n4252 22.5
r14064 t_r1_a n6928 135
r14065 t_r1_a n6929 13.5
r14066 t_r1_a n6930 45
r14067 t_r1_a n6931 22.5
r14068 t_r1_a n6932 67.5
r14069 t_r1_a n6933 135
r14070 t_r1_a n6934 135
r14071 t_r1_a n6935 22.5
r14072 n2635 n5284 8.5084033613445378
r14073 n2636 n5285 11.126373626373626
r14074 n2648 n5328 119.11764705882352
r14075 n2649 n5329 155.76923076923077
r14076 n3025 n6323 4.5
r14077 t_r1_b n6944 8.4375
r14078 t_r1_b n6945 9.6428571428571423
r14079 n2043 n3856 135
r14080 n2044 n3857 4.8214285714285712
r14081 n2045 n3858 135
r14082 n5558 n7514 1818.6666666666667
r14083 n5559 n7515 606.22222222222229
r14084 n5560 n7516 1818.6666666666667
r14085 n5561 n7517 202.07407407407408
r14086 n5562 n7518 181.86666666666667
r14087 n5563 n7519 363.73333333333335
r14088 n5564 n7520 363.73333333333335
r14089 n5565 n7521 1818.6666666666667
r14090 n5566 n7522 909.33333333333337
r14091 n5567 n7523 1818.6666666666667
r14092 n5568 n7524 1818.6666666666667
r14093 n5569 n7525 1818.6666666666667
r14094 n5589 n7533 2728
r14095 n5590 n7534 909.33333333333337
r14096 n5591 n7535 2728
r14097 n5592 n7536 303.11111111111114
r14098 n5593 n7537 272.80000000000001
r14099 n5594 n7538 545.60000000000002
r14100 n5595 n7539 545.60000000000002
r14101 n5596 n7540 2728
r14102 n5597 n7541 1364
r14103 n5598 n7542 2728
r14104 n5599 n7543 2728
r14105 n5600 n7544 2728
r14106 n5620 n7552 363.73333333333335
r14107 n5621 n7553 121.24444444444444
r14108 n5622 n7554 363.73333333333335
r14109 n5623 n7555 40.414814814814811
r14110 n5624 n7556 36.373333333333335
r14111 n5625 n7557 72.74666666666667
r14112 n5626 n7558 72.74666666666667
r14113 n5627 n7559 363.73333333333335
r14114 n5628 n7560 181.86666666666667
r14115 n5629 n7561 363.73333333333335
r14116 n5630 n7562 363.73333333333335
r14117 n5631 n7563 363.73333333333335
r14118 n5651 n7571 363.73333333333335
r14119 n5652 n7572 121.24444444444444
r14120 n5653 n7573 363.73333333333335
r14121 n5654 n7574 40.414814814814811
r14122 n5655 n7575 36.373333333333335
r14123 n5656 n7576 72.74666666666667
r14124 n5657 n7577 72.74666666666667
r14125 n5658 n7578 363.73333333333335
r14126 n5659 n7579 181.86666666666667
r14127 n5660 n7580 363.73333333333335
r14128 n5661 n7581 363.73333333333335
r14129 n5662 n7582 363.73333333333335
r14130 n5682 n7590 2728
r14131 n5683 n7591 909.33333333333337
r14132 n5684 n7592 2728
r14133 n5685 n7593 303.11111111111114
r14134 n5686 n7594 272.80000000000001
r14135 n5687 n7595 545.60000000000002
r14136 n5688 n7596 545.60000000000002
r14137 n5689 n7597 2728
r14138 n5690 n7598 1364
r14139 n5691 n7599 2728
r14140 n5692 n7600 2728
r14141 n5693 n7601 2728
r14142 n5713 n7609 1818.6666666666667
r14143 n5714 n7610 606.22222222222229
r14144 n5715 n7611 1818.6666666666667
r14145 n5716 n7612 202.07407407407408
r14146 n5717 n7613 181.86666666666667
r14147 n5718 n7614 363.73333333333335
r14148 n5719 n7615 363.73333333333335
r14149 n5720 n7616 1818.6666666666667
r14150 n5721 n7617 909.33333333333337
r14151 n5722 n7618 1818.6666666666667
r14152 n5723 n7619 1818.6666666666667
r14153 n5724 n7620 1818.6666666666667
r14154 n6817 n8159 363.73333333333335
r14155 n6818 n8160 1818.6666666666667
r14156 n6819 n8161 181.86666666666667
r14157 n6820 n8162 606.22222222222229
r14158 n6821 n8163 303.11111111111114
r14159 n6822 n8164 909.33333333333337
r14160 n6823 n8165 1818.6666666666667
r14161 n6824 n8166 1818.6666666666667
r14162 n6825 n8167 303.11111111111114
r14163 n6826 n8168 363.73333333333335
r14164 n6872 n8189 545.60000000000002
r14165 n6873 n8190 2728
r14166 n6874 n8191 272.80000000000001
r14167 n6875 n8192 909.33333333333337
r14168 n6876 n8193 454.66666666666669
r14169 n6877 n8194 1364
r14170 n6878 n8195 2728
r14171 n6879 n8196 2728
r14172 n6880 n8197 454.66666666666669
r14173 n6881 n8198 545.60000000000002
r14174 n6927 n8219 36.373333333333335
r14175 n6928 n8220 181.86666666666667
r14176 n6929 n8221 18.186666666666667
r14177 n6930 n8222 60.62222222222222
r14178 n6931 n8223 30.31111111111111
r14179 n6932 n8224 90.933333333333337
r14180 n6933 n8225 181.86666666666667
r14181 n6934 n8226 181.86666666666667
r14182 n6935 n8227 30.31111111111111
r14183 n6936 n8228 36.373333333333335
r14184 n6982 n8249 545.60000000000002
r14185 n6983 n8250 2728
r14186 n6984 n8251 272.80000000000001
r14187 n6985 n8252 909.33333333333337
r14188 n6986 n8253 454.66666666666669
r14189 n6987 n8254 1364
r14190 n6988 n8255 2728
r14191 n6989 n8256 2728
r14192 n6990 n8257 454.66666666666669
r14193 n6991 n8258 545.60000000000002
r14194 n7037 n8279 363.73333333333335
r14195 n7038 n8280 1818.6666666666667
r14196 n7039 n8281 181.86666666666667
r14197 n7040 n8282 606.22222222222229
r14198 n7041 n8283 303.11111111111114
r14199 n7042 n8284 909.33333333333337
r14200 n7043 n8285 1818.6666666666667
r14201 n7044 n8286 1818.6666666666667
r14202 n7045 n8287 303.11111111111114
r14203 n7046 n8288 363.73333333333335
r14204 n442 t_m1_b 585
r14205 n536 t_m1_b 1420.7142857142858
r14206 n573 t_m1_b 9945
r14207 n610 t_m1_b 4972.5
r14208 n614 t_m1_b 9945
r14209 n622 t_m1_b 19890
r14210 n630 t_m1_b 4972.5
r14211 n638 t_m1_b 9945
r14212 n646 t_m1_b 3978
r14213 n702 t_m1_b 4972.5
r14214 n710 t_m1_b 2841.4285714285716
r14215 n718 t_m1_b 6630
r14216 n726 t_m1_b 6630
r14217 n730 t_m1_b 9945
r14218 n767 t_m1_b 1326
r14219 n894 t_m1_b 9945
r14220 n898 t_m1_b 621.5625
r14221 n230 t_m1_b 10246.363636363636
r14222 n231 t_m1_b 338130
r14223 n298 t_m1_b 683.09090909090912
r14224 n299 t_m1_b 22542
r14225 n366 t_m1_b 10246.363636363636
r14226 n367 t_m1_b 338130
r14227 n910 t_m1_b 602.72727272727275
r14228 n911 t_m1_b 19890
r14229 n236 t_m1_b 338130
r14230 n237 t_m1_b 26010
r14231 n238 t_m1_b 33813
r14232 n239 t_m1_b 67626
r14233 n240 t_m1_b 67626
r14234 n304 t_m1_b 22542
r14235 n305 t_m1_b 1734
r14236 n306 t_m1_b 2254.2000000000003
r14237 n307 t_m1_b 4508.4000000000005
r14238 n308 t_m1_b 4508.4000000000005
r14239 n372 t_m1_b 338130
r14240 n373 t_m1_b 26010
r14241 n374 t_m1_b 33813
r14242 n375 t_m1_b 67626
r14243 n376 t_m1_b 67626
r14244 n916 t_m1_b 19890
r14245 n917 t_m1_b 1530
r14246 n918 t_m1_b 1989
r14247 n919 t_m1_b 3978
r14248 n920 t_m1_b 3978
r14249 n467 t_m1_s 8225.3846153846152
r14250 n468 t_m1_s 10693
r14251 n469 t_m1_s 21386
r14252 n470 t_m1_s 21386
r14253 n471 t_m1_s 106930
r14254 n504 t_m1_s 1028.1730769230769
r14255 n505 t_m1_s 1336.625
r14256 n506 t_m1_s 2673.25
r14257 n507 t_m1_s 2673.25
r14258 n508 t_m1_s 13366.25
r14259 n541 t_m1_s 1175.0549450549452
r14260 n542 t_m1_s 1527.5714285714287
r14261 n543 t_m1_s 3055.1428571428573
r14262 n544 t_m1_s 3055.1428571428573
r14263 n545 t_m1_s 15275.714285714286
r14264 n578 t_m1_s 8225.3846153846152
r14265 n579 t_m1_s 10693
r14266 n580 t_m1_s 21386
r14267 n581 t_m1_s 21386
r14268 n582 t_m1_s 106930
r14269 n735 t_m1_d 8225.3846153846152
r14270 n736 t_m1_d 10693
r14271 n737 t_m1_d 21386
r14272 n738 t_m1_d 21386
r14273 n739 t_m1_d 106930
r14274 n772 t_m1_d 1096.7179487179487
r14275 n773 t_m1_d 1425.7333333333333
r14276 n774 t_m1_d 2851.4666666666667
r14277 n775 t_m1_d 2851.4666666666667
r14278 n776 t_m1_d 14257.333333333334
r14279 n809 t_m1_d 1096.7179487179487
r14280 n810 t_m1_d 1425.7333333333333
r14281 n811 t_m1_d 2851.4666666666667
r14282 n812 t_m1_d 2851.4666666666667
r14283 n813 t_m1_d 14257.333333333334
r14284 n846 t_m1_d 8225.3846153846152
r14285 n847 t_m1_d 10693
r14286 n848 t_m1_d 21386
r14287 n849 t_m1_d 21386
r14288 n850 t_m1_d 106930
r14289 n251 t_m1_b 338130
r14290 n252 t_m1_b 338130
r14291 n253 t_m1_b 84532.5
r14292 n254 t_m1_b 67626
r14293 n255 t_m1_b 338130
r14294 n256 t_m1_b 33813
r14295 n257 t_m1_b 112710
r14296 n258 t_m1_b 56355
r14297 n259 t_m1_b 169065
r14298 n260 t_m1_b 338130
r14299 n319 t_m1_b 22542
r14300 n320 t_m1_b 22542
r14301 n321 t_m1_b 5635.5
r14302 n322 t_m1_b 4508.4000000000005
r14303 n323 t_m1_b 22542
r14304 n324 t_m1_b 2254.2000000000003
r14305 n325 t_m1_b 7514
r14306 n326 t_m1_b 3757
r14307 n327 t_m1_b 11271
r14308 n328 t_m1_b 22542
r14309 n387 t_m1_b 338130
r14310 n388 t_m1_b 338130
r14311 n389 t_m1_b 84532.5
r14312 n390 t_m1_b 67626
r14313 n391 t_m1_b 338130
r14314 n392 t_m1_b 33813
r14315 n393 t_m1_b 112710
r14316 n394 t_m1_b 56355
r14317 n395 t_m1_b 169065
r14318 n396 t_m1_b 338130
r14319 n931 t_m1_b 19890
r14320 n932 t_m1_b 19890
r14321 n933 t_m1_b 4972.5
r14322 n934 t_m1_b 3978
r14323 n935 t_m1_b 19890
r14324 n936 t_m1_b 1989
r14325 n937 t_m1_b 6630
r14326 n938 t_m1_b 3315
r14327 n939 t_m1_b 9945
r14328 n940 t_m1_b 19890
r14329 n482 t_m1_s 106930
r14330 n483 t_m1_s 26732.5
r14331 n484 t_m1_s 21386
r14332 n485 t_m1_s 106930
r14333 n486 t_m1_s 10693
r14334 n487 t_m1_s 35643.333333333336
r14335 n488 t_m1_s 17821.666666666668
r14336 n489 t_m1_s 53465
r14337 n490 t_m1_s 106930
r14338 n491 t_m1_s 106930
r14339 n519 t_m1_s 13366.25
r14340 n520 t_m1_s 3341.5625
r14341 n521 t_m1_s 2673.25
r14342 n522 t_m1_s 13366.25
r14343 n523 t_m1_s 1336.625
r14344 n524 t_m1_s 4455.416666666667
r14345 n525 t_m1_s 2227.7083333333335
r14346 n526 t_m1_s 6683.125
r14347 n527 t_m1_s 13366.25
r14348 n528 t_m1_s 13366.25
r14349 n556 t_m1_s 15275.714285714286
r14350 n557 t_m1_s 3818.9285714285716
r14351 n558 t_m1_s 3055.1428571428573
r14352 n559 t_m1_s 15275.714285714286
r14353 n560 t_m1_s 1527.5714285714287
r14354 n561 t_m1_s 5091.9047619047615
r14355 n562 t_m1_s 2545.9523809523807
r14356 n563 t_m1_s 7637.8571428571431
r14357 n564 t_m1_s 15275.714285714286
r14358 n565 t_m1_s 15275.714285714286
r14359 n593 t_m1_s 106930
r14360 n594 t_m1_s 26732.5
r14361 n595 t_m1_s 21386
r14362 n596 t_m1_s 106930
r14363 n597 t_m1_s 10693
r14364 n598 t_m1_s 35643.333333333336
r14365 n599 t_m1_s 17821.666666666668
r14366 n600 t_m1_s 53465
r14367 n601 t_m1_s 106930
r14368 n602 t_m1_s 106930
r14369 n750 t_m1_d 106930
r14370 n751 t_m1_d 26732.5
r14371 n752 t_m1_d 21386
r14372 n753 t_m1_d 106930
r14373 n754 t_m1_d 10693
r14374 n755 t_m1_d 35643.333333333336
r14375 n756 t_m1_d 17821.666666666668
r14376 n757 t_m1_d 53465
r14377 n758 t_m1_d 106930
r14378 n759 t_m1_d 106930
r14379 n787 t_m1_d 14257.333333333334
r14380 n788 t_m1_d 3564.3333333333335
r14381 n789 t_m1_d 2851.4666666666667
r14382 n790 t_m1_d 14257.333333333334
r14383 n791 t_m1_d 1425.7333333333333
r14384 n792 t_m1_d 4752.4444444444443
r14385 n793 t_m1_d 2376.2222222222222
r14386 n794 t_m1_d 7128.666666666667
r14387 n795 t_m1_d 14257.333333333334
r14388 n796 t_m1_d 14257.333333333334
r14389 n824 t_m1_d 14257.333333333334
r14390 n825 t_m1_d 3564.3333333333335
r14391 n826 t_m1_d 2851.4666666666667
r14392 n827 t_m1_d 14257.333333333334
r14393 n828 t_m1_d 1425.7333333333333
r14394 n829 t_m1_d 4752.4444444444443
r14395 n830 t_m1_d 2376.2222222222222
r14396 n831 t_m1_d 7128.666666666667
r14397 n832 t_m1_d 14257.333333333334
r14398 n833 t_m1_d 14257.333333333334
r14399 n861 t_m1_d 106930
r14400 n862 t_m1_d 26732.5
r14401 n863 t_m1_d 21386
r14402 n864 t_m1_d 106930
r14403 n865 t_m1_d 10693
r14404 n866 t_m1_d 35643.333333333336
r14405 n867 t_m1_d 17821.666666666668
r14406 n868 t_m1_d 53465
r14407 n869 t_m1_d 106930
r14408 n870 t_m1_d 106930
r14409 n270 t_m1_b 33813
r14410 n271 t_m1_b 84532.5
r14411 n272 t_m1_b 48304.285714285717
r14412 n273 t_m1_b 37570
r14413 n274 t_m1_b 84532.5
r14414 n338 t_m1_b 2254.2000000000003
r14415 n339 t_m1_b 5635.5
r14416 n340 t_m1_b 3220.2857142857142
r14417 n341 t_m1_b 2504.6666666666665
r14418 n342 t_m1_b 5635.5
r14419 n406 t_m1_b 33813
r14420 n407 t_m1_b 84532.5
r14421 n408 t_m1_b 48304.285714285717
r14422 n409 t_m1_b 37570
r14423 n410 t_m1_b 84532.5
r14424 n950 t_m1_b 1989
r14425 n951 t_m1_b 4972.5
r14426 n952 t_m1_b 2841.4285714285716
r14427 n953 t_m1_b 2210
r14428 n954 t_m1_b 4972.5
r14429 n663 t_m1_g 43928
r14430 n664 t_m1_g 5168
r14431 n665 t_m1_g 6758.1538461538457
r14432 n666 t_m1_g 43928
r14433 n671 t_m1_g 3137.7142857142858
r14434 n672 t_m1_g 369.14285714285717
r14435 n673 t_m1_g 482.72527472527474
r14436 n674 t_m1_g 3137.7142857142858
r14437 n679 t_m1_g 43928
r14438 n680 t_m1_g 5168
r14439 n681 t_m1_g 6758.1538461538457
r14440 n682 t_m1_g 43928
r14441 n687 t_m1_g 43928
r14442 n688 t_m1_g 5168
r14443 n689 t_m1_g 6758.1538461538457
r14444 n690 t_m1_g 43928
r14445 n280 t_m1_b 26010
r14446 n281 t_m1_b 169065
r14447 n282 t_m1_b 169065
r14448 n283 t_m1_b 84532.5
r14449 n284 t_m1_b 67626
r14450 n285 t_m1_b 42266.25
r14451 n348 t_m1_b 1734
r14452 n349 t_m1_b 11271
r14453 n350 t_m1_b 11271
r14454 n351 t_m1_b 5635.5
r14455 n352 t_m1_b 4508.4000000000005
r14456 n353 t_m1_b 2817.75
r14457 n416 t_m1_b 26010
r14458 n417 t_m1_b 169065
r14459 n418 t_m1_b 169065
r14460 n419 t_m1_b 84532.5
r14461 n420 t_m1_b 67626
r14462 n421 t_m1_b 42266.25
r14463 n960 t_m1_b 1530
r14464 n961 t_m1_b 9945
r14465 n962 t_m1_b 9945
r14466 n963 t_m1_b 4972.5
r14467 n964 t_m1_b 3978
r14468 n965 t_m1_b 2486.25
r14469 n443 t_m1_b 3978
r14470 n444 t_m1_b 736.66666666666674
r14471 n445 t_m1_b 9945
r14472 n570 t_m1_b 9660.8571428571431
r14473 n571 t_m1_b 1789.047619047619
r14474 n572 t_m1_b 24152.142857142859
r14475 n607 t_m1_b 67626
r14476 n608 t_m1_b 12523.333333333334
r14477 n609 t_m1_b 169065
r14478 n611 t_m1_b 33813
r14479 n612 t_m1_b 6261.666666666667
r14480 n613 t_m1_b 84532.5
r14481 n619 t_m1_b 67626
r14482 n620 t_m1_b 12523.333333333334
r14483 n621 t_m1_b 169065
r14484 n627 t_m1_b 135252
r14485 n628 t_m1_b 25046.666666666668
r14486 n629 t_m1_b 338130
r14487 n635 t_m1_b 33813
r14488 n636 t_m1_b 6261.666666666667
r14489 n637 t_m1_b 84532.5
r14490 n643 t_m1_b 67626
r14491 n644 t_m1_b 12523.333333333334
r14492 n645 t_m1_b 169065
r14493 n651 t_m1_b 27050.400000000001
r14494 n652 t_m1_b 5009.333333333333
r14495 n653 t_m1_b 67626
r14496 n707 t_m1_b 33813
r14497 n708 t_m1_b 6261.666666666667
r14498 n709 t_m1_b 84532.5
r14499 n715 t_m1_b 19321.714285714286
r14500 n716 t_m1_b 3578.0952380952381
r14501 n717 t_m1_b 48304.285714285717
r14502 n723 t_m1_b 45084
r14503 n724 t_m1_b 8348.8888888888887
r14504 n725 t_m1_b 112710
r14505 n727 t_m1_b 45084
r14506 n728 t_m1_b 8348.8888888888887
r14507 n729 t_m1_b 112710
r14508 n764 t_m1_b 67626
r14509 n765 t_m1_b 12523.333333333334
r14510 n766 t_m1_b 169065
r14511 n801 t_m1_b 9016.8000000000011
r14512 n802 t_m1_b 1669.7777777777778
r14513 n803 t_m1_b 22542
r14514 n895 t_m1_b 67626
r14515 n896 t_m1_b 12523.333333333334
r14516 n897 t_m1_b 169065
r14517 n899 t_m1_b 4226.625
r14518 n900 t_m1_b 782.70833333333337
r14519 n901 t_m1_b 10566.5625
r14520 n1427 t_r1_w 1808.181818181818
r14521 n1430 t_r1_w 1989
r14522 n1433 t_r1_w 9945
r14523 n1436 t_r1_w 6630
r14524 n1439 t_r1_w 3978
r14525 n1442 t_r1_w 6630
r14526 n1454 t_r1_w 6630
r14527 n1457 t_r1_w 3978
r14528 n1460 t_r1_w 6630
r14529 n1463 t_r1_w 9945
r14530 n1466 t_r1_w 1989
r14531 n1469 t_r1_w 1808.181818181818
r14532 n980 t_r1_w 338130
r14533 n981 t_r1_w 10246.363636363636
r14534 n1127 t_r1_w 22542
r14535 n1128 t_r1_w 683.09090909090912
r14536 n1274 t_r1_w 338130
r14537 n1275 t_r1_w 10246.363636363636
r14538 n1484 t_r1_w 19890
r14539 n1485 t_r1_w 602.72727272727275
r14540 n986 t_r1_w 67626
r14541 n987 t_r1_w 338130
r14542 n988 t_r1_w 26010
r14543 n989 t_r1_w 33813
r14544 n990 t_r1_w 67626
r14545 n1133 t_r1_w 4508.4000000000005
r14546 n1134 t_r1_w 22542
r14547 n1135 t_r1_w 1734
r14548 n1136 t_r1_w 2254.2000000000003
r14549 n1137 t_r1_w 4508.4000000000005
r14550 n1280 t_r1_w 67626
r14551 n1281 t_r1_w 338130
r14552 n1282 t_r1_w 26010
r14553 n1283 t_r1_w 33813
r14554 n1284 t_r1_w 67626
r14555 n1490 t_r1_w 3978
r14556 n1491 t_r1_w 19890
r14557 n1492 t_r1_w 1530
r14558 n1493 t_r1_w 1989
r14559 n1494 t_r1_w 3978
r14560 n998 t_r1_w 67626
r14561 n999 t_r1_w 338130
r14562 n1000 t_r1_w 169065
r14563 n1001 t_r1_w 338130
r14564 n1002 t_r1_w 338130
r14565 n1003 t_r1_w 338130
r14566 n1004 t_r1_w 84532.5
r14567 n1005 t_r1_w 67626
r14568 n1006 t_r1_w 338130
r14569 n1007 t_r1_w 33813
r14570 n1008 t_r1_w 112710
r14571 n1145 t_r1_w 4508.4000000000005
r14572 n1146 t_r1_w 22542
r14573 n1147 t_r1_w 11271
r14574 n1148 t_r1_w 22542
r14575 n1149 t_r1_w 22542
r14576 n1150 t_r1_w 22542
r14577 n1151 t_r1_w 5635.5
r14578 n1152 t_r1_w 4508.4000000000005
r14579 n1153 t_r1_w 22542
r14580 n1154 t_r1_w 2254.2000000000003
r14581 n1155 t_r1_w 7514
r14582 n1292 t_r1_w 67626
r14583 n1293 t_r1_w 338130
r14584 n1294 t_r1_w 169065
r14585 n1295 t_r1_w 338130
r14586 n1296 t_r1_w 338130
r14587 n1297 t_r1_w 338130
r14588 n1298 t_r1_w 84532.5
r14589 n1299 t_r1_w 67626
r14590 n1300 t_r1_w 338130
r14591 n1301 t_r1_w 33813
r14592 n1302 t_r1_w 112710
r14593 n1502 t_r1_w 3978
r14594 n1503 t_r1_w 19890
r14595 n1504 t_r1_w 9945
r14596 n1505 t_r1_w 19890
r14597 n1506 t_r1_w 19890
r14598 n1507 t_r1_w 19890
r14599 n1508 t_r1_w 4972.5
r14600 n1509 t_r1_w 3978
r14601 n1510 t_r1_w 19890
r14602 n1511 t_r1_w 1989
r14603 n1512 t_r1_w 6630
r14604 n1019 t_r1_w 48304.285714285717
r14605 n1020 t_r1_w 56355
r14606 n1021 t_r1_w 33813
r14607 n1022 t_r1_w 84532.5
r14608 n1023 t_r1_w 48304.285714285717
r14609 n1166 t_r1_w 3220.2857142857142
r14610 n1167 t_r1_w 3757
r14611 n1168 t_r1_w 2254.2000000000003
r14612 n1169 t_r1_w 5635.5
r14613 n1170 t_r1_w 3220.2857142857142
r14614 n1313 t_r1_w 48304.285714285717
r14615 n1314 t_r1_w 56355
r14616 n1315 t_r1_w 33813
r14617 n1316 t_r1_w 84532.5
r14618 n1317 t_r1_w 48304.285714285717
r14619 n1523 t_r1_w 2841.4285714285716
r14620 n1524 t_r1_w 3315
r14621 n1525 t_r1_w 1989
r14622 n1526 t_r1_w 4972.5
r14623 n1527 t_r1_w 2841.4285714285716
r14624 n1030 t_r1_w 19890
r14625 n1031 t_r1_w 26010
r14626 n1032 t_r1_w 169065
r14627 n1033 t_r1_w 169065
r14628 n1177 t_r1_w 1326
r14629 n1178 t_r1_w 1734
r14630 n1179 t_r1_w 11271
r14631 n1180 t_r1_w 11271
r14632 n1324 t_r1_w 19890
r14633 n1325 t_r1_w 26010
r14634 n1326 t_r1_w 169065
r14635 n1327 t_r1_w 169065
r14636 n1534 t_r1_w 1170
r14637 n1535 t_r1_w 1530
r14638 n1536 t_r1_w 9945
r14639 n1537 t_r1_w 9945
r14640 n1039 t_r1_w 48304.285714285717
r14641 n1040 t_r1_w 12523.333333333334
r14642 n1186 t_r1_w 3220.2857142857142
r14643 n1187 t_r1_w 834.88888888888891
r14644 n1333 t_r1_w 48304.285714285717
r14645 n1334 t_r1_w 12523.333333333334
r14646 n1543 t_r1_w 2841.4285714285716
r14647 n1544 t_r1_w 736.66666666666674
r14648 n1044 t_r1_w 169065
r14649 n1045 t_r1_w 10566.5625
r14650 n1191 t_r1_w 11271
r14651 n1192 t_r1_w 704.4375
r14652 n1338 t_r1_w 169065
r14653 n1339 t_r1_w 10566.5625
r14654 n1548 t_r1_w 9945
r14655 n1549 t_r1_w 621.5625
r14656 n1047 t_r1_w 9945
r14657 n1194 t_r1_w 663
r14658 n1341 t_r1_w 9945
r14659 n1551 t_r1_w 585
r14660 n1049 t_r1_w 9945
r14661 n1196 t_r1_w 663
r14662 n1343 t_r1_w 9945
r14663 n1553 t_r1_w 585
r14664 n1051 t_r1_w 9945
r14665 n1198 t_r1_w 663
r14666 n1345 t_r1_w 9945
r14667 n1555 t_r1_w 585
r14668 n1053 t_r1_w 9945
r14669 n1200 t_r1_w 663
r14670 n1347 t_r1_w 9945
r14671 n1557 t_r1_w 585
r14672 n1055 t_r1_w 9945
r14673 n1202 t_r1_w 663
r14674 n1349 t_r1_w 9945
r14675 n1559 t_r1_w 585
r14676 n1057 t_r1_w 9945
r14677 n1204 t_r1_w 663
r14678 n1351 t_r1_w 9945
r14679 n1561 t_r1_w 585
r14680 n1059 t_r1_w 9945
r14681 n1206 t_r1_w 663
r14682 n1353 t_r1_w 9945
r14683 n1563 t_r1_w 585
r14684 n1061 t_r1_w 9945
r14685 n1208 t_r1_w 663
r14686 n1355 t_r1_w 9945
r14687 n1565 t_r1_w 585
r14688 n1063 t_r1_w 9945
r14689 n1210 t_r1_w 663
r14690 n1357 t_r1_w 9945
r14691 n1567 t_r1_w 585
r14692 n1065 t_r1_w 9945
r14693 n1212 t_r1_w 663
r14694 n1359 t_r1_w 9945
r14695 n1569 t_r1_w 585
r14696 n1067 t_r1_w 9945
r14697 n1214 t_r1_w 663
r14698 n1361 t_r1_w 9945
r14699 n1571 t_r1_w 585
r14700 n1070 t_r1_w 169065
r14701 n1071 t_r1_w 11271
r14702 n1072 t_r1_w 169065
r14703 n1217 t_r1_w 11271
r14704 n1218 t_r1_w 751.39999999999998
r14705 n1219 t_r1_w 11271
r14706 n1364 t_r1_w 169065
r14707 n1365 t_r1_w 11271
r14708 n1366 t_r1_w 169065
r14709 n1574 t_r1_w 9945
r14710 n1575 t_r1_w 663
r14711 n1576 t_r1_w 9945
r14712 n1075 t_r1_w 9945
r14713 n1222 t_r1_w 663
r14714 n1369 t_r1_w 9945
r14715 n1579 t_r1_w 585
r14716 n1077 t_r1_w 9945
r14717 n1224 t_r1_w 663
r14718 n1371 t_r1_w 9945
r14719 n1581 t_r1_w 585
r14720 n1079 t_r1_w 9945
r14721 n1226 t_r1_w 663
r14722 n1373 t_r1_w 9945
r14723 n1583 t_r1_w 585
r14724 n1081 t_r1_w 9945
r14725 n1228 t_r1_w 663
r14726 n1375 t_r1_w 9945
r14727 n1585 t_r1_w 585
r14728 n1083 t_r1_w 9945
r14729 n1230 t_r1_w 663
r14730 n1377 t_r1_w 9945
r14731 n1587 t_r1_w 585
r14732 n1085 t_r1_w 9945
r14733 n1232 t_r1_w 663
r14734 n1379 t_r1_w 9945
r14735 n1589 t_r1_w 585
r14736 n1087 t_r1_w 9945
r14737 n1234 t_r1_w 663
r14738 n1381 t_r1_w 9945
r14739 n1591 t_r1_w 585
r14740 n1089 t_r1_w 9945
r14741 n1236 t_r1_w 663
r14742 n1383 t_r1_w 9945
r14743 n1593 t_r1_w 585
r14744 n1091 t_r1_w 9945
r14745 n1238 t_r1_w 663
r14746 n1385 t_r1_w 9945
r14747 n1595 t_r1_w 585
r14748 n1093 t_r1_w 9945
r14749 n1240 t_r1_w 663
r14750 n1387 t_r1_w 9945
r14751 n1597 t_r1_w 585
r14752 n1095 t_r1_w 9945
r14753 n1242 t_r1_w 663
r14754 n1389 t_r1_w 9945
r14755 n1599 t_r1_w 585
r14756 n1097 t_r1_w 9945
r14757 n1244 t_r1_w 663
r14758 n1391 t_r1_w 9945
r14759 n1601 t_r1_w 585
r14760 n1100 t_r1_w 9945
r14761 n1247 t_r1_w 663
r14762 n1394 t_r1_w 9945
r14763 n1604 t_r1_w 585
r14764 n1102 t_r1_w 9945
r14765 n1249 t_r1_w 663
r14766 n1396 t_r1_w 9945
r14767 n1606 t_r1_w 585
r14768 n1104 t_r1_w 12523.333333333334
r14769 n1105 t_r1_w 48304.285714285717
r14770 n1251 t_r1_w 834.88888888888891
r14771 n1252 t_r1_w 3220.2857142857142
r14772 n1398 t_r1_w 12523.333333333334
r14773 n1399 t_r1_w 48304.285714285717
r14774 n1608 t_r1_w 736.66666666666674
r14775 n1609 t_r1_w 2841.4285714285716
r14776 n1108 t_r1_w 24152.142857142859
r14777 n1109 t_r1_w 16906.5
r14778 n1255 t_r1_w 1610.1428571428571
r14779 n1256 t_r1_w 1127.1000000000001
r14780 n1402 t_r1_w 24152.142857142859
r14781 n1403 t_r1_w 16906.5
r14782 n1612 t_r1_w 1420.7142857142858
r14783 n1613 t_r1_w 994.5
r14784 n1112 t_r1_w 9945
r14785 n1259 t_r1_w 663
r14786 n1406 t_r1_w 9945
r14787 n1616 t_r1_w 585
r14788 n1114 t_r1_w 9945
r14789 n1261 t_r1_w 663
r14790 n1408 t_r1_w 9945
r14791 n1618 t_r1_w 585
r14792 n1428 t_r1_w 3616.363636363636
r14793 n1429 t_r1_w 3616.363636363636
r14794 n1431 t_r1_w 3978
r14795 n1432 t_r1_w 3978
r14796 n1434 t_r1_w 19890
r14797 n1435 t_r1_w 19890
r14798 n1437 t_r1_w 13260
r14799 n1438 t_r1_w 13260
r14800 n1440 t_r1_w 7956
r14801 n1441 t_r1_w 7956
r14802 n1443 t_r1_w 13260
r14803 n1444 t_r1_w 13260
r14804 n1455 t_r1_w 13260
r14805 n1456 t_r1_w 13260
r14806 n1458 t_r1_w 7956
r14807 n1459 t_r1_w 7956
r14808 n1461 t_r1_w 13260
r14809 n1462 t_r1_w 13260
r14810 n1464 t_r1_w 19890
r14811 n1465 t_r1_w 19890
r14812 n1467 t_r1_w 3978
r14813 n1468 t_r1_w 3978
r14814 n1470 t_r1_w 3616.363636363636
r14815 n1471 t_r1_w 3616.363636363636
.save v(out) v(in)
.control
set wr_singlescale
set wr_vecnames
ac dec 50 1000 100000000000.0
let h=(v(out)-0)/(v(in)-0)
let hr=real(h)
let hi=imag(h)
wrdata bode.csv hr hi
quit
.endc
.end
