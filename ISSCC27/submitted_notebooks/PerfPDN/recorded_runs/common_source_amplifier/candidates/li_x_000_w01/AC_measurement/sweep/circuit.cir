PerfPDN frequency sweep
.lib /home/gokalp/.local/share/perfpdn/pdks/sky130A/libs.tech/ngspice/sky130.lib.spice tt
.option scale=1e-6 reltol=1e-8 abstol=1e-14
.temp 27
.option klu reltol=1e-8 abstol=1e-14 vntol=1e-10
vin in 0 DC 0 AC 1 0
vdd vdd 0 DC 0 AC 0 0
C1 out 0 9.9999999999999998e-13
v_r1_a t_r1_a r1_a 0
v_r1_b t_r1_b r1_b -1.2
v_r1_w t_r1_w r1_w -0
XR1 r1_a r1_b r1_w sky130_fd_pr__res_high_po_0p35 L=8.67 mult=1 m=1
v_m1_d t_m1_d m1_d 0
v_m1_g t_m1_g m1_g -0.95472500000000005
v_m1_s t_m1_s m1_s -0
v_m1_b t_m1_b m1_b -0
XM1 m1_d m1_g m1_s m1_b sky130_fd_pr__nfet_01v8_lvt L=0.235 W=0.865 nf=1 ad='int(( 1 + 1 ) / 2 ) * 0.865 / 1 * 0.29' as='int(( 1 + 2 ) / 2 ) * 0.865 / 1 * 0.29' pd='2 * int(( 1 + 1 ) / 2 ) * ( 0.865 / 1 + 0.29 )' ps='2 * int(( 1 + 2 ) / 2 ) * ( 0.865 / 1 + 0.29 )' nrd='0.29 / 0.865 ' nrs='0.29 / 0.865 ' sa=0 sb=0 sd=0 mult=1 m=1
r0 n0 n1 4.0186046511627911
r1 n1 n2 4.9116279069767446
r2 n2 n3 2.6790697674418604
r3 n3 n4 4.7627906976744185
r4 n4 n5 4.7627906976744185
r5 n5 n6 2.6790697674418604
r6 n6 n7 4.9116279069767446
r7 n7 n8 4.0186046511627911
r8 n0 n9 49.280000000000001
r9 n1 n10 28.988235294117647
r10 n9 n10 5.0823529411764703
r11 n2 n11 30.800000000000001
r12 n10 n11 6.2117647058823531
r13 n3 n12 246.40000000000001
r14 n11 n12 3.388235294117647
r15 n4 n13 16.426666666666666
r16 n12 n13 6.0235294117647058
r17 n5 n14 246.40000000000001
r18 n13 n14 6.0235294117647058
r19 n6 n15 30.800000000000001
r20 n14 n15 3.388235294117647
r21 n7 n16 28.988235294117647
r22 n15 n16 6.2117647058823531
r23 n8 n17 49.280000000000001
r24 n16 n17 5.0823529411764703
r25 n9 n18 49.280000000000001
r26 n10 n19 28.988235294117647
r27 n18 n19 4.0186046511627911
r28 n11 n20 30.800000000000001
r29 n19 n20 4.9116279069767446
r30 n12 n21 246.40000000000001
r31 n20 n21 2.6790697674418604
r32 n13 n22 16.426666666666666
r33 n21 n22 4.7627906976744185
r34 n14 n23 246.40000000000001
r35 n22 n23 4.7627906976744185
r36 n15 n24 30.800000000000001
r37 n23 n24 2.6790697674418604
r38 n16 n25 28.988235294117647
r39 n24 n25 4.9116279069767446
r40 n17 n26 49.280000000000001
r41 n25 n26 4.0186046511627911
r42 n21 n27 297.60000000000002
r43 n22 n28 19.84
r44 n27 n28 4.0960000000000001
r45 n23 n29 297.60000000000002
r46 n28 n29 4.0960000000000001
r47 n27 n30 320
r48 n28 n31 21.333333333333332
r49 n30 n31 4.0960000000000001
r50 n29 n32 320
r51 n31 n32 4.0960000000000001
r52 n30 n34 318.72000000000003
r53 n33 n34 2.3225806451612905
r54 n31 n35 21.248000000000001
r55 n34 n35 4.129032258064516
r56 n32 n36 318.72000000000003
r57 n35 n36 4.129032258064516
r58 n36 n37 2.3225806451612905
r59 n33 n38 39.68
r60 n34 n39 317.44
r61 n38 n39 2.3225806451612905
r62 n35 n40 21.162666666666667
r63 n39 n40 4.129032258064516
r64 n36 n41 317.44
r65 n40 n41 4.129032258064516
r66 n37 n42 39.68
r67 n41 n42 2.3225806451612905
r68 n38 n43 39.68
r69 n39 n44 317.44
r70 n43 n44 2.3225806451612905
r71 n40 n45 21.162666666666667
r72 n44 n45 4.129032258064516
r73 n41 n46 317.44
r74 n45 n46 4.129032258064516
r75 n42 n47 39.68
r76 n46 n47 2.3225806451612905
r77 n43 n48 39.68
r78 n44 n49 317.44
r79 n48 n49 2.3225806451612905
r80 n45 n50 21.162666666666667
r81 n49 n50 4.129032258064516
r82 n46 n51 317.44
r83 n50 n51 4.129032258064516
r84 n47 n52 39.68
r85 n51 n52 2.3225806451612905
r86 n48 n53 39.68
r87 n49 n54 317.44
r88 n53 n54 2.3225806451612905
r89 n50 n55 21.162666666666667
r90 n54 n55 4.129032258064516
r91 n51 n56 317.44
r92 n55 n56 4.129032258064516
r93 n52 n57 39.68
r94 n56 n57 2.3225806451612905
r95 n53 n58 39.68
r96 n54 n59 317.44
r97 n58 n59 2.3225806451612905
r98 n55 n60 21.162666666666667
r99 n59 n60 4.129032258064516
r100 n56 n61 317.44
r101 n60 n61 4.129032258064516
r102 n57 n62 39.68
r103 n61 n62 2.3225806451612905
r104 n58 n63 39.600000000000001
r105 n59 n64 316.80000000000001
r106 n63 n64 2.331983805668016
r107 n60 n65 21.120000000000001
r108 n64 n65 4.1457489878542511
r109 n61 n66 316.80000000000001
r110 n65 n66 4.1457489878542511
r111 n62 n67 39.600000000000001
r112 n66 n67 2.331983805668016
r113 n63 n68 39.600000000000001
r114 n64 n69 316.80000000000001
r115 n68 n69 2.3225806451612905
r116 n65 n70 21.120000000000001
r117 n69 n70 4.129032258064516
r118 n66 n71 316.80000000000001
r119 n70 n71 4.129032258064516
r120 n67 n72 39.600000000000001
r121 n71 n72 2.3225806451612905
r122 n68 n73 39.68
r123 n69 n74 317.44
r124 n73 n74 2.3225806451612905
r125 n70 n75 21.162666666666667
r126 n74 n75 4.129032258064516
r127 n71 n76 317.44
r128 n75 n76 4.129032258064516
r129 n72 n77 39.68
r130 n76 n77 2.3225806451612905
r131 n73 n78 39.68
r132 n74 n79 317.44
r133 n78 n79 2.3225806451612905
r134 n75 n80 21.162666666666667
r135 n79 n80 4.129032258064516
r136 n76 n81 317.44
r137 n80 n81 4.129032258064516
r138 n77 n82 39.68
r139 n81 n82 2.3225806451612905
r140 n78 n83 39.68
r141 n79 n84 317.44
r142 n83 n84 2.3225806451612905
r143 n80 n85 21.162666666666667
r144 n84 n85 4.129032258064516
r145 n81 n86 317.44
r146 n85 n86 4.129032258064516
r147 n82 n87 39.68
r148 n86 n87 2.3225806451612905
r149 n83 n88 39.68
r150 n84 n89 317.44
r151 n88 n89 2.3225806451612905
r152 n85 n90 21.162666666666667
r153 n89 n90 4.129032258064516
r154 n86 n91 317.44
r155 n90 n91 4.129032258064516
r156 n87 n92 39.68
r157 n91 n92 2.3225806451612905
r158 n88 n93 39.68
r159 n89 n94 317.44
r160 n93 n94 2.3225806451612905
r161 n90 n95 21.162666666666667
r162 n94 n95 4.129032258064516
r163 n91 n96 317.44
r164 n95 n96 4.129032258064516
r165 n92 n97 39.68
r166 n96 n97 2.3225806451612905
r167 n93 n98 39.68
r168 n94 n99 317.44
r169 n98 n99 2.3225806451612905
r170 n95 n100 21.162666666666667
r171 n99 n100 4.129032258064516
r172 n96 n101 317.44
r173 n100 n101 4.129032258064516
r174 n97 n102 39.68
r175 n101 n102 2.3225806451612905
r176 n98 n103 39.68
r177 n99 n104 317.44
r178 n103 n104 2.3225806451612905
r179 n100 n105 21.162666666666667
r180 n104 n105 4.129032258064516
r181 n101 n106 317.44
r182 n105 n106 4.129032258064516
r183 n102 n107 39.68
r184 n106 n107 2.3225806451612905
r185 n103 n108 39.68
r186 n104 n109 317.44
r187 n108 n109 2.3225806451612905
r188 n105 n110 21.162666666666667
r189 n109 n110 4.129032258064516
r190 n106 n111 317.44
r191 n110 n111 4.129032258064516
r192 n107 n112 39.68
r193 n111 n112 2.3225806451612905
r194 n108 n113 39.68
r195 n109 n114 317.44
r196 n113 n114 2.3225806451612905
r197 n110 n115 21.162666666666667
r198 n114 n115 4.129032258064516
r199 n111 n116 317.44
r200 n115 n116 4.129032258064516
r201 n112 n117 39.68
r202 n116 n117 2.3225806451612905
r203 n113 n118 39.600000000000001
r204 n114 n119 316.80000000000001
r205 n118 n119 2.331983805668016
r206 n115 n120 21.120000000000001
r207 n119 n120 4.1457489878542511
r208 n116 n121 316.80000000000001
r209 n120 n121 4.1457489878542511
r210 n117 n122 39.600000000000001
r211 n121 n122 2.331983805668016
r212 n118 n123 39.600000000000001
r213 n119 n124 316.80000000000001
r214 n123 n124 2.3225806451612905
r215 n120 n125 21.120000000000001
r216 n124 n125 4.129032258064516
r217 n121 n126 316.80000000000001
r218 n125 n126 4.129032258064516
r219 n122 n127 39.600000000000001
r220 n126 n127 2.3225806451612905
r221 n123 n128 39.68
r222 n124 n129 317.44
r223 n128 n129 2.3225806451612905
r224 n125 n130 21.162666666666667
r225 n129 n130 4.129032258064516
r226 n126 n131 317.44
r227 n130 n131 4.129032258064516
r228 n127 n132 39.68
r229 n131 n132 2.3225806451612905
r230 n128 n133 39.68
r231 n129 n134 317.44
r232 n133 n134 2.3225806451612905
r233 n130 n135 21.162666666666667
r234 n134 n135 4.129032258064516
r235 n131 n136 317.44
r236 n135 n136 4.129032258064516
r237 n132 n137 39.68
r238 n136 n137 2.3225806451612905
r239 n133 n138 39.68
r240 n134 n139 317.44
r241 n138 n139 2.3225806451612905
r242 n135 n140 21.162666666666667
r243 n139 n140 4.129032258064516
r244 n136 n141 317.44
r245 n140 n141 4.129032258064516
r246 n137 n142 39.68
r247 n141 n142 2.3225806451612905
r248 n138 n143 39.68
r249 n139 n144 317.44
r250 n143 n144 2.3225806451612905
r251 n140 n145 21.162666666666667
r252 n144 n145 4.129032258064516
r253 n141 n146 317.44
r254 n145 n146 4.129032258064516
r255 n142 n147 39.68
r256 n146 n147 2.3225806451612905
r257 n143 n148 39.68
r258 n144 n149 317.44
r259 n148 n149 2.3225806451612905
r260 n145 n150 21.162666666666667
r261 n149 n150 4.129032258064516
r262 n146 n151 317.44
r263 n150 n151 4.129032258064516
r264 n147 n152 39.68
r265 n151 n152 2.3225806451612905
r266 n148 n153 39.68
r267 n149 n154 317.44
r268 n153 n154 2.3225806451612905
r269 n150 n155 21.162666666666667
r270 n154 n155 4.129032258064516
r271 n151 n156 317.44
r272 n155 n156 4.129032258064516
r273 n152 n157 39.68
r274 n156 n157 2.3225806451612905
r275 n153 n158 39.68
r276 n154 n159 317.44
r277 n158 n159 2.3225806451612905
r278 n155 n160 21.162666666666667
r279 n159 n160 4.129032258064516
r280 n156 n161 317.44
r281 n160 n161 4.129032258064516
r282 n157 n162 39.68
r283 n161 n162 2.3225806451612905
r284 n158 n163 39.68
r285 n159 n164 317.44
r286 n163 n164 2.3225806451612905
r287 n160 n165 21.162666666666667
r288 n164 n165 4.129032258064516
r289 n161 n166 317.44
r290 n165 n166 4.129032258064516
r291 n162 n167 39.68
r292 n166 n167 2.3225806451612905
r293 n163 n168 39.68
r294 n164 n169 317.44
r295 n168 n169 2.3225806451612905
r296 n165 n170 21.162666666666667
r297 n169 n170 4.129032258064516
r298 n166 n171 317.44
r299 n170 n171 4.129032258064516
r300 n167 n172 39.68
r301 n171 n172 2.3225806451612905
r302 n168 n173 39.68
r303 n169 n174 317.44
r304 n173 n174 2.3225806451612905
r305 n170 n175 21.162666666666667
r306 n174 n175 4.129032258064516
r307 n171 n176 317.44
r308 n175 n176 4.129032258064516
r309 n172 n177 39.68
r310 n176 n177 2.3225806451612905
r311 n173 n178 39.68
r312 n174 n179 317.44
r313 n178 n179 2.3225806451612905
r314 n175 n180 21.162666666666667
r315 n179 n180 4.129032258064516
r316 n176 n181 317.44
r317 n180 n181 4.129032258064516
r318 n177 n182 39.68
r319 n181 n182 2.3225806451612905
r320 n178 n183 39.600000000000001
r321 n179 n184 316.80000000000001
r322 n183 n184 2.331983805668016
r323 n180 n185 21.120000000000001
r324 n184 n185 4.1457489878542511
r325 n181 n186 316.80000000000001
r326 n185 n186 4.1457489878542511
r327 n182 n187 39.600000000000001
r328 n186 n187 2.331983805668016
r329 n183 n188 39.600000000000001
r330 n184 n189 316.80000000000001
r331 n188 n189 2.3225806451612905
r332 n185 n190 21.120000000000001
r333 n189 n190 4.129032258064516
r334 n186 n191 316.80000000000001
r335 n190 n191 4.129032258064516
r336 n187 n192 39.600000000000001
r337 n191 n192 2.3225806451612905
r338 n188 n193 39.68
r339 n189 n194 317.44
r340 n193 n194 2.3225806451612905
r341 n190 n195 21.162666666666667
r342 n194 n195 4.129032258064516
r343 n191 n196 317.44
r344 n195 n196 4.129032258064516
r345 n192 n197 39.68
r346 n196 n197 2.3225806451612905
r347 n193 n198 39.68
r348 n194 n199 317.44
r349 n198 n199 2.3225806451612905
r350 n195 n200 21.162666666666667
r351 n199 n200 4.129032258064516
r352 n196 n201 317.44
r353 n200 n201 4.129032258064516
r354 n197 n202 39.68
r355 n201 n202 2.3225806451612905
r356 n198 n203 39.68
r357 n199 n204 317.44
r358 n203 n204 2.3225806451612905
r359 n200 n205 21.162666666666667
r360 n204 n205 4.129032258064516
r361 n201 n206 317.44
r362 n205 n206 4.129032258064516
r363 n202 n207 39.68
r364 n206 n207 2.3225806451612905
r365 n203 n208 39.68
r366 n204 n209 317.44
r367 n208 n209 2.3225806451612905
r368 n205 n210 21.162666666666667
r369 n209 n210 4.129032258064516
r370 n206 n211 317.44
r371 n210 n211 4.129032258064516
r372 n207 n212 39.68
r373 n211 n212 2.3225806451612905
r374 n208 n213 39.68
r375 n209 n214 317.44
r376 n213 n214 2.3225806451612905
r377 n210 n215 21.162666666666667
r378 n214 n215 4.129032258064516
r379 n211 n216 317.44
r380 n215 n216 4.129032258064516
r381 n212 n217 39.68
r382 n216 n217 2.3225806451612905
r383 n213 n218 39.68
r384 n214 n219 317.44
r385 n218 n219 2.3225806451612905
r386 n215 n220 21.162666666666667
r387 n219 n220 4.129032258064516
r388 n216 n221 317.44
r389 n220 n221 4.129032258064516
r390 n217 n222 39.68
r391 n221 n222 2.3225806451612905
r392 n218 n223 39.68
r393 n219 n224 317.44
r394 n223 n224 2.3225806451612905
r395 n220 n225 21.162666666666667
r396 n224 n225 4.129032258064516
r397 n221 n226 317.44
r398 n225 n226 4.129032258064516
r399 n222 n227 39.68
r400 n226 n227 2.3225806451612905
r401 n223 n228 39.68
r402 n224 n229 317.44
r403 n228 n229 2.3225806451612905
r404 n225 n230 21.162666666666667
r405 n229 n230 4.129032258064516
r406 n226 n231 317.44
r407 n230 n231 4.129032258064516
r408 n227 n232 39.68
r409 n231 n232 2.3225806451612905
r410 n228 n233 39.68
r411 n229 n234 317.44
r412 n233 n234 2.3225806451612905
r413 n230 n235 21.162666666666667
r414 n234 n235 4.129032258064516
r415 n231 n236 317.44
r416 n235 n236 4.129032258064516
r417 n232 n237 39.68
r418 n236 n237 2.3225806451612905
r419 n233 n238 39.600000000000001
r420 n234 n239 316.80000000000001
r421 n238 n239 2.331983805668016
r422 n235 n240 21.120000000000001
r423 n239 n240 4.1457489878542511
r424 n236 n241 316.80000000000001
r425 n240 n241 4.1457489878542511
r426 n237 n242 39.600000000000001
r427 n241 n242 2.331983805668016
r428 n238 n243 39.600000000000001
r429 n239 n244 316.80000000000001
r430 n243 n244 2.3225806451612905
r431 n240 n245 21.120000000000001
r432 n244 n245 4.129032258064516
r433 n241 n246 316.80000000000001
r434 n245 n246 4.129032258064516
r435 n242 n247 39.600000000000001
r436 n246 n247 2.3225806451612905
r437 n243 n248 39.68
r438 n244 n249 317.44
r439 n248 n249 2.3225806451612905
r440 n245 n250 21.162666666666667
r441 n249 n250 4.129032258064516
r442 n246 n251 317.44
r443 n250 n251 4.129032258064516
r444 n247 n252 39.68
r445 n251 n252 2.3225806451612905
r446 n248 n253 39.68
r447 n249 n254 317.44
r448 n253 n254 2.3225806451612905
r449 n250 n255 21.162666666666667
r450 n254 n255 4.129032258064516
r451 n251 n256 317.44
r452 n255 n256 4.129032258064516
r453 n252 n257 39.68
r454 n256 n257 2.3225806451612905
r455 n253 n258 39.68
r456 n254 n259 317.44
r457 n258 n259 2.3225806451612905
r458 n255 n260 21.162666666666667
r459 n259 n260 4.129032258064516
r460 n256 n261 317.44
r461 n260 n261 4.129032258064516
r462 n257 n262 39.68
r463 n261 n262 2.3225806451612905
r464 n258 n263 39.68
r465 n259 n264 317.44
r466 n263 n264 2.3225806451612905
r467 n260 n265 21.162666666666667
r468 n264 n265 4.129032258064516
r469 n261 n266 317.44
r470 n265 n266 4.129032258064516
r471 n262 n267 39.68
r472 n266 n267 2.3225806451612905
r473 n263 n268 39.68
r474 n264 n269 317.44
r475 n268 n269 2.3225806451612905
r476 n265 n270 21.162666666666667
r477 n269 n270 4.129032258064516
r478 n266 n271 317.44
r479 n270 n271 4.129032258064516
r480 n267 n272 39.68
r481 n271 n272 2.3225806451612905
r482 n269 n273 318.72000000000003
r483 n270 n274 21.248000000000001
r484 n273 n274 4.0960000000000001
r485 n271 n275 318.72000000000003
r486 n274 n275 4.0960000000000001
r487 n273 n276 320
r488 n274 n277 21.333333333333332
r489 n276 n277 4.0960000000000001
r490 n275 n278 320
r491 n277 n278 4.0960000000000001
r492 n279 n280 8.6400000000000006
r493 n280 n281 10.56
r494 n276 n282 224
r495 n281 n282 5.7599999999999998
r496 n277 n283 14.933333333333334
r497 n282 n283 10.24
r498 n278 n284 224
r499 n283 n284 10.24
r500 n284 n285 5.7599999999999998
r501 n285 n286 10.56
r502 n286 n287 8.6400000000000006
r503 n279 n288 27.52
r504 n280 n289 16.188235294117646
r505 n288 n289 7.5130434782608697
r506 n281 n290 17.199999999999999
r507 n289 n290 9.1826086956521742
r508 n282 n291 137.59999999999999
r509 n290 n291 5.0086956521739134
r510 n283 n292 9.1733333333333338
r511 n291 n292 8.9043478260869566
r512 n284 n293 137.59999999999999
r513 n292 n293 8.9043478260869566
r514 n285 n294 17.199999999999999
r515 n293 n294 5.0086956521739134
r516 n286 n295 16.188235294117646
r517 n294 n295 9.1826086956521742
r518 n287 n296 27.52
r519 n295 n296 7.5130434782608697
r520 n288 n297 16
r521 n289 n298 9.4117647058823533
r522 n297 n298 86.400000000000006
r523 n290 n299 10
r524 n298 n299 105.59999999999999
r525 n291 n300 80
r526 n299 n300 57.600000000000001
r527 n292 n301 5.333333333333333
r528 n300 n301 102.40000000000001
r529 n293 n302 80
r530 n301 n302 102.40000000000001
r531 n294 n303 10
r532 n302 n303 57.600000000000001
r533 n295 n304 9.4117647058823533
r534 n303 n304 105.59999999999999
r535 n296 n305 16
r536 n304 n305 86.400000000000006
r537 n297 n306 20.48
r538 n298 n307 12.047058823529412
r539 n306 n307 5.7599999999999998
r540 n299 n308 12.800000000000001
r541 n307 n308 7.04
r542 n300 n309 102.40000000000001
r543 n308 n309 3.8399999999999999
r544 n301 n310 6.8266666666666671
r545 n309 n310 6.8266666666666671
r546 n302 n311 102.40000000000001
r547 n310 n311 6.8266666666666671
r548 n303 n312 12.800000000000001
r549 n311 n312 3.8399999999999999
r550 n304 n313 12.047058823529412
r551 n312 n313 7.04
r552 n305 n314 20.48
r553 n313 n314 5.7599999999999998
r554 n306 n315 20.48
r555 n307 n316 12.047058823529412
r556 n315 n316 86.400000000000006
r557 n308 n317 12.800000000000001
r558 n316 n317 105.59999999999999
r559 n309 n318 102.40000000000001
r560 n317 n318 57.600000000000001
r561 n310 n319 6.8266666666666671
r562 n318 n319 102.40000000000001
r563 n311 n320 102.40000000000001
r564 n319 n320 102.40000000000001
r565 n312 n321 12.800000000000001
r566 n320 n321 57.600000000000001
r567 n313 n322 12.047058823529412
r568 n321 n322 105.59999999999999
r569 n314 n323 20.48
r570 n322 n323 86.400000000000006
r571 n315 n324 16
r572 n316 n325 9.4117647058823533
r573 n324 n325 7.5130434782608697
r574 n317 n326 10
r575 n325 n326 9.1826086956521742
r576 n318 n327 80
r577 n326 n327 5.0086956521739134
r578 n319 n328 5.333333333333333
r579 n327 n328 8.9043478260869566
r580 n320 n329 80
r581 n328 n329 8.9043478260869566
r582 n321 n330 10
r583 n329 n330 5.0086956521739134
r584 n322 n331 9.4117647058823533
r585 n330 n331 9.1826086956521742
r586 n323 n332 16
r587 n331 n332 7.5130434782608697
r588 n324 n333 27.52
r589 n325 n334 16.188235294117646
r590 n333 n334 8.6400000000000006
r591 n326 n335 17.199999999999999
r592 n334 n335 10.56
r593 n327 n336 137.59999999999999
r594 n335 n336 5.7599999999999998
r595 n328 n337 9.1733333333333338
r596 n336 n337 10.24
r597 n329 n338 137.59999999999999
r598 n337 n338 10.24
r599 n330 n339 17.199999999999999
r600 n338 n339 5.7599999999999998
r601 n331 n340 16.188235294117646
r602 n339 n340 10.56
r603 n332 n341 27.52
r604 n340 n341 8.6400000000000006
r605 n342 n343 150.40000000000001
r606 n343 n344 169.59999999999999
r607 n344 n345 131.19999999999999
r608 n345 n346 108.8
r609 n346 n347 108.8
r610 n347 n348 76.799999999999997
r611 n348 n349 86.400000000000006
r612 n349 n350 32
r613 n350 n351 35.200000000000003
r614 n351 n352 19.199999999999999
r615 n352 n353 44.799999999999997
r616 n353 n354 73.599999999999994
r617 n354 n355 48
r618 n355 n356 32
r619 n356 n357 19.199999999999999
r620 n357 n358 12.800000000000001
r621 n358 n359 12.800000000000001
r622 n359 n360 32
r623 n360 n361 60.799999999999997
r624 n361 n362 48
r625 n362 n363 32
r626 n363 n364 19.199999999999999
r627 n364 n365 9.5999999999999996
r628 n365 n366 9.5999999999999996
r629 n366 n367 6.4000000000000004
r630 n367 n368 6.4000000000000004
r631 n368 n369 16
r632 n369 n370 28.800000000000001
r633 n370 n371 19.199999999999999
r634 n371 n372 35.200000000000003
r635 n372 n373 41.600000000000001
r636 n373 n374 28.800000000000001
r637 n374 n375 25.600000000000001
r638 n375 n376 9.5999999999999996
r639 n376 n377 6.4000000000000004
r640 n377 n378 22.399999999999999
r641 n378 n379 35.200000000000003
r642 n379 n380 19.199999999999999
r643 n380 n381 16
r644 n381 n382 28.800000000000001
r645 n382 n383 25.600000000000001
r646 n383 n384 32
r647 n384 n385 41.600000000000001
r648 n385 n386 51.200000000000003
r649 n386 n387 44.799999999999997
r650 n387 n388 35.200000000000003
r651 n388 n389 51.200000000000003
r652 n389 n390 41.600000000000001
r653 n390 n391 38.399999999999999
r654 n391 n392 41.600000000000001
r655 n392 n393 35.200000000000003
r656 n393 n394 25.600000000000001
r657 n394 n395 60.799999999999997
r658 n395 n396 96
r659 n396 n397 48
r660 n397 n398 12.800000000000001
r661 n398 n399 19.199999999999999
r662 n399 n400 28.800000000000001
r663 n400 n401 41.600000000000001
r664 n401 n402 38.399999999999999
r665 n402 n403 54.399999999999999
r666 n403 n404 64
r667 n404 n405 108.8
r668 n405 n406 92.799999999999997
r669 n406 n407 22.399999999999999
r670 n407 n408 102.40000000000001
r671 n408 n409 92.799999999999997
r672 n342 n410 6.0235294117647058
r673 n343 n411 15.753846153846155
r674 n410 n411 10.026666666666667
r675 n344 n412 5.1200000000000001
r676 n411 n412 11.306666666666667
r677 n345 n413 204.80000000000001
r678 n412 n413 8.7466666666666661
r679 n346 n414 6.2060606060606061
r680 n413 n414 7.253333333333333
r681 n347 n415 204.80000000000001
r682 n414 n415 7.253333333333333
r683 n348 n416 8.9043478260869566
r684 n415 n416 5.1200000000000001
r685 n349 n417 51.200000000000003
r686 n416 n417 5.7599999999999998
r687 n350 n418 34.133333333333333
r688 n417 n418 2.1333333333333333
r689 n351 n419 40.960000000000001
r690 n418 n419 2.3466666666666667
r691 n352 n420 204.80000000000001
r692 n419 n420 1.28
r693 n353 n421 15.753846153846155
r694 n420 n421 2.9866666666666668
r695 n354 n422 20.48
r696 n421 n422 4.9066666666666663
r697 n355 n423 40.960000000000001
r698 n422 n423 3.2000000000000002
r699 n356 n424 40.960000000000001
r700 n423 n424 2.1333333333333333
r701 n357 n425 204.80000000000001
r702 n424 n425 1.28
r703 n358 n426 68.266666666666666
r704 n425 n426 0.85333333333333339
r705 n359 n427 204.80000000000001
r706 n426 n427 0.85333333333333339
r707 n360 n428 22.755555555555556
r708 n427 n428 2.1333333333333333
r709 n361 n429 20.48
r710 n428 n429 4.0533333333333337
r711 n362 n430 40.960000000000001
r712 n429 n430 3.2000000000000002
r713 n363 n431 40.960000000000001
r714 n430 n431 2.1333333333333333
r715 n364 n432 204.80000000000001
r716 n431 n432 1.28
r717 n365 n433 102.40000000000001
r718 n432 n433 0.64000000000000001
r719 n366 n434 204.80000000000001
r720 n433 n434 0.64000000000000001
r721 n367 n435 204.80000000000001
r722 n434 n435 0.42666666666666669
r723 n368 n436 204.80000000000001
r724 n435 n436 0.42666666666666669
r725 n369 n437 51.200000000000003
r726 n436 n437 1.0666666666666667
r727 n370 n438 40.960000000000001
r728 n437 n438 1.9199999999999999
r729 n371 n439 204.80000000000001
r730 n438 n439 1.28
r731 n372 n440 20.48
r732 n439 n440 2.3466666666666667
r733 n373 n441 68.266666666666666
r734 n440 n441 2.7733333333333334
r735 n374 n442 34.133333333333333
r736 n441 n442 1.9199999999999999
r737 n375 n443 102.40000000000001
r738 n442 n443 1.7066666666666668
r739 n376 n444 204.80000000000001
r740 n443 n444 0.64000000000000001
r741 n377 n445 204.80000000000001
r742 n444 n445 0.42666666666666669
r743 n378 n446 34.133333333333333
r744 n445 n446 1.4933333333333334
r745 n379 n447 40.960000000000001
r746 n446 n447 2.3466666666666667
r747 n380 n448 204.80000000000001
r748 n447 n448 1.28
r749 n381 n449 51.200000000000003
r750 n448 n449 1.0666666666666667
r751 n382 n450 40.960000000000001
r752 n449 n450 1.9199999999999999
r753 n383 n451 68.266666666666666
r754 n450 n451 1.7066666666666668
r755 n384 n452 29.257142857142856
r756 n451 n452 2.1333333333333333
r757 n385 n453 34.133333333333333
r758 n452 n453 2.7733333333333334
r759 n386 n454 20.48
r760 n453 n454 3.4133333333333336
r761 n387 n455 51.200000000000003
r762 n454 n455 2.9866666666666668
r763 n388 n456 29.257142857142856
r764 n455 n456 2.3466666666666667
r765 n389 n457 22.755555555555556
r766 n456 n457 3.4133333333333336
r767 n390 n458 51.200000000000003
r768 n457 n458 2.7733333333333334
r769 n391 n459 25.600000000000001
r770 n458 n459 2.5600000000000001
r771 n392 n460 40.960000000000001
r772 n459 n460 2.7733333333333334
r773 n393 n461 34.133333333333333
r774 n460 n461 2.3466666666666667
r775 n394 n462 102.40000000000001
r776 n461 n462 1.7066666666666668
r777 n395 n463 12.047058823529412
r778 n462 n463 4.0533333333333337
r779 n396 n464 15.753846153846155
r780 n463 n464 6.4000000000000004
r781 n397 n465 102.40000000000001
r782 n464 n465 3.2000000000000002
r783 n398 n466 102.40000000000001
r784 n465 n466 0.85333333333333339
r785 n399 n467 51.200000000000003
r786 n466 n467 1.28
r787 n400 n468 40.960000000000001
r788 n467 n468 1.9199999999999999
r789 n401 n469 25.600000000000001
r790 n468 n469 2.7733333333333334
r791 n402 n470 51.200000000000003
r792 n469 n470 2.5600000000000001
r793 n403 n471 15.753846153846155
r794 n470 n471 3.6266666666666665
r795 n404 n472 29.257142857142856
r796 n471 n472 4.2666666666666666
r797 n405 n473 7.5851851851851855
r798 n472 n473 7.253333333333333
r799 n406 n474 102.40000000000001
r800 n473 n474 6.1866666666666665
r801 n407 n475 40.960000000000001
r802 n474 n475 1.4933333333333334
r803 n408 n476 7.5851851851851855
r804 n475 n476 6.8266666666666671
r805 n409 n477 102.40000000000001
r806 n476 n477 6.1866666666666665
r807 n410 n478 6.0235294117647058
r808 n411 n479 15.753846153846155
r809 n478 n479 150.40000000000001
r810 n412 n480 5.1200000000000001
r811 n479 n480 169.59999999999999
r812 n413 n481 204.80000000000001
r813 n480 n481 131.19999999999999
r814 n414 n482 6.2060606060606061
r815 n481 n482 108.8
r816 n415 n483 204.80000000000001
r817 n482 n483 108.8
r818 n416 n484 8.9043478260869566
r819 n483 n484 76.799999999999997
r820 n417 n485 51.200000000000003
r821 n484 n485 86.400000000000006
r822 n418 n486 34.133333333333333
r823 n485 n486 32
r824 n419 n487 40.960000000000001
r825 n486 n487 35.200000000000003
r826 n420 n488 204.80000000000001
r827 n487 n488 19.199999999999999
r828 n421 n489 15.753846153846155
r829 n488 n489 44.799999999999997
r830 n422 n490 20.48
r831 n489 n490 73.599999999999994
r832 n423 n491 40.960000000000001
r833 n490 n491 48
r834 n424 n492 40.960000000000001
r835 n491 n492 32
r836 n425 n493 204.80000000000001
r837 n492 n493 19.199999999999999
r838 n426 n494 68.266666666666666
r839 n493 n494 12.800000000000001
r840 n427 n495 204.80000000000001
r841 n494 n495 12.800000000000001
r842 n428 n496 22.755555555555556
r843 n495 n496 32
r844 n429 n497 20.48
r845 n496 n497 60.799999999999997
r846 n430 n498 40.960000000000001
r847 n497 n498 48
r848 n431 n499 40.960000000000001
r849 n498 n499 32
r850 n432 n500 204.80000000000001
r851 n499 n500 19.199999999999999
r852 n433 n501 102.40000000000001
r853 n500 n501 9.5999999999999996
r854 n434 n502 204.80000000000001
r855 n501 n502 9.5999999999999996
r856 n435 n503 204.80000000000001
r857 n502 n503 6.4000000000000004
r858 n436 n504 204.80000000000001
r859 n503 n504 6.4000000000000004
r860 n437 n505 51.200000000000003
r861 n504 n505 16
r862 n438 n506 40.960000000000001
r863 n505 n506 28.800000000000001
r864 n439 n507 204.80000000000001
r865 n506 n507 19.199999999999999
r866 n440 n508 20.48
r867 n507 n508 35.200000000000003
r868 n441 n509 68.266666666666666
r869 n508 n509 41.600000000000001
r870 n442 n510 34.133333333333333
r871 n509 n510 28.800000000000001
r872 n443 n511 102.40000000000001
r873 n510 n511 25.600000000000001
r874 n444 n512 204.80000000000001
r875 n511 n512 9.5999999999999996
r876 n445 n513 204.80000000000001
r877 n512 n513 6.4000000000000004
r878 n446 n514 34.133333333333333
r879 n513 n514 22.399999999999999
r880 n447 n515 40.960000000000001
r881 n514 n515 35.200000000000003
r882 n448 n516 204.80000000000001
r883 n515 n516 19.199999999999999
r884 n449 n517 51.200000000000003
r885 n516 n517 16
r886 n450 n518 40.960000000000001
r887 n517 n518 28.800000000000001
r888 n451 n519 68.266666666666666
r889 n518 n519 25.600000000000001
r890 n452 n520 29.257142857142856
r891 n519 n520 32
r892 n453 n521 34.133333333333333
r893 n520 n521 41.600000000000001
r894 n454 n522 20.48
r895 n521 n522 51.200000000000003
r896 n455 n523 51.200000000000003
r897 n522 n523 44.799999999999997
r898 n456 n524 29.257142857142856
r899 n523 n524 35.200000000000003
r900 n457 n525 22.755555555555556
r901 n524 n525 51.200000000000003
r902 n458 n526 51.200000000000003
r903 n525 n526 41.600000000000001
r904 n459 n527 25.600000000000001
r905 n526 n527 38.399999999999999
r906 n460 n528 40.960000000000001
r907 n527 n528 41.600000000000001
r908 n461 n529 34.133333333333333
r909 n528 n529 35.200000000000003
r910 n462 n530 102.40000000000001
r911 n529 n530 25.600000000000001
r912 n463 n531 12.047058823529412
r913 n530 n531 60.799999999999997
r914 n464 n532 15.753846153846155
r915 n531 n532 96
r916 n465 n533 102.40000000000001
r917 n532 n533 48
r918 n466 n534 102.40000000000001
r919 n533 n534 12.800000000000001
r920 n467 n535 51.200000000000003
r921 n534 n535 19.199999999999999
r922 n468 n536 40.960000000000001
r923 n535 n536 28.800000000000001
r924 n469 n537 25.600000000000001
r925 n536 n537 41.600000000000001
r926 n470 n538 51.200000000000003
r927 n537 n538 38.399999999999999
r928 n471 n539 15.753846153846155
r929 n538 n539 54.399999999999999
r930 n472 n540 29.257142857142856
r931 n539 n540 64
r932 n473 n541 7.5851851851851855
r933 n540 n541 108.8
r934 n474 n542 102.40000000000001
r935 n541 n542 92.799999999999997
r936 n475 n543 40.960000000000001
r937 n542 n543 22.399999999999999
r938 n476 n544 7.5851851851851855
r939 n543 n544 102.40000000000001
r940 n477 n545 102.40000000000001
r941 n544 n545 92.799999999999997
r942 n478 n546 2.447058823529412
r943 n543 n547 16.640000000000001
r944 n544 n548 3.0814814814814815
r945 n547 n548 18.618181818181817
r946 n545 n549 41.600000000000001
r947 n548 n549 16.872727272727271
r948 n546 n550 2.447058823529412
r949 n547 n551 16.640000000000001
r950 n548 n552 3.0814814814814815
r951 n551 n552 102.40000000000001
r952 n549 n553 41.600000000000001
r953 n552 n553 92.799999999999997
r954 n550 n554 6.9647058823529413
r955 n551 n555 47.359999999999999
r956 n552 n556 8.7703703703703706
r957 n555 n556 5.8514285714285714
r958 n553 n557 118.40000000000001
r959 n556 n557 5.3028571428571425
r960 n554 n558 12.988235294117647
r961 n555 n559 88.319999999999993
r962 n556 n560 16.355555555555554
r963 n559 n560 6.0235294117647058
r964 n557 n561 220.80000000000001
r965 n560 n561 5.4588235294117649
r966 n558 n562 7.7176470588235295
r967 n559 n563 52.479999999999997
r968 n560 n564 9.7185185185185183
r969 n563 n564 29.257142857142856
r970 n561 n565 131.19999999999999
r971 n564 n565 26.514285714285716
r972 n562 n566 1.6941176470588235
r973 n563 n567 11.52
r974 n564 n568 2.1333333333333333
r975 n567 n568 102.40000000000001
r976 n565 n569 28.800000000000001
r977 n568 n569 92.799999999999997
r978 n566 n570 1.3176470588235294
r979 n567 n571 8.9600000000000009
r980 n568 n572 1.6592592592592592
r981 n571 n572 40.960000000000001
r982 n569 n573 22.399999999999999
r983 n572 n573 37.119999999999997
r984 n570 n574 2.0705882352941178
r985 n571 n575 14.08
r986 n572 n576 2.6074074074074076
r987 n575 n576 34.133333333333333
r988 n573 n577 35.200000000000003
r989 n576 n577 30.933333333333334
r990 n574 n578 1.5058823529411764
r991 n579 n580 32
r992 n580 n581 35.200000000000003
r993 n581 n582 19.199999999999999
r994 n582 n583 44.799999999999997
r995 n583 n584 73.599999999999994
r996 n584 n585 48
r997 n585 n586 32
r998 n586 n587 19.199999999999999
r999 n587 n588 12.800000000000001
r1000 n588 n589 12.800000000000001
r1001 n589 n590 32
r1002 n590 n591 60.799999999999997
r1003 n591 n592 48
r1004 n592 n593 32
r1005 n593 n594 19.199999999999999
r1006 n594 n595 9.5999999999999996
r1007 n595 n596 9.5999999999999996
r1008 n596 n597 6.4000000000000004
r1009 n597 n598 6.4000000000000004
r1010 n598 n599 16
r1011 n599 n600 28.800000000000001
r1012 n600 n601 19.199999999999999
r1013 n601 n602 35.200000000000003
r1014 n602 n603 41.600000000000001
r1015 n603 n604 28.800000000000001
r1016 n604 n605 25.600000000000001
r1017 n605 n606 9.5999999999999996
r1018 n606 n607 6.4000000000000004
r1019 n607 n608 22.399999999999999
r1020 n608 n609 35.200000000000003
r1021 n609 n610 19.199999999999999
r1022 n610 n611 16
r1023 n575 n612 10.24
r1024 n576 n613 1.8962962962962964
r1025 n612 n613 102.40000000000001
r1026 n577 n614 25.600000000000001
r1027 n613 n614 92.799999999999997
r1028 n578 n615 3.388235294117647
r1029 n579 n616 28.800000000000001
r1030 n580 n617 19.199999999999999
r1031 n616 n617 4
r1032 n581 n618 23.039999999999999
r1033 n617 n618 4.4000000000000004
r1034 n582 n619 115.2
r1035 n618 n619 2.3999999999999999
r1036 n583 n620 8.861538461538462
r1037 n619 n620 5.5999999999999996
r1038 n584 n621 11.52
r1039 n620 n621 9.1999999999999993
r1040 n585 n622 23.039999999999999
r1041 n621 n622 6
r1042 n586 n623 23.039999999999999
r1043 n622 n623 4
r1044 n587 n624 115.2
r1045 n623 n624 2.3999999999999999
r1046 n588 n625 38.399999999999999
r1047 n624 n625 1.6000000000000001
r1048 n589 n626 115.2
r1049 n625 n626 1.6000000000000001
r1050 n590 n627 12.800000000000001
r1051 n626 n627 4
r1052 n591 n628 11.52
r1053 n627 n628 7.5999999999999996
r1054 n592 n629 23.039999999999999
r1055 n628 n629 6
r1056 n593 n630 23.039999999999999
r1057 n629 n630 4
r1058 n594 n631 115.2
r1059 n630 n631 2.3999999999999999
r1060 n595 n632 57.600000000000001
r1061 n631 n632 1.2
r1062 n596 n633 115.2
r1063 n632 n633 1.2
r1064 n597 n634 115.2
r1065 n633 n634 0.80000000000000004
r1066 n598 n635 115.2
r1067 n634 n635 0.80000000000000004
r1068 n599 n636 28.800000000000001
r1069 n635 n636 2
r1070 n600 n637 23.039999999999999
r1071 n636 n637 3.6000000000000001
r1072 n601 n638 115.2
r1073 n637 n638 2.3999999999999999
r1074 n602 n639 11.52
r1075 n638 n639 4.4000000000000004
r1076 n603 n640 38.399999999999999
r1077 n639 n640 5.2000000000000002
r1078 n604 n641 19.199999999999999
r1079 n640 n641 3.6000000000000001
r1080 n605 n642 57.600000000000001
r1081 n641 n642 3.2000000000000002
r1082 n606 n643 115.2
r1083 n642 n643 1.2
r1084 n607 n644 115.2
r1085 n643 n644 0.80000000000000004
r1086 n608 n645 19.199999999999999
r1087 n644 n645 2.7999999999999998
r1088 n609 n646 23.039999999999999
r1089 n645 n646 4.4000000000000004
r1090 n610 n647 115.2
r1091 n646 n647 2.3999999999999999
r1092 n611 n648 28.800000000000001
r1093 n647 n648 2
r1094 n612 n649 23.039999999999999
r1095 n613 n650 4.2666666666666666
r1096 n649 n650 12.800000000000001
r1097 n614 n651 57.600000000000001
r1098 n650 n651 11.6
r1099 n615 n652 5.6470588235294121
r1100 n616 n653 48
r1101 n617 n654 32
r1102 n653 n654 4.5714285714285712
r1103 n618 n655 38.399999999999999
r1104 n654 n655 5.0285714285714285
r1105 n619 n656 192
r1106 n655 n656 2.7428571428571429
r1107 n620 n657 14.76923076923077
r1108 n656 n657 6.4000000000000004
r1109 n621 n658 19.199999999999999
r1110 n657 n658 10.514285714285714
r1111 n622 n659 38.399999999999999
r1112 n658 n659 6.8571428571428568
r1113 n623 n660 38.399999999999999
r1114 n659 n660 4.5714285714285712
r1115 n624 n661 192
r1116 n660 n661 2.7428571428571429
r1117 n625 n662 64
r1118 n661 n662 1.8285714285714285
r1119 n626 n663 192
r1120 n662 n663 1.8285714285714285
r1121 n627 n664 21.333333333333332
r1122 n663 n664 4.5714285714285712
r1123 n628 n665 19.199999999999999
r1124 n664 n665 8.6857142857142851
r1125 n629 n666 38.399999999999999
r1126 n665 n666 6.8571428571428568
r1127 n630 n667 38.399999999999999
r1128 n666 n667 4.5714285714285712
r1129 n631 n668 192
r1130 n667 n668 2.7428571428571429
r1131 n632 n669 96
r1132 n668 n669 1.3714285714285714
r1133 n633 n670 192
r1134 n669 n670 1.3714285714285714
r1135 n634 n671 192
r1136 n670 n671 0.91428571428571426
r1137 n635 n672 192
r1138 n671 n672 0.91428571428571426
r1139 n636 n673 48
r1140 n672 n673 2.2857142857142856
r1141 n637 n674 38.399999999999999
r1142 n673 n674 4.1142857142857139
r1143 n638 n675 192
r1144 n674 n675 2.7428571428571429
r1145 n639 n676 19.199999999999999
r1146 n675 n676 5.0285714285714285
r1147 n640 n677 64
r1148 n676 n677 5.9428571428571431
r1149 n641 n678 32
r1150 n677 n678 4.1142857142857139
r1151 n642 n679 96
r1152 n678 n679 3.657142857142857
r1153 n643 n680 192
r1154 n679 n680 1.3714285714285714
r1155 n644 n681 192
r1156 n680 n681 0.91428571428571426
r1157 n645 n682 32
r1158 n681 n682 3.2000000000000002
r1159 n646 n683 38.399999999999999
r1160 n682 n683 5.0285714285714285
r1161 n647 n684 192
r1162 n683 n684 2.7428571428571429
r1163 n648 n685 48
r1164 n684 n685 2.2857142857142856
r1165 n649 n686 38.399999999999999
r1166 n650 n687 7.1111111111111107
r1167 n686 n687 14.628571428571428
r1168 n651 n688 96
r1169 n687 n688 13.257142857142858
r1170 n652 n689 3.0117647058823529
r1171 n653 n690 25.600000000000001
r1172 n654 n691 17.066666666666666
r1173 n690 n691 32
r1174 n655 n692 20.48
r1175 n691 n692 35.200000000000003
r1176 n656 n693 102.40000000000001
r1177 n692 n693 19.199999999999999
r1178 n657 n694 7.8769230769230774
r1179 n693 n694 44.799999999999997
r1180 n658 n695 10.24
r1181 n694 n695 73.599999999999994
r1182 n659 n696 20.48
r1183 n695 n696 48
r1184 n660 n697 20.48
r1185 n696 n697 32
r1186 n661 n698 102.40000000000001
r1187 n697 n698 19.199999999999999
r1188 n662 n699 34.133333333333333
r1189 n698 n699 12.800000000000001
r1190 n663 n700 102.40000000000001
r1191 n699 n700 12.800000000000001
r1192 n664 n701 11.377777777777778
r1193 n700 n701 32
r1194 n665 n702 10.24
r1195 n701 n702 60.799999999999997
r1196 n666 n703 20.48
r1197 n702 n703 48
r1198 n667 n704 20.48
r1199 n703 n704 32
r1200 n668 n705 102.40000000000001
r1201 n704 n705 19.199999999999999
r1202 n669 n706 51.200000000000003
r1203 n705 n706 9.5999999999999996
r1204 n670 n707 102.40000000000001
r1205 n706 n707 9.5999999999999996
r1206 n671 n708 102.40000000000001
r1207 n707 n708 6.4000000000000004
r1208 n672 n709 102.40000000000001
r1209 n708 n709 6.4000000000000004
r1210 n673 n710 25.600000000000001
r1211 n709 n710 16
r1212 n674 n711 20.48
r1213 n710 n711 28.800000000000001
r1214 n675 n712 102.40000000000001
r1215 n711 n712 19.199999999999999
r1216 n676 n713 10.24
r1217 n712 n713 35.200000000000003
r1218 n677 n714 34.133333333333333
r1219 n713 n714 41.600000000000001
r1220 n678 n715 17.066666666666666
r1221 n714 n715 28.800000000000001
r1222 n679 n716 51.200000000000003
r1223 n715 n716 25.600000000000001
r1224 n680 n717 102.40000000000001
r1225 n716 n717 9.5999999999999996
r1226 n681 n718 102.40000000000001
r1227 n717 n718 6.4000000000000004
r1228 n682 n719 17.066666666666666
r1229 n718 n719 22.399999999999999
r1230 n683 n720 20.48
r1231 n719 n720 35.200000000000003
r1232 n684 n721 102.40000000000001
r1233 n720 n721 19.199999999999999
r1234 n685 n722 25.600000000000001
r1235 n721 n722 16
r1236 n686 n723 20.48
r1237 n687 n724 3.7925925925925927
r1238 n723 n724 102.40000000000001
r1239 n688 n725 51.200000000000003
r1240 n724 n725 92.799999999999997
r1241 n689 n726 1.1294117647058823
r1242 n723 n727 7.6799999999999997
r1243 n724 n728 1.4222222222222223
r1244 n727 n728 51.200000000000003
r1245 n725 n729 19.199999999999999
r1246 n728 n729 46.399999999999999
r1247 n726 n730 1.1294117647058823
r1248 n731 n732 60.799999999999997
r1249 n732 n733 96
r1250 n733 n734 48
r1251 n727 n735 7.6799999999999997
r1252 n728 n736 1.4222222222222223
r1253 n735 n736 102.40000000000001
r1254 n729 n737 19.199999999999999
r1255 n736 n737 92.799999999999997
r1256 n730 n738 0.56470588235294117
r1257 n731 n739 9.5999999999999996
r1258 n732 n740 1.1294117647058823
r1259 n739 n740 121.59999999999999
r1260 n733 n741 1.476923076923077
r1261 n740 n741 192
r1262 n734 n742 9.5999999999999996
r1263 n741 n742 96
r1264 n735 n743 3.8399999999999999
r1265 n736 n744 0.71111111111111114
r1266 n743 n744 204.80000000000001
r1267 n737 n745 9.5999999999999996
r1268 n744 n745 185.59999999999999
r1269 n738 n746 0.94117647058823528
r1270 n739 n747 16
r1271 n740 n748 1.8823529411764706
r1272 n747 n748 30.399999999999999
r1273 n741 n749 2.4615384615384617
r1274 n748 n749 48
r1275 n742 n750 16
r1276 n749 n750 24
r1277 n743 n751 6.4000000000000004
r1278 n744 n752 1.1851851851851851
r1279 n751 n752 51.200000000000003
r1280 n745 n753 16
r1281 n752 n753 46.399999999999999
r1282 n746 n754 1.1294117647058823
r1283 n747 n755 19.199999999999999
r1284 n748 n756 2.2588235294117647
r1285 n755 n756 60.799999999999997
r1286 n749 n757 2.953846153846154
r1287 n756 n757 96
r1288 n750 n758 19.199999999999999
r1289 n757 n758 48
r1290 n751 n759 7.6799999999999997
r1291 n752 n760 1.4222222222222223
r1292 n759 n760 102.40000000000001
r1293 n753 n761 19.199999999999999
r1294 n760 n761 92.799999999999997
r1295 n754 n762 1.3176470588235294
r1296 n755 n763 22.399999999999999
r1297 n756 n764 2.6352941176470588
r1298 n763 n764 24.32
r1299 n757 n765 3.4461538461538463
r1300 n764 n765 38.399999999999999
r1301 n758 n766 22.399999999999999
r1302 n765 n766 19.199999999999999
r1303 n759 n767 8.9600000000000009
r1304 n760 n768 1.6592592592592592
r1305 n767 n768 40.960000000000001
r1306 n761 n769 22.399999999999999
r1307 n768 n769 37.119999999999997
r1308 n762 n770 1.3176470588235294
r1309 n763 n771 22.399999999999999
r1310 n764 n772 2.6352941176470588
r1311 n771 n772 60.799999999999997
r1312 n765 n773 3.4461538461538463
r1313 n772 n773 96
r1314 n766 n774 22.399999999999999
r1315 n773 n774 48
r1316 n767 n775 8.9600000000000009
r1317 n768 n776 1.6592592592592592
r1318 n775 n776 102.40000000000001
r1319 n769 n777 22.399999999999999
r1320 n776 n777 92.799999999999997
r1321 n770 n778 0.75294117647058822
r1322 n771 n779 12.800000000000001
r1323 n772 n780 1.5058823529411764
r1324 n779 n780 60.799999999999997
r1325 n773 n781 1.9692307692307693
r1326 n780 n781 96
r1327 n774 n782 12.800000000000001
r1328 n781 n782 48
r1329 n775 n783 5.1200000000000001
r1330 n776 n784 0.94814814814814818
r1331 n783 n784 102.40000000000001
r1332 n777 n785 12.800000000000001
r1333 n784 n785 92.799999999999997
r1334 n778 n786 5.6470588235294121
r1335 n779 n787 96
r1336 n780 n788 11.294117647058824
r1337 n787 n788 4.3428571428571425
r1338 n781 n789 14.76923076923077
r1339 n788 n789 6.8571428571428568
r1340 n782 n790 96
r1341 n789 n790 3.4285714285714284
r1342 n783 n791 38.399999999999999
r1343 n784 n792 7.1111111111111107
r1344 n791 n792 7.3142857142857141
r1345 n785 n793 96
r1346 n792 n793 6.628571428571429
r1347 n786 n794 5.6470588235294121
r1348 n787 n795 96
r1349 n788 n796 11.294117647058824
r1350 n795 n796 60.799999999999997
r1351 n789 n797 14.76923076923077
r1352 n796 n797 96
r1353 n790 n798 96
r1354 n797 n798 48
r1355 n791 n799 38.399999999999999
r1356 n792 n800 7.1111111111111107
r1357 n799 n800 102.40000000000001
r1358 n793 n801 96
r1359 n800 n801 92.799999999999997
r1360 n794 n802 0.75294117647058822
r1361 n795 n803 12.800000000000001
r1362 n796 n804 1.5058823529411764
r1363 n803 n804 60.799999999999997
r1364 n797 n805 1.9692307692307693
r1365 n804 n805 96
r1366 n798 n806 12.800000000000001
r1367 n805 n806 48
r1368 n799 n807 5.1200000000000001
r1369 n800 n808 0.94814814814814818
r1370 n807 n808 102.40000000000001
r1371 n801 n809 12.800000000000001
r1372 n808 n809 92.799999999999997
r1373 n802 n810 0.75294117647058822
r1374 n803 n811 12.800000000000001
r1375 n804 n812 1.5058823529411764
r1376 n811 n812 60.799999999999997
r1377 n805 n813 1.9692307692307693
r1378 n812 n813 96
r1379 n806 n814 12.800000000000001
r1380 n813 n814 48
r1381 n807 n815 5.1200000000000001
r1382 n808 n816 0.94814814814814818
r1383 n815 n816 102.40000000000001
r1384 n809 n817 12.800000000000001
r1385 n816 n817 92.799999999999997
r1386 n810 n818 1.1294117647058823
r1387 n811 n819 19.199999999999999
r1388 n812 n820 2.2588235294117647
r1389 n819 n820 30.399999999999999
r1390 n813 n821 2.953846153846154
r1391 n820 n821 48
r1392 n814 n822 19.199999999999999
r1393 n821 n822 24
r1394 n815 n823 7.6799999999999997
r1395 n816 n824 1.4222222222222223
r1396 n823 n824 51.200000000000003
r1397 n817 n825 19.199999999999999
r1398 n824 n825 46.399999999999999
r1399 n818 n826 2.0705882352941178
r1400 n819 n827 35.200000000000003
r1401 n820 n828 4.1411764705882357
r1402 n827 n828 17.37142857142857
r1403 n821 n829 5.4153846153846157
r1404 n828 n829 27.428571428571427
r1405 n822 n830 35.200000000000003
r1406 n829 n830 13.714285714285714
r1407 n823 n831 14.08
r1408 n824 n832 2.6074074074074076
r1409 n831 n832 29.257142857142856
r1410 n825 n833 35.200000000000003
r1411 n832 n833 26.514285714285716
r1412 n826 n834 1.8823529411764706
r1413 n827 n835 32
r1414 n828 n836 3.7647058823529411
r1415 n835 n836 40.533333333333331
r1416 n829 n837 4.9230769230769234
r1417 n836 n837 64
r1418 n830 n838 32
r1419 n837 n838 32
r1420 n831 n839 12.800000000000001
r1421 n832 n840 2.3703703703703702
r1422 n839 n840 68.266666666666666
r1423 n833 n841 32
r1424 n840 n841 61.866666666666667
r1425 n834 n842 1.1294117647058823
r1426 n839 n843 7.6799999999999997
r1427 n840 n844 1.4222222222222223
r1428 n843 n844 68.266666666666666
r1429 n841 n845 19.199999999999999
r1430 n844 n845 61.866666666666667
r1431 n842 n846 0.94117647058823528
r1432 n847 n848 32
r1433 n848 n849 35.200000000000003
r1434 n849 n850 19.199999999999999
r1435 n850 n851 44.799999999999997
r1436 n851 n852 73.599999999999994
r1437 n852 n853 48
r1438 n853 n854 32
r1439 n854 n855 19.199999999999999
r1440 n855 n856 12.800000000000001
r1441 n856 n857 12.800000000000001
r1442 n857 n858 32
r1443 n858 n859 60.799999999999997
r1444 n859 n860 48
r1445 n860 n861 32
r1446 n861 n862 19.199999999999999
r1447 n862 n863 9.5999999999999996
r1448 n863 n864 9.5999999999999996
r1449 n864 n865 6.4000000000000004
r1450 n865 n866 6.4000000000000004
r1451 n866 n867 16
r1452 n867 n868 28.800000000000001
r1453 n868 n869 19.199999999999999
r1454 n869 n870 35.200000000000003
r1455 n870 n871 41.600000000000001
r1456 n871 n872 28.800000000000001
r1457 n872 n873 25.600000000000001
r1458 n873 n874 9.5999999999999996
r1459 n874 n875 6.4000000000000004
r1460 n875 n876 22.399999999999999
r1461 n876 n877 35.200000000000003
r1462 n877 n878 19.199999999999999
r1463 n878 n879 16
r1464 n843 n880 6.4000000000000004
r1465 n844 n881 1.1851851851851851
r1466 n880 n881 102.40000000000001
r1467 n845 n882 16
r1468 n881 n882 92.799999999999997
r1469 n846 n883 3.2000000000000002
r1470 n847 n884 27.199999999999999
r1471 n848 n885 18.133333333333333
r1472 n884 n885 4.2666666666666666
r1473 n849 n886 21.760000000000002
r1474 n885 n886 4.6933333333333334
r1475 n850 n887 108.8
r1476 n886 n887 2.5600000000000001
r1477 n851 n888 8.3692307692307697
r1478 n887 n888 5.9733333333333336
r1479 n852 n889 10.880000000000001
r1480 n888 n889 9.8133333333333326
r1481 n853 n890 21.760000000000002
r1482 n889 n890 6.4000000000000004
r1483 n854 n891 21.760000000000002
r1484 n890 n891 4.2666666666666666
r1485 n855 n892 108.8
r1486 n891 n892 2.5600000000000001
r1487 n856 n893 36.266666666666666
r1488 n892 n893 1.7066666666666668
r1489 n857 n894 108.8
r1490 n893 n894 1.7066666666666668
r1491 n858 n895 12.088888888888889
r1492 n894 n895 4.2666666666666666
r1493 n859 n896 10.880000000000001
r1494 n895 n896 8.1066666666666674
r1495 n860 n897 21.760000000000002
r1496 n896 n897 6.4000000000000004
r1497 n861 n898 21.760000000000002
r1498 n897 n898 4.2666666666666666
r1499 n862 n899 108.8
r1500 n898 n899 2.5600000000000001
r1501 n863 n900 54.399999999999999
r1502 n899 n900 1.28
r1503 n864 n901 108.8
r1504 n900 n901 1.28
r1505 n865 n902 108.8
r1506 n901 n902 0.85333333333333339
r1507 n866 n903 108.8
r1508 n902 n903 0.85333333333333339
r1509 n867 n904 27.199999999999999
r1510 n903 n904 2.1333333333333333
r1511 n868 n905 21.760000000000002
r1512 n904 n905 3.8399999999999999
r1513 n869 n906 108.8
r1514 n905 n906 2.5600000000000001
r1515 n870 n907 10.880000000000001
r1516 n906 n907 4.6933333333333334
r1517 n871 n908 36.266666666666666
r1518 n907 n908 5.5466666666666669
r1519 n872 n909 18.133333333333333
r1520 n908 n909 3.8399999999999999
r1521 n873 n910 54.399999999999999
r1522 n909 n910 3.4133333333333336
r1523 n874 n911 108.8
r1524 n910 n911 1.28
r1525 n875 n912 108.8
r1526 n911 n912 0.85333333333333339
r1527 n876 n913 18.133333333333333
r1528 n912 n913 2.9866666666666668
r1529 n877 n914 21.760000000000002
r1530 n913 n914 4.6933333333333334
r1531 n878 n915 108.8
r1532 n914 n915 2.5600000000000001
r1533 n879 n916 27.199999999999999
r1534 n915 n916 2.1333333333333333
r1535 n880 n917 21.760000000000002
r1536 n881 n918 4.0296296296296292
r1537 n917 n918 13.653333333333334
r1538 n882 n919 54.399999999999999
r1539 n918 n919 12.373333333333333
r1540 n883 n920 5.6470588235294121
r1541 n884 n921 48
r1542 n885 n922 32
r1543 n921 n922 4.2666666666666666
r1544 n886 n923 38.399999999999999
r1545 n922 n923 4.6933333333333334
r1546 n887 n924 192
r1547 n923 n924 2.5600000000000001
r1548 n888 n925 14.76923076923077
r1549 n924 n925 5.9733333333333336
r1550 n889 n926 19.199999999999999
r1551 n925 n926 9.8133333333333326
r1552 n890 n927 38.399999999999999
r1553 n926 n927 6.4000000000000004
r1554 n891 n928 38.399999999999999
r1555 n927 n928 4.2666666666666666
r1556 n892 n929 192
r1557 n928 n929 2.5600000000000001
r1558 n893 n930 64
r1559 n929 n930 1.7066666666666668
r1560 n894 n931 192
r1561 n930 n931 1.7066666666666668
r1562 n895 n932 21.333333333333332
r1563 n931 n932 4.2666666666666666
r1564 n896 n933 19.199999999999999
r1565 n932 n933 8.1066666666666674
r1566 n897 n934 38.399999999999999
r1567 n933 n934 6.4000000000000004
r1568 n898 n935 38.399999999999999
r1569 n934 n935 4.2666666666666666
r1570 n899 n936 192
r1571 n935 n936 2.5600000000000001
r1572 n900 n937 96
r1573 n936 n937 1.28
r1574 n901 n938 192
r1575 n937 n938 1.28
r1576 n902 n939 192
r1577 n938 n939 0.85333333333333339
r1578 n903 n940 192
r1579 n939 n940 0.85333333333333339
r1580 n904 n941 48
r1581 n940 n941 2.1333333333333333
r1582 n905 n942 38.399999999999999
r1583 n941 n942 3.8399999999999999
r1584 n906 n943 192
r1585 n942 n943 2.5600000000000001
r1586 n907 n944 19.199999999999999
r1587 n943 n944 4.6933333333333334
r1588 n908 n945 64
r1589 n944 n945 5.5466666666666669
r1590 n909 n946 32
r1591 n945 n946 3.8399999999999999
r1592 n910 n947 96
r1593 n946 n947 3.4133333333333336
r1594 n911 n948 192
r1595 n947 n948 1.28
r1596 n912 n949 192
r1597 n948 n949 0.85333333333333339
r1598 n913 n950 32
r1599 n949 n950 2.9866666666666668
r1600 n914 n951 38.399999999999999
r1601 n950 n951 4.6933333333333334
r1602 n915 n952 192
r1603 n951 n952 2.5600000000000001
r1604 n916 n953 48
r1605 n952 n953 2.1333333333333333
r1606 n917 n954 38.399999999999999
r1607 n918 n955 7.1111111111111107
r1608 n954 n955 13.653333333333334
r1609 n919 n956 96
r1610 n955 n956 12.373333333333333
r1611 n920 n957 3.2000000000000002
r1612 n921 n958 27.199999999999999
r1613 n922 n959 18.133333333333333
r1614 n958 n959 32
r1615 n923 n960 21.760000000000002
r1616 n959 n960 35.200000000000003
r1617 n924 n961 108.8
r1618 n960 n961 19.199999999999999
r1619 n925 n962 8.3692307692307697
r1620 n961 n962 44.799999999999997
r1621 n926 n963 10.880000000000001
r1622 n962 n963 73.599999999999994
r1623 n927 n964 21.760000000000002
r1624 n963 n964 48
r1625 n928 n965 21.760000000000002
r1626 n964 n965 32
r1627 n929 n966 108.8
r1628 n965 n966 19.199999999999999
r1629 n930 n967 36.266666666666666
r1630 n966 n967 12.800000000000001
r1631 n931 n968 108.8
r1632 n967 n968 12.800000000000001
r1633 n932 n969 12.088888888888889
r1634 n968 n969 32
r1635 n933 n970 10.880000000000001
r1636 n969 n970 60.799999999999997
r1637 n934 n971 21.760000000000002
r1638 n970 n971 48
r1639 n935 n972 21.760000000000002
r1640 n971 n972 32
r1641 n936 n973 108.8
r1642 n972 n973 19.199999999999999
r1643 n937 n974 54.399999999999999
r1644 n973 n974 9.5999999999999996
r1645 n938 n975 108.8
r1646 n974 n975 9.5999999999999996
r1647 n939 n976 108.8
r1648 n975 n976 6.4000000000000004
r1649 n940 n977 108.8
r1650 n976 n977 6.4000000000000004
r1651 n941 n978 27.199999999999999
r1652 n977 n978 16
r1653 n942 n979 21.760000000000002
r1654 n978 n979 28.800000000000001
r1655 n943 n980 108.8
r1656 n979 n980 19.199999999999999
r1657 n944 n981 10.880000000000001
r1658 n980 n981 35.200000000000003
r1659 n945 n982 36.266666666666666
r1660 n981 n982 41.600000000000001
r1661 n946 n983 18.133333333333333
r1662 n982 n983 28.800000000000001
r1663 n947 n984 54.399999999999999
r1664 n983 n984 25.600000000000001
r1665 n948 n985 108.8
r1666 n984 n985 9.5999999999999996
r1667 n949 n986 108.8
r1668 n985 n986 6.4000000000000004
r1669 n950 n987 18.133333333333333
r1670 n986 n987 22.399999999999999
r1671 n951 n988 21.760000000000002
r1672 n987 n988 35.200000000000003
r1673 n952 n989 108.8
r1674 n988 n989 19.199999999999999
r1675 n953 n990 27.199999999999999
r1676 n989 n990 16
r1677 n954 n991 21.760000000000002
r1678 n955 n992 4.0296296296296292
r1679 n991 n992 102.40000000000001
r1680 n956 n993 54.399999999999999
r1681 n992 n993 92.799999999999997
r1682 n957 n994 0.94117647058823528
r1683 n991 n995 6.4000000000000004
r1684 n992 n996 1.1851851851851851
r1685 n995 n996 68.266666666666666
r1686 n993 n997 16
r1687 n996 n997 61.866666666666667
r1688 n994 n998 1.1294117647058823
r1689 n995 n999 7.6799999999999997
r1690 n996 n1000 1.4222222222222223
r1691 n999 n1000 68.266666666666666
r1692 n997 n1001 19.199999999999999
r1693 n1000 n1001 61.866666666666667
r1694 n998 n1002 1.8823529411764706
r1695 n999 n1003 12.800000000000001
r1696 n1000 n1004 2.3703703703703702
r1697 n1003 n1004 29.257142857142856
r1698 n1001 n1005 32
r1699 n1004 n1005 26.514285714285716
r1700 n1002 n1006 2.8235294117647061
r1701 n1003 n1007 19.199999999999999
r1702 n1004 n1008 3.5555555555555554
r1703 n1007 n1008 25.600000000000001
r1704 n1005 n1009 48
r1705 n1008 n1009 23.199999999999999
r1706 n1006 n1010 1.8823529411764706
r1707 n1007 n1011 12.800000000000001
r1708 n1008 n1012 2.3703703703703702
r1709 n1011 n1012 102.40000000000001
r1710 n1009 n1013 32
r1711 n1012 n1013 92.799999999999997
r1712 n1010 n1014 6.4000000000000004
r1713 n1011 n1015 43.520000000000003
r1714 n1012 n1016 8.0592592592592585
r1715 n1015 n1016 6.4000000000000004
r1716 n1013 n1017 108.8
r1717 n1016 n1017 5.7999999999999998
r1718 n1014 n1018 14.870588235294118
r1719 n1015 n1019 101.12
r1720 n1016 n1020 18.725925925925925
r1721 n1019 n1020 4.3574468085106384
r1722 n1017 n1021 252.80000000000001
r1723 n1020 n1021 3.9489361702127659
r1724 n1018 n1022 15.247058823529411
r1725 n1022 n1023 8.8470588235294123
r1726 n1023 n1024 9.9764705882352942
r1727 n1024 n1025 7.7176470588235295
r1728 n1025 n1026 6.4000000000000004
r1729 n1026 n1027 6.4000000000000004
r1730 n1027 n1028 4.5176470588235293
r1731 n1028 n1029 5.0823529411764703
r1732 n1029 n1030 1.8823529411764706
r1733 n1030 n1031 2.0705882352941178
r1734 n1031 n1032 1.1294117647058823
r1735 n1032 n1033 2.6352941176470588
r1736 n1033 n1034 4.3294117647058821
r1737 n1034 n1035 2.8235294117647061
r1738 n1035 n1036 1.8823529411764706
r1739 n1036 n1037 1.1294117647058823
r1740 n1037 n1038 0.75294117647058822
r1741 n1038 n1039 0.75294117647058822
r1742 n1039 n1040 1.8823529411764706
r1743 n1040 n1041 3.5764705882352943
r1744 n1041 n1042 2.8235294117647061
r1745 n1042 n1043 1.8823529411764706
r1746 n1043 n1044 1.1294117647058823
r1747 n1044 n1045 0.56470588235294117
r1748 n1045 n1046 0.56470588235294117
r1749 n1046 n1047 0.37647058823529411
r1750 n1047 n1048 0.37647058823529411
r1751 n1048 n1049 0.94117647058823528
r1752 n1049 n1050 1.6941176470588235
r1753 n1050 n1051 1.1294117647058823
r1754 n1051 n1052 2.0705882352941178
r1755 n1052 n1053 2.447058823529412
r1756 n1053 n1054 1.6941176470588235
r1757 n1054 n1055 1.5058823529411764
r1758 n1055 n1056 0.56470588235294117
r1759 n1056 n1057 0.37647058823529411
r1760 n1057 n1058 1.3176470588235294
r1761 n1058 n1059 2.0705882352941178
r1762 n1059 n1060 1.1294117647058823
r1763 n1060 n1061 0.94117647058823528
r1764 n1061 n1062 1.6941176470588235
r1765 n1062 n1063 1.5058823529411764
r1766 n1063 n1064 1.8823529411764706
r1767 n1064 n1065 2.447058823529412
r1768 n1065 n1066 3.0117647058823529
r1769 n1066 n1067 2.6352941176470588
r1770 n1067 n1068 2.0705882352941178
r1771 n1068 n1069 3.0117647058823529
r1772 n1069 n1070 2.447058823529412
r1773 n1070 n1071 2.2588235294117647
r1774 n1071 n1072 2.447058823529412
r1775 n1072 n1073 2.0705882352941178
r1776 n1073 n1074 1.5058823529411764
r1777 n1074 n1075 3.5764705882352943
r1778 n1075 n1076 5.6470588235294121
r1779 n1076 n1077 2.8235294117647061
r1780 n1077 n1078 0.75294117647058822
r1781 n1078 n1079 1.1294117647058823
r1782 n1079 n1080 1.6941176470588235
r1783 n1080 n1081 2.447058823529412
r1784 n1081 n1082 2.2588235294117647
r1785 n1082 n1083 3.2000000000000002
r1786 n1083 n1084 3.7647058823529411
r1787 n1084 n1085 6.4000000000000004
r1788 n1085 n1086 5.4588235294117649
r1789 n1019 n1087 103.68000000000001
r1790 n1086 n1087 1.3176470588235294
r1791 n1020 n1088 19.199999999999999
r1792 n1087 n1088 6.0235294117647058
r1793 n1021 n1089 259.19999999999999
r1794 n1088 n1089 5.4588235294117649
r1795 n1090 n1091 196.48000000000002
r1796 n1091 n1092 176
r1797 n1092 n1093 197.12
r1798 n1093 n1094 150.40000000000001
r1799 n1094 n1095 169.59999999999999
r1800 n1095 n1096 131.19999999999999
r1801 n1096 n1097 108.8
r1802 n1097 n1098 108.8
r1803 n1098 n1099 76.799999999999997
r1804 n1099 n1100 86.400000000000006
r1805 n1100 n1101 32
r1806 n1101 n1102 35.200000000000003
r1807 n1102 n1103 19.199999999999999
r1808 n1103 n1104 44.799999999999997
r1809 n1104 n1105 73.599999999999994
r1810 n1105 n1106 48
r1811 n1106 n1107 32
r1812 n1107 n1108 19.199999999999999
r1813 n1108 n1109 12.800000000000001
r1814 n1109 n1110 12.800000000000001
r1815 n1110 n1111 32
r1816 n1111 n1112 60.799999999999997
r1817 n1112 n1113 48
r1818 n1113 n1114 32
r1819 n1114 n1115 19.199999999999999
r1820 n1115 n1116 9.5999999999999996
r1821 n1116 n1117 9.5999999999999996
r1822 n1117 n1118 6.4000000000000004
r1823 n1118 n1119 6.4000000000000004
r1824 n1119 n1120 16
r1825 n1120 n1121 28.800000000000001
r1826 n1121 n1122 19.199999999999999
r1827 n1122 n1123 35.200000000000003
r1828 n1123 n1124 41.600000000000001
r1829 n1124 n1125 28.800000000000001
r1830 n1125 n1126 25.600000000000001
r1831 n1126 n1127 9.5999999999999996
r1832 n1127 n1128 6.4000000000000004
r1833 n1128 n1129 22.399999999999999
r1834 n1129 n1130 35.200000000000003
r1835 n1130 n1131 19.199999999999999
r1836 n1131 n1132 16
r1837 n1132 n1133 28.800000000000001
r1838 n1133 n1134 25.600000000000001
r1839 n1134 n1135 32
r1840 n1135 n1136 41.600000000000001
r1841 n1136 n1137 51.200000000000003
r1842 n1137 n1138 44.799999999999997
r1843 n1138 n1139 35.200000000000003
r1844 n1139 n1140 51.200000000000003
r1845 n1140 n1141 41.600000000000001
r1846 n1141 n1142 38.399999999999999
r1847 n1142 n1143 41.600000000000001
r1848 n1143 n1144 35.200000000000003
r1849 n1144 n1145 25.600000000000001
r1850 n1145 n1146 60.799999999999997
r1851 n1146 n1147 96
r1852 n1147 n1148 48
r1853 n1148 n1149 12.800000000000001
r1854 n1149 n1150 19.199999999999999
r1855 n1150 n1151 28.800000000000001
r1856 n1151 n1152 41.600000000000001
r1857 n1152 n1153 38.399999999999999
r1858 n1153 n1154 54.399999999999999
r1859 n1154 n1155 64
r1860 n1155 n1156 108.8
r1861 n1156 n1157 92.799999999999997
r1862 n1157 n1158 22.399999999999999
r1863 n1158 n1159 102.40000000000001
r1864 n1159 n1160 92.799999999999997
r1865 n1160 n1161 108.8
r1866 n1161 n1162 211.19999999999999
r1867 n1162 n1163 217.59999999999999
r1868 n1163 n1164 217.59999999999999
r1869 n1164 n1165 217.59999999999999
r1870 n1165 n1166 217.59999999999999
r1871 n1166 n1167 217.59999999999999
r1872 n1167 n1168 217.59999999999999
r1873 n1168 n1169 217.59999999999999
r1874 n1169 n1170 217.59999999999999
r1875 n1170 n1171 217.59999999999999
r1876 n1171 n1172 217.59999999999999
r1877 n1172 n1173 217.59999999999999
r1878 n1173 n1174 217.59999999999999
r1879 n1174 n1175 217.59999999999999
r1880 n1175 n1176 217.59999999999999
r1881 n1176 n1177 217.59999999999999
r1882 n1177 n1178 217.59999999999999
r1883 n1178 n1179 217.59999999999999
r1884 n1179 n1180 217.59999999999999
r1885 n1180 n1181 217.59999999999999
r1886 n1181 n1182 217.59999999999999
r1887 n1182 n1183 217.59999999999999
r1888 n1183 n1184 144
r1889 n1184 n1185 108.8
r1890 n1185 n1186 80
r1891 n1186 n1187 102.40000000000001
r1892 n1187 n1188 102.40000000000001
r1893 n1188 n1189 80
r1894 n1189 n1190 108.8
r1895 n1190 n1191 144
r1896 n1191 n1192 217.59999999999999
r1897 n1192 n1193 217.59999999999999
r1898 n1193 n1194 217.59999999999999
r1899 n1194 n1195 217.59999999999999
r1900 n1195 n1196 217.59999999999999
r1901 n1196 n1197 217.59999999999999
r1902 n1197 n1198 217.59999999999999
r1903 n1198 n1199 217.59999999999999
r1904 n1199 n1200 217.59999999999999
r1905 n1200 n1201 217.59999999999999
r1906 n1201 n1202 217.59999999999999
r1907 n1202 n1203 217.59999999999999
r1908 n1203 n1204 217.59999999999999
r1909 n1204 n1205 217.59999999999999
r1910 n1205 n1206 217.59999999999999
r1911 n1206 n1207 217.59999999999999
r1912 n1207 n1208 217.59999999999999
r1913 n1208 n1209 217.59999999999999
r1914 n1209 n1210 217.59999999999999
r1915 n1210 n1211 217.59999999999999
r1916 n1211 n1212 217.59999999999999
r1917 n1212 n1213 217.59999999999999
r1918 n1213 n1214 195.19999999999999
r1919 n1214 n1215 108.8
r1920 n1215 n1216 131.19999999999999
r1921 n1216 n1217 217.59999999999999
r1922 n1217 n1218 217.59999999999999
r1923 n1218 n1219 217.59999999999999
r1924 n1219 n1220 195.19999999999999
r1925 n1220 n1221 108.8
r1926 n1221 n1222 80
r1927 n1222 n1223 108.8
r1928 n1223 n1224 96
r1929 n1224 n1225 108.8
r1930 n1225 n1226 80
r1931 n1226 n1227 108.8
r1932 n1227 n1228 201.59999999999999
r1933 n1228 n1229 217.59999999999999
r1934 n1229 n1230 217.59999999999999
r1935 n1230 n1231 236.80000000000001
r1936 n1231 n1232 236.80000000000001
r1937 n1232 n1233 217.59999999999999
r1938 n1233 n1234 217.59999999999999
r1939 n1234 n1235 163.19999999999999
r1940 n1235 n1236 108.8
r1941 n1090 n1237 6.0235294117647058
r1942 n1091 n1238 7.4744525547445253
r1943 n1237 n1238 13.098666666666668
r1944 n1092 n1239 7.4202898550724639
r1945 n1238 n1239 11.733333333333333
r1946 n1093 n1240 6.0235294117647058
r1947 n1239 n1240 13.141333333333334
r1948 n1094 n1241 15.753846153846155
r1949 n1240 n1241 10.026666666666667
r1950 n1095 n1242 5.1200000000000001
r1951 n1241 n1242 11.306666666666667
r1952 n1096 n1243 204.80000000000001
r1953 n1242 n1243 8.7466666666666661
r1954 n1097 n1244 6.2060606060606061
r1955 n1243 n1244 7.253333333333333
r1956 n1098 n1245 204.80000000000001
r1957 n1244 n1245 7.253333333333333
r1958 n1099 n1246 8.9043478260869566
r1959 n1245 n1246 5.1200000000000001
r1960 n1100 n1247 51.200000000000003
r1961 n1246 n1247 5.7599999999999998
r1962 n1101 n1248 34.133333333333333
r1963 n1247 n1248 2.1333333333333333
r1964 n1102 n1249 40.960000000000001
r1965 n1248 n1249 2.3466666666666667
r1966 n1103 n1250 204.80000000000001
r1967 n1249 n1250 1.28
r1968 n1104 n1251 15.753846153846155
r1969 n1250 n1251 2.9866666666666668
r1970 n1105 n1252 20.48
r1971 n1251 n1252 4.9066666666666663
r1972 n1106 n1253 40.960000000000001
r1973 n1252 n1253 3.2000000000000002
r1974 n1107 n1254 40.960000000000001
r1975 n1253 n1254 2.1333333333333333
r1976 n1108 n1255 204.80000000000001
r1977 n1254 n1255 1.28
r1978 n1109 n1256 68.266666666666666
r1979 n1255 n1256 0.85333333333333339
r1980 n1110 n1257 204.80000000000001
r1981 n1256 n1257 0.85333333333333339
r1982 n1111 n1258 22.755555555555556
r1983 n1257 n1258 2.1333333333333333
r1984 n1112 n1259 20.48
r1985 n1258 n1259 4.0533333333333337
r1986 n1113 n1260 40.960000000000001
r1987 n1259 n1260 3.2000000000000002
r1988 n1114 n1261 40.960000000000001
r1989 n1260 n1261 2.1333333333333333
r1990 n1115 n1262 204.80000000000001
r1991 n1261 n1262 1.28
r1992 n1116 n1263 102.40000000000001
r1993 n1262 n1263 0.64000000000000001
r1994 n1117 n1264 204.80000000000001
r1995 n1263 n1264 0.64000000000000001
r1996 n1118 n1265 204.80000000000001
r1997 n1264 n1265 0.42666666666666669
r1998 n1119 n1266 204.80000000000001
r1999 n1265 n1266 0.42666666666666669
r2000 n1120 n1267 51.200000000000003
r2001 n1266 n1267 1.0666666666666667
r2002 n1121 n1268 40.960000000000001
r2003 n1267 n1268 1.9199999999999999
r2004 n1122 n1269 204.80000000000001
r2005 n1268 n1269 1.28
r2006 n1123 n1270 20.48
r2007 n1269 n1270 2.3466666666666667
r2008 n1124 n1271 68.266666666666666
r2009 n1270 n1271 2.7733333333333334
r2010 n1125 n1272 34.133333333333333
r2011 n1271 n1272 1.9199999999999999
r2012 n1126 n1273 102.40000000000001
r2013 n1272 n1273 1.7066666666666668
r2014 n1127 n1274 204.80000000000001
r2015 n1273 n1274 0.64000000000000001
r2016 n1128 n1275 204.80000000000001
r2017 n1274 n1275 0.42666666666666669
r2018 n1129 n1276 34.133333333333333
r2019 n1275 n1276 1.4933333333333334
r2020 n1130 n1277 40.960000000000001
r2021 n1276 n1277 2.3466666666666667
r2022 n1131 n1278 204.80000000000001
r2023 n1277 n1278 1.28
r2024 n1132 n1279 51.200000000000003
r2025 n1278 n1279 1.0666666666666667
r2026 n1133 n1280 40.960000000000001
r2027 n1279 n1280 1.9199999999999999
r2028 n1134 n1281 68.266666666666666
r2029 n1280 n1281 1.7066666666666668
r2030 n1135 n1282 29.257142857142856
r2031 n1281 n1282 2.1333333333333333
r2032 n1136 n1283 34.133333333333333
r2033 n1282 n1283 2.7733333333333334
r2034 n1137 n1284 20.48
r2035 n1283 n1284 3.4133333333333336
r2036 n1138 n1285 51.200000000000003
r2037 n1284 n1285 2.9866666666666668
r2038 n1139 n1286 29.257142857142856
r2039 n1285 n1286 2.3466666666666667
r2040 n1140 n1287 22.755555555555556
r2041 n1286 n1287 3.4133333333333336
r2042 n1141 n1288 51.200000000000003
r2043 n1287 n1288 2.7733333333333334
r2044 n1142 n1289 25.600000000000001
r2045 n1288 n1289 2.5600000000000001
r2046 n1143 n1290 40.960000000000001
r2047 n1289 n1290 2.7733333333333334
r2048 n1144 n1291 34.133333333333333
r2049 n1290 n1291 2.3466666666666667
r2050 n1145 n1292 102.40000000000001
r2051 n1291 n1292 1.7066666666666668
r2052 n1146 n1293 12.047058823529412
r2053 n1292 n1293 4.0533333333333337
r2054 n1147 n1294 15.753846153846155
r2055 n1293 n1294 6.4000000000000004
r2056 n1148 n1295 102.40000000000001
r2057 n1294 n1295 3.2000000000000002
r2058 n1149 n1296 102.40000000000001
r2059 n1295 n1296 0.85333333333333339
r2060 n1150 n1297 51.200000000000003
r2061 n1296 n1297 1.28
r2062 n1151 n1298 40.960000000000001
r2063 n1297 n1298 1.9199999999999999
r2064 n1152 n1299 25.600000000000001
r2065 n1298 n1299 2.7733333333333334
r2066 n1153 n1300 51.200000000000003
r2067 n1299 n1300 2.5600000000000001
r2068 n1154 n1301 15.753846153846155
r2069 n1300 n1301 3.6266666666666665
r2070 n1155 n1302 29.257142857142856
r2071 n1301 n1302 4.2666666666666666
r2072 n1156 n1303 7.5851851851851855
r2073 n1302 n1303 7.253333333333333
r2074 n1157 n1304 102.40000000000001
r2075 n1303 n1304 6.1866666666666665
r2076 n1158 n1305 40.960000000000001
r2077 n1304 n1305 1.4933333333333334
r2078 n1159 n1306 7.5851851851851855
r2079 n1305 n1306 6.8266666666666671
r2080 n1160 n1307 102.40000000000001
r2081 n1306 n1307 6.1866666666666665
r2082 n1161 n1308 6.4000000000000004
r2083 n1307 n1308 7.253333333333333
r2084 n1162 n1309 6.0235294117647058
r2085 n1308 n1309 14.08
r2086 n1163 n1310 6.0235294117647058
r2087 n1309 n1310 14.506666666666666
r2088 n1164 n1311 6.0235294117647058
r2089 n1310 n1311 14.506666666666666
r2090 n1165 n1312 6.0235294117647058
r2091 n1311 n1312 14.506666666666666
r2092 n1166 n1313 6.0235294117647058
r2093 n1312 n1313 14.506666666666666
r2094 n1167 n1314 6.0235294117647058
r2095 n1313 n1314 14.506666666666666
r2096 n1168 n1315 6.0235294117647058
r2097 n1314 n1315 14.506666666666666
r2098 n1169 n1316 6.0235294117647058
r2099 n1315 n1316 14.506666666666666
r2100 n1170 n1317 6.0235294117647058
r2101 n1316 n1317 14.506666666666666
r2102 n1171 n1318 6.0235294117647058
r2103 n1317 n1318 14.506666666666666
r2104 n1172 n1319 6.0235294117647058
r2105 n1318 n1319 14.506666666666666
r2106 n1173 n1320 6.0235294117647058
r2107 n1319 n1320 14.506666666666666
r2108 n1174 n1321 6.0235294117647058
r2109 n1320 n1321 14.506666666666666
r2110 n1175 n1322 6.0235294117647058
r2111 n1321 n1322 14.506666666666666
r2112 n1176 n1323 6.0235294117647058
r2113 n1322 n1323 14.506666666666666
r2114 n1177 n1324 6.0235294117647058
r2115 n1323 n1324 14.506666666666666
r2116 n1178 n1325 6.0235294117647058
r2117 n1324 n1325 14.506666666666666
r2118 n1179 n1326 6.0235294117647058
r2119 n1325 n1326 14.506666666666666
r2120 n1180 n1327 6.0235294117647058
r2121 n1326 n1327 14.506666666666666
r2122 n1181 n1328 6.0235294117647058
r2123 n1327 n1328 14.506666666666666
r2124 n1182 n1329 6.0235294117647058
r2125 n1328 n1329 14.506666666666666
r2126 n1183 n1330 6.0235294117647058
r2127 n1329 n1330 14.506666666666666
r2128 n1184 n1331 18.618181818181817
r2129 n1330 n1331 9.5999999999999996
r2130 n1185 n1332 8.9043478260869566
r2131 n1331 n1332 7.253333333333333
r2132 n1186 n1333 102.40000000000001
r2133 n1332 n1333 5.333333333333333
r2134 n1187 n1334 6.8266666666666671
r2135 n1333 n1334 6.8266666666666671
r2136 n1188 n1335 102.40000000000001
r2137 n1334 n1335 6.8266666666666671
r2138 n1189 n1336 8.9043478260869566
r2139 n1335 n1336 5.333333333333333
r2140 n1190 n1337 18.618181818181817
r2141 n1336 n1337 7.253333333333333
r2142 n1191 n1338 6.0235294117647058
r2143 n1337 n1338 9.5999999999999996
r2144 n1192 n1339 6.0235294117647058
r2145 n1338 n1339 14.506666666666666
r2146 n1193 n1340 6.0235294117647058
r2147 n1339 n1340 14.506666666666666
r2148 n1194 n1341 6.0235294117647058
r2149 n1340 n1341 14.506666666666666
r2150 n1195 n1342 6.0235294117647058
r2151 n1341 n1342 14.506666666666666
r2152 n1196 n1343 6.0235294117647058
r2153 n1342 n1343 14.506666666666666
r2154 n1197 n1344 6.0235294117647058
r2155 n1343 n1344 14.506666666666666
r2156 n1198 n1345 6.0235294117647058
r2157 n1344 n1345 14.506666666666666
r2158 n1199 n1346 6.0235294117647058
r2159 n1345 n1346 14.506666666666666
r2160 n1200 n1347 6.0235294117647058
r2161 n1346 n1347 14.506666666666666
r2162 n1201 n1348 6.0235294117647058
r2163 n1347 n1348 14.506666666666666
r2164 n1202 n1349 6.0235294117647058
r2165 n1348 n1349 14.506666666666666
r2166 n1203 n1350 6.0235294117647058
r2167 n1349 n1350 14.506666666666666
r2168 n1204 n1351 6.0235294117647058
r2169 n1350 n1351 14.506666666666666
r2170 n1205 n1352 6.0235294117647058
r2171 n1351 n1352 14.506666666666666
r2172 n1206 n1353 6.0235294117647058
r2173 n1352 n1353 14.506666666666666
r2174 n1207 n1354 6.0235294117647058
r2175 n1353 n1354 14.506666666666666
r2176 n1208 n1355 6.0235294117647058
r2177 n1354 n1355 14.506666666666666
r2178 n1209 n1356 6.0235294117647058
r2179 n1355 n1356 14.506666666666666
r2180 n1210 n1357 6.0235294117647058
r2181 n1356 n1357 14.506666666666666
r2182 n1211 n1358 6.0235294117647058
r2183 n1357 n1358 14.506666666666666
r2184 n1212 n1359 6.0235294117647058
r2185 n1358 n1359 14.506666666666666
r2186 n1213 n1360 6.0235294117647058
r2187 n1359 n1360 14.506666666666666
r2188 n1214 n1361 7.5851851851851855
r2189 n1360 n1361 13.013333333333334
r2190 n1215 n1362 29.257142857142856
r2191 n1361 n1362 7.253333333333333
r2192 n1216 n1363 6.0235294117647058
r2193 n1362 n1363 8.7466666666666661
r2194 n1217 n1364 6.0235294117647058
r2195 n1363 n1364 14.506666666666666
r2196 n1218 n1365 6.0235294117647058
r2197 n1364 n1365 14.506666666666666
r2198 n1219 n1366 6.0235294117647058
r2199 n1365 n1366 14.506666666666666
r2200 n1220 n1367 7.5851851851851855
r2201 n1366 n1367 13.013333333333334
r2202 n1221 n1368 29.257142857142856
r2203 n1367 n1368 7.253333333333333
r2204 n1222 n1369 11.377777777777778
r2205 n1368 n1369 5.333333333333333
r2206 n1223 n1370 12.800000000000001
r2207 n1369 n1370 7.253333333333333
r2208 n1224 n1371 14.628571428571428
r2209 n1370 n1371 6.4000000000000004
r2210 n1225 n1372 10.24
r2211 n1371 n1372 7.253333333333333
r2212 n1226 n1373 40.960000000000001
r2213 n1372 n1373 5.333333333333333
r2214 n1227 n1374 7.0620689655172413
r2215 n1373 n1374 7.253333333333333
r2216 n1228 n1375 6.0235294117647058
r2217 n1374 n1375 13.44
r2218 n1229 n1376 6.0235294117647058
r2219 n1375 n1376 14.506666666666666
r2220 n1230 n1377 6.0235294117647058
r2221 n1376 n1377 14.506666666666666
r2222 n1231 n1378 5.1200000000000001
r2223 n1377 n1378 15.786666666666667
r2224 n1232 n1379 6.0235294117647058
r2225 n1378 n1379 15.786666666666667
r2226 n1233 n1380 6.0235294117647058
r2227 n1379 n1380 14.506666666666666
r2228 n1234 n1381 6.0235294117647058
r2229 n1380 n1381 14.506666666666666
r2230 n1235 n1382 12.047058823529412
r2231 n1381 n1382 10.880000000000001
r2232 n1236 n1383 12.047058823529412
r2233 n1382 n1383 7.253333333333333
r2234 n1237 n1384 6.0235294117647058
r2235 n1238 n1385 7.4744525547445253
r2236 n1384 n1385 196.48000000000002
r2237 n1239 n1386 7.4202898550724639
r2238 n1385 n1386 176
r2239 n1240 n1387 6.0235294117647058
r2240 n1386 n1387 197.12
r2241 n1241 n1388 15.753846153846155
r2242 n1387 n1388 150.40000000000001
r2243 n1242 n1389 5.1200000000000001
r2244 n1388 n1389 169.59999999999999
r2245 n1243 n1390 204.80000000000001
r2246 n1389 n1390 131.19999999999999
r2247 n1244 n1391 6.2060606060606061
r2248 n1390 n1391 108.8
r2249 n1245 n1392 204.80000000000001
r2250 n1391 n1392 108.8
r2251 n1246 n1393 8.9043478260869566
r2252 n1392 n1393 76.799999999999997
r2253 n1247 n1394 51.200000000000003
r2254 n1393 n1394 86.400000000000006
r2255 n1248 n1395 34.133333333333333
r2256 n1394 n1395 32
r2257 n1249 n1396 40.960000000000001
r2258 n1395 n1396 35.200000000000003
r2259 n1250 n1397 204.80000000000001
r2260 n1396 n1397 19.199999999999999
r2261 n1251 n1398 15.753846153846155
r2262 n1397 n1398 44.799999999999997
r2263 n1252 n1399 20.48
r2264 n1398 n1399 73.599999999999994
r2265 n1253 n1400 40.960000000000001
r2266 n1399 n1400 48
r2267 n1254 n1401 40.960000000000001
r2268 n1400 n1401 32
r2269 n1255 n1402 204.80000000000001
r2270 n1401 n1402 19.199999999999999
r2271 n1256 n1403 68.266666666666666
r2272 n1402 n1403 12.800000000000001
r2273 n1257 n1404 204.80000000000001
r2274 n1403 n1404 12.800000000000001
r2275 n1258 n1405 22.755555555555556
r2276 n1404 n1405 32
r2277 n1259 n1406 20.48
r2278 n1405 n1406 60.799999999999997
r2279 n1260 n1407 40.960000000000001
r2280 n1406 n1407 48
r2281 n1261 n1408 40.960000000000001
r2282 n1407 n1408 32
r2283 n1262 n1409 204.80000000000001
r2284 n1408 n1409 19.199999999999999
r2285 n1263 n1410 102.40000000000001
r2286 n1409 n1410 9.5999999999999996
r2287 n1264 n1411 204.80000000000001
r2288 n1410 n1411 9.5999999999999996
r2289 n1265 n1412 204.80000000000001
r2290 n1411 n1412 6.4000000000000004
r2291 n1266 n1413 204.80000000000001
r2292 n1412 n1413 6.4000000000000004
r2293 n1267 n1414 51.200000000000003
r2294 n1413 n1414 16
r2295 n1268 n1415 40.960000000000001
r2296 n1414 n1415 28.800000000000001
r2297 n1269 n1416 204.80000000000001
r2298 n1415 n1416 19.199999999999999
r2299 n1270 n1417 20.48
r2300 n1416 n1417 35.200000000000003
r2301 n1271 n1418 68.266666666666666
r2302 n1417 n1418 41.600000000000001
r2303 n1272 n1419 34.133333333333333
r2304 n1418 n1419 28.800000000000001
r2305 n1273 n1420 102.40000000000001
r2306 n1419 n1420 25.600000000000001
r2307 n1274 n1421 204.80000000000001
r2308 n1420 n1421 9.5999999999999996
r2309 n1275 n1422 204.80000000000001
r2310 n1421 n1422 6.4000000000000004
r2311 n1276 n1423 34.133333333333333
r2312 n1422 n1423 22.399999999999999
r2313 n1277 n1424 40.960000000000001
r2314 n1423 n1424 35.200000000000003
r2315 n1278 n1425 204.80000000000001
r2316 n1424 n1425 19.199999999999999
r2317 n1279 n1426 51.200000000000003
r2318 n1425 n1426 16
r2319 n1280 n1427 40.960000000000001
r2320 n1426 n1427 28.800000000000001
r2321 n1281 n1428 68.266666666666666
r2322 n1427 n1428 25.600000000000001
r2323 n1282 n1429 29.257142857142856
r2324 n1428 n1429 32
r2325 n1283 n1430 34.133333333333333
r2326 n1429 n1430 41.600000000000001
r2327 n1284 n1431 20.48
r2328 n1430 n1431 51.200000000000003
r2329 n1285 n1432 51.200000000000003
r2330 n1431 n1432 44.799999999999997
r2331 n1286 n1433 29.257142857142856
r2332 n1432 n1433 35.200000000000003
r2333 n1287 n1434 22.755555555555556
r2334 n1433 n1434 51.200000000000003
r2335 n1288 n1435 51.200000000000003
r2336 n1434 n1435 41.600000000000001
r2337 n1289 n1436 25.600000000000001
r2338 n1435 n1436 38.399999999999999
r2339 n1290 n1437 40.960000000000001
r2340 n1436 n1437 41.600000000000001
r2341 n1291 n1438 34.133333333333333
r2342 n1437 n1438 35.200000000000003
r2343 n1292 n1439 102.40000000000001
r2344 n1438 n1439 25.600000000000001
r2345 n1293 n1440 12.047058823529412
r2346 n1439 n1440 60.799999999999997
r2347 n1294 n1441 15.753846153846155
r2348 n1440 n1441 96
r2349 n1295 n1442 102.40000000000001
r2350 n1441 n1442 48
r2351 n1296 n1443 102.40000000000001
r2352 n1442 n1443 12.800000000000001
r2353 n1297 n1444 51.200000000000003
r2354 n1443 n1444 19.199999999999999
r2355 n1298 n1445 40.960000000000001
r2356 n1444 n1445 28.800000000000001
r2357 n1299 n1446 25.600000000000001
r2358 n1445 n1446 41.600000000000001
r2359 n1300 n1447 51.200000000000003
r2360 n1446 n1447 38.399999999999999
r2361 n1301 n1448 15.753846153846155
r2362 n1447 n1448 54.399999999999999
r2363 n1302 n1449 29.257142857142856
r2364 n1448 n1449 64
r2365 n1303 n1450 7.5851851851851855
r2366 n1449 n1450 108.8
r2367 n1304 n1451 102.40000000000001
r2368 n1450 n1451 92.799999999999997
r2369 n1305 n1452 40.960000000000001
r2370 n1451 n1452 22.399999999999999
r2371 n1306 n1453 7.5851851851851855
r2372 n1452 n1453 102.40000000000001
r2373 n1307 n1454 102.40000000000001
r2374 n1453 n1454 92.799999999999997
r2375 n1308 n1455 6.4000000000000004
r2376 n1454 n1455 108.8
r2377 n1309 n1456 6.0235294117647058
r2378 n1455 n1456 211.19999999999999
r2379 n1310 n1457 6.0235294117647058
r2380 n1456 n1457 217.59999999999999
r2381 n1311 n1458 6.0235294117647058
r2382 n1457 n1458 217.59999999999999
r2383 n1312 n1459 6.0235294117647058
r2384 n1458 n1459 217.59999999999999
r2385 n1313 n1460 6.0235294117647058
r2386 n1459 n1460 217.59999999999999
r2387 n1314 n1461 6.0235294117647058
r2388 n1460 n1461 217.59999999999999
r2389 n1315 n1462 6.0235294117647058
r2390 n1461 n1462 217.59999999999999
r2391 n1316 n1463 6.0235294117647058
r2392 n1462 n1463 217.59999999999999
r2393 n1317 n1464 6.0235294117647058
r2394 n1463 n1464 217.59999999999999
r2395 n1318 n1465 6.0235294117647058
r2396 n1464 n1465 217.59999999999999
r2397 n1319 n1466 6.0235294117647058
r2398 n1465 n1466 217.59999999999999
r2399 n1320 n1467 6.0235294117647058
r2400 n1466 n1467 217.59999999999999
r2401 n1321 n1468 6.0235294117647058
r2402 n1467 n1468 217.59999999999999
r2403 n1322 n1469 6.0235294117647058
r2404 n1468 n1469 217.59999999999999
r2405 n1323 n1470 6.0235294117647058
r2406 n1469 n1470 217.59999999999999
r2407 n1324 n1471 6.0235294117647058
r2408 n1470 n1471 217.59999999999999
r2409 n1325 n1472 6.0235294117647058
r2410 n1471 n1472 217.59999999999999
r2411 n1326 n1473 6.0235294117647058
r2412 n1472 n1473 217.59999999999999
r2413 n1327 n1474 6.0235294117647058
r2414 n1473 n1474 217.59999999999999
r2415 n1328 n1475 6.0235294117647058
r2416 n1474 n1475 217.59999999999999
r2417 n1329 n1476 6.0235294117647058
r2418 n1475 n1476 217.59999999999999
r2419 n1330 n1477 6.0235294117647058
r2420 n1476 n1477 217.59999999999999
r2421 n1331 n1478 18.618181818181817
r2422 n1477 n1478 144
r2423 n1332 n1479 8.9043478260869566
r2424 n1478 n1479 108.8
r2425 n1333 n1480 102.40000000000001
r2426 n1479 n1480 80
r2427 n1334 n1481 6.8266666666666671
r2428 n1480 n1481 102.40000000000001
r2429 n1335 n1482 102.40000000000001
r2430 n1481 n1482 102.40000000000001
r2431 n1336 n1483 8.9043478260869566
r2432 n1482 n1483 80
r2433 n1337 n1484 18.618181818181817
r2434 n1483 n1484 108.8
r2435 n1338 n1485 6.0235294117647058
r2436 n1484 n1485 144
r2437 n1339 n1486 6.0235294117647058
r2438 n1485 n1486 217.59999999999999
r2439 n1340 n1487 6.0235294117647058
r2440 n1486 n1487 217.59999999999999
r2441 n1341 n1488 6.0235294117647058
r2442 n1487 n1488 217.59999999999999
r2443 n1342 n1489 6.0235294117647058
r2444 n1488 n1489 217.59999999999999
r2445 n1343 n1490 6.0235294117647058
r2446 n1489 n1490 217.59999999999999
r2447 n1344 n1491 6.0235294117647058
r2448 n1490 n1491 217.59999999999999
r2449 n1345 n1492 6.0235294117647058
r2450 n1491 n1492 217.59999999999999
r2451 n1346 n1493 6.0235294117647058
r2452 n1492 n1493 217.59999999999999
r2453 n1347 n1494 6.0235294117647058
r2454 n1493 n1494 217.59999999999999
r2455 n1348 n1495 6.0235294117647058
r2456 n1494 n1495 217.59999999999999
r2457 n1349 n1496 6.0235294117647058
r2458 n1495 n1496 217.59999999999999
r2459 n1350 n1497 6.0235294117647058
r2460 n1496 n1497 217.59999999999999
r2461 n1351 n1498 6.0235294117647058
r2462 n1497 n1498 217.59999999999999
r2463 n1352 n1499 6.0235294117647058
r2464 n1498 n1499 217.59999999999999
r2465 n1353 n1500 6.0235294117647058
r2466 n1499 n1500 217.59999999999999
r2467 n1354 n1501 6.0235294117647058
r2468 n1500 n1501 217.59999999999999
r2469 n1355 n1502 6.0235294117647058
r2470 n1501 n1502 217.59999999999999
r2471 n1356 n1503 6.0235294117647058
r2472 n1502 n1503 217.59999999999999
r2473 n1357 n1504 6.0235294117647058
r2474 n1503 n1504 217.59999999999999
r2475 n1358 n1505 6.0235294117647058
r2476 n1504 n1505 217.59999999999999
r2477 n1359 n1506 6.0235294117647058
r2478 n1505 n1506 217.59999999999999
r2479 n1360 n1507 6.0235294117647058
r2480 n1506 n1507 217.59999999999999
r2481 n1361 n1508 7.5851851851851855
r2482 n1507 n1508 195.19999999999999
r2483 n1362 n1509 29.257142857142856
r2484 n1508 n1509 108.8
r2485 n1363 n1510 6.0235294117647058
r2486 n1509 n1510 131.19999999999999
r2487 n1364 n1511 6.0235294117647058
r2488 n1510 n1511 217.59999999999999
r2489 n1365 n1512 6.0235294117647058
r2490 n1511 n1512 217.59999999999999
r2491 n1366 n1513 6.0235294117647058
r2492 n1512 n1513 217.59999999999999
r2493 n1367 n1514 7.5851851851851855
r2494 n1513 n1514 195.19999999999999
r2495 n1368 n1515 29.257142857142856
r2496 n1514 n1515 108.8
r2497 n1369 n1516 11.377777777777778
r2498 n1515 n1516 80
r2499 n1370 n1517 12.800000000000001
r2500 n1516 n1517 108.8
r2501 n1371 n1518 14.628571428571428
r2502 n1517 n1518 96
r2503 n1372 n1519 10.24
r2504 n1518 n1519 108.8
r2505 n1373 n1520 40.960000000000001
r2506 n1519 n1520 80
r2507 n1374 n1521 7.0620689655172413
r2508 n1520 n1521 108.8
r2509 n1375 n1522 6.0235294117647058
r2510 n1521 n1522 201.59999999999999
r2511 n1376 n1523 6.0235294117647058
r2512 n1522 n1523 217.59999999999999
r2513 n1377 n1524 6.0235294117647058
r2514 n1523 n1524 217.59999999999999
r2515 n1378 n1525 5.1200000000000001
r2516 n1524 n1525 236.80000000000001
r2517 n1379 n1526 6.0235294117647058
r2518 n1525 n1526 236.80000000000001
r2519 n1380 n1527 6.0235294117647058
r2520 n1526 n1527 217.59999999999999
r2521 n1381 n1528 6.0235294117647058
r2522 n1527 n1528 217.59999999999999
r2523 n1382 n1529 12.047058823529412
r2524 n1528 n1529 163.19999999999999
r2525 n1383 n1530 12.047058823529412
r2526 n1529 n1530 108.8
r2527 n1384 n1531 2.447058823529412
r2528 n1529 n1532 4.8941176470588239
r2529 n1530 n1533 4.8941176470588239
r2530 n1532 n1533 19.781818181818181
r2531 n1531 n1534 2.447058823529412
r2532 n1532 n1535 4.8941176470588239
r2533 n1533 n1536 4.8941176470588239
r2534 n1535 n1536 108.8
r2535 n1534 n1537 6.7011764705882353
r2536 n1535 n1538 13.402352941176471
r2537 n1536 n1539 13.402352941176471
r2538 n1538 n1539 6.4761904761904763
r2539 n1537 n1540 12.611764705882353
r2540 n1538 n1541 25.223529411764705
r2541 n1539 n1542 25.223529411764705
r2542 n1541 n1542 6.5149700598802394
r2543 n1540 n1543 8.357647058823531
r2544 n1541 n1544 16.715294117647062
r2545 n1542 n1545 16.715294117647062
r2546 n1544 n1545 19.781818181818181
r2547 n1543 n1546 3.9529411764705884
r2548 n1544 n1547 7.9058823529411768
r2549 n1545 n1548 7.9058823529411768
r2550 n1547 n1548 21.760000000000002
r2551 n1546 n1549 2.2588235294117647
r2552 n1547 n1550 4.5176470588235293
r2553 n1548 n1551 4.5176470588235293
r2554 n1550 n1551 108.8
r2555 n1549 n1552 0.94117647058823528
r2556 n1550 n1553 1.8823529411764706
r2557 n1551 n1554 1.8823529411764706
r2558 n1553 n1554 72.533333333333331
r2559 n1552 n1555 1.5058823529411764
r2560 n1553 n1556 3.0117647058823529
r2561 n1554 n1557 3.0117647058823529
r2562 n1556 n1557 43.520000000000003
r2563 n1555 n1558 1.5058823529411764
r2564 n1556 n1559 3.0117647058823529
r2565 n1557 n1560 3.0117647058823529
r2566 n1559 n1560 72.533333333333331
r2567 n1558 n1561 0.94117647058823528
r2568 n1559 n1562 1.8823529411764706
r2569 n1560 n1563 1.8823529411764706
r2570 n1562 n1563 108.8
r2571 n1561 n1564 6.0235294117647058
r2572 n1562 n1565 12.047058823529412
r2573 n1563 n1566 12.047058823529412
r2574 n1565 n1566 7.253333333333333
r2575 n1564 n1567 6.0235294117647058
r2576 n1565 n1568 12.047058823529412
r2577 n1566 n1569 12.047058823529412
r2578 n1568 n1569 108.8
r2579 n1567 n1570 0.94117647058823528
r2580 n1568 n1571 1.8823529411764706
r2581 n1569 n1572 1.8823529411764706
r2582 n1571 n1572 72.533333333333331
r2583 n1570 n1573 1.5058823529411764
r2584 n1571 n1574 3.0117647058823529
r2585 n1572 n1575 3.0117647058823529
r2586 n1574 n1575 43.520000000000003
r2587 n1573 n1576 1.5058823529411764
r2588 n1574 n1577 3.0117647058823529
r2589 n1575 n1578 3.0117647058823529
r2590 n1577 n1578 72.533333333333331
r2591 n1576 n1579 0.94117647058823528
r2592 n1577 n1580 1.8823529411764706
r2593 n1578 n1581 1.8823529411764706
r2594 n1580 n1581 108.8
r2595 n1579 n1582 2.2588235294117647
r2596 n1580 n1583 4.5176470588235293
r2597 n1581 n1584 4.5176470588235293
r2598 n1583 n1584 21.760000000000002
r2599 n1582 n1585 3.9529411764705884
r2600 n1583 n1586 7.9058823529411768
r2601 n1584 n1587 7.9058823529411768
r2602 n1586 n1587 19.781818181818181
r2603 n1585 n1588 9.5999999999999996
r2604 n1586 n1589 19.199999999999999
r2605 n1587 n1590 19.199999999999999
r2606 n1589 n1590 5.4400000000000004
r2607 n1588 n1591 15.058823529411764
r2608 n1589 n1592 30.117647058823529
r2609 n1590 n1593 30.117647058823529
r2610 n1592 n1593 5.4400000000000004
r2611 n1591 n1594 13.929411764705883
r2612 n1594 n1595 11.55764705882353
r2613 n1595 n1596 10.352941176470589
r2614 n1596 n1597 11.595294117647059
r2615 n1597 n1598 8.8470588235294123
r2616 n1598 n1599 9.9764705882352942
r2617 n1599 n1600 7.7176470588235295
r2618 n1600 n1601 6.4000000000000004
r2619 n1601 n1602 6.4000000000000004
r2620 n1602 n1603 4.5176470588235293
r2621 n1603 n1604 5.0823529411764703
r2622 n1604 n1605 1.8823529411764706
r2623 n1605 n1606 2.0705882352941178
r2624 n1606 n1607 1.1294117647058823
r2625 n1607 n1608 2.6352941176470588
r2626 n1608 n1609 4.3294117647058821
r2627 n1609 n1610 2.8235294117647061
r2628 n1610 n1611 1.8823529411764706
r2629 n1611 n1612 1.1294117647058823
r2630 n1612 n1613 0.75294117647058822
r2631 n1613 n1614 0.75294117647058822
r2632 n1614 n1615 1.8823529411764706
r2633 n1615 n1616 3.5764705882352943
r2634 n1616 n1617 2.8235294117647061
r2635 n1617 n1618 1.8823529411764706
r2636 n1618 n1619 1.1294117647058823
r2637 n1619 n1620 0.56470588235294117
r2638 n1620 n1621 0.56470588235294117
r2639 n1621 n1622 0.37647058823529411
r2640 n1622 n1623 0.37647058823529411
r2641 n1623 n1624 0.94117647058823528
r2642 n1624 n1625 1.6941176470588235
r2643 n1625 n1626 1.1294117647058823
r2644 n1626 n1627 2.0705882352941178
r2645 n1627 n1628 2.447058823529412
r2646 n1628 n1629 1.6941176470588235
r2647 n1629 n1630 1.5058823529411764
r2648 n1630 n1631 0.56470588235294117
r2649 n1631 n1632 0.37647058823529411
r2650 n1632 n1633 1.3176470588235294
r2651 n1633 n1634 2.0705882352941178
r2652 n1634 n1635 1.1294117647058823
r2653 n1635 n1636 0.94117647058823528
r2654 n1636 n1637 1.6941176470588235
r2655 n1637 n1638 1.5058823529411764
r2656 n1638 n1639 1.8823529411764706
r2657 n1639 n1640 2.447058823529412
r2658 n1640 n1641 3.0117647058823529
r2659 n1641 n1642 2.6352941176470588
r2660 n1642 n1643 2.0705882352941178
r2661 n1643 n1644 3.0117647058823529
r2662 n1644 n1645 2.447058823529412
r2663 n1645 n1646 2.2588235294117647
r2664 n1646 n1647 2.447058823529412
r2665 n1647 n1648 2.0705882352941178
r2666 n1648 n1649 1.5058823529411764
r2667 n1649 n1650 3.5764705882352943
r2668 n1650 n1651 5.6470588235294121
r2669 n1651 n1652 2.8235294117647061
r2670 n1652 n1653 0.75294117647058822
r2671 n1653 n1654 1.1294117647058823
r2672 n1654 n1655 1.6941176470588235
r2673 n1655 n1656 2.447058823529412
r2674 n1656 n1657 2.2588235294117647
r2675 n1657 n1658 3.2000000000000002
r2676 n1658 n1659 3.7647058823529411
r2677 n1659 n1660 6.4000000000000004
r2678 n1660 n1661 5.4588235294117649
r2679 n1661 n1662 1.3176470588235294
r2680 n1662 n1663 6.0235294117647058
r2681 n1663 n1664 5.4588235294117649
r2682 n1664 n1665 6.4000000000000004
r2683 n1665 n1666 12.423529411764706
r2684 n1666 n1667 12.800000000000001
r2685 n1667 n1668 12.800000000000001
r2686 n1668 n1669 12.800000000000001
r2687 n1669 n1670 12.800000000000001
r2688 n1670 n1671 12.800000000000001
r2689 n1671 n1672 12.800000000000001
r2690 n1672 n1673 12.800000000000001
r2691 n1673 n1674 12.800000000000001
r2692 n1674 n1675 12.800000000000001
r2693 n1675 n1676 12.800000000000001
r2694 n1676 n1677 12.800000000000001
r2695 n1677 n1678 12.800000000000001
r2696 n1678 n1679 12.800000000000001
r2697 n1679 n1680 12.800000000000001
r2698 n1680 n1681 12.800000000000001
r2699 n1681 n1682 12.800000000000001
r2700 n1682 n1683 12.800000000000001
r2701 n1683 n1684 12.800000000000001
r2702 n1684 n1685 12.800000000000001
r2703 n1685 n1686 12.800000000000001
r2704 n1686 n1687 12.800000000000001
r2705 n1687 n1688 8.4705882352941178
r2706 n1688 n1689 6.4000000000000004
r2707 n1689 n1690 4.7058823529411766
r2708 n1690 n1691 6.0235294117647058
r2709 n1691 n1692 6.0235294117647058
r2710 n1692 n1693 4.7058823529411766
r2711 n1693 n1694 6.4000000000000004
r2712 n1694 n1695 8.4705882352941178
r2713 n1695 n1696 12.800000000000001
r2714 n1696 n1697 12.800000000000001
r2715 n1697 n1698 12.800000000000001
r2716 n1698 n1699 12.800000000000001
r2717 n1699 n1700 12.800000000000001
r2718 n1700 n1701 12.800000000000001
r2719 n1701 n1702 12.800000000000001
r2720 n1702 n1703 12.800000000000001
r2721 n1703 n1704 12.800000000000001
r2722 n1704 n1705 12.800000000000001
r2723 n1705 n1706 12.800000000000001
r2724 n1706 n1707 12.800000000000001
r2725 n1707 n1708 12.800000000000001
r2726 n1708 n1709 12.800000000000001
r2727 n1709 n1710 12.800000000000001
r2728 n1710 n1711 12.800000000000001
r2729 n1711 n1712 12.800000000000001
r2730 n1712 n1713 12.800000000000001
r2731 n1713 n1714 12.800000000000001
r2732 n1714 n1715 12.800000000000001
r2733 n1715 n1716 12.800000000000001
r2734 n1716 n1717 12.800000000000001
r2735 n1717 n1718 11.482352941176471
r2736 n1718 n1719 6.4000000000000004
r2737 n1719 n1720 7.7176470588235295
r2738 n1720 n1721 12.800000000000001
r2739 n1721 n1722 12.800000000000001
r2740 n1722 n1723 12.800000000000001
r2741 n1723 n1724 11.482352941176471
r2742 n1724 n1725 6.4000000000000004
r2743 n1725 n1726 4.7058823529411766
r2744 n1726 n1727 6.4000000000000004
r2745 n1727 n1728 5.6470588235294121
r2746 n1728 n1729 6.4000000000000004
r2747 n1729 n1730 4.7058823529411766
r2748 n1730 n1731 6.4000000000000004
r2749 n1731 n1732 11.858823529411765
r2750 n1732 n1733 12.800000000000001
r2751 n1733 n1734 12.800000000000001
r2752 n1734 n1735 13.929411764705883
r2753 n1735 n1736 13.929411764705883
r2754 n1736 n1737 12.800000000000001
r2755 n1737 n1738 12.800000000000001
r2756 n1592 n1739 27.858823529411765
r2757 n1738 n1739 9.5999999999999996
r2758 n1593 n1740 27.858823529411765
r2759 n1739 n1740 6.4000000000000004
r2760 vdd n1869 0.22321428571428573
r2761 n1869 n1870 22.035714285714285
r2762 n1870 n1871 43.959821428571431
r2763 n1871 n1872 44.071428571428569
r2764 n1872 n1873 44.071428571428569
r2765 n1873 n1874 44.071428571428569
r2766 n1874 n1875 44.071428571428569
r2767 n1875 n1876 44.071428571428569
r2768 n1876 n1877 44.071428571428569
r2769 n1877 n1878 44.071428571428569
r2770 n1878 n1879 44.071428571428569
r2771 n1879 n1880 44.071428571428569
r2772 n1880 n1881 44.071428571428569
r2773 n1881 n1882 44.071428571428569
r2774 n1882 n1883 44.071428571428569
r2775 n1883 n1884 44.071428571428569
r2776 n1884 n1885 44.071428571428569
r2777 n1885 n1886 44.071428571428569
r2778 n1886 n1887 44.071428571428569
r2779 n1887 n1888 44.071428571428569
r2780 n1888 n1889 43.959821428571431
r2781 n1889 n1890 22.035714285714285
r2782 n1890 n1900 0.20758928571428573
r2783 n1900 n1910 0.171875
r2784 n1910 n1920 0.171875
r2785 n1920 n1921 0.20758928571428573
r2786 n1921 n1922 0.22321428571428573
r2787 n1922 n1923 0.22232142857142856
r2788 n1923 n1924 0.22142857142857142
r2789 n1924 n1925 0.22142857142857142
r2790 n1925 n1926 0.22142857142857142
r2791 n1926 n1927 0.22142857142857142
r2792 n1927 n1928 0.22142857142857142
r2793 n1928 n1929 0.22098214285714285
r2794 n1929 n1930 0.22098214285714285
r2795 n1930 n1931 0.22142857142857142
r2796 n1931 n1932 0.22142857142857142
r2797 n1932 n1933 0.22142857142857142
r2798 n1933 n1934 0.22142857142857142
r2799 n1934 n1935 0.22142857142857142
r2800 n1935 n1936 0.22142857142857142
r2801 n1936 n1937 0.22142857142857142
r2802 n1937 n1938 0.22142857142857142
r2803 n1938 n1939 0.22142857142857142
r2804 n1939 n1940 0.22098214285714285
r2805 n1940 n1941 0.22098214285714285
r2806 n1941 n1942 0.22142857142857142
r2807 n1942 n1943 0.22142857142857142
r2808 n1943 n1944 0.22142857142857142
r2809 n1944 n1945 0.22142857142857142
r2810 n1945 n1946 0.22142857142857142
r2811 n1946 n1947 0.22142857142857142
r2812 n1947 n1948 0.22142857142857142
r2813 n1948 n1949 0.22142857142857142
r2814 n1949 n1950 0.22142857142857142
r2815 n1950 n1951 0.22142857142857142
r2816 n1951 n1952 0.22142857142857142
r2817 n1952 n1953 0.22098214285714285
r2818 n1953 n1954 0.22098214285714285
r2819 n1954 n1955 0.22142857142857142
r2820 n1955 n1956 0.22142857142857142
r2821 n1956 n1957 0.22142857142857142
r2822 n1957 n1958 0.22142857142857142
r2823 n1958 n1959 0.22142857142857142
r2824 n1959 n1960 0.22142857142857142
r2825 n1960 n1961 0.22142857142857142
r2826 n1961 n1962 0.22142857142857142
r2827 n1962 n1963 0.22142857142857142
r2828 n1963 n1964 0.22098214285714285
r2829 n1964 n1965 0.22098214285714285
r2830 n1965 n1966 0.22142857142857142
r2831 n1966 n1967 0.22142857142857142
r2832 n1967 n1968 0.22142857142857142
r2833 n1968 n1969 0.22142857142857142
r2834 n1969 n1970 0.22142857142857142
r2835 n1970 n1971 0.22232142857142856
r2836 n1971 n1972 0.22321428571428573
r2837 n1973 n1974 0.084375000000000006
r2838 n1974 n1975 0.10312499999999999
r2839 n1975 n1976 0.056250000000000001
r2840 n1976 n1977 0.10000000000000001
r2841 n1977 n1978 0.10000000000000001
r2842 n1978 n1979 0.056250000000000001
r2843 n1979 n1980 0.10312499999999999
r2844 n1980 n1981 0.084375000000000006
r2845 n1972 n1982 0.15625
r2846 n1973 n1983 0.26874999999999999
r2847 n1974 n1984 0.15808823529411764
r2848 n1983 n1984 0.073369565217391311
r2849 n1975 n1985 0.16796875
r2850 n1984 n1985 0.089673913043478257
r2851 n1976 n1986 1.34375
r2852 n1985 n1986 0.048913043478260872
r2853 n1977 n1987 0.089583333333333334
r2854 n1986 n1987 0.086956521739130432
r2855 n1978 n1988 1.34375
r2856 n1987 n1988 0.086956521739130432
r2857 n1979 n1989 0.16796875
r2858 n1988 n1989 0.048913043478260872
r2859 n1980 n1990 0.15808823529411764
r2860 n1989 n1990 0.089673913043478257
r2861 n1981 n1991 0.26874999999999999
r2862 n1990 n1991 0.073369565217391311
r2863 n1992 n1993 0.070652173913043473
r2864 n1982 n1994 0.095982142857142863
r2865 n1993 n1994 0.07880434782608696
r2866 n1994 n1995 0.07880434782608696
r2867 n1995 n1996 0.070652173913043473
r2868 n1983 n1997 0.15625
r2869 n1984 n1998 0.091911764705882359
r2870 n1997 n1998 0.84375
r2871 n1985 n1999 0.09765625
r2872 n1998 n1999 1.03125
r2873 n1986 n2000 0.78125
r2874 n1999 n2000 0.5625
r2875 n1987 n2001 0.052083333333333336
r2876 n2000 n2001 1
r2877 n1988 n2002 0.78125
r2878 n2001 n2002 1
r2879 n1989 n2003 0.09765625
r2880 n2002 n2003 0.5625
r2881 n1990 n2004 0.091911764705882359
r2882 n2003 n2004 1.03125
r2883 n1991 n2005 0.15625
r2884 n2004 n2005 0.84375
r2885 n1992 n2006 0.0625
r2886 n1993 n2007 1.5625
r2887 n2006 n2007 0.8125
r2888 n1994 n2008 0.055803571428571432
r2889 n2007 n2008 0.90625
r2890 n1995 n2009 1.5625
r2891 n2008 n2009 0.90625
r2892 n1996 n2010 0.0625
r2893 n2009 n2010 0.8125
r2894 n1997 n2011 0.20000000000000001
r2895 n1998 n2012 0.11764705882352941
r2896 n2011 n2012 0.056250000000000001
r2897 n1999 n2013 0.125
r2898 n2012 n2013 0.068750000000000006
r2899 n2000 n2014 1
r2900 n2013 n2014 0.037499999999999999
r2901 n2001 n2015 0.066666666666666666
r2902 n2014 n2015 0.066666666666666666
r2903 n2002 n2016 1
r2904 n2015 n2016 0.066666666666666666
r2905 n2003 n2017 0.125
r2906 n2016 n2017 0.037499999999999999
r2907 n2004 n2018 0.11764705882352941
r2908 n2017 n2018 0.068750000000000006
r2909 n2005 n2019 0.20000000000000001
r2910 n2018 n2019 0.056250000000000001
r2911 n2006 n2020 0.080000000000000002
r2912 n2007 n2021 2
r2913 n2020 n2021 0.054166666666666669
r2914 n2008 n2022 0.071428571428571425
r2915 n2021 n2022 0.060416666666666667
r2916 n2009 n2023 2
r2917 n2022 n2023 0.060416666666666667
r2918 n2010 n2024 0.080000000000000002
r2919 n2023 n2024 0.054166666666666669
r2920 n2011 n2025 0.20000000000000001
r2921 n2012 n2026 0.11764705882352941
r2922 n2025 n2026 0.84375
r2923 n2013 n2027 0.125
r2924 n2026 n2027 1.03125
r2925 n2014 n2028 1
r2926 n2027 n2028 0.5625
r2927 n2015 n2029 0.066666666666666666
r2928 n2028 n2029 1
r2929 n2016 n2030 1
r2930 n2029 n2030 1
r2931 n2017 n2031 0.125
r2932 n2030 n2031 0.5625
r2933 n2018 n2032 0.11764705882352941
r2934 n2031 n2032 1.03125
r2935 n2019 n2033 0.20000000000000001
r2936 n2032 n2033 0.84375
r2937 n2020 n2034 0.080000000000000002
r2938 n2021 n2035 2
r2939 n2034 n2035 0.8125
r2940 n2022 n2036 0.071428571428571425
r2941 n2035 n2036 0.90625
r2942 n2023 n2037 2
r2943 n2036 n2037 0.90625
r2944 n2024 n2038 0.080000000000000002
r2945 n2037 n2038 0.8125
r2946 n2025 n2039 0.15625
r2947 n2026 n2040 0.091911764705882359
r2948 n2039 n2040 0.073369565217391311
r2949 n2027 n2041 0.09765625
r2950 n2040 n2041 0.089673913043478257
r2951 n2028 n2042 0.78125
r2952 n2041 n2042 0.048913043478260872
r2953 n2029 n2043 0.052083333333333336
r2954 n2042 n2043 0.086956521739130432
r2955 n2030 n2044 0.78125
r2956 n2043 n2044 0.086956521739130432
r2957 n2031 n2045 0.09765625
r2958 n2044 n2045 0.048913043478260872
r2959 n2032 n2046 0.091911764705882359
r2960 n2045 n2046 0.089673913043478257
r2961 n2033 n2047 0.15625
r2962 n2046 n2047 0.073369565217391311
r2963 n2034 n2048 0.0625
r2964 n2035 n2049 1.5625
r2965 n2048 n2049 0.070652173913043473
r2966 n2036 n2050 0.055803571428571432
r2967 n2049 n2050 0.07880434782608696
r2968 n2037 n2051 1.5625
r2969 n2050 n2051 0.07880434782608696
r2970 n2038 n2052 0.0625
r2971 n2051 n2052 0.070652173913043473
r2972 n2039 n2053 0.26874999999999999
r2973 n2040 n2054 0.15808823529411764
r2974 n2053 n2054 0.084375000000000006
r2975 n2041 n2055 0.16796875
r2976 n2054 n2055 0.10312499999999999
r2977 n2042 n2056 1.34375
r2978 n2055 n2056 0.056250000000000001
r2979 n2043 n2057 0.089583333333333334
r2980 n2056 n2057 0.10000000000000001
r2981 n2044 n2058 1.34375
r2982 n2057 n2058 0.10000000000000001
r2983 n2045 n2059 0.16796875
r2984 n2058 n2059 0.056250000000000001
r2985 n2046 n2060 0.15808823529411764
r2986 n2059 n2060 0.10312499999999999
r2987 n2047 n2061 0.26874999999999999
r2988 n2060 n2061 0.084375000000000006
r2989 n2062 n2063 0.46875
r2990 n2063 n2064 0.3125
r2991 n2064 n2065 0.1875
r2992 n2065 n2066 0.09375
r2993 n2066 n2067 0.09375
r2994 n2067 n2068 0.0625
r2995 n2068 n2069 0.0625
r2996 n2069 n2070 0.15625
r2997 n2070 n2071 0.28125
r2998 n2071 n2072 0.1875
r2999 n2072 n2073 0.34375
r3000 n2073 n2074 0.40625
r3001 n2074 n2075 0.28125
r3002 n2075 n2076 0.25
r3003 n2076 n2077 0.09375
r3004 n2077 n2078 0.0625
r3005 n2078 n2079 0.21875
r3006 n2079 n2080 0.34375
r3007 n2080 n2081 0.1875
r3008 n2081 n2082 0.15625
r3009 n2082 n2083 0.28125
r3010 n2062 n2084 0.081250000000000003
r3011 n2063 n2085 0.16250000000000001
r3012 n2084 n2085 0.085227272727272721
r3013 n2064 n2086 0.16250000000000001
r3014 n2085 n2086 0.056818181818181816
r3015 n2065 n2087 0.8125
r3016 n2086 n2087 0.034090909090909088
r3017 n2066 n2088 0.40625
r3018 n2087 n2088 0.017045454545454544
r3019 n2067 n2089 0.8125
r3020 n2088 n2089 0.017045454545454544
r3021 n2068 n2090 0.8125
r3022 n2089 n2090 0.011363636363636364
r3023 n2069 n2091 0.8125
r3024 n2090 n2091 0.011363636363636364
r3025 n2070 n2092 0.203125
r3026 n2091 n2092 0.028409090909090908
r3027 n2071 n2093 0.16250000000000001
r3028 n2092 n2093 0.05113636363636364
r3029 n2072 n2094 0.8125
r3030 n2093 n2094 0.034090909090909088
r3031 n2073 n2095 0.081250000000000003
r3032 n2094 n2095 0.0625
r3033 n2074 n2096 0.27083333333333331
r3034 n2095 n2096 0.073863636363636367
r3035 n2075 n2097 0.13541666666666666
r3036 n2096 n2097 0.05113636363636364
r3037 n2076 n2098 0.40625
r3038 n2097 n2098 0.045454545454545456
r3039 n2077 n2099 0.8125
r3040 n2098 n2099 0.017045454545454544
r3041 n2078 n2100 0.8125
r3042 n2099 n2100 0.011363636363636364
r3043 n2079 n2101 0.13541666666666666
r3044 n2100 n2101 0.039772727272727272
r3045 n2080 n2102 0.16250000000000001
r3046 n2101 n2102 0.0625
r3047 n2081 n2103 0.8125
r3048 n2102 n2103 0.034090909090909088
r3049 n2082 n2104 0.203125
r3050 n2103 n2104 0.028409090909090908
r3051 n2083 n2105 0.16250000000000001
r3052 n2104 n2105 0.05113636363636364
r3053 n2084 n2106 0.081250000000000003
r3054 n2085 n2107 0.16250000000000001
r3055 n2106 n2107 0.46875
r3056 n2086 n2108 0.16250000000000001
r3057 n2107 n2108 0.3125
r3058 n2087 n2109 0.8125
r3059 n2108 n2109 0.1875
r3060 n2088 n2110 0.40625
r3061 n2109 n2110 0.09375
r3062 n2089 n2111 0.8125
r3063 n2110 n2111 0.09375
r3064 n2090 n2112 0.8125
r3065 n2111 n2112 0.0625
r3066 n2091 n2113 0.8125
r3067 n2112 n2113 0.0625
r3068 n2092 n2114 0.203125
r3069 n2113 n2114 0.15625
r3070 n2093 n2115 0.16250000000000001
r3071 n2114 n2115 0.28125
r3072 n2094 n2116 0.8125
r3073 n2115 n2116 0.1875
r3074 n2095 n2117 0.081250000000000003
r3075 n2116 n2117 0.34375
r3076 n2096 n2118 0.27083333333333331
r3077 n2117 n2118 0.40625
r3078 n2097 n2119 0.13541666666666666
r3079 n2118 n2119 0.28125
r3080 n2098 n2120 0.40625
r3081 n2119 n2120 0.25
r3082 n2099 n2121 0.8125
r3083 n2120 n2121 0.09375
r3084 n2100 n2122 0.8125
r3085 n2121 n2122 0.0625
r3086 n2101 n2123 0.13541666666666666
r3087 n2122 n2123 0.21875
r3088 n2102 n2124 0.16250000000000001
r3089 n2123 n2124 0.34375
r3090 n2103 n2125 0.8125
r3091 n2124 n2125 0.1875
r3092 n2104 n2126 0.203125
r3093 n2125 n2126 0.15625
r3094 n2105 n2127 0.16250000000000001
r3095 n2126 n2127 0.28125
r3096 n2106 n2128 0.20000000000000001
r3097 n2107 n2129 0.40000000000000002
r3098 n2128 n2129 0.03125
r3099 n2108 n2130 0.40000000000000002
r3100 n2129 n2130 0.020833333333333332
r3101 n2109 n2131 2
r3102 n2130 n2131 0.012500000000000001
r3103 n2110 n2132 1
r3104 n2131 n2132 0.0062500000000000003
r3105 n2111 n2133 2
r3106 n2132 n2133 0.0062500000000000003
r3107 n2112 n2134 2
r3108 n2133 n2134 0.0041666666666666666
r3109 n2113 n2135 2
r3110 n2134 n2135 0.0041666666666666666
r3111 n2114 n2136 0.5
r3112 n2135 n2136 0.010416666666666666
r3113 n2115 n2137 0.40000000000000002
r3114 n2136 n2137 0.018749999999999999
r3115 n2116 n2138 2
r3116 n2137 n2138 0.012500000000000001
r3117 n2117 n2139 0.20000000000000001
r3118 n2138 n2139 0.022916666666666665
r3119 n2118 n2140 0.66666666666666663
r3120 n2139 n2140 0.027083333333333334
r3121 n2119 n2141 0.33333333333333331
r3122 n2140 n2141 0.018749999999999999
r3123 n2120 n2142 1
r3124 n2141 n2142 0.016666666666666666
r3125 n2121 n2143 2
r3126 n2142 n2143 0.0062500000000000003
r3127 n2122 n2144 2
r3128 n2143 n2144 0.0041666666666666666
r3129 n2123 n2145 0.33333333333333331
r3130 n2144 n2145 0.014583333333333334
r3131 n2124 n2146 0.40000000000000002
r3132 n2145 n2146 0.022916666666666665
r3133 n2125 n2147 2
r3134 n2146 n2147 0.012500000000000001
r3135 n2126 n2148 0.5
r3136 n2147 n2148 0.010416666666666666
r3137 n2127 n2149 0.40000000000000002
r3138 n2148 n2149 0.018749999999999999
r3139 n2128 n2150 0.20000000000000001
r3140 n2129 n2151 0.40000000000000002
r3141 n2150 n2151 0.46875
r3142 n2130 n2152 0.40000000000000002
r3143 n2151 n2152 0.3125
r3144 n2131 n2153 2
r3145 n2152 n2153 0.1875
r3146 n2132 n2154 1
r3147 n2153 n2154 0.09375
r3148 n2133 n2155 2
r3149 n2154 n2155 0.09375
r3150 n2134 n2156 2
r3151 n2155 n2156 0.0625
r3152 n2135 n2157 2
r3153 n2156 n2157 0.0625
r3154 n2136 n2158 0.5
r3155 n2157 n2158 0.15625
r3156 n2137 n2159 0.40000000000000002
r3157 n2158 n2159 0.28125
r3158 n2138 n2160 2
r3159 n2159 n2160 0.1875
r3160 n2139 n2161 0.20000000000000001
r3161 n2160 n2161 0.34375
r3162 n2140 n2162 0.66666666666666663
r3163 n2161 n2162 0.40625
r3164 n2141 n2163 0.33333333333333331
r3165 n2162 n2163 0.28125
r3166 n2142 n2164 1
r3167 n2163 n2164 0.25
r3168 n2143 n2165 2
r3169 n2164 n2165 0.09375
r3170 n2144 n2166 2
r3171 n2165 n2166 0.0625
r3172 n2145 n2167 0.33333333333333331
r3173 n2166 n2167 0.21875
r3174 n2146 n2168 0.40000000000000002
r3175 n2167 n2168 0.34375
r3176 n2147 n2169 2
r3177 n2168 n2169 0.1875
r3178 n2148 n2170 0.5
r3179 n2169 n2170 0.15625
r3180 n2149 n2171 0.40000000000000002
r3181 n2170 n2171 0.28125
r3182 n2150 n2172 0.081250000000000003
r3183 n2151 n2173 0.16250000000000001
r3184 n2172 n2173 0.085227272727272721
r3185 n2152 n2174 0.16250000000000001
r3186 n2173 n2174 0.056818181818181816
r3187 n2153 n2175 0.8125
r3188 n2174 n2175 0.034090909090909088
r3189 n2154 n2176 0.40625
r3190 n2175 n2176 0.017045454545454544
r3191 n2155 n2177 0.8125
r3192 n2176 n2177 0.017045454545454544
r3193 n2156 n2178 0.8125
r3194 n2177 n2178 0.011363636363636364
r3195 n2157 n2179 0.8125
r3196 n2178 n2179 0.011363636363636364
r3197 n2158 n2180 0.203125
r3198 n2179 n2180 0.028409090909090908
r3199 n2159 n2181 0.16250000000000001
r3200 n2180 n2181 0.05113636363636364
r3201 n2160 n2182 0.8125
r3202 n2181 n2182 0.034090909090909088
r3203 n2161 n2183 0.081250000000000003
r3204 n2182 n2183 0.0625
r3205 n2162 n2184 0.27083333333333331
r3206 n2183 n2184 0.073863636363636367
r3207 n2163 n2185 0.13541666666666666
r3208 n2184 n2185 0.05113636363636364
r3209 n2164 n2186 0.40625
r3210 n2185 n2186 0.045454545454545456
r3211 n2165 n2187 0.8125
r3212 n2186 n2187 0.017045454545454544
r3213 n2166 n2188 0.8125
r3214 n2187 n2188 0.011363636363636364
r3215 n2167 n2189 0.13541666666666666
r3216 n2188 n2189 0.039772727272727272
r3217 n2168 n2190 0.16250000000000001
r3218 n2189 n2190 0.0625
r3219 n2169 n2191 0.8125
r3220 n2190 n2191 0.034090909090909088
r3221 n2170 n2192 0.203125
r3222 n2191 n2192 0.028409090909090908
r3223 n2171 n2193 0.16250000000000001
r3224 n2192 n2193 0.05113636363636364
r3225 n2172 n2194 0.081250000000000003
r3226 n2173 n2195 0.16250000000000001
r3227 n2194 n2195 0.46875
r3228 n2174 n2196 0.16250000000000001
r3229 n2195 n2196 0.3125
r3230 n2175 n2197 0.8125
r3231 n2196 n2197 0.1875
r3232 n2176 n2198 0.40625
r3233 n2197 n2198 0.09375
r3234 n2177 n2199 0.8125
r3235 n2198 n2199 0.09375
r3236 n2178 n2200 0.8125
r3237 n2199 n2200 0.0625
r3238 n2179 n2201 0.8125
r3239 n2200 n2201 0.0625
r3240 n2180 n2202 0.203125
r3241 n2201 n2202 0.15625
r3242 n2181 n2203 0.16250000000000001
r3243 n2202 n2203 0.28125
r3244 n2182 n2204 0.8125
r3245 n2203 n2204 0.1875
r3246 n2183 n2205 0.081250000000000003
r3247 n2204 n2205 0.34375
r3248 n2184 n2206 0.27083333333333331
r3249 n2205 n2206 0.40625
r3250 n2185 n2207 0.13541666666666666
r3251 n2206 n2207 0.28125
r3252 n2186 n2208 0.40625
r3253 n2207 n2208 0.25
r3254 n2187 n2209 0.8125
r3255 n2208 n2209 0.09375
r3256 n2188 n2210 0.8125
r3257 n2209 n2210 0.0625
r3258 n2189 n2211 0.13541666666666666
r3259 n2210 n2211 0.21875
r3260 n2190 n2212 0.16250000000000001
r3261 n2211 n2212 0.34375
r3262 n2191 n2213 0.8125
r3263 n2212 n2213 0.1875
r3264 n2192 n2214 0.203125
r3265 n2213 n2214 0.15625
r3266 n2193 n2215 0.16250000000000001
r3267 n2214 n2215 0.28125
r3268 n2216 n2217 0.46875
r3269 n2217 n2218 0.3125
r3270 n2218 n2219 0.1875
r3271 n2219 n2220 0.125
r3272 n2220 n2221 0.125
r3273 n2221 n2222 0.3125
r3274 n2222 n2223 0.59375
r3275 n2223 n2224 0.46875
r3276 n2224 n2225 0.3125
r3277 n2225 n2226 0.1875
r3278 n2226 n2227 0.09375
r3279 n2227 n2228 0.09375
r3280 n2228 n2229 0.0625
r3281 n2229 n2230 0.0625
r3282 n2230 n2231 0.15625
r3283 n2231 n2232 0.28125
r3284 n2232 n2233 0.1875
r3285 n2233 n2234 0.34375
r3286 n2216 n2235 0.043749999999999997
r3287 n2217 n2236 0.087499999999999994
r3288 n2235 n2236 0.1875
r3289 n2218 n2237 0.087499999999999994
r3290 n2236 n2237 0.125
r3291 n2219 n2238 0.4375
r3292 n2237 n2238 0.074999999999999997
r3293 n2220 n2239 0.14583333333333334
r3294 n2238 n2239 0.050000000000000003
r3295 n2221 n2240 0.4375
r3296 n2239 n2240 0.050000000000000003
r3297 n2222 n2241 0.048611111111111112
r3298 n2240 n2241 0.125
r3299 n2223 n2242 0.043749999999999997
r3300 n2241 n2242 0.23749999999999999
r3301 n2224 n2243 0.087499999999999994
r3302 n2242 n2243 0.1875
r3303 n2225 n2244 0.087499999999999994
r3304 n2243 n2244 0.125
r3305 n2226 n2245 0.4375
r3306 n2244 n2245 0.074999999999999997
r3307 n2227 n2246 0.21875
r3308 n2245 n2246 0.037499999999999999
r3309 n2228 n2247 0.4375
r3310 n2246 n2247 0.037499999999999999
r3311 n2229 n2248 0.4375
r3312 n2247 n2248 0.025000000000000001
r3313 n2230 n2249 0.4375
r3314 n2248 n2249 0.025000000000000001
r3315 n2231 n2250 0.109375
r3316 n2249 n2250 0.0625
r3317 n2232 n2251 0.087499999999999994
r3318 n2250 n2251 0.1125
r3319 n2233 n2252 0.4375
r3320 n2251 n2252 0.074999999999999997
r3321 n2234 n2253 0.043749999999999997
r3322 n2252 n2253 0.13750000000000001
r3323 n2254 n2255 0.11458333333333333
r3324 n2255 n2256 0.0625
r3325 n2256 n2257 0.14583333333333334
r3326 n2235 n2258 0.068750000000000006
r3327 n2257 n2258 0.23958333333333334
r3328 n2236 n2259 0.13750000000000001
r3329 n2258 n2259 0.15625
r3330 n2237 n2260 0.13750000000000001
r3331 n2259 n2260 0.10416666666666667
r3332 n2238 n2261 0.6875
r3333 n2260 n2261 0.0625
r3334 n2239 n2262 0.22916666666666666
r3335 n2261 n2262 0.041666666666666664
r3336 n2240 n2263 0.6875
r3337 n2262 n2263 0.041666666666666664
r3338 n2241 n2264 0.076388888888888895
r3339 n2263 n2264 0.10416666666666667
r3340 n2242 n2265 0.068750000000000006
r3341 n2264 n2265 0.19791666666666666
r3342 n2243 n2266 0.13750000000000001
r3343 n2265 n2266 0.15625
r3344 n2244 n2267 0.13750000000000001
r3345 n2266 n2267 0.10416666666666667
r3346 n2245 n2268 0.6875
r3347 n2267 n2268 0.0625
r3348 n2246 n2269 0.34375
r3349 n2268 n2269 0.03125
r3350 n2247 n2270 0.6875
r3351 n2269 n2270 0.03125
r3352 n2248 n2271 0.6875
r3353 n2270 n2271 0.020833333333333332
r3354 n2249 n2272 0.6875
r3355 n2271 n2272 0.020833333333333332
r3356 n2250 n2273 0.171875
r3357 n2272 n2273 0.052083333333333336
r3358 n2251 n2274 0.13750000000000001
r3359 n2273 n2274 0.09375
r3360 n2252 n2275 0.6875
r3361 n2274 n2275 0.0625
r3362 n2253 n2276 0.068750000000000006
r3363 n2275 n2276 0.11458333333333333
r3364 n2276 n2277 0.13541666666666666
r3365 n2277 n2278 0.09375
r3366 n2278 n2279 0.083333333333333329
r3367 n2279 n2280 0.03125
r3368 n2280 n2281 0.020833333333333332
r3369 n2281 n2282 0.072916666666666671
r3370 n2282 n2283 0.11458333333333333
r3371 n2283 n2284 0.0625
r3372 n2254 n2285 0.083333333333333329
r3373 n2255 n2286 0.10000000000000001
r3374 n2285 n2286 0.34375
r3375 n2256 n2287 0.5
r3376 n2286 n2287 0.1875
r3377 n2257 n2288 0.038461538461538464
r3378 n2287 n2288 0.4375
r3379 n2258 n2289 0.050000000000000003
r3380 n2288 n2289 0.71875
r3381 n2259 n2290 0.10000000000000001
r3382 n2289 n2290 0.46875
r3383 n2260 n2291 0.10000000000000001
r3384 n2290 n2291 0.3125
r3385 n2261 n2292 0.5
r3386 n2291 n2292 0.1875
r3387 n2262 n2293 0.16666666666666666
r3388 n2292 n2293 0.125
r3389 n2263 n2294 0.5
r3390 n2293 n2294 0.125
r3391 n2264 n2295 0.055555555555555552
r3392 n2294 n2295 0.3125
r3393 n2265 n2296 0.050000000000000003
r3394 n2295 n2296 0.59375
r3395 n2266 n2297 0.10000000000000001
r3396 n2296 n2297 0.46875
r3397 n2267 n2298 0.10000000000000001
r3398 n2297 n2298 0.3125
r3399 n2268 n2299 0.5
r3400 n2298 n2299 0.1875
r3401 n2269 n2300 0.25
r3402 n2299 n2300 0.09375
r3403 n2270 n2301 0.5
r3404 n2300 n2301 0.09375
r3405 n2271 n2302 0.5
r3406 n2301 n2302 0.0625
r3407 n2272 n2303 0.5
r3408 n2302 n2303 0.0625
r3409 n2273 n2304 0.125
r3410 n2303 n2304 0.15625
r3411 n2274 n2305 0.10000000000000001
r3412 n2304 n2305 0.28125
r3413 n2275 n2306 0.5
r3414 n2305 n2306 0.1875
r3415 n2276 n2307 0.050000000000000003
r3416 n2306 n2307 0.34375
r3417 n2277 n2308 0.16666666666666666
r3418 n2307 n2308 0.40625
r3419 n2278 n2309 0.083333333333333329
r3420 n2308 n2309 0.28125
r3421 n2279 n2310 0.25
r3422 n2309 n2310 0.25
r3423 n2280 n2311 0.5
r3424 n2310 n2311 0.09375
r3425 n2281 n2312 0.5
r3426 n2311 n2312 0.0625
r3427 n2282 n2313 0.083333333333333329
r3428 n2312 n2313 0.21875
r3429 n2283 n2314 0.10000000000000001
r3430 n2313 n2314 0.34375
r3431 n2284 n2315 0.5
r3432 n2314 n2315 0.1875
r3433 n2285 n2316 0.1875
r3434 n2286 n2317 0.22500000000000001
r3435 n2316 n2317 0.04296875
r3436 n2287 n2318 1.125
r3437 n2317 n2318 0.0234375
r3438 n2288 n2319 0.086538461538461536
r3439 n2318 n2319 0.0546875
r3440 n2289 n2320 0.1125
r3441 n2319 n2320 0.08984375
r3442 n2290 n2321 0.22500000000000001
r3443 n2320 n2321 0.05859375
r3444 n2291 n2322 0.22500000000000001
r3445 n2321 n2322 0.0390625
r3446 n2292 n2323 1.125
r3447 n2322 n2323 0.0234375
r3448 n2293 n2324 0.375
r3449 n2323 n2324 0.015625
r3450 n2294 n2325 1.125
r3451 n2324 n2325 0.015625
r3452 n2295 n2326 0.125
r3453 n2325 n2326 0.0390625
r3454 n2296 n2327 0.1125
r3455 n2326 n2327 0.07421875
r3456 n2297 n2328 0.22500000000000001
r3457 n2327 n2328 0.05859375
r3458 n2298 n2329 0.22500000000000001
r3459 n2328 n2329 0.0390625
r3460 n2299 n2330 1.125
r3461 n2329 n2330 0.0234375
r3462 n2300 n2331 0.5625
r3463 n2330 n2331 0.01171875
r3464 n2301 n2332 1.125
r3465 n2331 n2332 0.01171875
r3466 n2302 n2333 1.125
r3467 n2332 n2333 0.0078125
r3468 n2303 n2334 1.125
r3469 n2333 n2334 0.0078125
r3470 n2304 n2335 0.28125
r3471 n2334 n2335 0.01953125
r3472 n2305 n2336 0.22500000000000001
r3473 n2335 n2336 0.03515625
r3474 n2306 n2337 1.125
r3475 n2336 n2337 0.0234375
r3476 n2307 n2338 0.1125
r3477 n2337 n2338 0.04296875
r3478 n2308 n2339 0.375
r3479 n2338 n2339 0.05078125
r3480 n2309 n2340 0.1875
r3481 n2339 n2340 0.03515625
r3482 n2310 n2341 0.5625
r3483 n2340 n2341 0.03125
r3484 n2311 n2342 1.125
r3485 n2341 n2342 0.01171875
r3486 n2312 n2343 1.125
r3487 n2342 n2343 0.0078125
r3488 n2313 n2344 0.1875
r3489 n2343 n2344 0.02734375
r3490 n2314 n2345 0.22500000000000001
r3491 n2344 n2345 0.04296875
r3492 n2315 n2346 1.125
r3493 n2345 n2346 0.0234375
r3494 n2316 n2347 0.3125
r3495 n2317 n2348 0.375
r3496 n2347 n2348 0.049107142857142856
r3497 n2318 n2349 1.875
r3498 n2348 n2349 0.026785714285714284
r3499 n2319 n2350 0.14423076923076922
r3500 n2349 n2350 0.0625
r3501 n2320 n2351 0.1875
r3502 n2350 n2351 0.10267857142857142
r3503 n2321 n2352 0.375
r3504 n2351 n2352 0.066964285714285712
r3505 n2322 n2353 0.375
r3506 n2352 n2353 0.044642857142857144
r3507 n2323 n2354 1.875
r3508 n2353 n2354 0.026785714285714284
r3509 n2324 n2355 0.625
r3510 n2354 n2355 0.017857142857142856
r3511 n2325 n2356 1.875
r3512 n2355 n2356 0.017857142857142856
r3513 n2326 n2357 0.20833333333333334
r3514 n2356 n2357 0.044642857142857144
r3515 n2327 n2358 0.1875
r3516 n2357 n2358 0.084821428571428575
r3517 n2328 n2359 0.375
r3518 n2358 n2359 0.066964285714285712
r3519 n2329 n2360 0.375
r3520 n2359 n2360 0.044642857142857144
r3521 n2330 n2361 1.875
r3522 n2360 n2361 0.026785714285714284
r3523 n2331 n2362 0.9375
r3524 n2361 n2362 0.013392857142857142
r3525 n2332 n2363 1.875
r3526 n2362 n2363 0.013392857142857142
r3527 n2333 n2364 1.875
r3528 n2363 n2364 0.0089285714285714281
r3529 n2334 n2365 1.875
r3530 n2364 n2365 0.0089285714285714281
r3531 n2335 n2366 0.46875
r3532 n2365 n2366 0.022321428571428572
r3533 n2336 n2367 0.375
r3534 n2366 n2367 0.040178571428571432
r3535 n2337 n2368 1.875
r3536 n2367 n2368 0.026785714285714284
r3537 n2338 n2369 0.1875
r3538 n2368 n2369 0.049107142857142856
r3539 n2339 n2370 0.625
r3540 n2369 n2370 0.058035714285714288
r3541 n2340 n2371 0.3125
r3542 n2370 n2371 0.040178571428571432
r3543 n2341 n2372 0.9375
r3544 n2371 n2372 0.035714285714285712
r3545 n2342 n2373 1.875
r3546 n2372 n2373 0.013392857142857142
r3547 n2343 n2374 1.875
r3548 n2373 n2374 0.0089285714285714281
r3549 n2344 n2375 0.3125
r3550 n2374 n2375 0.03125
r3551 n2345 n2376 0.375
r3552 n2375 n2376 0.049107142857142856
r3553 n2346 n2377 1.875
r3554 n2376 n2377 0.026785714285714284
r3555 n2347 n2378 0.16666666666666666
r3556 n2348 n2379 0.20000000000000001
r3557 n2378 n2379 0.34375
r3558 n2349 n2380 1
r3559 n2379 n2380 0.1875
r3560 n2350 n2381 0.076923076923076927
r3561 n2380 n2381 0.4375
r3562 n2351 n2382 0.10000000000000001
r3563 n2381 n2382 0.71875
r3564 n2352 n2383 0.20000000000000001
r3565 n2382 n2383 0.46875
r3566 n2353 n2384 0.20000000000000001
r3567 n2383 n2384 0.3125
r3568 n2354 n2385 1
r3569 n2384 n2385 0.1875
r3570 n2355 n2386 0.33333333333333331
r3571 n2385 n2386 0.125
r3572 n2356 n2387 1
r3573 n2386 n2387 0.125
r3574 n2357 n2388 0.1111111111111111
r3575 n2387 n2388 0.3125
r3576 n2358 n2389 0.10000000000000001
r3577 n2388 n2389 0.59375
r3578 n2359 n2390 0.20000000000000001
r3579 n2389 n2390 0.46875
r3580 n2360 n2391 0.20000000000000001
r3581 n2390 n2391 0.3125
r3582 n2361 n2392 1
r3583 n2391 n2392 0.1875
r3584 n2362 n2393 0.5
r3585 n2392 n2393 0.09375
r3586 n2363 n2394 1
r3587 n2393 n2394 0.09375
r3588 n2364 n2395 1
r3589 n2394 n2395 0.0625
r3590 n2365 n2396 1
r3591 n2395 n2396 0.0625
r3592 n2366 n2397 0.25
r3593 n2396 n2397 0.15625
r3594 n2367 n2398 0.20000000000000001
r3595 n2397 n2398 0.28125
r3596 n2368 n2399 1
r3597 n2398 n2399 0.1875
r3598 n2369 n2400 0.10000000000000001
r3599 n2399 n2400 0.34375
r3600 n2370 n2401 0.33333333333333331
r3601 n2400 n2401 0.40625
r3602 n2371 n2402 0.16666666666666666
r3603 n2401 n2402 0.28125
r3604 n2372 n2403 0.5
r3605 n2402 n2403 0.25
r3606 n2373 n2404 1
r3607 n2403 n2404 0.09375
r3608 n2374 n2405 1
r3609 n2404 n2405 0.0625
r3610 n2375 n2406 0.16666666666666666
r3611 n2405 n2406 0.21875
r3612 n2376 n2407 0.20000000000000001
r3613 n2406 n2407 0.34375
r3614 n2377 n2408 1
r3615 n2407 n2408 0.1875
r3616 n2378 n2409 0.0625
r3617 n2379 n2410 0.074999999999999997
r3618 n2409 n2410 0.171875
r3619 n2380 n2411 0.375
r3620 n2410 n2411 0.09375
r3621 n2381 n2412 0.028846153846153848
r3622 n2411 n2412 0.21875
r3623 n2382 n2413 0.037499999999999999
r3624 n2412 n2413 0.359375
r3625 n2383 n2414 0.074999999999999997
r3626 n2413 n2414 0.234375
r3627 n2384 n2415 0.074999999999999997
r3628 n2414 n2415 0.15625
r3629 n2385 n2416 0.375
r3630 n2415 n2416 0.09375
r3631 n2386 n2417 0.125
r3632 n2416 n2417 0.0625
r3633 n2387 n2418 0.375
r3634 n2417 n2418 0.0625
r3635 n2388 n2419 0.041666666666666664
r3636 n2418 n2419 0.15625
r3637 n2389 n2420 0.037499999999999999
r3638 n2419 n2420 0.296875
r3639 n2390 n2421 0.074999999999999997
r3640 n2420 n2421 0.234375
r3641 n2391 n2422 0.074999999999999997
r3642 n2421 n2422 0.15625
r3643 n2392 n2423 0.375
r3644 n2422 n2423 0.09375
r3645 n2393 n2424 0.1875
r3646 n2423 n2424 0.046875
r3647 n2394 n2425 0.375
r3648 n2424 n2425 0.046875
r3649 n2395 n2426 0.375
r3650 n2425 n2426 0.03125
r3651 n2396 n2427 0.375
r3652 n2426 n2427 0.03125
r3653 n2397 n2428 0.09375
r3654 n2427 n2428 0.078125
r3655 n2398 n2429 0.074999999999999997
r3656 n2428 n2429 0.140625
r3657 n2399 n2430 0.375
r3658 n2429 n2430 0.09375
r3659 n2400 n2431 0.037499999999999999
r3660 n2430 n2431 0.171875
r3661 n2401 n2432 0.125
r3662 n2431 n2432 0.203125
r3663 n2402 n2433 0.0625
r3664 n2432 n2433 0.140625
r3665 n2403 n2434 0.1875
r3666 n2433 n2434 0.125
r3667 n2404 n2435 0.375
r3668 n2434 n2435 0.046875
r3669 n2405 n2436 0.375
r3670 n2435 n2436 0.03125
r3671 n2406 n2437 0.0625
r3672 n2436 n2437 0.109375
r3673 n2407 n2438 0.074999999999999997
r3674 n2437 n2438 0.171875
r3675 n2408 n2439 0.375
r3676 n2438 n2439 0.09375
r3677 n2440 n2441 0.125
r3678 n2441 n2442 0.296875
r3679 n2442 n2443 0.46875
r3680 n2443 n2444 0.234375
r3681 n2444 n2445 0.0625
r3682 n2445 n2446 0.09375
r3683 n2409 n2447 0.0625
r3684 n2410 n2448 0.074999999999999997
r3685 n2447 n2448 0.34375
r3686 n2411 n2449 0.375
r3687 n2448 n2449 0.1875
r3688 n2412 n2450 0.028846153846153848
r3689 n2449 n2450 0.4375
r3690 n2413 n2451 0.037499999999999999
r3691 n2450 n2451 0.71875
r3692 n2414 n2452 0.074999999999999997
r3693 n2451 n2452 0.46875
r3694 n2415 n2453 0.074999999999999997
r3695 n2452 n2453 0.3125
r3696 n2416 n2454 0.375
r3697 n2453 n2454 0.1875
r3698 n2417 n2455 0.125
r3699 n2454 n2455 0.125
r3700 n2418 n2456 0.375
r3701 n2455 n2456 0.125
r3702 n2419 n2457 0.041666666666666664
r3703 n2456 n2457 0.3125
r3704 n2420 n2458 0.037499999999999999
r3705 n2457 n2458 0.59375
r3706 n2421 n2459 0.074999999999999997
r3707 n2458 n2459 0.46875
r3708 n2422 n2460 0.074999999999999997
r3709 n2459 n2460 0.3125
r3710 n2423 n2461 0.375
r3711 n2460 n2461 0.1875
r3712 n2424 n2462 0.1875
r3713 n2461 n2462 0.09375
r3714 n2425 n2463 0.375
r3715 n2462 n2463 0.09375
r3716 n2426 n2464 0.375
r3717 n2463 n2464 0.0625
r3718 n2427 n2465 0.375
r3719 n2464 n2465 0.0625
r3720 n2428 n2466 0.09375
r3721 n2465 n2466 0.15625
r3722 n2429 n2467 0.074999999999999997
r3723 n2466 n2467 0.28125
r3724 n2430 n2468 0.375
r3725 n2467 n2468 0.1875
r3726 n2431 n2469 0.037499999999999999
r3727 n2468 n2469 0.34375
r3728 n2432 n2470 0.125
r3729 n2469 n2470 0.40625
r3730 n2433 n2471 0.0625
r3731 n2470 n2471 0.28125
r3732 n2434 n2472 0.1875
r3733 n2471 n2472 0.25
r3734 n2435 n2473 0.375
r3735 n2472 n2473 0.09375
r3736 n2436 n2474 0.375
r3737 n2473 n2474 0.0625
r3738 n2437 n2475 0.0625
r3739 n2474 n2475 0.21875
r3740 n2438 n2476 0.074999999999999997
r3741 n2475 n2476 0.34375
r3742 n2439 n2477 0.375
r3743 n2476 n2477 0.1875
r3744 n2440 n2478 0.0625
r3745 n2441 n2479 0.1875
r3746 n2478 n2479 0.25
r3747 n2442 n2480 0.022058823529411766
r3748 n2479 n2480 0.59375
r3749 n2443 n2481 0.028846153846153848
r3750 n2480 n2481 0.9375
r3751 n2444 n2482 0.1875
r3752 n2481 n2482 0.46875
r3753 n2445 n2483 0.1875
r3754 n2482 n2483 0.125
r3755 n2446 n2484 0.09375
r3756 n2483 n2484 0.1875
r3757 n2451 n2485 0.018749999999999999
r3758 n2452 n2486 0.037499999999999999
r3759 n2485 n2486 0.9375
r3760 n2453 n2487 0.037499999999999999
r3761 n2486 n2487 0.625
r3762 n2454 n2488 0.1875
r3763 n2487 n2488 0.375
r3764 n2455 n2489 0.0625
r3765 n2488 n2489 0.25
r3766 n2456 n2490 0.1875
r3767 n2489 n2490 0.25
r3768 n2457 n2491 0.020833333333333332
r3769 n2490 n2491 0.625
r3770 n2458 n2492 0.018749999999999999
r3771 n2491 n2492 1.1875
r3772 n2459 n2493 0.037499999999999999
r3773 n2492 n2493 0.9375
r3774 n2460 n2494 0.037499999999999999
r3775 n2493 n2494 0.625
r3776 n2461 n2495 0.1875
r3777 n2494 n2495 0.375
r3778 n2462 n2496 0.09375
r3779 n2495 n2496 0.1875
r3780 n2463 n2497 0.1875
r3781 n2496 n2497 0.1875
r3782 n2464 n2498 0.1875
r3783 n2497 n2498 0.125
r3784 n2465 n2499 0.1875
r3785 n2498 n2499 0.125
r3786 n2466 n2500 0.046875
r3787 n2499 n2500 0.3125
r3788 n2467 n2501 0.037499999999999999
r3789 n2500 n2501 0.5625
r3790 n2468 n2502 0.1875
r3791 n2501 n2502 0.375
r3792 n2469 n2503 0.018749999999999999
r3793 n2502 n2503 0.6875
r3794 n2478 n2504 0.03125
r3795 n2479 n2505 0.09375
r3796 n2504 n2505 0.5
r3797 n2480 n2506 0.011029411764705883
r3798 n2505 n2506 1.1875
r3799 n2481 n2507 0.014423076923076924
r3800 n2506 n2507 1.875
r3801 n2482 n2508 0.09375
r3802 n2507 n2508 0.9375
r3803 n2483 n2509 0.09375
r3804 n2508 n2509 0.25
r3805 n2484 n2510 0.046875
r3806 n2509 n2510 0.375
r3807 n2485 n2511 0.03125
r3808 n2486 n2512 0.0625
r3809 n2511 n2512 0.234375
r3810 n2487 n2513 0.0625
r3811 n2512 n2513 0.15625
r3812 n2488 n2514 0.3125
r3813 n2513 n2514 0.09375
r3814 n2489 n2515 0.10416666666666667
r3815 n2514 n2515 0.0625
r3816 n2490 n2516 0.3125
r3817 n2515 n2516 0.0625
r3818 n2491 n2517 0.034722222222222224
r3819 n2516 n2517 0.15625
r3820 n2492 n2518 0.03125
r3821 n2517 n2518 0.296875
r3822 n2493 n2519 0.0625
r3823 n2518 n2519 0.234375
r3824 n2494 n2520 0.0625
r3825 n2519 n2520 0.15625
r3826 n2495 n2521 0.3125
r3827 n2520 n2521 0.09375
r3828 n2496 n2522 0.15625
r3829 n2521 n2522 0.046875
r3830 n2497 n2523 0.3125
r3831 n2522 n2523 0.046875
r3832 n2498 n2524 0.3125
r3833 n2523 n2524 0.03125
r3834 n2499 n2525 0.3125
r3835 n2524 n2525 0.03125
r3836 n2500 n2526 0.078125
r3837 n2525 n2526 0.078125
r3838 n2501 n2527 0.0625
r3839 n2526 n2527 0.140625
r3840 n2502 n2528 0.3125
r3841 n2527 n2528 0.09375
r3842 n2503 n2529 0.03125
r3843 n2528 n2529 0.171875
r3844 n2530 n2531 0.1875
r3845 n2531 n2532 0.203125
r3846 n2504 n2533 0.052083333333333336
r3847 n2532 n2533 0.171875
r3848 n2505 n2534 0.15625
r3849 n2533 n2534 0.125
r3850 n2506 n2535 0.018382352941176471
r3851 n2534 n2535 0.296875
r3852 n2507 n2536 0.02403846153846154
r3853 n2535 n2536 0.46875
r3854 n2508 n2537 0.15625
r3855 n2536 n2537 0.234375
r3856 n2509 n2538 0.15625
r3857 n2537 n2538 0.0625
r3858 n2510 n2539 0.078125
r3859 n2538 n2539 0.09375
r3860 n2539 n2540 0.140625
r3861 n2540 n2541 0.203125
r3862 n2541 n2542 0.1875
r3863 n2511 n2543 0.037499999999999999
r3864 n2512 n2544 0.074999999999999997
r3865 n2543 n2544 0.46875
r3866 n2513 n2545 0.074999999999999997
r3867 n2544 n2545 0.3125
r3868 n2514 n2546 0.375
r3869 n2545 n2546 0.1875
r3870 n2515 n2547 0.125
r3871 n2546 n2547 0.125
r3872 n2516 n2548 0.375
r3873 n2547 n2548 0.125
r3874 n2517 n2549 0.041666666666666664
r3875 n2548 n2549 0.3125
r3876 n2518 n2550 0.037499999999999999
r3877 n2549 n2550 0.59375
r3878 n2519 n2551 0.074999999999999997
r3879 n2550 n2551 0.46875
r3880 n2520 n2552 0.074999999999999997
r3881 n2551 n2552 0.3125
r3882 n2521 n2553 0.375
r3883 n2552 n2553 0.1875
r3884 n2522 n2554 0.1875
r3885 n2553 n2554 0.09375
r3886 n2523 n2555 0.375
r3887 n2554 n2555 0.09375
r3888 n2524 n2556 0.375
r3889 n2555 n2556 0.0625
r3890 n2525 n2557 0.375
r3891 n2556 n2557 0.0625
r3892 n2526 n2558 0.09375
r3893 n2557 n2558 0.15625
r3894 n2527 n2559 0.074999999999999997
r3895 n2558 n2559 0.28125
r3896 n2528 n2560 0.375
r3897 n2559 n2560 0.1875
r3898 n2529 n2561 0.037499999999999999
r3899 n2560 n2561 0.34375
r3900 n2530 n2562 0.09375
r3901 n2531 n2563 0.046875
r3902 n2562 n2563 0.375
r3903 n2532 n2564 0.074999999999999997
r3904 n2563 n2564 0.40625
r3905 n2533 n2565 0.0625
r3906 n2564 n2565 0.34375
r3907 n2534 n2566 0.1875
r3908 n2565 n2566 0.25
r3909 n2535 n2567 0.022058823529411766
r3910 n2566 n2567 0.59375
r3911 n2536 n2568 0.028846153846153848
r3912 n2567 n2568 0.9375
r3913 n2537 n2569 0.1875
r3914 n2568 n2569 0.46875
r3915 n2538 n2570 0.1875
r3916 n2569 n2570 0.125
r3917 n2539 n2571 0.09375
r3918 n2570 n2571 0.1875
r3919 n2540 n2572 0.074999999999999997
r3920 n2571 n2572 0.28125
r3921 n2541 n2573 0.046875
r3922 n2572 n2573 0.40625
r3923 n2542 n2574 0.09375
r3924 n2573 n2574 0.375
r3925 n2562 n2575 0.109375
r3926 n2563 n2576 0.0546875
r3927 n2575 n2576 0.14999999999999999
r3928 n2564 n2577 0.087499999999999994
r3929 n2576 n2577 0.16250000000000001
r3930 n2565 n2578 0.072916666666666671
r3931 n2577 n2578 0.13750000000000001
r3932 n2566 n2579 0.21875
r3933 n2578 n2579 0.10000000000000001
r3934 n2567 n2580 0.025735294117647058
r3935 n2579 n2580 0.23749999999999999
r3936 n2568 n2581 0.033653846153846152
r3937 n2580 n2581 0.375
r3938 n2569 n2582 0.21875
r3939 n2581 n2582 0.1875
r3940 n2570 n2583 0.21875
r3941 n2582 n2583 0.050000000000000003
r3942 n2571 n2584 0.109375
r3943 n2583 n2584 0.074999999999999997
r3944 n2572 n2585 0.087499999999999994
r3945 n2584 n2585 0.1125
r3946 n2573 n2586 0.0546875
r3947 n2585 n2586 0.16250000000000001
r3948 n2574 n2587 0.109375
r3949 n2586 n2587 0.14999999999999999
r3950 n2575 n2588 0.109375
r3951 n2576 n2589 0.0546875
r3952 n2588 n2589 0.375
r3953 n2577 n2590 0.087499999999999994
r3954 n2589 n2590 0.40625
r3955 n2578 n2591 0.072916666666666671
r3956 n2590 n2591 0.34375
r3957 n2579 n2592 0.21875
r3958 n2591 n2592 0.25
r3959 n2580 n2593 0.025735294117647058
r3960 n2592 n2593 0.59375
r3961 n2581 n2594 0.033653846153846152
r3962 n2593 n2594 0.9375
r3963 n2582 n2595 0.21875
r3964 n2594 n2595 0.46875
r3965 n2583 n2596 0.21875
r3966 n2595 n2596 0.125
r3967 n2584 n2597 0.109375
r3968 n2596 n2597 0.1875
r3969 n2585 n2598 0.087499999999999994
r3970 n2597 n2598 0.28125
r3971 n2586 n2599 0.0546875
r3972 n2598 n2599 0.40625
r3973 n2587 n2600 0.109375
r3974 n2599 n2600 0.375
r3975 n2588 n2601 0.0625
r3976 n2589 n2602 0.03125
r3977 n2601 n2602 0.375
r3978 n2590 n2603 0.050000000000000003
r3979 n2602 n2603 0.40625
r3980 n2591 n2604 0.041666666666666664
r3981 n2603 n2604 0.34375
r3982 n2592 n2605 0.125
r3983 n2604 n2605 0.25
r3984 n2593 n2606 0.014705882352941176
r3985 n2605 n2606 0.59375
r3986 n2594 n2607 0.019230769230769232
r3987 n2606 n2607 0.9375
r3988 n2595 n2608 0.125
r3989 n2607 n2608 0.46875
r3990 n2596 n2609 0.125
r3991 n2608 n2609 0.125
r3992 n2597 n2610 0.0625
r3993 n2609 n2610 0.1875
r3994 n2598 n2611 0.050000000000000003
r3995 n2610 n2611 0.28125
r3996 n2599 n2612 0.03125
r3997 n2611 n2612 0.40625
r3998 n2600 n2613 0.0625
r3999 n2612 n2613 0.375
r4000 n2601 n2614 0.46875
r4001 n2602 n2615 0.234375
r4002 n2614 n2615 0.026785714285714284
r4003 n2603 n2616 0.375
r4004 n2615 n2616 0.029017857142857144
r4005 n2604 n2617 0.3125
r4006 n2616 n2617 0.024553571428571428
r4007 n2605 n2618 0.9375
r4008 n2617 n2618 0.017857142857142856
r4009 n2606 n2619 0.11029411764705882
r4010 n2618 n2619 0.042410714285714288
r4011 n2607 n2620 0.14423076923076922
r4012 n2619 n2620 0.066964285714285712
r4013 n2608 n2621 0.9375
r4014 n2620 n2621 0.033482142857142856
r4015 n2609 n2622 0.9375
r4016 n2621 n2622 0.0089285714285714281
r4017 n2610 n2623 0.46875
r4018 n2622 n2623 0.013392857142857142
r4019 n2611 n2624 0.375
r4020 n2623 n2624 0.020089285714285716
r4021 n2612 n2625 0.234375
r4022 n2624 n2625 0.029017857142857144
r4023 n2613 n2626 0.46875
r4024 n2625 n2626 0.026785714285714284
r4025 n2614 n2627 0.46875
r4026 n2615 n2628 0.234375
r4027 n2627 n2628 0.375
r4028 n2616 n2629 0.375
r4029 n2628 n2629 0.40625
r4030 n2617 n2630 0.3125
r4031 n2629 n2630 0.34375
r4032 n2618 n2631 0.9375
r4033 n2630 n2631 0.25
r4034 n2619 n2632 0.11029411764705882
r4035 n2631 n2632 0.59375
r4036 n2620 n2633 0.14423076923076922
r4037 n2632 n2633 0.9375
r4038 n2621 n2634 0.9375
r4039 n2633 n2634 0.46875
r4040 n2622 n2635 0.9375
r4041 n2634 n2635 0.125
r4042 n2623 n2636 0.46875
r4043 n2635 n2636 0.1875
r4044 n2624 n2637 0.375
r4045 n2636 n2637 0.28125
r4046 n2625 n2638 0.234375
r4047 n2637 n2638 0.40625
r4048 n2626 n2639 0.46875
r4049 n2638 n2639 0.375
r4050 n2627 n2640 0.0625
r4051 n2628 n2641 0.03125
r4052 n2640 n2641 0.375
r4053 n2629 n2642 0.050000000000000003
r4054 n2641 n2642 0.40625
r4055 n2630 n2643 0.041666666666666664
r4056 n2642 n2643 0.34375
r4057 n2631 n2644 0.125
r4058 n2643 n2644 0.25
r4059 n2632 n2645 0.014705882352941176
r4060 n2644 n2645 0.59375
r4061 n2633 n2646 0.019230769230769232
r4062 n2645 n2646 0.9375
r4063 n2634 n2647 0.125
r4064 n2646 n2647 0.46875
r4065 n2635 n2648 0.125
r4066 n2647 n2648 0.125
r4067 n2636 n2649 0.0625
r4068 n2648 n2649 0.1875
r4069 n2637 n2650 0.050000000000000003
r4070 n2649 n2650 0.28125
r4071 n2638 n2651 0.03125
r4072 n2650 n2651 0.40625
r4073 n2639 n2652 0.0625
r4074 n2651 n2652 0.375
r4075 n2640 n2653 0.0625
r4076 n2641 n2654 0.03125
r4077 n2653 n2654 0.375
r4078 n2642 n2655 0.050000000000000003
r4079 n2654 n2655 0.40625
r4080 n2643 n2656 0.041666666666666664
r4081 n2655 n2656 0.34375
r4082 n2644 n2657 0.125
r4083 n2656 n2657 0.25
r4084 n2645 n2658 0.014705882352941176
r4085 n2657 n2658 0.59375
r4086 n2646 n2659 0.019230769230769232
r4087 n2658 n2659 0.9375
r4088 n2647 n2660 0.125
r4089 n2659 n2660 0.46875
r4090 n2648 n2661 0.125
r4091 n2660 n2661 0.125
r4092 n2649 n2662 0.0625
r4093 n2661 n2662 0.1875
r4094 n2650 n2663 0.050000000000000003
r4095 n2662 n2663 0.28125
r4096 n2651 n2664 0.03125
r4097 n2663 n2664 0.40625
r4098 n2652 n2665 0.0625
r4099 n2664 n2665 0.375
r4100 n2653 n2666 0.09375
r4101 n2654 n2667 0.046875
r4102 n2666 n2667 0.1875
r4103 n2655 n2668 0.074999999999999997
r4104 n2667 n2668 0.203125
r4105 n2656 n2669 0.0625
r4106 n2668 n2669 0.171875
r4107 n2657 n2670 0.1875
r4108 n2669 n2670 0.125
r4109 n2658 n2671 0.022058823529411766
r4110 n2670 n2671 0.296875
r4111 n2659 n2672 0.028846153846153848
r4112 n2671 n2672 0.46875
r4113 n2660 n2673 0.1875
r4114 n2672 n2673 0.234375
r4115 n2661 n2674 0.1875
r4116 n2673 n2674 0.0625
r4117 n2662 n2675 0.09375
r4118 n2674 n2675 0.09375
r4119 n2663 n2676 0.074999999999999997
r4120 n2675 n2676 0.140625
r4121 n2664 n2677 0.046875
r4122 n2676 n2677 0.203125
r4123 n2665 n2678 0.09375
r4124 n2677 n2678 0.1875
r4125 n2679 n2680 0.13392857142857142
r4126 n2680 n2681 0.089285714285714288
r4127 n2681 n2682 0.053571428571428568
r4128 n2682 n2683 0.035714285714285712
r4129 n2683 n2684 0.035714285714285712
r4130 n2684 n2685 0.089285714285714288
r4131 n2685 n2686 0.16964285714285715
r4132 n2686 n2687 0.13392857142857142
r4133 n2687 n2688 0.089285714285714288
r4134 n2688 n2689 0.053571428571428568
r4135 n2689 n2690 0.026785714285714284
r4136 n2690 n2691 0.026785714285714284
r4137 n2691 n2692 0.017857142857142856
r4138 n2692 n2693 0.017857142857142856
r4139 n2693 n2694 0.044642857142857144
r4140 n2694 n2695 0.080357142857142863
r4141 n2695 n2696 0.053571428571428568
r4142 n2696 n2697 0.098214285714285712
r4143 n2666 n2698 0.171875
r4144 n2667 n2699 0.0859375
r4145 n2698 n2699 0.10714285714285714
r4146 n2668 n2700 0.13750000000000001
r4147 n2699 n2700 0.11607142857142858
r4148 n2669 n2701 0.11458333333333333
r4149 n2700 n2701 0.098214285714285712
r4150 n2670 n2702 0.34375
r4151 n2701 n2702 0.071428571428571425
r4152 n2671 n2703 0.040441176470588237
r4153 n2702 n2703 0.16964285714285715
r4154 n2672 n2704 0.052884615384615384
r4155 n2703 n2704 0.26785714285714285
r4156 n2673 n2705 0.34375
r4157 n2704 n2705 0.13392857142857142
r4158 n2674 n2706 0.34375
r4159 n2705 n2706 0.035714285714285712
r4160 n2675 n2707 0.171875
r4161 n2706 n2707 0.053571428571428568
r4162 n2676 n2708 0.13750000000000001
r4163 n2707 n2708 0.080357142857142863
r4164 n2677 n2709 0.0859375
r4165 n2708 n2709 0.11607142857142858
r4166 n2678 n2710 0.171875
r4167 n2709 n2710 0.10714285714285714
r4168 n2711 n2712 0.22916666666666666
r4169 n2712 n2713 0.125
r4170 n2713 n2714 0.29166666666666669
r4171 n2679 n2715 0.0625
r4172 n2714 n2715 0.47916666666666669
r4173 n2680 n2716 0.125
r4174 n2715 n2716 0.3125
r4175 n2681 n2717 0.125
r4176 n2716 n2717 0.20833333333333334
r4177 n2682 n2718 0.625
r4178 n2717 n2718 0.125
r4179 n2683 n2719 0.20833333333333334
r4180 n2718 n2719 0.083333333333333329
r4181 n2684 n2720 0.625
r4182 n2719 n2720 0.083333333333333329
r4183 n2685 n2721 0.069444444444444448
r4184 n2720 n2721 0.20833333333333334
r4185 n2686 n2722 0.0625
r4186 n2721 n2722 0.39583333333333331
r4187 n2687 n2723 0.125
r4188 n2722 n2723 0.3125
r4189 n2688 n2724 0.125
r4190 n2723 n2724 0.20833333333333334
r4191 n2689 n2725 0.625
r4192 n2724 n2725 0.125
r4193 n2690 n2726 0.3125
r4194 n2725 n2726 0.0625
r4195 n2691 n2727 0.625
r4196 n2726 n2727 0.0625
r4197 n2692 n2728 0.625
r4198 n2727 n2728 0.041666666666666664
r4199 n2693 n2729 0.625
r4200 n2728 n2729 0.041666666666666664
r4201 n2694 n2730 0.15625
r4202 n2729 n2730 0.10416666666666667
r4203 n2695 n2731 0.125
r4204 n2730 n2731 0.1875
r4205 n2696 n2732 0.625
r4206 n2731 n2732 0.125
r4207 n2697 n2733 0.0625
r4208 n2732 n2733 0.22916666666666666
r4209 n2733 n2734 0.27083333333333331
r4210 n2734 n2735 0.1875
r4211 n2735 n2736 0.16666666666666666
r4212 n2736 n2737 0.0625
r4213 n2737 n2738 0.041666666666666664
r4214 n2738 n2739 0.14583333333333334
r4215 n2739 n2740 0.22916666666666666
r4216 n2740 n2741 0.125
r4217 n2701 n2742 0.10416666666666667
r4218 n2702 n2743 0.3125
r4219 n2742 n2743 0.16666666666666666
r4220 n2703 n2744 0.036764705882352942
r4221 n2743 n2744 0.39583333333333331
r4222 n2704 n2745 0.04807692307692308
r4223 n2744 n2745 0.625
r4224 n2705 n2746 0.3125
r4225 n2745 n2746 0.3125
r4226 n2706 n2747 0.3125
r4227 n2746 n2747 0.083333333333333329
r4228 n2707 n2748 0.15625
r4229 n2747 n2748 0.125
r4230 n2711 n2749 0.0625
r4231 n2712 n2750 0.074999999999999997
r4232 n2749 n2750 0.22916666666666666
r4233 n2713 n2751 0.375
r4234 n2750 n2751 0.125
r4235 n2714 n2752 0.028846153846153848
r4236 n2751 n2752 0.29166666666666669
r4237 n2715 n2753 0.037499999999999999
r4238 n2752 n2753 0.47916666666666669
r4239 n2716 n2754 0.074999999999999997
r4240 n2753 n2754 0.3125
r4241 n2717 n2755 0.074999999999999997
r4242 n2754 n2755 0.20833333333333334
r4243 n2718 n2756 0.375
r4244 n2755 n2756 0.125
r4245 n2719 n2757 0.125
r4246 n2756 n2757 0.083333333333333329
r4247 n2720 n2758 0.375
r4248 n2757 n2758 0.083333333333333329
r4249 n2721 n2759 0.041666666666666664
r4250 n2758 n2759 0.20833333333333334
r4251 n2722 n2760 0.037499999999999999
r4252 n2759 n2760 0.39583333333333331
r4253 n2723 n2761 0.074999999999999997
r4254 n2760 n2761 0.3125
r4255 n2724 n2762 0.074999999999999997
r4256 n2761 n2762 0.20833333333333334
r4257 n2725 n2763 0.375
r4258 n2762 n2763 0.125
r4259 n2726 n2764 0.1875
r4260 n2763 n2764 0.0625
r4261 n2727 n2765 0.375
r4262 n2764 n2765 0.0625
r4263 n2728 n2766 0.375
r4264 n2765 n2766 0.041666666666666664
r4265 n2729 n2767 0.375
r4266 n2766 n2767 0.041666666666666664
r4267 n2730 n2768 0.09375
r4268 n2767 n2768 0.10416666666666667
r4269 n2731 n2769 0.074999999999999997
r4270 n2768 n2769 0.1875
r4271 n2732 n2770 0.375
r4272 n2769 n2770 0.125
r4273 n2733 n2771 0.037499999999999999
r4274 n2770 n2771 0.22916666666666666
r4275 n2734 n2772 0.125
r4276 n2771 n2772 0.27083333333333331
r4277 n2735 n2773 0.0625
r4278 n2772 n2773 0.1875
r4279 n2736 n2774 0.1875
r4280 n2773 n2774 0.16666666666666666
r4281 n2737 n2775 0.375
r4282 n2774 n2775 0.0625
r4283 n2738 n2776 0.375
r4284 n2775 n2776 0.041666666666666664
r4285 n2739 n2777 0.0625
r4286 n2776 n2777 0.14583333333333334
r4287 n2740 n2778 0.074999999999999997
r4288 n2777 n2778 0.22916666666666666
r4289 n2741 n2779 0.375
r4290 n2778 n2779 0.125
r4291 n2742 n2780 0.0625
r4292 n2743 n2781 0.1875
r4293 n2780 n2781 0.16666666666666666
r4294 n2744 n2782 0.022058823529411766
r4295 n2781 n2782 0.39583333333333331
r4296 n2745 n2783 0.028846153846153848
r4297 n2782 n2783 0.625
r4298 n2746 n2784 0.1875
r4299 n2783 n2784 0.3125
r4300 n2747 n2785 0.1875
r4301 n2784 n2785 0.083333333333333329
r4302 n2748 n2786 0.09375
r4303 n2785 n2786 0.125
r4304 n2749 n2787 0.052083333333333336
r4305 n2750 n2788 0.0625
r4306 n2787 n2788 0.34375
r4307 n2751 n2789 0.3125
r4308 n2788 n2789 0.1875
r4309 n2752 n2790 0.02403846153846154
r4310 n2789 n2790 0.4375
r4311 n2753 n2791 0.03125
r4312 n2790 n2791 0.71875
r4313 n2754 n2792 0.0625
r4314 n2791 n2792 0.46875
r4315 n2755 n2793 0.0625
r4316 n2792 n2793 0.3125
r4317 n2756 n2794 0.3125
r4318 n2793 n2794 0.1875
r4319 n2757 n2795 0.10416666666666667
r4320 n2794 n2795 0.125
r4321 n2758 n2796 0.3125
r4322 n2795 n2796 0.125
r4323 n2759 n2797 0.034722222222222224
r4324 n2796 n2797 0.3125
r4325 n2760 n2798 0.03125
r4326 n2797 n2798 0.59375
r4327 n2761 n2799 0.0625
r4328 n2798 n2799 0.46875
r4329 n2762 n2800 0.0625
r4330 n2799 n2800 0.3125
r4331 n2763 n2801 0.3125
r4332 n2800 n2801 0.1875
r4333 n2764 n2802 0.15625
r4334 n2801 n2802 0.09375
r4335 n2765 n2803 0.3125
r4336 n2802 n2803 0.09375
r4337 n2766 n2804 0.3125
r4338 n2803 n2804 0.0625
r4339 n2767 n2805 0.3125
r4340 n2804 n2805 0.0625
r4341 n2768 n2806 0.078125
r4342 n2805 n2806 0.15625
r4343 n2769 n2807 0.0625
r4344 n2806 n2807 0.28125
r4345 n2770 n2808 0.3125
r4346 n2807 n2808 0.1875
r4347 n2771 n2809 0.03125
r4348 n2808 n2809 0.34375
r4349 n2772 n2810 0.10416666666666667
r4350 n2809 n2810 0.40625
r4351 n2773 n2811 0.052083333333333336
r4352 n2810 n2811 0.28125
r4353 n2774 n2812 0.15625
r4354 n2811 n2812 0.25
r4355 n2775 n2813 0.3125
r4356 n2812 n2813 0.09375
r4357 n2776 n2814 0.3125
r4358 n2813 n2814 0.0625
r4359 n2777 n2815 0.052083333333333336
r4360 n2814 n2815 0.21875
r4361 n2778 n2816 0.0625
r4362 n2815 n2816 0.34375
r4363 n2779 n2817 0.3125
r4364 n2816 n2817 0.1875
r4365 n2787 n2818 0.17708333333333334
r4366 n2788 n2819 0.21249999999999999
r4367 n2818 n2819 0.04583333333333333
r4368 n2789 n2820 1.0625
r4369 n2819 n2820 0.025000000000000001
r4370 n2790 n2821 0.081730769230769232
r4371 n2820 n2821 0.058333333333333334
r4372 n2791 n2822 0.10625
r4373 n2821 n2822 0.09583333333333334
r4374 n2792 n2823 0.21249999999999999
r4375 n2822 n2823 0.0625
r4376 n2793 n2824 0.21249999999999999
r4377 n2823 n2824 0.041666666666666664
r4378 n2794 n2825 1.0625
r4379 n2824 n2825 0.025000000000000001
r4380 n2795 n2826 0.35416666666666669
r4381 n2825 n2826 0.016666666666666666
r4382 n2796 n2827 1.0625
r4383 n2826 n2827 0.016666666666666666
r4384 n2797 n2828 0.11805555555555555
r4385 n2827 n2828 0.041666666666666664
r4386 n2798 n2829 0.10625
r4387 n2828 n2829 0.079166666666666663
r4388 n2799 n2830 0.21249999999999999
r4389 n2829 n2830 0.0625
r4390 n2800 n2831 0.21249999999999999
r4391 n2830 n2831 0.041666666666666664
r4392 n2801 n2832 1.0625
r4393 n2831 n2832 0.025000000000000001
r4394 n2802 n2833 0.53125
r4395 n2832 n2833 0.012500000000000001
r4396 n2803 n2834 1.0625
r4397 n2833 n2834 0.012500000000000001
r4398 n2804 n2835 1.0625
r4399 n2834 n2835 0.0083333333333333332
r4400 n2805 n2836 1.0625
r4401 n2835 n2836 0.0083333333333333332
r4402 n2806 n2837 0.265625
r4403 n2836 n2837 0.020833333333333332
r4404 n2807 n2838 0.21249999999999999
r4405 n2837 n2838 0.037499999999999999
r4406 n2808 n2839 1.0625
r4407 n2838 n2839 0.025000000000000001
r4408 n2809 n2840 0.10625
r4409 n2839 n2840 0.04583333333333333
r4410 n2810 n2841 0.35416666666666669
r4411 n2840 n2841 0.054166666666666669
r4412 n2811 n2842 0.17708333333333334
r4413 n2841 n2842 0.037499999999999999
r4414 n2812 n2843 0.53125
r4415 n2842 n2843 0.033333333333333333
r4416 n2813 n2844 1.0625
r4417 n2843 n2844 0.012500000000000001
r4418 n2814 n2845 1.0625
r4419 n2844 n2845 0.0083333333333333332
r4420 n2815 n2846 0.17708333333333334
r4421 n2845 n2846 0.029166666666666667
r4422 n2816 n2847 0.21249999999999999
r4423 n2846 n2847 0.04583333333333333
r4424 n2817 n2848 1.0625
r4425 n2847 n2848 0.025000000000000001
r4426 n2818 n2849 0.3125
r4427 n2819 n2850 0.375
r4428 n2849 n2850 0.04583333333333333
r4429 n2820 n2851 1.875
r4430 n2850 n2851 0.025000000000000001
r4431 n2821 n2852 0.14423076923076922
r4432 n2851 n2852 0.058333333333333334
r4433 n2822 n2853 0.1875
r4434 n2852 n2853 0.09583333333333334
r4435 n2823 n2854 0.375
r4436 n2853 n2854 0.0625
r4437 n2824 n2855 0.375
r4438 n2854 n2855 0.041666666666666664
r4439 n2825 n2856 1.875
r4440 n2855 n2856 0.025000000000000001
r4441 n2826 n2857 0.625
r4442 n2856 n2857 0.016666666666666666
r4443 n2827 n2858 1.875
r4444 n2857 n2858 0.016666666666666666
r4445 n2828 n2859 0.20833333333333334
r4446 n2858 n2859 0.041666666666666664
r4447 n2829 n2860 0.1875
r4448 n2859 n2860 0.079166666666666663
r4449 n2830 n2861 0.375
r4450 n2860 n2861 0.0625
r4451 n2831 n2862 0.375
r4452 n2861 n2862 0.041666666666666664
r4453 n2832 n2863 1.875
r4454 n2862 n2863 0.025000000000000001
r4455 n2833 n2864 0.9375
r4456 n2863 n2864 0.012500000000000001
r4457 n2834 n2865 1.875
r4458 n2864 n2865 0.012500000000000001
r4459 n2835 n2866 1.875
r4460 n2865 n2866 0.0083333333333333332
r4461 n2836 n2867 1.875
r4462 n2866 n2867 0.0083333333333333332
r4463 n2837 n2868 0.46875
r4464 n2867 n2868 0.020833333333333332
r4465 n2838 n2869 0.375
r4466 n2868 n2869 0.037499999999999999
r4467 n2839 n2870 1.875
r4468 n2869 n2870 0.025000000000000001
r4469 n2840 n2871 0.1875
r4470 n2870 n2871 0.04583333333333333
r4471 n2841 n2872 0.625
r4472 n2871 n2872 0.054166666666666669
r4473 n2842 n2873 0.3125
r4474 n2872 n2873 0.037499999999999999
r4475 n2843 n2874 0.9375
r4476 n2873 n2874 0.033333333333333333
r4477 n2844 n2875 1.875
r4478 n2874 n2875 0.012500000000000001
r4479 n2845 n2876 1.875
r4480 n2875 n2876 0.0083333333333333332
r4481 n2846 n2877 0.3125
r4482 n2876 n2877 0.029166666666666667
r4483 n2847 n2878 0.375
r4484 n2877 n2878 0.04583333333333333
r4485 n2848 n2879 1.875
r4486 n2878 n2879 0.025000000000000001
r4487 n2849 n2880 0.17708333333333334
r4488 n2850 n2881 0.21249999999999999
r4489 n2880 n2881 0.34375
r4490 n2851 n2882 1.0625
r4491 n2881 n2882 0.1875
r4492 n2852 n2883 0.081730769230769232
r4493 n2882 n2883 0.4375
r4494 n2853 n2884 0.10625
r4495 n2883 n2884 0.71875
r4496 n2854 n2885 0.21249999999999999
r4497 n2884 n2885 0.46875
r4498 n2855 n2886 0.21249999999999999
r4499 n2885 n2886 0.3125
r4500 n2856 n2887 1.0625
r4501 n2886 n2887 0.1875
r4502 n2857 n2888 0.35416666666666669
r4503 n2887 n2888 0.125
r4504 n2858 n2889 1.0625
r4505 n2888 n2889 0.125
r4506 n2859 n2890 0.11805555555555555
r4507 n2889 n2890 0.3125
r4508 n2860 n2891 0.10625
r4509 n2890 n2891 0.59375
r4510 n2861 n2892 0.21249999999999999
r4511 n2891 n2892 0.46875
r4512 n2862 n2893 0.21249999999999999
r4513 n2892 n2893 0.3125
r4514 n2863 n2894 1.0625
r4515 n2893 n2894 0.1875
r4516 n2864 n2895 0.53125
r4517 n2894 n2895 0.09375
r4518 n2865 n2896 1.0625
r4519 n2895 n2896 0.09375
r4520 n2866 n2897 1.0625
r4521 n2896 n2897 0.0625
r4522 n2867 n2898 1.0625
r4523 n2897 n2898 0.0625
r4524 n2868 n2899 0.265625
r4525 n2898 n2899 0.15625
r4526 n2869 n2900 0.21249999999999999
r4527 n2899 n2900 0.28125
r4528 n2870 n2901 1.0625
r4529 n2900 n2901 0.1875
r4530 n2871 n2902 0.10625
r4531 n2901 n2902 0.34375
r4532 n2872 n2903 0.35416666666666669
r4533 n2902 n2903 0.40625
r4534 n2873 n2904 0.17708333333333334
r4535 n2903 n2904 0.28125
r4536 n2874 n2905 0.53125
r4537 n2904 n2905 0.25
r4538 n2875 n2906 1.0625
r4539 n2905 n2906 0.09375
r4540 n2876 n2907 1.0625
r4541 n2906 n2907 0.0625
r4542 n2877 n2908 0.17708333333333334
r4543 n2907 n2908 0.21875
r4544 n2878 n2909 0.21249999999999999
r4545 n2908 n2909 0.34375
r4546 n2879 n2910 1.0625
r4547 n2909 n2910 0.1875
r4548 n2880 n2911 0.052083333333333336
r4549 n2881 n2912 0.0625
r4550 n2911 n2912 0.22916666666666666
r4551 n2882 n2913 0.3125
r4552 n2912 n2913 0.125
r4553 n2883 n2914 0.02403846153846154
r4554 n2913 n2914 0.29166666666666669
r4555 n2884 n2915 0.03125
r4556 n2914 n2915 0.47916666666666669
r4557 n2885 n2916 0.0625
r4558 n2915 n2916 0.3125
r4559 n2886 n2917 0.0625
r4560 n2916 n2917 0.20833333333333334
r4561 n2887 n2918 0.3125
r4562 n2917 n2918 0.125
r4563 n2888 n2919 0.10416666666666667
r4564 n2918 n2919 0.083333333333333329
r4565 n2889 n2920 0.3125
r4566 n2919 n2920 0.083333333333333329
r4567 n2890 n2921 0.034722222222222224
r4568 n2920 n2921 0.20833333333333334
r4569 n2891 n2922 0.03125
r4570 n2921 n2922 0.39583333333333331
r4571 n2892 n2923 0.0625
r4572 n2922 n2923 0.3125
r4573 n2893 n2924 0.0625
r4574 n2923 n2924 0.20833333333333334
r4575 n2894 n2925 0.3125
r4576 n2924 n2925 0.125
r4577 n2895 n2926 0.15625
r4578 n2925 n2926 0.0625
r4579 n2896 n2927 0.3125
r4580 n2926 n2927 0.0625
r4581 n2897 n2928 0.3125
r4582 n2927 n2928 0.041666666666666664
r4583 n2898 n2929 0.3125
r4584 n2928 n2929 0.041666666666666664
r4585 n2899 n2930 0.078125
r4586 n2929 n2930 0.10416666666666667
r4587 n2900 n2931 0.0625
r4588 n2930 n2931 0.1875
r4589 n2901 n2932 0.3125
r4590 n2931 n2932 0.125
r4591 n2902 n2933 0.03125
r4592 n2932 n2933 0.22916666666666666
r4593 n2903 n2934 0.10416666666666667
r4594 n2933 n2934 0.27083333333333331
r4595 n2904 n2935 0.052083333333333336
r4596 n2934 n2935 0.1875
r4597 n2905 n2936 0.15625
r4598 n2935 n2936 0.16666666666666666
r4599 n2906 n2937 0.3125
r4600 n2936 n2937 0.0625
r4601 n2907 n2938 0.3125
r4602 n2937 n2938 0.041666666666666664
r4603 n2908 n2939 0.052083333333333336
r4604 n2938 n2939 0.14583333333333334
r4605 n2909 n2940 0.0625
r4606 n2939 n2940 0.22916666666666666
r4607 n2910 n2941 0.3125
r4608 n2940 n2941 0.125
r4609 n2911 n2942 0.0625
r4610 n2912 n2943 0.074999999999999997
r4611 n2942 n2943 0.22916666666666666
r4612 n2913 n2944 0.375
r4613 n2943 n2944 0.125
r4614 n2914 n2945 0.028846153846153848
r4615 n2944 n2945 0.29166666666666669
r4616 n2915 n2946 0.037499999999999999
r4617 n2945 n2946 0.47916666666666669
r4618 n2916 n2947 0.074999999999999997
r4619 n2946 n2947 0.3125
r4620 n2917 n2948 0.074999999999999997
r4621 n2947 n2948 0.20833333333333334
r4622 n2918 n2949 0.375
r4623 n2948 n2949 0.125
r4624 n2919 n2950 0.125
r4625 n2949 n2950 0.083333333333333329
r4626 n2920 n2951 0.375
r4627 n2950 n2951 0.083333333333333329
r4628 n2921 n2952 0.041666666666666664
r4629 n2951 n2952 0.20833333333333334
r4630 n2922 n2953 0.037499999999999999
r4631 n2952 n2953 0.39583333333333331
r4632 n2923 n2954 0.074999999999999997
r4633 n2953 n2954 0.3125
r4634 n2924 n2955 0.074999999999999997
r4635 n2954 n2955 0.20833333333333334
r4636 n2925 n2956 0.375
r4637 n2955 n2956 0.125
r4638 n2926 n2957 0.1875
r4639 n2956 n2957 0.0625
r4640 n2927 n2958 0.375
r4641 n2957 n2958 0.0625
r4642 n2928 n2959 0.375
r4643 n2958 n2959 0.041666666666666664
r4644 n2929 n2960 0.375
r4645 n2959 n2960 0.041666666666666664
r4646 n2930 n2961 0.09375
r4647 n2960 n2961 0.10416666666666667
r4648 n2931 n2962 0.074999999999999997
r4649 n2961 n2962 0.1875
r4650 n2932 n2963 0.375
r4651 n2962 n2963 0.125
r4652 n2933 n2964 0.037499999999999999
r4653 n2963 n2964 0.22916666666666666
r4654 n2934 n2965 0.125
r4655 n2964 n2965 0.27083333333333331
r4656 n2935 n2966 0.0625
r4657 n2965 n2966 0.1875
r4658 n2936 n2967 0.1875
r4659 n2966 n2967 0.16666666666666666
r4660 n2937 n2968 0.375
r4661 n2967 n2968 0.0625
r4662 n2938 n2969 0.375
r4663 n2968 n2969 0.041666666666666664
r4664 n2939 n2970 0.0625
r4665 n2969 n2970 0.14583333333333334
r4666 n2940 n2971 0.074999999999999997
r4667 n2970 n2971 0.22916666666666666
r4668 n2941 n2972 0.375
r4669 n2971 n2972 0.125
r4670 n2946 n2973 0.0625
r4671 n2947 n2974 0.125
r4672 n2973 n2974 0.13392857142857142
r4673 n2948 n2975 0.125
r4674 n2974 n2975 0.089285714285714288
r4675 n2949 n2976 0.625
r4676 n2975 n2976 0.053571428571428568
r4677 n2950 n2977 0.20833333333333334
r4678 n2976 n2977 0.035714285714285712
r4679 n2951 n2978 0.625
r4680 n2977 n2978 0.035714285714285712
r4681 n2952 n2979 0.069444444444444448
r4682 n2978 n2979 0.089285714285714288
r4683 n2953 n2980 0.0625
r4684 n2979 n2980 0.16964285714285715
r4685 n2954 n2981 0.125
r4686 n2980 n2981 0.13392857142857142
r4687 n2955 n2982 0.125
r4688 n2981 n2982 0.089285714285714288
r4689 n2956 n2983 0.625
r4690 n2982 n2983 0.053571428571428568
r4691 n2957 n2984 0.3125
r4692 n2983 n2984 0.026785714285714284
r4693 n2958 n2985 0.625
r4694 n2984 n2985 0.026785714285714284
r4695 n2959 n2986 0.625
r4696 n2985 n2986 0.017857142857142856
r4697 n2960 n2987 0.625
r4698 n2986 n2987 0.017857142857142856
r4699 n2961 n2988 0.15625
r4700 n2987 n2988 0.044642857142857144
r4701 n2962 n2989 0.125
r4702 n2988 n2989 0.080357142857142863
r4703 n2963 n2990 0.625
r4704 n2989 n2990 0.053571428571428568
r4705 n2964 n2991 0.0625
r4706 n2990 n2991 0.098214285714285712
r4707 n2992 n2993 0.78125
r4708 n2993 n2994 1
r4709 n2994 n2995 1
r4710 n2995 n2996 0.78125
r4711 n2992 n2997 0.035326086956521736
r4712 n2993 n2998 0.40625
r4713 n2997 n2998 0.14204545454545456
r4714 n2994 n2999 0.027083333333333334
r4715 n2998 n2999 0.18181818181818182
r4716 n2995 n3000 0.40625
r4717 n2999 n3000 0.18181818181818182
r4718 n2996 n3001 0.035326086956521736
r4719 n3000 n3001 0.14204545454545456
r4720 n2997 n3002 0.035326086956521736
r4721 n2998 n3003 0.40625
r4722 n3002 n3003 0.78125
r4723 n2999 n3004 0.027083333333333334
r4724 n3003 n3004 1
r4725 n3000 n3005 0.40625
r4726 n3004 n3005 1
r4727 n3001 n3006 0.035326086956521736
r4728 n3005 n3006 0.78125
r4729 n3002 n3007 0.086956521739130432
r4730 n3003 n3008 1
r4731 n3007 n3008 0.052083333333333336
r4732 n3004 n3009 0.066666666666666666
r4733 n3008 n3009 0.066666666666666666
r4734 n3005 n3010 1
r4735 n3009 n3010 0.066666666666666666
r4736 n3006 n3011 0.086956521739130432
r4737 n3010 n3011 0.052083333333333336
r4738 n3007 n3012 0.086956521739130432
r4739 n3008 n3013 1
r4740 n3012 n3013 0.78125
r4741 n3009 n3014 0.066666666666666666
r4742 n3013 n3014 1
r4743 n3010 n3015 1
r4744 n3014 n3015 1
r4745 n3011 n3016 0.086956521739130432
r4746 n3015 n3016 0.78125
r4747 n3012 n3017 0.035326086956521736
r4748 n3013 n3018 0.40625
r4749 n3017 n3018 0.14204545454545456
r4750 n3014 n3019 0.027083333333333334
r4751 n3018 n3019 0.18181818181818182
r4752 n3015 n3020 0.40625
r4753 n3019 n3020 0.18181818181818182
r4754 n3016 n3021 0.035326086956521736
r4755 n3020 n3021 0.14204545454545456
r4756 n3017 n3022 0.035326086956521736
r4757 n3018 n3023 0.40625
r4758 n3022 n3023 0.78125
r4759 n3019 n3024 0.027083333333333334
r4760 n3023 n3024 1
r4761 n3020 n3025 0.40625
r4762 n3024 n3025 1
r4763 n3021 n3026 0.035326086956521736
r4764 n3025 n3026 0.78125
r4765 n3027 n3028 0.3125
r4766 n3028 n3029 0.1875
r4767 n3029 n3030 0.09375
r4768 n3030 n3031 0.09375
r4769 n3031 n3032 0.0625
r4770 n3032 n3033 0.0625
r4771 n3033 n3034 0.15625
r4772 n3034 n3035 0.28125
r4773 n3035 n3036 0.1875
r4774 n3036 n3037 0.34375
r4775 n3037 n3038 0.40625
r4776 n3038 n3039 0.28125
r4777 n3039 n3040 0.25
r4778 n3040 n3041 0.09375
r4779 n3041 n3042 0.0625
r4780 n3042 n3043 0.21875
r4781 n3043 n3044 0.34375
r4782 n3044 n3045 0.1875
r4783 n3045 n3046 0.15625
r4784 n3046 n3047 0.28125
r4785 n3047 n3048 0.25
r4786 n3048 n3049 0.3125
r4787 n3050 n3051 0.78125
r4788 n3051 n3052 1.0625
r4789 n3052 n3053 0.9375
r4790 n3053 n3054 1.0625
r4791 n3054 n3055 0.78125
r4792 n3027 n3056 0.0625
r4793 n3028 n3057 0.0625
r4794 n3056 n3057 0.20833333333333334
r4795 n3029 n3058 0.3125
r4796 n3057 n3058 0.125
r4797 n3030 n3059 0.15625
r4798 n3058 n3059 0.0625
r4799 n3031 n3060 0.3125
r4800 n3059 n3060 0.0625
r4801 n3032 n3061 0.3125
r4802 n3060 n3061 0.041666666666666664
r4803 n3033 n3062 0.3125
r4804 n3061 n3062 0.041666666666666664
r4805 n3034 n3063 0.078125
r4806 n3062 n3063 0.10416666666666667
r4807 n3035 n3064 0.0625
r4808 n3063 n3064 0.1875
r4809 n3036 n3065 0.3125
r4810 n3064 n3065 0.125
r4811 n3037 n3066 0.03125
r4812 n3065 n3066 0.22916666666666666
r4813 n3038 n3067 0.10416666666666667
r4814 n3066 n3067 0.27083333333333331
r4815 n3039 n3068 0.052083333333333336
r4816 n3067 n3068 0.1875
r4817 n3040 n3069 0.15625
r4818 n3068 n3069 0.16666666666666666
r4819 n3041 n3070 0.3125
r4820 n3069 n3070 0.0625
r4821 n3042 n3071 0.3125
r4822 n3070 n3071 0.041666666666666664
r4823 n3043 n3072 0.052083333333333336
r4824 n3071 n3072 0.14583333333333334
r4825 n3044 n3073 0.0625
r4826 n3072 n3073 0.22916666666666666
r4827 n3045 n3074 0.3125
r4828 n3073 n3074 0.125
r4829 n3046 n3075 0.078125
r4830 n3074 n3075 0.10416666666666667
r4831 n3047 n3076 0.0625
r4832 n3075 n3076 0.1875
r4833 n3048 n3077 0.10416666666666667
r4834 n3076 n3077 0.16666666666666666
r4835 n3049 n3078 0.044642857142857144
r4836 n3077 n3078 0.20833333333333334
r4837 n3050 n3079 0.044642857142857144
r4838 n3051 n3080 0.017361111111111112
r4839 n3079 n3080 0.52083333333333337
r4840 n3052 n3081 0.01953125
r4841 n3080 n3081 0.70833333333333337
r4842 n3053 n3082 0.022321428571428572
r4843 n3081 n3082 0.625
r4844 n3054 n3083 0.015625
r4845 n3082 n3083 0.70833333333333337
r4846 n3055 n3084 0.0625
r4847 n3083 n3084 0.52083333333333337
r4848 n3056 t_r1_a 0.10000000000000001
r4849 n3057 t_r1_a 0.10000000000000001
r4850 n3058 t_r1_a 0.5
r4851 n3059 t_r1_a 0.25
r4852 n3060 t_r1_a 0.5
r4853 n3061 t_r1_a 0.5
r4854 n3062 t_r1_a 0.5
r4855 n3063 t_r1_a 0.125
r4856 n3064 t_r1_a 0.10000000000000001
r4857 n3065 t_r1_a 0.5
r4858 n3066 t_r1_a 0.050000000000000003
r4859 n3067 t_r1_a 0.16666666666666666
r4860 n3068 t_r1_a 0.083333333333333329
r4861 n3069 t_r1_a 0.25
r4862 n3070 t_r1_a 0.5
r4863 n3071 t_r1_a 0.5
r4864 n3072 t_r1_a 0.083333333333333329
r4865 n3073 t_r1_a 0.10000000000000001
r4866 n3074 t_r1_a 0.5
r4867 n3075 t_r1_a 0.125
r4868 n3076 t_r1_a 0.10000000000000001
r4869 n3077 t_r1_a 0.16666666666666666
r4870 n3078 t_r1_a 0.071428571428571425
r4871 n3079 t_r1_b 0.071428571428571425
r4872 n3080 t_r1_b 0.027777777777777776
r4873 n3081 t_r1_b 0.03125
r4874 n3082 t_r1_b 0.035714285714285712
r4875 n3083 t_r1_b 0.025000000000000001
r4876 n3084 t_r1_b 0.10000000000000001
r4877 t_r1_a n3652 0.10000000000000001
r4878 t_r1_a n3653 0.10000000000000001
r4879 n3652 n3653 0.20833333333333334
r4880 t_r1_a n3654 0.5
r4881 n3653 n3654 0.125
r4882 t_r1_a n3655 0.25
r4883 n3654 n3655 0.0625
r4884 t_r1_a n3656 0.5
r4885 n3655 n3656 0.0625
r4886 t_r1_a n3657 0.5
r4887 n3656 n3657 0.041666666666666664
r4888 t_r1_a n3658 0.5
r4889 n3657 n3658 0.041666666666666664
r4890 t_r1_a n3659 0.125
r4891 n3658 n3659 0.10416666666666667
r4892 t_r1_a n3660 0.10000000000000001
r4893 n3659 n3660 0.1875
r4894 t_r1_a n3661 0.5
r4895 n3660 n3661 0.125
r4896 t_r1_a n3662 0.050000000000000003
r4897 n3661 n3662 0.22916666666666666
r4898 t_r1_a n3663 0.16666666666666666
r4899 n3662 n3663 0.27083333333333331
r4900 t_r1_a n3664 0.083333333333333329
r4901 n3663 n3664 0.1875
r4902 t_r1_a n3665 0.25
r4903 n3664 n3665 0.16666666666666666
r4904 t_r1_a n3666 0.5
r4905 n3665 n3666 0.0625
r4906 t_r1_a n3667 0.5
r4907 n3666 n3667 0.041666666666666664
r4908 t_r1_a n3668 0.083333333333333329
r4909 n3667 n3668 0.14583333333333334
r4910 t_r1_a n3669 0.10000000000000001
r4911 n3668 n3669 0.22916666666666666
r4912 t_r1_a n3670 0.5
r4913 n3669 n3670 0.125
r4914 t_r1_a n3671 0.125
r4915 n3670 n3671 0.10416666666666667
r4916 t_r1_a n3672 0.10000000000000001
r4917 n3671 n3672 0.1875
r4918 t_r1_a n3673 0.16666666666666666
r4919 n3672 n3673 0.16666666666666666
r4920 t_r1_a n3674 0.071428571428571425
r4921 n3673 n3674 0.20833333333333334
r4922 t_r1_b n3675 0.071428571428571425
r4923 t_r1_b n3676 0.027777777777777776
r4924 n3675 n3676 0.52083333333333337
r4925 t_r1_b n3677 0.03125
r4926 n3676 n3677 0.70833333333333337
r4927 t_r1_b n3678 0.035714285714285712
r4928 n3677 n3678 0.625
r4929 t_r1_b n3679 0.025000000000000001
r4930 n3678 n3679 0.70833333333333337
r4931 t_r1_b n3680 0.10000000000000001
r4932 n3679 n3680 0.52083333333333337
r4933 n3652 n3681 0.0625
r4934 n3653 n3682 0.0625
r4935 n3681 n3682 0.3125
r4936 n3654 n3683 0.3125
r4937 n3682 n3683 0.1875
r4938 n3655 n3684 0.15625
r4939 n3683 n3684 0.09375
r4940 n3656 n3685 0.3125
r4941 n3684 n3685 0.09375
r4942 n3657 n3686 0.3125
r4943 n3685 n3686 0.0625
r4944 n3658 n3687 0.3125
r4945 n3686 n3687 0.0625
r4946 n3659 n3688 0.078125
r4947 n3687 n3688 0.15625
r4948 n3660 n3689 0.0625
r4949 n3688 n3689 0.28125
r4950 n3661 n3690 0.3125
r4951 n3689 n3690 0.1875
r4952 n3662 n3691 0.03125
r4953 n3690 n3691 0.34375
r4954 n3663 n3692 0.10416666666666667
r4955 n3691 n3692 0.40625
r4956 n3664 n3693 0.052083333333333336
r4957 n3692 n3693 0.28125
r4958 n3665 n3694 0.15625
r4959 n3693 n3694 0.25
r4960 n3666 n3695 0.3125
r4961 n3694 n3695 0.09375
r4962 n3667 n3696 0.3125
r4963 n3695 n3696 0.0625
r4964 n3668 n3697 0.052083333333333336
r4965 n3696 n3697 0.21875
r4966 n3669 n3698 0.0625
r4967 n3697 n3698 0.34375
r4968 n3670 n3699 0.3125
r4969 n3698 n3699 0.1875
r4970 n3671 n3700 0.078125
r4971 n3699 n3700 0.15625
r4972 n3672 n3701 0.0625
r4973 n3700 n3701 0.28125
r4974 n3673 n3702 0.10416666666666667
r4975 n3701 n3702 0.25
r4976 n3674 n3703 0.044642857142857144
r4977 n3702 n3703 0.3125
r4978 n3675 n3704 0.044642857142857144
r4979 n3676 n3705 0.017361111111111112
r4980 n3704 n3705 0.78125
r4981 n3677 n3706 0.01953125
r4982 n3705 n3706 1.0625
r4983 n3678 n3707 0.022321428571428572
r4984 n3706 n3707 0.9375
r4985 n3679 n3708 0.015625
r4986 n3707 n3708 1.0625
r4987 n3680 n3709 0.0625
r4988 n3708 n3709 0.78125
r4989 n3710 n3711 0.084375000000000006
r4990 n3711 n3712 0.10312499999999999
r4991 n3712 n3713 0.056250000000000001
r4992 n3713 n3714 0.10000000000000001
r4993 n3714 n3715 0.10000000000000001
r4994 n3715 n3716 0.056250000000000001
r4995 n3716 n3717 0.10312499999999999
r4996 n3717 n3718 0.084375000000000006
r4997 n3737 n3738 0.0625
r4998 n3738 n3739 0.109375
r4999 n3739 n3740 0.081250000000000003
r5000 n3740 n3741 0.090624999999999997
r5001 n3741 n3742 0.090624999999999997
r5002 n3742 n3743 0.081250000000000003
r5003 n3743 n3744 0.109375
r5004 n3744 n3745 0.0625
r5005 n3710 n3746 0.26874999999999999
r5006 n3711 n3747 0.15808823529411764
r5007 n3746 n3747 0.073369565217391311
r5008 n3712 n3748 0.16796875
r5009 n3747 n3748 0.089673913043478257
r5010 n3713 n3749 1.34375
r5011 n3748 n3749 0.048913043478260872
r5012 n3714 n3750 0.089583333333333334
r5013 n3749 n3750 0.086956521739130432
r5014 n3715 n3751 1.34375
r5015 n3750 n3751 0.086956521739130432
r5016 n3716 n3752 0.16796875
r5017 n3751 n3752 0.048913043478260872
r5018 n3717 n3753 0.15808823529411764
r5019 n3752 n3753 0.089673913043478257
r5020 n3718 n3754 0.26874999999999999
r5021 n3753 n3754 0.073369565217391311
r5022 n3737 n3773 0.26874999999999999
r5023 n3738 n3774 0.26874999999999999
r5024 n3773 n3774 0.05434782608695652
r5025 n3739 n3775 0.1075
r5026 n3774 n3775 0.095108695652173919
r5027 n3740 n3776 2.6875
r5028 n3775 n3776 0.070652173913043473
r5029 n3741 n3777 0.095982142857142863
r5030 n3776 n3777 0.07880434782608696
r5031 n3742 n3778 2.6875
r5032 n3777 n3778 0.07880434782608696
r5033 n3743 n3779 0.1075
r5034 n3778 n3779 0.070652173913043473
r5035 n3744 n3780 0.26874999999999999
r5036 n3779 n3780 0.095108695652173919
r5037 n3745 n3781 0.26874999999999999
r5038 n3780 n3781 0.05434782608695652
r5039 n3746 n3782 0.15625
r5040 n3747 n3783 0.091911764705882359
r5041 n3782 n3783 0.84375
r5042 n3748 n3784 0.09765625
r5043 n3783 n3784 1.03125
r5044 n3749 n3785 0.78125
r5045 n3784 n3785 0.5625
r5046 n3750 n3786 0.052083333333333336
r5047 n3785 n3786 1
r5048 n3751 n3787 0.78125
r5049 n3786 n3787 1
r5050 n3752 n3788 0.09765625
r5051 n3787 n3788 0.5625
r5052 n3753 n3789 0.091911764705882359
r5053 n3788 n3789 1.03125
r5054 n3754 n3790 0.15625
r5055 n3789 n3790 0.84375
r5056 n3773 n3809 0.15625
r5057 n3774 n3810 0.15625
r5058 n3809 n3810 0.625
r5059 n3775 n3811 0.0625
r5060 n3810 n3811 1.09375
r5061 n3776 n3812 1.5625
r5062 n3811 n3812 0.8125
r5063 n3777 n3813 0.055803571428571432
r5064 n3812 n3813 0.90625
r5065 n3778 n3814 1.5625
r5066 n3813 n3814 0.90625
r5067 n3779 n3815 0.0625
r5068 n3814 n3815 0.8125
r5069 n3780 n3816 0.15625
r5070 n3815 n3816 1.09375
r5071 n3781 n3817 0.15625
r5072 n3816 n3817 0.625
r5073 n3782 n3818 0.20000000000000001
r5074 n3783 n3819 0.11764705882352941
r5075 n3818 n3819 0.056250000000000001
r5076 n3784 n3820 0.125
r5077 n3819 n3820 0.068750000000000006
r5078 n3785 n3821 1
r5079 n3820 n3821 0.037499999999999999
r5080 n3786 n3822 0.066666666666666666
r5081 n3821 n3822 0.066666666666666666
r5082 n3787 n3823 1
r5083 n3822 n3823 0.066666666666666666
r5084 n3788 n3824 0.125
r5085 n3823 n3824 0.037499999999999999
r5086 n3789 n3825 0.11764705882352941
r5087 n3824 n3825 0.068750000000000006
r5088 n3790 n3826 0.20000000000000001
r5089 n3825 n3826 0.056250000000000001
r5090 n3809 n3845 0.20000000000000001
r5091 n3810 n3846 0.20000000000000001
r5092 n3845 n3846 0.041666666666666664
r5093 n3811 n3847 0.080000000000000002
r5094 n3846 n3847 0.072916666666666671
r5095 n3812 n3848 2
r5096 n3847 n3848 0.054166666666666669
r5097 n3813 n3849 0.071428571428571425
r5098 n3848 n3849 0.060416666666666667
r5099 n3814 n3850 2
r5100 n3849 n3850 0.060416666666666667
r5101 n3815 n3851 0.080000000000000002
r5102 n3850 n3851 0.054166666666666669
r5103 n3816 n3852 0.20000000000000001
r5104 n3851 n3852 0.072916666666666671
r5105 n3817 n3853 0.20000000000000001
r5106 n3852 n3853 0.041666666666666664
r5107 n3818 n3854 0.20000000000000001
r5108 n3819 n3855 0.11764705882352941
r5109 n3854 n3855 0.84375
r5110 n3820 n3856 0.125
r5111 n3855 n3856 1.03125
r5112 n3821 n3857 1
r5113 n3856 n3857 0.5625
r5114 n3822 n3858 0.066666666666666666
r5115 n3857 n3858 1
r5116 n3823 n3859 1
r5117 n3858 n3859 1
r5118 n3824 n3860 0.125
r5119 n3859 n3860 0.5625
r5120 n3825 n3861 0.11764705882352941
r5121 n3860 n3861 1.03125
r5122 n3826 n3862 0.20000000000000001
r5123 n3861 n3862 0.84375
r5124 n3845 n3881 0.20000000000000001
r5125 n3846 n3882 0.20000000000000001
r5126 n3881 n3882 0.625
r5127 n3847 n3883 0.080000000000000002
r5128 n3882 n3883 1.09375
r5129 n3848 n3884 2
r5130 n3883 n3884 0.8125
r5131 n3849 n3885 0.071428571428571425
r5132 n3884 n3885 0.90625
r5133 n3850 n3886 2
r5134 n3885 n3886 0.90625
r5135 n3851 n3887 0.080000000000000002
r5136 n3886 n3887 0.8125
r5137 n3852 n3888 0.20000000000000001
r5138 n3887 n3888 1.09375
r5139 n3853 n3889 0.20000000000000001
r5140 n3888 n3889 0.625
r5141 n3854 n3890 0.15625
r5142 n3855 n3891 0.091911764705882359
r5143 n3890 n3891 0.073369565217391311
r5144 n3856 n3892 0.09765625
r5145 n3891 n3892 0.089673913043478257
r5146 n3857 n3893 0.78125
r5147 n3892 n3893 0.048913043478260872
r5148 n3858 n3894 0.052083333333333336
r5149 n3893 n3894 0.086956521739130432
r5150 n3859 n3895 0.78125
r5151 n3894 n3895 0.086956521739130432
r5152 n3860 n3896 0.09765625
r5153 n3895 n3896 0.048913043478260872
r5154 n3861 n3897 0.091911764705882359
r5155 n3896 n3897 0.089673913043478257
r5156 n3862 n3898 0.15625
r5157 n3897 n3898 0.073369565217391311
r5158 n3881 n3917 0.15625
r5159 n3882 n3918 0.15625
r5160 n3917 n3918 0.05434782608695652
r5161 n3883 n3919 0.0625
r5162 n3918 n3919 0.095108695652173919
r5163 n3884 n3920 1.5625
r5164 n3919 n3920 0.070652173913043473
r5165 n3885 n3921 0.055803571428571432
r5166 n3920 n3921 0.07880434782608696
r5167 n3886 n3922 1.5625
r5168 n3921 n3922 0.07880434782608696
r5169 n3887 n3923 0.0625
r5170 n3922 n3923 0.070652173913043473
r5171 n3888 n3924 0.15625
r5172 n3923 n3924 0.095108695652173919
r5173 n3889 n3925 0.15625
r5174 n3924 n3925 0.05434782608695652
r5175 n3890 n3926 0.26874999999999999
r5176 n3891 n3927 0.15808823529411764
r5177 n3926 n3927 0.084375000000000006
r5178 n3892 n3928 0.16796875
r5179 n3927 n3928 0.10312499999999999
r5180 n3893 n3929 1.34375
r5181 n3928 n3929 0.056250000000000001
r5182 n3894 n3930 0.089583333333333334
r5183 n3929 n3930 0.10000000000000001
r5184 n3895 n3931 1.34375
r5185 n3930 n3931 0.10000000000000001
r5186 n3896 n3932 0.16796875
r5187 n3931 n3932 0.056250000000000001
r5188 n3897 n3933 0.15808823529411764
r5189 n3932 n3933 0.10312499999999999
r5190 n3898 n3934 0.26874999999999999
r5191 n3933 n3934 0.084375000000000006
r5192 n3917 n3953 0.26874999999999999
r5193 n3918 n3954 0.26874999999999999
r5194 n3953 n3954 0.0625
r5195 n3919 n3955 0.1075
r5196 n3954 n3955 0.109375
r5197 n3920 n3956 2.6875
r5198 n3955 n3956 0.081250000000000003
r5199 n3921 n3957 0.095982142857142863
r5200 n3956 n3957 0.090624999999999997
r5201 n3922 n3958 2.6875
r5202 n3957 n3958 0.090624999999999997
r5203 n3923 n3959 0.1075
r5204 n3958 n3959 0.081250000000000003
r5205 n3924 n3960 0.26874999999999999
r5206 n3959 n3960 0.109375
r5207 n3925 n3961 0.26874999999999999
r5208 n3960 n3961 0.0625
r5209 n3927 n3962 0.25
r5210 n3928 n3963 0.265625
r5211 n3962 n3963 0.04296875
r5212 n3929 n3964 2.125
r5213 n3963 n3964 0.0234375
r5214 n3930 n3965 0.14166666666666666
r5215 n3964 n3965 0.041666666666666664
r5216 n3931 n3966 2.125
r5217 n3965 n3966 0.041666666666666664
r5218 n3932 n3967 0.265625
r5219 n3966 n3967 0.0234375
r5220 n3933 n3968 0.25
r5221 n3967 n3968 0.04296875
r5222 in n3969 0.84999999999999998
r5223 in n3970 0.70833333333333337
r5224 n3969 n3970 0.014322916666666666
r5225 in n3971 2.125
r5226 n3970 n3971 0.010416666666666666
r5227 in n3972 0.25
r5228 n3971 n3972 0.024739583333333332
r5229 in n3973 0.32692307692307693
r5230 n3972 n3973 0.0390625
r5231 in n3974 2.125
r5232 n3973 n3974 0.01953125
r5233 in n3975 2.125
r5234 n3974 n3975 0.005208333333333333
r5235 in n3976 1.0625
r5236 n3975 n3976 0.0078125
r5237 in n3977 0.84999999999999998
r5238 n3976 n3977 0.01171875
r5239 n3954 n3978 0.42499999999999999
r5240 n3955 n3979 0.17000000000000001
r5241 n3978 n3979 0.045572916666666664
r5242 n3956 n3980 4.25
r5243 n3979 n3980 0.033854166666666664
r5244 n3957 n3981 0.15178571428571427
r5245 n3980 n3981 0.037760416666666664
r5246 n3958 n3982 4.25
r5247 n3981 n3982 0.037760416666666664
r5248 n3959 n3983 0.17000000000000001
r5249 n3982 n3983 0.033854166666666664
r5250 n3960 n3984 0.42499999999999999
r5251 n3983 n3984 0.045572916666666664
r5252 n3962 n3985 0.35294117647058826
r5253 n3963 n3986 0.375
r5254 n3985 n3986 0.04296875
r5255 n3964 n3987 3
r5256 n3986 n3987 0.0234375
r5257 n3965 n3988 0.20000000000000001
r5258 n3987 n3988 0.041666666666666664
r5259 n3966 n3989 3
r5260 n3988 n3989 0.041666666666666664
r5261 n3967 n3990 0.375
r5262 n3989 n3990 0.0234375
r5263 n3968 n3991 0.35294117647058826
r5264 n3990 n3991 0.04296875
r5265 n3969 n3992 1.2
r5266 n3970 n3993 1
r5267 n3992 n3993 0.014322916666666666
r5268 n3971 n3994 3
r5269 n3993 n3994 0.010416666666666666
r5270 n3972 n3995 0.35294117647058826
r5271 n3994 n3995 0.024739583333333332
r5272 n3973 n3996 0.46153846153846156
r5273 n3995 n3996 0.0390625
r5274 n3974 n3997 3
r5275 n3996 n3997 0.01953125
r5276 n3975 n3998 3
r5277 n3997 n3998 0.005208333333333333
r5278 n3976 n3999 1.5
r5279 n3998 n3999 0.0078125
r5280 n3977 n4000 1.2
r5281 n3999 n4000 0.01171875
r5282 n3978 n4001 0.59999999999999998
r5283 n3979 n4002 0.23999999999999999
r5284 n4001 n4002 0.045572916666666664
r5285 n3980 n4003 6
r5286 n4002 n4003 0.033854166666666664
r5287 n3981 n4004 0.21428571428571427
r5288 n4003 n4004 0.037760416666666664
r5289 n3982 n4005 6
r5290 n4004 n4005 0.037760416666666664
r5291 n3983 n4006 0.23999999999999999
r5292 n4005 n4006 0.033854166666666664
r5293 n3984 n4007 0.59999999999999998
r5294 n4006 n4007 0.045572916666666664
r5295 n3985 n4008 0.35294117647058826
r5296 n3986 n4009 0.375
r5297 n4008 n4009 0.04296875
r5298 n3987 n4010 3
r5299 n4009 n4010 0.0234375
r5300 n3988 n4011 0.20000000000000001
r5301 n4010 n4011 0.041666666666666664
r5302 n3989 n4012 3
r5303 n4011 n4012 0.041666666666666664
r5304 n3990 n4013 0.375
r5305 n4012 n4013 0.0234375
r5306 n3991 n4014 0.35294117647058826
r5307 n4013 n4014 0.04296875
r5308 n3992 n4015 1.2
r5309 n3993 n4016 1
r5310 n4015 n4016 0.014322916666666666
r5311 n3994 n4017 3
r5312 n4016 n4017 0.010416666666666666
r5313 n3995 n4018 0.35294117647058826
r5314 n4017 n4018 0.024739583333333332
r5315 n3996 n4019 0.46153846153846156
r5316 n4018 n4019 0.0390625
r5317 n3997 n4020 3
r5318 n4019 n4020 0.01953125
r5319 n3998 n4021 3
r5320 n4020 n4021 0.005208333333333333
r5321 n3999 n4022 1.5
r5322 n4021 n4022 0.0078125
r5323 n4000 n4023 1.2
r5324 n4022 n4023 0.01171875
r5325 n4001 n4024 0.59999999999999998
r5326 n4002 n4025 0.23999999999999999
r5327 n4024 n4025 0.045572916666666664
r5328 n4003 n4026 6
r5329 n4025 n4026 0.033854166666666664
r5330 n4004 n4027 0.21428571428571427
r5331 n4026 n4027 0.037760416666666664
r5332 n4005 n4028 6
r5333 n4027 n4028 0.037760416666666664
r5334 n4006 n4029 0.23999999999999999
r5335 n4028 n4029 0.033854166666666664
r5336 n4007 n4030 0.59999999999999998
r5337 n4029 n4030 0.045572916666666664
r5338 n4008 n4031 0.18382352941176472
r5339 n4009 n4032 0.1953125
r5340 n4031 n4032 1.03125
r5341 n4010 n4033 1.5625
r5342 n4032 n4033 0.5625
r5343 n4011 n4034 0.10416666666666667
r5344 n4033 n4034 1
r5345 n4012 n4035 1.5625
r5346 n4034 n4035 1
r5347 n4013 n4036 0.1953125
r5348 n4035 n4036 0.5625
r5349 n4014 n4037 0.18382352941176472
r5350 n4036 n4037 1.03125
r5351 n4038 n4039 0.46875
r5352 n4039 n4040 0.3125
r5353 n4040 n4041 0.1875
r5354 n4041 n4042 0.09375
r5355 n4042 n4043 0.09375
r5356 n4043 n4044 0.0625
r5357 n4044 n4045 0.0625
r5358 n4045 n4046 0.15625
r5359 n4046 n4047 0.28125
r5360 n4047 n4048 0.1875
r5361 n4048 n4049 0.34375
r5362 n4049 n4050 0.40625
r5363 n4050 n4051 0.28125
r5364 n4051 n4052 0.25
r5365 n4052 n4053 0.09375
r5366 n4053 n4054 0.0625
r5367 n4054 n4055 0.21875
r5368 n4055 n4056 0.34375
r5369 n4056 n4057 0.1875
r5370 n4057 n4058 0.15625
r5371 n4058 n4059 0.28125
r5372 n4015 n4060 0.625
r5373 n4016 n4061 0.52083333333333337
r5374 n4060 n4061 0.34375
r5375 n4017 n4062 1.5625
r5376 n4061 n4062 0.25
r5377 n4018 n4063 0.18382352941176472
r5378 n4062 n4063 0.59375
r5379 n4019 n4064 0.24038461538461539
r5380 n4063 n4064 0.9375
r5381 n4020 n4065 1.5625
r5382 n4064 n4065 0.46875
r5383 n4021 n4066 1.5625
r5384 n4065 n4066 0.125
r5385 n4022 n4067 0.78125
r5386 n4066 n4067 0.1875
r5387 n4023 n4068 0.625
r5388 n4067 n4068 0.28125
r5389 n4024 n4069 0.3125
r5390 n4025 n4070 0.125
r5391 n4069 n4070 1.09375
r5392 n4026 n4071 3.125
r5393 n4070 n4071 0.8125
r5394 n4027 n4072 0.11160714285714286
r5395 n4071 n4072 0.90625
r5396 n4028 n4073 3.125
r5397 n4072 n4073 0.90625
r5398 n4029 n4074 0.125
r5399 n4073 n4074 0.8125
r5400 n4030 n4075 0.3125
r5401 n4074 n4075 1.09375
r5402 n4031 n4076 0.04779411764705882
r5403 n4032 n4077 0.05078125
r5404 n4076 n4077 0.1875
r5405 n4033 n4078 0.40625
r5406 n4077 n4078 0.10227272727272728
r5407 n4034 n4079 0.027083333333333334
r5408 n4078 n4079 0.18181818181818182
r5409 n4035 n4080 0.40625
r5410 n4079 n4080 0.18181818181818182
r5411 n4036 n4081 0.05078125
r5412 n4080 n4081 0.10227272727272728
r5413 n4037 n4082 0.04779411764705882
r5414 n4081 n4082 0.1875
r5415 n4082 n4083 0.15340909090909091
r5416 n4083 n4084 0.28977272727272729
r5417 n4084 n4085 0.46590909090909088
r5418 n4085 n4086 0.46590909090909088
r5419 n4086 n4087 0.42613636363636365
r5420 n4087 n4088 0.34886363636363638
r5421 n4088 n4089 0.3125
r5422 n4089 n4090 0.34999999999999998
r5423 n4090 n4091 0.26704545454545453
r5424 n4091 n4092 0.30113636363636365
r5425 n4092 n4093 0.23295454545454544
r5426 n4093 n4094 0.19318181818181818
r5427 n4094 n4095 0.19318181818181818
r5428 n4095 n4096 0.13636363636363635
r5429 n4096 n4097 0.15340909090909091
r5430 n4097 n4098 0.056818181818181816
r5431 n4098 n4099 0.0625
r5432 n4099 n4100 0.034090909090909088
r5433 n4100 n4101 0.079545454545454544
r5434 n4101 n4102 0.13068181818181818
r5435 n4102 n4103 0.085227272727272721
r5436 n4103 n4104 0.056818181818181816
r5437 n4104 n4105 0.034090909090909088
r5438 n4105 n4106 0.022727272727272728
r5439 n4106 n4107 0.022727272727272728
r5440 n4107 n4108 0.056818181818181816
r5441 n4038 n4109 0.081250000000000003
r5442 n4108 n4109 0.10795454545454546
r5443 n4039 n4110 0.16250000000000001
r5444 n4109 n4110 0.085227272727272721
r5445 n4040 n4111 0.16250000000000001
r5446 n4110 n4111 0.056818181818181816
r5447 n4041 n4112 0.8125
r5448 n4111 n4112 0.034090909090909088
r5449 n4042 n4113 0.40625
r5450 n4112 n4113 0.017045454545454544
r5451 n4043 n4114 0.8125
r5452 n4113 n4114 0.017045454545454544
r5453 n4044 n4115 0.8125
r5454 n4114 n4115 0.011363636363636364
r5455 n4045 n4116 0.8125
r5456 n4115 n4116 0.011363636363636364
r5457 n4046 n4117 0.203125
r5458 n4116 n4117 0.028409090909090908
r5459 n4047 n4118 0.16250000000000001
r5460 n4117 n4118 0.05113636363636364
r5461 n4048 n4119 0.8125
r5462 n4118 n4119 0.034090909090909088
r5463 n4049 n4120 0.081250000000000003
r5464 n4119 n4120 0.0625
r5465 n4050 n4121 0.27083333333333331
r5466 n4120 n4121 0.073863636363636367
r5467 n4051 n4122 0.13541666666666666
r5468 n4121 n4122 0.05113636363636364
r5469 n4052 n4123 0.40625
r5470 n4122 n4123 0.045454545454545456
r5471 n4053 n4124 0.8125
r5472 n4123 n4124 0.017045454545454544
r5473 n4054 n4125 0.8125
r5474 n4124 n4125 0.011363636363636364
r5475 n4055 n4126 0.13541666666666666
r5476 n4125 n4126 0.039772727272727272
r5477 n4056 n4127 0.16250000000000001
r5478 n4126 n4127 0.0625
r5479 n4057 n4128 0.8125
r5480 n4127 n4128 0.034090909090909088
r5481 n4058 n4129 0.203125
r5482 n4128 n4129 0.028409090909090908
r5483 n4059 n4130 0.16250000000000001
r5484 n4129 n4130 0.05113636363636364
r5485 n4060 n4131 0.16250000000000001
r5486 n4061 n4132 0.13541666666666666
r5487 n4131 n4132 0.0625
r5488 n4062 n4133 0.40625
r5489 n4132 n4133 0.045454545454545456
r5490 n4063 n4134 0.04779411764705882
r5491 n4133 n4134 0.10795454545454546
r5492 n4064 n4135 0.0625
r5493 n4134 n4135 0.17045454545454544
r5494 n4065 n4136 0.40625
r5495 n4135 n4136 0.085227272727272721
r5496 n4066 n4137 0.40625
r5497 n4136 n4137 0.022727272727272728
r5498 n4067 n4138 0.203125
r5499 n4137 n4138 0.034090909090909088
r5500 n4068 n4139 0.16250000000000001
r5501 n4138 n4139 0.05113636363636364
r5502 n4069 n4140 0.081250000000000003
r5503 n4070 n4141 0.032500000000000001
r5504 n4140 n4141 0.19886363636363635
r5505 n4071 n4142 0.8125
r5506 n4141 n4142 0.14772727272727273
r5507 n4072 n4143 0.029017857142857144
r5508 n4142 n4143 0.16477272727272727
r5509 n4073 n4144 0.8125
r5510 n4143 n4144 0.16477272727272727
r5511 n4074 n4145 0.032500000000000001
r5512 n4144 n4145 0.14772727272727273
r5513 n4075 n4146 0.081250000000000003
r5514 n4145 n4146 0.19886363636363635
r5515 n4076 n4147 0.04779411764705882
r5516 n4077 n4148 0.05078125
r5517 n4147 n4148 1.03125
r5518 n4078 n4149 0.40625
r5519 n4148 n4149 0.5625
r5520 n4079 n4150 0.027083333333333334
r5521 n4149 n4150 1
r5522 n4080 n4151 0.40625
r5523 n4150 n4151 1
r5524 n4081 n4152 0.05078125
r5525 n4151 n4152 0.5625
r5526 n4082 n4153 0.04779411764705882
r5527 n4152 n4153 1.03125
r5528 n4083 n4154 0.081250000000000003
r5529 n4153 n4154 0.84375
r5530 n4084 n4155 0.019817073170731708
r5531 n4154 n4155 1.59375
r5532 n4085 n4156 0.019817073170731708
r5533 n4155 n4156 2.5625
r5534 n4086 n4157 0.019817073170731708
r5535 n4156 n4157 2.5625
r5536 n4087 n4158 0.02389705882352941
r5537 n4157 n4158 2.34375
r5538 n4088 n4159 0.029653284671532845
r5539 n4158 n4159 1.91875
r5540 n4089 n4160 0.029438405797101448
r5541 n4159 n4160 1.71875
r5542 n4090 n4161 0.02389705882352941
r5543 n4160 n4161 1.925
r5544 n4091 n4162 0.0625
r5545 n4161 n4162 1.46875
r5546 n4092 n4163 0.020312500000000001
r5547 n4162 n4163 1.65625
r5548 n4093 n4164 0.8125
r5549 n4163 n4164 1.28125
r5550 n4094 n4165 0.02462121212121212
r5551 n4164 n4165 1.0625
r5552 n4095 n4166 0.8125
r5553 n4165 n4166 1.0625
r5554 n4096 n4167 0.035326086956521736
r5555 n4166 n4167 0.75
r5556 n4097 n4168 0.203125
r5557 n4167 n4168 0.84375
r5558 n4098 n4169 0.13541666666666666
r5559 n4168 n4169 0.3125
r5560 n4099 n4170 0.16250000000000001
r5561 n4169 n4170 0.34375
r5562 n4100 n4171 0.8125
r5563 n4170 n4171 0.1875
r5564 n4101 n4172 0.0625
r5565 n4171 n4172 0.4375
r5566 n4102 n4173 0.081250000000000003
r5567 n4172 n4173 0.71875
r5568 n4103 n4174 0.16250000000000001
r5569 n4173 n4174 0.46875
r5570 n4104 n4175 0.16250000000000001
r5571 n4174 n4175 0.3125
r5572 n4105 n4176 0.8125
r5573 n4175 n4176 0.1875
r5574 n4106 n4177 0.27083333333333331
r5575 n4176 n4177 0.125
r5576 n4107 n4178 0.8125
r5577 n4177 n4178 0.125
r5578 n4108 n4179 0.090277777777777776
r5579 n4178 n4179 0.3125
r5580 n4109 n4180 0.081250000000000003
r5581 n4179 n4180 0.59375
r5582 n4110 n4181 0.16250000000000001
r5583 n4180 n4181 0.46875
r5584 n4111 n4182 0.16250000000000001
r5585 n4181 n4182 0.3125
r5586 n4112 n4183 0.8125
r5587 n4182 n4183 0.1875
r5588 n4113 n4184 0.40625
r5589 n4183 n4184 0.09375
r5590 n4114 n4185 0.8125
r5591 n4184 n4185 0.09375
r5592 n4115 n4186 0.8125
r5593 n4185 n4186 0.0625
r5594 n4116 n4187 0.8125
r5595 n4186 n4187 0.0625
r5596 n4117 n4188 0.203125
r5597 n4187 n4188 0.15625
r5598 n4118 n4189 0.16250000000000001
r5599 n4188 n4189 0.28125
r5600 n4119 n4190 0.8125
r5601 n4189 n4190 0.1875
r5602 n4120 n4191 0.081250000000000003
r5603 n4190 n4191 0.34375
r5604 n4121 n4192 0.27083333333333331
r5605 n4191 n4192 0.40625
r5606 n4122 n4193 0.13541666666666666
r5607 n4192 n4193 0.28125
r5608 n4123 n4194 0.40625
r5609 n4193 n4194 0.25
r5610 n4124 n4195 0.8125
r5611 n4194 n4195 0.09375
r5612 n4125 n4196 0.8125
r5613 n4195 n4196 0.0625
r5614 n4126 n4197 0.13541666666666666
r5615 n4196 n4197 0.21875
r5616 n4127 n4198 0.16250000000000001
r5617 n4197 n4198 0.34375
r5618 n4128 n4199 0.8125
r5619 n4198 n4199 0.1875
r5620 n4129 n4200 0.203125
r5621 n4199 n4200 0.15625
r5622 n4130 n4201 0.16250000000000001
r5623 n4200 n4201 0.28125
r5624 n4131 n4202 0.16250000000000001
r5625 n4132 n4203 0.13541666666666666
r5626 n4202 n4203 0.34375
r5627 n4133 n4204 0.40625
r5628 n4203 n4204 0.25
r5629 n4134 n4205 0.04779411764705882
r5630 n4204 n4205 0.59375
r5631 n4135 n4206 0.0625
r5632 n4205 n4206 0.9375
r5633 n4136 n4207 0.40625
r5634 n4206 n4207 0.46875
r5635 n4137 n4208 0.40625
r5636 n4207 n4208 0.125
r5637 n4138 n4209 0.203125
r5638 n4208 n4209 0.1875
r5639 n4139 n4210 0.16250000000000001
r5640 n4209 n4210 0.28125
r5641 n4140 n4211 0.081250000000000003
r5642 n4141 n4212 0.032500000000000001
r5643 n4211 n4212 1.09375
r5644 n4142 n4213 0.8125
r5645 n4212 n4213 0.8125
r5646 n4143 n4214 0.029017857142857144
r5647 n4213 n4214 0.90625
r5648 n4144 n4215 0.8125
r5649 n4214 n4215 0.90625
r5650 n4145 n4216 0.032500000000000001
r5651 n4215 n4216 0.8125
r5652 n4146 n4217 0.081250000000000003
r5653 n4216 n4217 1.09375
r5654 n4147 n4218 0.11764705882352941
r5655 n4148 n4219 0.125
r5656 n4218 n4219 0.068750000000000006
r5657 n4149 n4220 1
r5658 n4219 n4220 0.037499999999999999
r5659 n4150 n4221 0.066666666666666666
r5660 n4220 n4221 0.066666666666666666
r5661 n4151 n4222 1
r5662 n4221 n4222 0.066666666666666666
r5663 n4152 n4223 0.125
r5664 n4222 n4223 0.037499999999999999
r5665 n4153 n4224 0.11764705882352941
r5666 n4223 n4224 0.068750000000000006
r5667 n4154 n4225 0.20000000000000001
r5668 n4224 n4225 0.056250000000000001
r5669 n4155 n4226 0.04878048780487805
r5670 n4225 n4226 0.10625
r5671 n4156 n4227 0.04878048780487805
r5672 n4226 n4227 0.17083333333333334
r5673 n4157 n4228 0.04878048780487805
r5674 n4227 n4228 0.17083333333333334
r5675 n4158 n4229 0.058823529411764705
r5676 n4228 n4229 0.15625
r5677 n4159 n4230 0.072992700729927001
r5678 n4229 n4230 0.12791666666666668
r5679 n4160 n4231 0.072463768115942032
r5680 n4230 n4231 0.11458333333333333
r5681 n4161 n4232 0.058823529411764705
r5682 n4231 n4232 0.12833333333333333
r5683 n4162 n4233 0.15384615384615385
r5684 n4232 n4233 0.097916666666666666
r5685 n4163 n4234 0.050000000000000003
r5686 n4233 n4234 0.11041666666666666
r5687 n4164 n4235 2
r5688 n4234 n4235 0.085416666666666669
r5689 n4165 n4236 0.060606060606060608
r5690 n4235 n4236 0.070833333333333331
r5691 n4166 n4237 2
r5692 n4236 n4237 0.070833333333333331
r5693 n4167 n4238 0.086956521739130432
r5694 n4237 n4238 0.050000000000000003
r5695 n4168 n4239 0.5
r5696 n4238 n4239 0.056250000000000001
r5697 n4169 n4240 0.33333333333333331
r5698 n4239 n4240 0.020833333333333332
r5699 n4170 n4241 0.40000000000000002
r5700 n4240 n4241 0.022916666666666665
r5701 n4171 n4242 2
r5702 n4241 n4242 0.012500000000000001
r5703 n4172 n4243 0.15384615384615385
r5704 n4242 n4243 0.029166666666666667
r5705 n4173 n4244 0.20000000000000001
r5706 n4243 n4244 0.04791666666666667
r5707 n4174 n4245 0.40000000000000002
r5708 n4244 n4245 0.03125
r5709 n4175 n4246 0.40000000000000002
r5710 n4245 n4246 0.020833333333333332
r5711 n4176 n4247 2
r5712 n4246 n4247 0.012500000000000001
r5713 n4177 n4248 0.66666666666666663
r5714 n4247 n4248 0.0083333333333333332
r5715 n4178 n4249 2
r5716 n4248 n4249 0.0083333333333333332
r5717 n4179 n4250 0.22222222222222221
r5718 n4249 n4250 0.020833333333333332
r5719 n4180 n4251 0.20000000000000001
r5720 n4250 n4251 0.039583333333333331
r5721 n4181 n4252 0.40000000000000002
r5722 n4251 n4252 0.03125
r5723 n4182 n4253 0.40000000000000002
r5724 n4252 n4253 0.020833333333333332
r5725 n4183 n4254 2
r5726 n4253 n4254 0.012500000000000001
r5727 n4184 n4255 1
r5728 n4254 n4255 0.0062500000000000003
r5729 n4185 n4256 2
r5730 n4255 n4256 0.0062500000000000003
r5731 n4186 n4257 2
r5732 n4256 n4257 0.0041666666666666666
r5733 n4187 n4258 2
r5734 n4257 n4258 0.0041666666666666666
r5735 n4188 n4259 0.5
r5736 n4258 n4259 0.010416666666666666
r5737 n4189 n4260 0.40000000000000002
r5738 n4259 n4260 0.018749999999999999
r5739 n4190 n4261 2
r5740 n4260 n4261 0.012500000000000001
r5741 n4191 n4262 0.20000000000000001
r5742 n4261 n4262 0.022916666666666665
r5743 n4192 n4263 0.66666666666666663
r5744 n4262 n4263 0.027083333333333334
r5745 n4193 n4264 0.33333333333333331
r5746 n4263 n4264 0.018749999999999999
r5747 n4194 n4265 1
r5748 n4264 n4265 0.016666666666666666
r5749 n4195 n4266 2
r5750 n4265 n4266 0.0062500000000000003
r5751 n4196 n4267 2
r5752 n4266 n4267 0.0041666666666666666
r5753 n4197 n4268 0.33333333333333331
r5754 n4267 n4268 0.014583333333333334
r5755 n4198 n4269 0.40000000000000002
r5756 n4268 n4269 0.022916666666666665
r5757 n4199 n4270 2
r5758 n4269 n4270 0.012500000000000001
r5759 n4200 n4271 0.5
r5760 n4270 n4271 0.010416666666666666
r5761 n4201 n4272 0.40000000000000002
r5762 n4271 n4272 0.018749999999999999
r5763 n4202 n4273 0.40000000000000002
r5764 n4203 n4274 0.33333333333333331
r5765 n4273 n4274 0.022916666666666665
r5766 n4204 n4275 1
r5767 n4274 n4275 0.016666666666666666
r5768 n4205 n4276 0.11764705882352941
r5769 n4275 n4276 0.039583333333333331
r5770 n4206 n4277 0.15384615384615385
r5771 n4276 n4277 0.0625
r5772 n4207 n4278 1
r5773 n4277 n4278 0.03125
r5774 n4208 n4279 1
r5775 n4278 n4279 0.0083333333333333332
r5776 n4209 n4280 0.5
r5777 n4279 n4280 0.012500000000000001
r5778 n4210 n4281 0.40000000000000002
r5779 n4280 n4281 0.018749999999999999
r5780 n4211 n4282 0.20000000000000001
r5781 n4212 n4283 0.080000000000000002
r5782 n4282 n4283 0.072916666666666671
r5783 n4213 n4284 2
r5784 n4283 n4284 0.054166666666666669
r5785 n4214 n4285 0.071428571428571425
r5786 n4284 n4285 0.060416666666666667
r5787 n4215 n4286 2
r5788 n4285 n4286 0.060416666666666667
r5789 n4216 n4287 0.080000000000000002
r5790 n4286 n4287 0.054166666666666669
r5791 n4217 n4288 0.20000000000000001
r5792 n4287 n4288 0.072916666666666671
r5793 n4218 n4289 0.11764705882352941
r5794 n4219 n4290 0.125
r5795 n4289 n4290 1.03125
r5796 n4220 n4291 1
r5797 n4290 n4291 0.5625
r5798 n4221 n4292 0.066666666666666666
r5799 n4291 n4292 1
r5800 n4222 n4293 1
r5801 n4292 n4293 1
r5802 n4223 n4294 0.125
r5803 n4293 n4294 0.5625
r5804 n4224 n4295 0.11764705882352941
r5805 n4294 n4295 1.03125
r5806 n4225 n4296 0.20000000000000001
r5807 n4295 n4296 0.84375
r5808 n4226 n4297 0.04878048780487805
r5809 n4296 n4297 1.59375
r5810 n4227 n4298 0.04878048780487805
r5811 n4297 n4298 2.5625
r5812 n4228 n4299 0.04878048780487805
r5813 n4298 n4299 2.5625
r5814 n4229 n4300 0.058823529411764705
r5815 n4299 n4300 2.34375
r5816 n4230 n4301 0.072992700729927001
r5817 n4300 n4301 1.91875
r5818 n4231 n4302 0.072463768115942032
r5819 n4301 n4302 1.71875
r5820 n4232 n4303 0.058823529411764705
r5821 n4302 n4303 1.925
r5822 n4233 n4304 0.15384615384615385
r5823 n4303 n4304 1.46875
r5824 n4234 n4305 0.050000000000000003
r5825 n4304 n4305 1.65625
r5826 n4235 n4306 2
r5827 n4305 n4306 1.28125
r5828 n4236 n4307 0.060606060606060608
r5829 n4306 n4307 1.0625
r5830 n4237 n4308 2
r5831 n4307 n4308 1.0625
r5832 n4238 n4309 0.086956521739130432
r5833 n4308 n4309 0.75
r5834 n4239 n4310 0.5
r5835 n4309 n4310 0.84375
r5836 n4240 n4311 0.33333333333333331
r5837 n4310 n4311 0.3125
r5838 n4241 n4312 0.40000000000000002
r5839 n4311 n4312 0.34375
r5840 n4242 n4313 2
r5841 n4312 n4313 0.1875
r5842 n4243 n4314 0.15384615384615385
r5843 n4313 n4314 0.4375
r5844 n4244 n4315 0.20000000000000001
r5845 n4314 n4315 0.71875
r5846 n4245 n4316 0.40000000000000002
r5847 n4315 n4316 0.46875
r5848 n4246 n4317 0.40000000000000002
r5849 n4316 n4317 0.3125
r5850 n4247 n4318 2
r5851 n4317 n4318 0.1875
r5852 n4248 n4319 0.66666666666666663
r5853 n4318 n4319 0.125
r5854 n4249 n4320 2
r5855 n4319 n4320 0.125
r5856 n4250 n4321 0.22222222222222221
r5857 n4320 n4321 0.3125
r5858 n4251 n4322 0.20000000000000001
r5859 n4321 n4322 0.59375
r5860 n4252 n4323 0.40000000000000002
r5861 n4322 n4323 0.46875
r5862 n4253 n4324 0.40000000000000002
r5863 n4323 n4324 0.3125
r5864 n4254 n4325 2
r5865 n4324 n4325 0.1875
r5866 n4255 n4326 1
r5867 n4325 n4326 0.09375
r5868 n4256 n4327 2
r5869 n4326 n4327 0.09375
r5870 n4257 n4328 2
r5871 n4327 n4328 0.0625
r5872 n4258 n4329 2
r5873 n4328 n4329 0.0625
r5874 n4259 n4330 0.5
r5875 n4329 n4330 0.15625
r5876 n4260 n4331 0.40000000000000002
r5877 n4330 n4331 0.28125
r5878 n4261 n4332 2
r5879 n4331 n4332 0.1875
r5880 n4262 n4333 0.20000000000000001
r5881 n4332 n4333 0.34375
r5882 n4263 n4334 0.66666666666666663
r5883 n4333 n4334 0.40625
r5884 n4264 n4335 0.33333333333333331
r5885 n4334 n4335 0.28125
r5886 n4265 n4336 1
r5887 n4335 n4336 0.25
r5888 n4266 n4337 2
r5889 n4336 n4337 0.09375
r5890 n4267 n4338 2
r5891 n4337 n4338 0.0625
r5892 n4268 n4339 0.33333333333333331
r5893 n4338 n4339 0.21875
r5894 n4269 n4340 0.40000000000000002
r5895 n4339 n4340 0.34375
r5896 n4270 n4341 2
r5897 n4340 n4341 0.1875
r5898 n4271 n4342 0.5
r5899 n4341 n4342 0.15625
r5900 n4272 n4343 0.40000000000000002
r5901 n4342 n4343 0.28125
r5902 n4273 n4344 0.40000000000000002
r5903 n4274 n4345 0.33333333333333331
r5904 n4344 n4345 0.34375
r5905 n4275 n4346 1
r5906 n4345 n4346 0.25
r5907 n4276 n4347 0.11764705882352941
r5908 n4346 n4347 0.59375
r5909 n4277 n4348 0.15384615384615385
r5910 n4347 n4348 0.9375
r5911 n4278 n4349 1
r5912 n4348 n4349 0.46875
r5913 n4279 n4350 1
r5914 n4349 n4350 0.125
r5915 n4280 n4351 0.5
r5916 n4350 n4351 0.1875
r5917 n4281 n4352 0.40000000000000002
r5918 n4351 n4352 0.28125
r5919 n4282 n4353 0.20000000000000001
r5920 n4283 n4354 0.080000000000000002
r5921 n4353 n4354 1.09375
r5922 n4284 n4355 2
r5923 n4354 n4355 0.8125
r5924 n4285 n4356 0.071428571428571425
r5925 n4355 n4356 0.90625
r5926 n4286 n4357 2
r5927 n4356 n4357 0.90625
r5928 n4287 n4358 0.080000000000000002
r5929 n4357 n4358 0.8125
r5930 n4288 n4359 0.20000000000000001
r5931 n4358 n4359 1.09375
r5932 n4289 n4360 0.04779411764705882
r5933 n4290 n4361 0.05078125
r5934 n4360 n4361 0.1875
r5935 n4291 n4362 0.40625
r5936 n4361 n4362 0.10227272727272728
r5937 n4292 n4363 0.027083333333333334
r5938 n4362 n4363 0.18181818181818182
r5939 n4293 n4364 0.40625
r5940 n4363 n4364 0.18181818181818182
r5941 n4294 n4365 0.05078125
r5942 n4364 n4365 0.10227272727272728
r5943 n4295 n4366 0.04779411764705882
r5944 n4365 n4366 0.1875
r5945 n4296 n4367 0.081250000000000003
r5946 n4366 n4367 0.15340909090909091
r5947 n4297 n4368 0.019817073170731708
r5948 n4367 n4368 0.28977272727272729
r5949 n4298 n4369 0.019817073170731708
r5950 n4368 n4369 0.46590909090909088
r5951 n4299 n4370 0.019817073170731708
r5952 n4369 n4370 0.46590909090909088
r5953 n4300 n4371 0.02389705882352941
r5954 n4370 n4371 0.42613636363636365
r5955 n4301 n4372 0.029653284671532845
r5956 n4371 n4372 0.34886363636363638
r5957 n4302 n4373 0.029438405797101448
r5958 n4372 n4373 0.3125
r5959 n4303 n4374 0.02389705882352941
r5960 n4373 n4374 0.34999999999999998
r5961 n4304 n4375 0.0625
r5962 n4374 n4375 0.26704545454545453
r5963 n4305 n4376 0.020312500000000001
r5964 n4375 n4376 0.30113636363636365
r5965 n4306 n4377 0.8125
r5966 n4376 n4377 0.23295454545454544
r5967 n4307 n4378 0.02462121212121212
r5968 n4377 n4378 0.19318181818181818
r5969 n4308 n4379 0.8125
r5970 n4378 n4379 0.19318181818181818
r5971 n4309 n4380 0.035326086956521736
r5972 n4379 n4380 0.13636363636363635
r5973 n4310 n4381 0.203125
r5974 n4380 n4381 0.15340909090909091
r5975 n4311 n4382 0.13541666666666666
r5976 n4381 n4382 0.056818181818181816
r5977 n4312 n4383 0.16250000000000001
r5978 n4382 n4383 0.0625
r5979 n4313 n4384 0.8125
r5980 n4383 n4384 0.034090909090909088
r5981 n4314 n4385 0.0625
r5982 n4384 n4385 0.079545454545454544
r5983 n4315 n4386 0.081250000000000003
r5984 n4385 n4386 0.13068181818181818
r5985 n4316 n4387 0.16250000000000001
r5986 n4386 n4387 0.085227272727272721
r5987 n4317 n4388 0.16250000000000001
r5988 n4387 n4388 0.056818181818181816
r5989 n4318 n4389 0.8125
r5990 n4388 n4389 0.034090909090909088
r5991 n4319 n4390 0.27083333333333331
r5992 n4389 n4390 0.022727272727272728
r5993 n4320 n4391 0.8125
r5994 n4390 n4391 0.022727272727272728
r5995 n4321 n4392 0.090277777777777776
r5996 n4391 n4392 0.056818181818181816
r5997 n4322 n4393 0.081250000000000003
r5998 n4392 n4393 0.10795454545454546
r5999 n4323 n4394 0.16250000000000001
r6000 n4393 n4394 0.085227272727272721
r6001 n4324 n4395 0.16250000000000001
r6002 n4394 n4395 0.056818181818181816
r6003 n4325 n4396 0.8125
r6004 n4395 n4396 0.034090909090909088
r6005 n4326 n4397 0.40625
r6006 n4396 n4397 0.017045454545454544
r6007 n4327 n4398 0.8125
r6008 n4397 n4398 0.017045454545454544
r6009 n4328 n4399 0.8125
r6010 n4398 n4399 0.011363636363636364
r6011 n4329 n4400 0.8125
r6012 n4399 n4400 0.011363636363636364
r6013 n4330 n4401 0.203125
r6014 n4400 n4401 0.028409090909090908
r6015 n4331 n4402 0.16250000000000001
r6016 n4401 n4402 0.05113636363636364
r6017 n4332 n4403 0.8125
r6018 n4402 n4403 0.034090909090909088
r6019 n4333 n4404 0.081250000000000003
r6020 n4403 n4404 0.0625
r6021 n4334 n4405 0.27083333333333331
r6022 n4404 n4405 0.073863636363636367
r6023 n4335 n4406 0.13541666666666666
r6024 n4405 n4406 0.05113636363636364
r6025 n4336 n4407 0.40625
r6026 n4406 n4407 0.045454545454545456
r6027 n4337 n4408 0.8125
r6028 n4407 n4408 0.017045454545454544
r6029 n4338 n4409 0.8125
r6030 n4408 n4409 0.011363636363636364
r6031 n4339 n4410 0.13541666666666666
r6032 n4409 n4410 0.039772727272727272
r6033 n4340 n4411 0.16250000000000001
r6034 n4410 n4411 0.0625
r6035 n4341 n4412 0.8125
r6036 n4411 n4412 0.034090909090909088
r6037 n4342 n4413 0.203125
r6038 n4412 n4413 0.028409090909090908
r6039 n4343 n4414 0.16250000000000001
r6040 n4413 n4414 0.05113636363636364
r6041 n4344 n4415 0.16250000000000001
r6042 n4345 n4416 0.13541666666666666
r6043 n4415 n4416 0.0625
r6044 n4346 n4417 0.40625
r6045 n4416 n4417 0.045454545454545456
r6046 n4347 n4418 0.04779411764705882
r6047 n4417 n4418 0.10795454545454546
r6048 n4348 n4419 0.0625
r6049 n4418 n4419 0.17045454545454544
r6050 n4349 n4420 0.40625
r6051 n4419 n4420 0.085227272727272721
r6052 n4350 n4421 0.40625
r6053 n4420 n4421 0.022727272727272728
r6054 n4351 n4422 0.203125
r6055 n4421 n4422 0.034090909090909088
r6056 n4352 n4423 0.16250000000000001
r6057 n4422 n4423 0.05113636363636364
r6058 n4353 n4424 0.081250000000000003
r6059 n4354 n4425 0.032500000000000001
r6060 n4424 n4425 0.19886363636363635
r6061 n4355 n4426 0.8125
r6062 n4425 n4426 0.14772727272727273
r6063 n4356 n4427 0.029017857142857144
r6064 n4426 n4427 0.16477272727272727
r6065 n4357 n4428 0.8125
r6066 n4427 n4428 0.16477272727272727
r6067 n4358 n4429 0.032500000000000001
r6068 n4428 n4429 0.14772727272727273
r6069 n4359 n4430 0.081250000000000003
r6070 n4429 n4430 0.19886363636363635
r6071 n4360 n4431 0.04779411764705882
r6072 n4361 n4432 0.05078125
r6073 n4431 n4432 1.03125
r6074 n4362 n4433 0.40625
r6075 n4432 n4433 0.5625
r6076 n4363 n4434 0.027083333333333334
r6077 n4433 n4434 1
r6078 n4364 n4435 0.40625
r6079 n4434 n4435 1
r6080 n4365 n4436 0.05078125
r6081 n4435 n4436 0.5625
r6082 n4366 n4437 0.04779411764705882
r6083 n4436 n4437 1.03125
r6084 n4393 n4438 0.081250000000000003
r6085 n4394 n4439 0.16250000000000001
r6086 n4438 n4439 0.46875
r6087 n4395 n4440 0.16250000000000001
r6088 n4439 n4440 0.3125
r6089 n4396 n4441 0.8125
r6090 n4440 n4441 0.1875
r6091 n4397 n4442 0.40625
r6092 n4441 n4442 0.09375
r6093 n4398 n4443 0.8125
r6094 n4442 n4443 0.09375
r6095 n4399 n4444 0.8125
r6096 n4443 n4444 0.0625
r6097 n4400 n4445 0.8125
r6098 n4444 n4445 0.0625
r6099 n4401 n4446 0.203125
r6100 n4445 n4446 0.15625
r6101 n4402 n4447 0.16250000000000001
r6102 n4446 n4447 0.28125
r6103 n4403 n4448 0.8125
r6104 n4447 n4448 0.1875
r6105 n4404 n4449 0.081250000000000003
r6106 n4448 n4449 0.34375
r6107 n4405 n4450 0.27083333333333331
r6108 n4449 n4450 0.40625
r6109 n4406 n4451 0.13541666666666666
r6110 n4450 n4451 0.28125
r6111 n4407 n4452 0.40625
r6112 n4451 n4452 0.25
r6113 n4408 n4453 0.8125
r6114 n4452 n4453 0.09375
r6115 n4409 n4454 0.8125
r6116 n4453 n4454 0.0625
r6117 n4410 n4455 0.13541666666666666
r6118 n4454 n4455 0.21875
r6119 n4411 n4456 0.16250000000000001
r6120 n4455 n4456 0.34375
r6121 n4412 n4457 0.8125
r6122 n4456 n4457 0.1875
r6123 n4413 n4458 0.203125
r6124 n4457 n4458 0.15625
r6125 n4414 n4459 0.16250000000000001
r6126 n4458 n4459 0.28125
r6127 n4415 n4460 0.16250000000000001
r6128 n4416 n4461 0.13541666666666666
r6129 n4460 n4461 0.34375
r6130 n4417 n4462 0.40625
r6131 n4461 n4462 0.25
r6132 n4418 n4463 0.04779411764705882
r6133 n4462 n4463 0.59375
r6134 n4419 n4464 0.0625
r6135 n4463 n4464 0.9375
r6136 n4420 n4465 0.40625
r6137 n4464 n4465 0.46875
r6138 n4421 n4466 0.40625
r6139 n4465 n4466 0.125
r6140 n4422 n4467 0.203125
r6141 n4466 n4467 0.1875
r6142 n4423 n4468 0.16250000000000001
r6143 n4467 n4468 0.28125
r6144 n4424 n4469 0.081250000000000003
r6145 n4425 n4470 0.032500000000000001
r6146 n4469 n4470 1.09375
r6147 n4426 n4471 0.8125
r6148 n4470 n4471 0.8125
r6149 n4427 n4472 0.029017857142857144
r6150 n4471 n4472 0.90625
r6151 n4428 n4473 0.8125
r6152 n4472 n4473 0.90625
r6153 n4429 n4474 0.032500000000000001
r6154 n4473 n4474 0.8125
r6155 n4430 n4475 0.081250000000000003
r6156 n4474 n4475 1.09375
r6157 n4431 n4476 0.13602941176470587
r6158 n4432 n4477 0.14453125
r6159 n4476 n4477 0.058928571428571427
r6160 n4433 n4478 1.15625
r6161 n4477 n4478 0.03214285714285714
r6162 n4434 n4479 0.077083333333333337
r6163 n4478 n4479 0.057142857142857141
r6164 n4435 n4480 1.15625
r6165 n4479 n4480 0.057142857142857141
r6166 n4436 n4481 0.14453125
r6167 n4480 n4481 0.03214285714285714
r6168 n4437 n4482 0.13602941176470587
r6169 n4481 n4482 0.058928571428571427
r6170 n4460 n4483 0.46250000000000002
r6171 n4461 n4484 0.38541666666666669
r6172 n4483 n4484 0.019642857142857142
r6173 n4462 n4485 1.15625
r6174 n4484 n4485 0.014285714285714285
r6175 n4463 n4486 0.13602941176470587
r6176 n4485 n4486 0.033928571428571426
r6177 n4464 n4487 0.17788461538461539
r6178 n4486 n4487 0.053571428571428568
r6179 n4465 n4488 1.15625
r6180 n4487 n4488 0.026785714285714284
r6181 n4466 n4489 1.15625
r6182 n4488 n4489 0.0071428571428571426
r6183 n4467 n4490 0.578125
r6184 n4489 n4490 0.010714285714285714
r6185 n4468 n4491 0.46250000000000002
r6186 n4490 n4491 0.01607142857142857
r6187 n4469 n4492 0.23125000000000001
r6188 n4470 n4493 0.092499999999999999
r6189 n4492 n4493 0.0625
r6190 n4471 n4494 2.3125
r6191 n4493 n4494 0.04642857142857143
r6192 n4472 n4495 0.082589285714285712
r6193 n4494 n4495 0.051785714285714289
r6194 n4473 n4496 2.3125
r6195 n4495 n4496 0.051785714285714289
r6196 n4474 n4497 0.092499999999999999
r6197 n4496 n4497 0.04642857142857143
r6198 n4475 n4498 0.23125000000000001
r6199 n4497 n4498 0.0625
r6200 n4476 n4499 0.25367647058823528
r6201 n4477 n4500 0.26953125
r6202 n4499 n4500 0.060661764705882353
r6203 n4478 n4501 2.15625
r6204 n4500 n4501 0.033088235294117647
r6205 n4479 n4502 0.14374999999999999
r6206 n4501 n4502 0.058823529411764705
r6207 n4480 n4503 2.15625
r6208 n4502 n4503 0.058823529411764705
r6209 n4481 n4504 0.26953125
r6210 n4503 n4504 0.033088235294117647
r6211 n4482 n4505 0.25367647058823528
r6212 n4504 n4505 0.060661764705882353
r6213 n4483 n4506 0.86250000000000004
r6214 n4484 n4507 0.71875
r6215 n4506 n4507 0.020220588235294119
r6216 n4485 n4508 2.15625
r6217 n4507 n4508 0.014705882352941176
r6218 n4486 n4509 0.25367647058823528
r6219 n4508 n4509 0.034926470588235295
r6220 n4487 n4510 0.33173076923076922
r6221 n4509 n4510 0.05514705882352941
r6222 n4488 n4511 2.15625
r6223 n4510 n4511 0.027573529411764705
r6224 n4489 n4512 2.15625
r6225 n4511 n4512 0.0073529411764705881
r6226 n4490 n4513 1.078125
r6227 n4512 n4513 0.011029411764705883
r6228 n4491 n4514 0.86250000000000004
r6229 n4513 n4514 0.016544117647058824
r6230 n4492 n4515 0.43125000000000002
r6231 n4493 n4516 0.17249999999999999
r6232 n4515 n4516 0.064338235294117641
r6233 n4494 n4517 4.3125
r6234 n4516 n4517 0.04779411764705882
r6235 n4495 n4518 0.15401785714285715
r6236 n4517 n4518 0.053308823529411763
r6237 n4496 n4519 4.3125
r6238 n4518 n4519 0.053308823529411763
r6239 n4497 n4520 0.17249999999999999
r6240 n4519 n4520 0.04779411764705882
r6241 n4498 n4521 0.43125000000000002
r6242 n4520 n4521 0.064338235294117641
r6243 n4499 n4522 0.15073529411764705
r6244 n4500 n4523 0.16015625
r6245 n4522 n4523 0.29464285714285715
r6246 n4501 n4524 1.28125
r6247 n4523 n4524 0.16071428571428573
r6248 n4502 n4525 0.085416666666666669
r6249 n4524 n4525 0.2857142857142857
r6250 n4503 n4526 1.28125
r6251 n4525 n4526 0.2857142857142857
r6252 n4504 n4527 0.16015625
r6253 n4526 n4527 0.16071428571428573
r6254 n4505 n4528 0.15073529411764705
r6255 n4527 n4528 0.29464285714285715
r6256 n4506 n4529 0.51249999999999996
r6257 n4507 n4530 0.42708333333333331
r6258 n4529 n4530 0.098214285714285712
r6259 n4508 n4531 1.28125
r6260 n4530 n4531 0.071428571428571425
r6261 n4509 n4532 0.15073529411764705
r6262 n4531 n4532 0.16964285714285715
r6263 n4510 n4533 0.19711538461538461
r6264 n4532 n4533 0.26785714285714285
r6265 n4511 n4534 1.28125
r6266 n4533 n4534 0.13392857142857142
r6267 n4512 n4535 1.28125
r6268 n4534 n4535 0.035714285714285712
r6269 n4513 n4536 0.640625
r6270 n4535 n4536 0.053571428571428568
r6271 n4514 n4537 0.51249999999999996
r6272 n4536 n4537 0.080357142857142863
r6273 n4515 n4538 0.25624999999999998
r6274 n4516 n4539 0.10249999999999999
r6275 n4538 n4539 0.3125
r6276 n4517 n4540 2.5625
r6277 n4539 n4540 0.23214285714285715
r6278 n4518 n4541 0.091517857142857137
r6279 n4540 n4541 0.25892857142857145
r6280 n4519 n4542 2.5625
r6281 n4541 n4542 0.25892857142857145
r6282 n4520 n4543 0.10249999999999999
r6283 n4542 n4543 0.23214285714285715
r6284 n4521 n4544 0.25624999999999998
r6285 n4543 n4544 0.3125
r6286 n4522 n4545 0.033088235294117647
r6287 n4523 n4546 0.03515625
r6288 n4545 n4546 1.03125
r6289 n4524 n4547 0.28125
r6290 n4546 n4547 0.5625
r6291 n4525 n4548 0.018749999999999999
r6292 n4547 n4548 1
r6293 n4526 n4549 0.28125
r6294 n4548 n4549 1
r6295 n4527 n4550 0.03515625
r6296 n4549 n4550 0.5625
r6297 n4528 n4551 0.033088235294117647
r6298 n4550 n4551 1.03125
r6299 n4552 n4553 0.46875
r6300 n4553 n4554 0.3125
r6301 n4554 n4555 0.1875
r6302 n4555 n4556 0.125
r6303 n4556 n4557 0.125
r6304 n4557 n4558 0.3125
r6305 n4558 n4559 0.59375
r6306 n4559 n4560 0.46875
r6307 n4560 n4561 0.3125
r6308 n4561 n4562 0.1875
r6309 n4562 n4563 0.09375
r6310 n4563 n4564 0.09375
r6311 n4564 n4565 0.0625
r6312 n4565 n4566 0.0625
r6313 n4566 n4567 0.15625
r6314 n4567 n4568 0.28125
r6315 n4568 n4569 0.1875
r6316 n4569 n4570 0.34375
r6317 n4529 n4571 0.1125
r6318 n4530 n4572 0.09375
r6319 n4571 n4572 0.34375
r6320 n4531 n4573 0.28125
r6321 n4572 n4573 0.25
r6322 n4532 n4574 0.033088235294117647
r6323 n4573 n4574 0.59375
r6324 n4533 n4575 0.043269230769230768
r6325 n4574 n4575 0.9375
r6326 n4534 n4576 0.28125
r6327 n4575 n4576 0.46875
r6328 n4535 n4577 0.28125
r6329 n4576 n4577 0.125
r6330 n4536 n4578 0.140625
r6331 n4577 n4578 0.1875
r6332 n4537 n4579 0.1125
r6333 n4578 n4579 0.28125
r6334 n4538 n4580 0.056250000000000001
r6335 n4539 n4581 0.022499999999999999
r6336 n4580 n4581 1.09375
r6337 n4540 n4582 0.5625
r6338 n4581 n4582 0.8125
r6339 n4541 n4583 0.020089285714285716
r6340 n4582 n4583 0.90625
r6341 n4542 n4584 0.5625
r6342 n4583 n4584 0.90625
r6343 n4543 n4585 0.022499999999999999
r6344 n4584 n4585 0.8125
r6345 n4544 n4586 0.056250000000000001
r6346 n4585 n4586 1.09375
r6347 n4545 n4587 0.025735294117647058
r6348 n4546 n4588 0.02734375
r6349 n4587 n4588 0.41249999999999998
r6350 n4547 n4589 0.21875
r6351 n4588 n4589 0.22500000000000001
r6352 n4548 n4590 0.014583333333333334
r6353 n4589 n4590 0.40000000000000002
r6354 n4549 n4591 0.21875
r6355 n4590 n4591 0.40000000000000002
r6356 n4550 n4592 0.02734375
r6357 n4591 n4592 0.22500000000000001
r6358 n4551 n4593 0.025735294117647058
r6359 n4592 n4593 0.41249999999999998
r6360 n4593 n4594 0.33750000000000002
r6361 n4594 n4595 0.63749999999999996
r6362 n4595 n4596 1.0249999999999999
r6363 n4596 n4597 1.0249999999999999
r6364 n4597 n4598 0.9375
r6365 n4598 n4599 0.76749999999999996
r6366 n4599 n4600 0.6875
r6367 n4600 n4601 0.77000000000000002
r6368 n4601 n4602 0.58750000000000002
r6369 n4602 n4603 0.66249999999999998
r6370 n4603 n4604 0.51249999999999996
r6371 n4604 n4605 0.42499999999999999
r6372 n4605 n4606 0.42499999999999999
r6373 n4606 n4607 0.29999999999999999
r6374 n4607 n4608 0.33750000000000002
r6375 n4608 n4609 0.125
r6376 n4609 n4610 0.13750000000000001
r6377 n4610 n4611 0.074999999999999997
r6378 n4611 n4612 0.17499999999999999
r6379 n4552 n4613 0.043749999999999997
r6380 n4612 n4613 0.28749999999999998
r6381 n4553 n4614 0.087499999999999994
r6382 n4613 n4614 0.1875
r6383 n4554 n4615 0.087499999999999994
r6384 n4614 n4615 0.125
r6385 n4555 n4616 0.4375
r6386 n4615 n4616 0.074999999999999997
r6387 n4556 n4617 0.14583333333333334
r6388 n4616 n4617 0.050000000000000003
r6389 n4557 n4618 0.4375
r6390 n4617 n4618 0.050000000000000003
r6391 n4558 n4619 0.048611111111111112
r6392 n4618 n4619 0.125
r6393 n4559 n4620 0.043749999999999997
r6394 n4619 n4620 0.23749999999999999
r6395 n4560 n4621 0.087499999999999994
r6396 n4620 n4621 0.1875
r6397 n4561 n4622 0.087499999999999994
r6398 n4621 n4622 0.125
r6399 n4562 n4623 0.4375
r6400 n4622 n4623 0.074999999999999997
r6401 n4563 n4624 0.21875
r6402 n4623 n4624 0.037499999999999999
r6403 n4564 n4625 0.4375
r6404 n4624 n4625 0.037499999999999999
r6405 n4565 n4626 0.4375
r6406 n4625 n4626 0.025000000000000001
r6407 n4566 n4627 0.4375
r6408 n4626 n4627 0.025000000000000001
r6409 n4567 n4628 0.109375
r6410 n4627 n4628 0.0625
r6411 n4568 n4629 0.087499999999999994
r6412 n4628 n4629 0.1125
r6413 n4569 n4630 0.4375
r6414 n4629 n4630 0.074999999999999997
r6415 n4570 n4631 0.043749999999999997
r6416 n4630 n4631 0.13750000000000001
r6417 n4571 n4632 0.087499999999999994
r6418 n4572 n4633 0.072916666666666671
r6419 n4632 n4633 0.13750000000000001
r6420 n4573 n4634 0.21875
r6421 n4633 n4634 0.10000000000000001
r6422 n4574 n4635 0.025735294117647058
r6423 n4634 n4635 0.23749999999999999
r6424 n4575 n4636 0.033653846153846152
r6425 n4635 n4636 0.375
r6426 n4576 n4637 0.21875
r6427 n4636 n4637 0.1875
r6428 n4577 n4638 0.21875
r6429 n4637 n4638 0.050000000000000003
r6430 n4578 n4639 0.109375
r6431 n4638 n4639 0.074999999999999997
r6432 n4579 n4640 0.087499999999999994
r6433 n4639 n4640 0.1125
r6434 n4580 n4641 0.043749999999999997
r6435 n4581 n4642 0.017500000000000002
r6436 n4641 n4642 0.4375
r6437 n4582 n4643 0.4375
r6438 n4642 n4643 0.32500000000000001
r6439 n4583 n4644 0.015625
r6440 n4643 n4644 0.36249999999999999
r6441 n4584 n4645 0.4375
r6442 n4644 n4645 0.36249999999999999
r6443 n4585 n4646 0.017500000000000002
r6444 n4645 n4646 0.32500000000000001
r6445 n4586 n4647 0.043749999999999997
r6446 n4646 n4647 0.4375
r6447 n4587 n4648 0.040441176470588237
r6448 n4588 n4649 0.04296875
r6449 n4648 n4649 0.34375
r6450 n4589 n4650 0.34375
r6451 n4649 n4650 0.1875
r6452 n4590 n4651 0.022916666666666665
r6453 n4650 n4651 0.33333333333333331
r6454 n4591 n4652 0.34375
r6455 n4651 n4652 0.33333333333333331
r6456 n4592 n4653 0.04296875
r6457 n4652 n4653 0.1875
r6458 n4593 n4654 0.040441176470588237
r6459 n4653 n4654 0.34375
r6460 n4594 n4655 0.068750000000000006
r6461 n4654 n4655 0.28125
r6462 n4595 n4656 0.01676829268292683
r6463 n4655 n4656 0.53125
r6464 n4596 n4657 0.01676829268292683
r6465 n4656 n4657 0.85416666666666663
r6466 n4597 n4658 0.01676829268292683
r6467 n4657 n4658 0.85416666666666663
r6468 n4598 n4659 0.020220588235294119
r6469 n4658 n4659 0.78125
r6470 n4599 n4660 0.025091240875912409
r6471 n4659 n4660 0.63958333333333328
r6472 n4600 n4661 0.024909420289855072
r6473 n4660 n4661 0.57291666666666663
r6474 n4601 n4662 0.020220588235294119
r6475 n4661 n4662 0.64166666666666672
r6476 n4602 n4663 0.052884615384615384
r6477 n4662 n4663 0.48958333333333331
r6478 n4603 n4664 0.017187500000000001
r6479 n4663 n4664 0.55208333333333337
r6480 n4604 n4665 0.6875
r6481 n4664 n4665 0.42708333333333331
r6482 n4605 n4666 0.020833333333333332
r6483 n4665 n4666 0.35416666666666669
r6484 n4606 n4667 0.6875
r6485 n4666 n4667 0.35416666666666669
r6486 n4607 n4668 0.029891304347826088
r6487 n4667 n4668 0.25
r6488 n4608 n4669 0.171875
r6489 n4668 n4669 0.28125
r6490 n4609 n4670 0.11458333333333333
r6491 n4669 n4670 0.10416666666666667
r6492 n4610 n4671 0.13750000000000001
r6493 n4670 n4671 0.11458333333333333
r6494 n4611 n4672 0.6875
r6495 n4671 n4672 0.0625
r6496 n4612 n4673 0.052884615384615384
r6497 n4672 n4673 0.14583333333333334
r6498 n4613 n4674 0.068750000000000006
r6499 n4673 n4674 0.23958333333333334
r6500 n4614 n4675 0.13750000000000001
r6501 n4674 n4675 0.15625
r6502 n4615 n4676 0.13750000000000001
r6503 n4675 n4676 0.10416666666666667
r6504 n4616 n4677 0.6875
r6505 n4676 n4677 0.0625
r6506 n4617 n4678 0.22916666666666666
r6507 n4677 n4678 0.041666666666666664
r6508 n4618 n4679 0.6875
r6509 n4678 n4679 0.041666666666666664
r6510 n4619 n4680 0.076388888888888895
r6511 n4679 n4680 0.10416666666666667
r6512 n4620 n4681 0.068750000000000006
r6513 n4680 n4681 0.19791666666666666
r6514 n4621 n4682 0.13750000000000001
r6515 n4681 n4682 0.15625
r6516 n4622 n4683 0.13750000000000001
r6517 n4682 n4683 0.10416666666666667
r6518 n4623 n4684 0.6875
r6519 n4683 n4684 0.0625
r6520 n4624 n4685 0.34375
r6521 n4684 n4685 0.03125
r6522 n4625 n4686 0.6875
r6523 n4685 n4686 0.03125
r6524 n4626 n4687 0.6875
r6525 n4686 n4687 0.020833333333333332
r6526 n4627 n4688 0.6875
r6527 n4687 n4688 0.020833333333333332
r6528 n4628 n4689 0.171875
r6529 n4688 n4689 0.052083333333333336
r6530 n4629 n4690 0.13750000000000001
r6531 n4689 n4690 0.09375
r6532 n4630 n4691 0.6875
r6533 n4690 n4691 0.0625
r6534 n4631 n4692 0.068750000000000006
r6535 n4691 n4692 0.11458333333333333
r6536 n4632 n4693 0.13750000000000001
r6537 n4633 n4694 0.11458333333333333
r6538 n4693 n4694 0.11458333333333333
r6539 n4634 n4695 0.34375
r6540 n4694 n4695 0.083333333333333329
r6541 n4635 n4696 0.040441176470588237
r6542 n4695 n4696 0.19791666666666666
r6543 n4636 n4697 0.052884615384615384
r6544 n4696 n4697 0.3125
r6545 n4637 n4698 0.34375
r6546 n4697 n4698 0.15625
r6547 n4638 n4699 0.34375
r6548 n4698 n4699 0.041666666666666664
r6549 n4639 n4700 0.171875
r6550 n4699 n4700 0.0625
r6551 n4640 n4701 0.13750000000000001
r6552 n4700 n4701 0.09375
r6553 n4641 n4702 0.068750000000000006
r6554 n4642 n4703 0.0275
r6555 n4702 n4703 0.36458333333333331
r6556 n4643 n4704 0.6875
r6557 n4703 n4704 0.27083333333333331
r6558 n4644 n4705 0.024553571428571428
r6559 n4704 n4705 0.30208333333333331
r6560 n4645 n4706 0.6875
r6561 n4705 n4706 0.30208333333333331
r6562 n4646 n4707 0.0275
r6563 n4706 n4707 0.27083333333333331
r6564 n4647 n4708 0.068750000000000006
r6565 n4707 n4708 0.36458333333333331
r6566 n4648 n4709 0.029411764705882353
r6567 n4649 n4710 0.03125
r6568 n4709 n4710 1.03125
r6569 n4650 n4711 0.25
r6570 n4710 n4711 0.5625
r6571 n4651 n4712 0.016666666666666666
r6572 n4711 n4712 1
r6573 n4652 n4713 0.25
r6574 n4712 n4713 1
r6575 n4653 n4714 0.03125
r6576 n4713 n4714 0.5625
r6577 n4654 n4715 0.029411764705882353
r6578 n4714 n4715 1.03125
r6579 n4655 n4716 0.050000000000000003
r6580 n4715 n4716 0.84375
r6581 n4656 n4717 0.012195121951219513
r6582 n4716 n4717 1.59375
r6583 n4657 n4718 0.012195121951219513
r6584 n4717 n4718 2.5625
r6585 n4658 n4719 0.012195121951219513
r6586 n4718 n4719 2.5625
r6587 n4659 n4720 0.014705882352941176
r6588 n4719 n4720 2.34375
r6589 n4660 n4721 0.01824817518248175
r6590 n4720 n4721 1.91875
r6591 n4661 n4722 0.018115942028985508
r6592 n4721 n4722 1.71875
r6593 n4662 n4723 0.014705882352941176
r6594 n4722 n4723 1.925
r6595 n4663 n4724 0.038461538461538464
r6596 n4723 n4724 1.46875
r6597 n4664 n4725 0.012500000000000001
r6598 n4724 n4725 1.65625
r6599 n4665 n4726 0.5
r6600 n4725 n4726 1.28125
r6601 n4666 n4727 0.015151515151515152
r6602 n4726 n4727 1.0625
r6603 n4667 n4728 0.5
r6604 n4727 n4728 1.0625
r6605 n4668 n4729 0.021739130434782608
r6606 n4728 n4729 0.75
r6607 n4669 n4730 0.125
r6608 n4729 n4730 0.84375
r6609 n4670 n4731 0.083333333333333329
r6610 n4730 n4731 0.3125
r6611 n4671 n4732 0.10000000000000001
r6612 n4731 n4732 0.34375
r6613 n4672 n4733 0.5
r6614 n4732 n4733 0.1875
r6615 n4673 n4734 0.038461538461538464
r6616 n4733 n4734 0.4375
r6617 n4674 n4735 0.050000000000000003
r6618 n4734 n4735 0.71875
r6619 n4675 n4736 0.10000000000000001
r6620 n4735 n4736 0.46875
r6621 n4676 n4737 0.10000000000000001
r6622 n4736 n4737 0.3125
r6623 n4677 n4738 0.5
r6624 n4737 n4738 0.1875
r6625 n4678 n4739 0.16666666666666666
r6626 n4738 n4739 0.125
r6627 n4679 n4740 0.5
r6628 n4739 n4740 0.125
r6629 n4680 n4741 0.055555555555555552
r6630 n4740 n4741 0.3125
r6631 n4681 n4742 0.050000000000000003
r6632 n4741 n4742 0.59375
r6633 n4682 n4743 0.10000000000000001
r6634 n4742 n4743 0.46875
r6635 n4683 n4744 0.10000000000000001
r6636 n4743 n4744 0.3125
r6637 n4684 n4745 0.5
r6638 n4744 n4745 0.1875
r6639 n4685 n4746 0.25
r6640 n4745 n4746 0.09375
r6641 n4686 n4747 0.5
r6642 n4746 n4747 0.09375
r6643 n4687 n4748 0.5
r6644 n4747 n4748 0.0625
r6645 n4688 n4749 0.5
r6646 n4748 n4749 0.0625
r6647 n4689 n4750 0.125
r6648 n4749 n4750 0.15625
r6649 n4690 n4751 0.10000000000000001
r6650 n4750 n4751 0.28125
r6651 n4691 n4752 0.5
r6652 n4751 n4752 0.1875
r6653 n4692 n4753 0.050000000000000003
r6654 n4752 n4753 0.34375
r6655 n4693 n4754 0.10000000000000001
r6656 n4694 n4755 0.083333333333333329
r6657 n4754 n4755 0.34375
r6658 n4695 n4756 0.25
r6659 n4755 n4756 0.25
r6660 n4696 n4757 0.029411764705882353
r6661 n4756 n4757 0.59375
r6662 n4697 n4758 0.038461538461538464
r6663 n4757 n4758 0.9375
r6664 n4698 n4759 0.25
r6665 n4758 n4759 0.46875
r6666 n4699 n4760 0.25
r6667 n4759 n4760 0.125
r6668 n4700 n4761 0.125
r6669 n4760 n4761 0.1875
r6670 n4701 n4762 0.10000000000000001
r6671 n4761 n4762 0.28125
r6672 n4702 n4763 0.050000000000000003
r6673 n4703 n4764 0.02
r6674 n4763 n4764 1.09375
r6675 n4704 n4765 0.5
r6676 n4764 n4765 0.8125
r6677 n4705 n4766 0.017857142857142856
r6678 n4765 n4766 0.90625
r6679 n4706 n4767 0.5
r6680 n4766 n4767 0.90625
r6681 n4707 n4768 0.02
r6682 n4767 n4768 0.8125
r6683 n4708 n4769 0.050000000000000003
r6684 n4768 n4769 1.09375
r6685 n4709 n4770 0.066176470588235295
r6686 n4710 n4771 0.0703125
r6687 n4770 n4771 0.12890625
r6688 n4711 n4772 0.5625
r6689 n4771 n4772 0.0703125
r6690 n4712 n4773 0.037499999999999999
r6691 n4772 n4773 0.125
r6692 n4713 n4774 0.5625
r6693 n4773 n4774 0.125
r6694 n4714 n4775 0.0703125
r6695 n4774 n4775 0.0703125
r6696 n4715 n4776 0.066176470588235295
r6697 n4775 n4776 0.12890625
r6698 n4716 n4777 0.1125
r6699 n4776 n4777 0.10546875
r6700 n4717 n4778 0.027439024390243903
r6701 n4777 n4778 0.19921875
r6702 n4718 n4779 0.027439024390243903
r6703 n4778 n4779 0.3203125
r6704 n4719 n4780 0.027439024390243903
r6705 n4779 n4780 0.3203125
r6706 n4720 n4781 0.033088235294117647
r6707 n4780 n4781 0.29296875
r6708 n4721 n4782 0.04105839416058394
r6709 n4781 n4782 0.23984374999999999
r6710 n4722 n4783 0.040760869565217392
r6711 n4782 n4783 0.21484375
r6712 n4723 n4784 0.033088235294117647
r6713 n4783 n4784 0.24062500000000001
r6714 n4724 n4785 0.086538461538461536
r6715 n4784 n4785 0.18359375
r6716 n4725 n4786 0.028125000000000001
r6717 n4785 n4786 0.20703125
r6718 n4726 n4787 1.125
r6719 n4786 n4787 0.16015625
r6720 n4727 n4788 0.034090909090909088
r6721 n4787 n4788 0.1328125
r6722 n4728 n4789 1.125
r6723 n4788 n4789 0.1328125
r6724 n4729 n4790 0.048913043478260872
r6725 n4789 n4790 0.09375
r6726 n4730 n4791 0.28125
r6727 n4790 n4791 0.10546875
r6728 n4731 n4792 0.1875
r6729 n4791 n4792 0.0390625
r6730 n4732 n4793 0.22500000000000001
r6731 n4792 n4793 0.04296875
r6732 n4733 n4794 1.125
r6733 n4793 n4794 0.0234375
r6734 n4734 n4795 0.086538461538461536
r6735 n4794 n4795 0.0546875
r6736 n4735 n4796 0.1125
r6737 n4795 n4796 0.08984375
r6738 n4736 n4797 0.22500000000000001
r6739 n4796 n4797 0.05859375
r6740 n4737 n4798 0.22500000000000001
r6741 n4797 n4798 0.0390625
r6742 n4738 n4799 1.125
r6743 n4798 n4799 0.0234375
r6744 n4739 n4800 0.375
r6745 n4799 n4800 0.015625
r6746 n4740 n4801 1.125
r6747 n4800 n4801 0.015625
r6748 n4741 n4802 0.125
r6749 n4801 n4802 0.0390625
r6750 n4742 n4803 0.1125
r6751 n4802 n4803 0.07421875
r6752 n4743 n4804 0.22500000000000001
r6753 n4803 n4804 0.05859375
r6754 n4744 n4805 0.22500000000000001
r6755 n4804 n4805 0.0390625
r6756 n4745 n4806 1.125
r6757 n4805 n4806 0.0234375
r6758 n4746 n4807 0.5625
r6759 n4806 n4807 0.01171875
r6760 n4747 n4808 1.125
r6761 n4807 n4808 0.01171875
r6762 n4748 n4809 1.125
r6763 n4808 n4809 0.0078125
r6764 n4749 n4810 1.125
r6765 n4809 n4810 0.0078125
r6766 n4750 n4811 0.28125
r6767 n4810 n4811 0.01953125
r6768 n4751 n4812 0.22500000000000001
r6769 n4811 n4812 0.03515625
r6770 n4752 n4813 1.125
r6771 n4812 n4813 0.0234375
r6772 n4753 n4814 0.1125
r6773 n4813 n4814 0.04296875
r6774 n4754 n4815 0.22500000000000001
r6775 n4755 n4816 0.1875
r6776 n4815 n4816 0.04296875
r6777 n4756 n4817 0.5625
r6778 n4816 n4817 0.03125
r6779 n4757 n4818 0.066176470588235295
r6780 n4817 n4818 0.07421875
r6781 n4758 n4819 0.086538461538461536
r6782 n4818 n4819 0.1171875
r6783 n4759 n4820 0.5625
r6784 n4819 n4820 0.05859375
r6785 n4760 n4821 0.5625
r6786 n4820 n4821 0.015625
r6787 n4761 n4822 0.28125
r6788 n4821 n4822 0.0234375
r6789 n4762 n4823 0.22500000000000001
r6790 n4822 n4823 0.03515625
r6791 n4763 n4824 0.1125
r6792 n4764 n4825 0.044999999999999998
r6793 n4824 n4825 0.13671875
r6794 n4765 n4826 1.125
r6795 n4825 n4826 0.1015625
r6796 n4766 n4827 0.040178571428571432
r6797 n4826 n4827 0.11328125
r6798 n4767 n4828 1.125
r6799 n4827 n4828 0.11328125
r6800 n4768 n4829 0.044999999999999998
r6801 n4828 n4829 0.1015625
r6802 n4769 n4830 0.1125
r6803 n4829 n4830 0.13671875
r6804 n4770 n4831 0.11029411764705882
r6805 n4771 n4832 0.1171875
r6806 n4831 n4832 0.14732142857142858
r6807 n4772 n4833 0.9375
r6808 n4832 n4833 0.080357142857142863
r6809 n4773 n4834 0.0625
r6810 n4833 n4834 0.14285714285714285
r6811 n4774 n4835 0.9375
r6812 n4834 n4835 0.14285714285714285
r6813 n4775 n4836 0.1171875
r6814 n4835 n4836 0.080357142857142863
r6815 n4776 n4837 0.11029411764705882
r6816 n4836 n4837 0.14732142857142858
r6817 n4777 n4838 0.1875
r6818 n4837 n4838 0.12053571428571429
r6819 n4778 n4839 0.04573170731707317
r6820 n4838 n4839 0.22767857142857142
r6821 n4779 n4840 0.04573170731707317
r6822 n4839 n4840 0.36607142857142855
r6823 n4780 n4841 0.04573170731707317
r6824 n4840 n4841 0.36607142857142855
r6825 n4781 n4842 0.05514705882352941
r6826 n4841 n4842 0.33482142857142855
r6827 n4782 n4843 0.068430656934306569
r6828 n4842 n4843 0.27410714285714288
r6829 n4783 n4844 0.067934782608695649
r6830 n4843 n4844 0.24553571428571427
r6831 n4784 n4845 0.05514705882352941
r6832 n4844 n4845 0.27500000000000002
r6833 n4785 n4846 0.14423076923076922
r6834 n4845 n4846 0.20982142857142858
r6835 n4786 n4847 0.046875
r6836 n4846 n4847 0.23660714285714285
r6837 n4787 n4848 1.875
r6838 n4847 n4848 0.18303571428571427
r6839 n4788 n4849 0.056818181818181816
r6840 n4848 n4849 0.15178571428571427
r6841 n4789 n4850 1.875
r6842 n4849 n4850 0.15178571428571427
r6843 n4790 n4851 0.081521739130434784
r6844 n4850 n4851 0.10714285714285714
r6845 n4791 n4852 0.46875
r6846 n4851 n4852 0.12053571428571429
r6847 n4792 n4853 0.3125
r6848 n4852 n4853 0.044642857142857144
r6849 n4793 n4854 0.375
r6850 n4853 n4854 0.049107142857142856
r6851 n4794 n4855 1.875
r6852 n4854 n4855 0.026785714285714284
r6853 n4795 n4856 0.14423076923076922
r6854 n4855 n4856 0.0625
r6855 n4796 n4857 0.1875
r6856 n4856 n4857 0.10267857142857142
r6857 n4797 n4858 0.375
r6858 n4857 n4858 0.066964285714285712
r6859 n4798 n4859 0.375
r6860 n4858 n4859 0.044642857142857144
r6861 n4799 n4860 1.875
r6862 n4859 n4860 0.026785714285714284
r6863 n4800 n4861 0.625
r6864 n4860 n4861 0.017857142857142856
r6865 n4801 n4862 1.875
r6866 n4861 n4862 0.017857142857142856
r6867 n4802 n4863 0.20833333333333334
r6868 n4862 n4863 0.044642857142857144
r6869 n4803 n4864 0.1875
r6870 n4863 n4864 0.084821428571428575
r6871 n4804 n4865 0.375
r6872 n4864 n4865 0.066964285714285712
r6873 n4805 n4866 0.375
r6874 n4865 n4866 0.044642857142857144
r6875 n4806 n4867 1.875
r6876 n4866 n4867 0.026785714285714284
r6877 n4807 n4868 0.9375
r6878 n4867 n4868 0.013392857142857142
r6879 n4808 n4869 1.875
r6880 n4868 n4869 0.013392857142857142
r6881 n4809 n4870 1.875
r6882 n4869 n4870 0.0089285714285714281
r6883 n4810 n4871 1.875
r6884 n4870 n4871 0.0089285714285714281
r6885 n4811 n4872 0.46875
r6886 n4871 n4872 0.022321428571428572
r6887 n4812 n4873 0.375
r6888 n4872 n4873 0.040178571428571432
r6889 n4813 n4874 1.875
r6890 n4873 n4874 0.026785714285714284
r6891 n4814 n4875 0.1875
r6892 n4874 n4875 0.049107142857142856
r6893 n4815 n4876 0.375
r6894 n4816 n4877 0.3125
r6895 n4876 n4877 0.049107142857142856
r6896 n4817 n4878 0.9375
r6897 n4877 n4878 0.035714285714285712
r6898 n4818 n4879 0.11029411764705882
r6899 n4878 n4879 0.084821428571428575
r6900 n4819 n4880 0.14423076923076922
r6901 n4879 n4880 0.13392857142857142
r6902 n4820 n4881 0.9375
r6903 n4880 n4881 0.066964285714285712
r6904 n4821 n4882 0.9375
r6905 n4881 n4882 0.017857142857142856
r6906 n4822 n4883 0.46875
r6907 n4882 n4883 0.026785714285714284
r6908 n4823 n4884 0.375
r6909 n4883 n4884 0.040178571428571432
r6910 n4824 n4885 0.1875
r6911 n4825 n4886 0.074999999999999997
r6912 n4885 n4886 0.15625
r6913 n4826 n4887 1.875
r6914 n4886 n4887 0.11607142857142858
r6915 n4827 n4888 0.066964285714285712
r6916 n4887 n4888 0.12946428571428573
r6917 n4828 n4889 1.875
r6918 n4888 n4889 0.12946428571428573
r6919 n4829 n4890 0.074999999999999997
r6920 n4889 n4890 0.11607142857142858
r6921 n4830 n4891 0.1875
r6922 n4890 n4891 0.15625
r6923 n4831 n4892 0.058823529411764705
r6924 n4832 n4893 0.0625
r6925 n4892 n4893 1.03125
r6926 n4833 n4894 0.5
r6927 n4893 n4894 0.5625
r6928 n4834 n4895 0.033333333333333333
r6929 n4894 n4895 1
r6930 n4835 n4896 0.5
r6931 n4895 n4896 1
r6932 n4836 n4897 0.0625
r6933 n4896 n4897 0.5625
r6934 n4837 n4898 0.058823529411764705
r6935 n4897 n4898 1.03125
r6936 n4838 n4899 0.10000000000000001
r6937 n4898 n4899 0.84375
r6938 n4839 n4900 0.024390243902439025
r6939 n4899 n4900 1.59375
r6940 n4840 n4901 0.024390243902439025
r6941 n4900 n4901 2.5625
r6942 n4841 n4902 0.024390243902439025
r6943 n4901 n4902 2.5625
r6944 n4842 n4903 0.029411764705882353
r6945 n4902 n4903 2.34375
r6946 n4843 n4904 0.036496350364963501
r6947 n4903 n4904 1.91875
r6948 n4844 n4905 0.036231884057971016
r6949 n4904 n4905 1.71875
r6950 n4845 n4906 0.029411764705882353
r6951 n4905 n4906 1.925
r6952 n4846 n4907 0.076923076923076927
r6953 n4906 n4907 1.46875
r6954 n4847 n4908 0.025000000000000001
r6955 n4907 n4908 1.65625
r6956 n4848 n4909 1
r6957 n4908 n4909 1.28125
r6958 n4849 n4910 0.030303030303030304
r6959 n4909 n4910 1.0625
r6960 n4850 n4911 1
r6961 n4910 n4911 1.0625
r6962 n4851 n4912 0.043478260869565216
r6963 n4911 n4912 0.75
r6964 n4852 n4913 0.25
r6965 n4912 n4913 0.84375
r6966 n4853 n4914 0.16666666666666666
r6967 n4913 n4914 0.3125
r6968 n4854 n4915 0.20000000000000001
r6969 n4914 n4915 0.34375
r6970 n4855 n4916 1
r6971 n4915 n4916 0.1875
r6972 n4856 n4917 0.076923076923076927
r6973 n4916 n4917 0.4375
r6974 n4857 n4918 0.10000000000000001
r6975 n4917 n4918 0.71875
r6976 n4858 n4919 0.20000000000000001
r6977 n4918 n4919 0.46875
r6978 n4859 n4920 0.20000000000000001
r6979 n4919 n4920 0.3125
r6980 n4860 n4921 1
r6981 n4920 n4921 0.1875
r6982 n4861 n4922 0.33333333333333331
r6983 n4921 n4922 0.125
r6984 n4862 n4923 1
r6985 n4922 n4923 0.125
r6986 n4863 n4924 0.1111111111111111
r6987 n4923 n4924 0.3125
r6988 n4864 n4925 0.10000000000000001
r6989 n4924 n4925 0.59375
r6990 n4865 n4926 0.20000000000000001
r6991 n4925 n4926 0.46875
r6992 n4866 n4927 0.20000000000000001
r6993 n4926 n4927 0.3125
r6994 n4867 n4928 1
r6995 n4927 n4928 0.1875
r6996 n4868 n4929 0.5
r6997 n4928 n4929 0.09375
r6998 n4869 n4930 1
r6999 n4929 n4930 0.09375
r7000 n4870 n4931 1
r7001 n4930 n4931 0.0625
r7002 n4871 n4932 1
r7003 n4931 n4932 0.0625
r7004 n4872 n4933 0.25
r7005 n4932 n4933 0.15625
r7006 n4873 n4934 0.20000000000000001
r7007 n4933 n4934 0.28125
r7008 n4874 n4935 1
r7009 n4934 n4935 0.1875
r7010 n4875 n4936 0.10000000000000001
r7011 n4935 n4936 0.34375
r7012 n4876 n4937 0.20000000000000001
r7013 n4877 n4938 0.16666666666666666
r7014 n4937 n4938 0.34375
r7015 n4878 n4939 0.5
r7016 n4938 n4939 0.25
r7017 n4879 n4940 0.058823529411764705
r7018 n4939 n4940 0.59375
r7019 n4880 n4941 0.076923076923076927
r7020 n4940 n4941 0.9375
r7021 n4881 n4942 0.5
r7022 n4941 n4942 0.46875
r7023 n4882 n4943 0.5
r7024 n4942 n4943 0.125
r7025 n4883 n4944 0.25
r7026 n4943 n4944 0.1875
r7027 n4884 n4945 0.20000000000000001
r7028 n4944 n4945 0.28125
r7029 n4885 n4946 0.10000000000000001
r7030 n4886 n4947 0.040000000000000001
r7031 n4946 n4947 1.09375
r7032 n4887 n4948 1
r7033 n4947 n4948 0.8125
r7034 n4888 n4949 0.035714285714285712
r7035 n4948 n4949 0.90625
r7036 n4889 n4950 1
r7037 n4949 n4950 0.90625
r7038 n4890 n4951 0.040000000000000001
r7039 n4950 n4951 0.8125
r7040 n4891 n4952 0.10000000000000001
r7041 n4951 n4952 1.09375
r7042 n4892 n4953 0.022058823529411766
r7043 n4893 n4954 0.0234375
r7044 n4953 n4954 0.515625
r7045 n4894 n4955 0.1875
r7046 n4954 n4955 0.28125
r7047 n4895 n4956 0.012500000000000001
r7048 n4955 n4956 0.5
r7049 n4896 n4957 0.1875
r7050 n4956 n4957 0.5
r7051 n4897 n4958 0.0234375
r7052 n4957 n4958 0.28125
r7053 n4898 n4959 0.022058823529411766
r7054 n4958 n4959 0.515625
r7055 n4899 n4960 0.037499999999999999
r7056 n4959 n4960 0.421875
r7057 n4900 n4961 0.0091463414634146336
r7058 n4960 n4961 0.796875
r7059 n4901 n4962 0.0091463414634146336
r7060 n4961 n4962 1.28125
r7061 n4902 n4963 0.0091463414634146336
r7062 n4962 n4963 1.28125
r7063 n4903 n4964 0.011029411764705883
r7064 n4963 n4964 1.171875
r7065 n4904 n4965 0.013686131386861315
r7066 n4964 n4965 0.95937499999999998
r7067 n4905 n4966 0.01358695652173913
r7068 n4965 n4966 0.859375
r7069 n4906 n4967 0.011029411764705883
r7070 n4966 n4967 0.96250000000000002
r7071 n4907 n4968 0.028846153846153848
r7072 n4967 n4968 0.734375
r7073 n4908 n4969 0.0093749999999999997
r7074 n4968 n4969 0.828125
r7075 n4909 n4970 0.375
r7076 n4969 n4970 0.640625
r7077 n4910 n4971 0.011363636363636364
r7078 n4970 n4971 0.53125
r7079 n4911 n4972 0.375
r7080 n4971 n4972 0.53125
r7081 n4912 n4973 0.016304347826086956
r7082 n4972 n4973 0.375
r7083 n4913 n4974 0.09375
r7084 n4973 n4974 0.421875
r7085 n4914 n4975 0.0625
r7086 n4974 n4975 0.15625
r7087 n4915 n4976 0.074999999999999997
r7088 n4975 n4976 0.171875
r7089 n4916 n4977 0.375
r7090 n4976 n4977 0.09375
r7091 n4917 n4978 0.028846153846153848
r7092 n4977 n4978 0.21875
r7093 n4918 n4979 0.037499999999999999
r7094 n4978 n4979 0.359375
r7095 n4919 n4980 0.074999999999999997
r7096 n4979 n4980 0.234375
r7097 n4920 n4981 0.074999999999999997
r7098 n4980 n4981 0.15625
r7099 n4921 n4982 0.375
r7100 n4981 n4982 0.09375
r7101 n4922 n4983 0.125
r7102 n4982 n4983 0.0625
r7103 n4923 n4984 0.375
r7104 n4983 n4984 0.0625
r7105 n4924 n4985 0.041666666666666664
r7106 n4984 n4985 0.15625
r7107 n4925 n4986 0.037499999999999999
r7108 n4985 n4986 0.296875
r7109 n4926 n4987 0.074999999999999997
r7110 n4986 n4987 0.234375
r7111 n4927 n4988 0.074999999999999997
r7112 n4987 n4988 0.15625
r7113 n4928 n4989 0.375
r7114 n4988 n4989 0.09375
r7115 n4929 n4990 0.1875
r7116 n4989 n4990 0.046875
r7117 n4930 n4991 0.375
r7118 n4990 n4991 0.046875
r7119 n4931 n4992 0.375
r7120 n4991 n4992 0.03125
r7121 n4932 n4993 0.375
r7122 n4992 n4993 0.03125
r7123 n4933 n4994 0.09375
r7124 n4993 n4994 0.078125
r7125 n4934 n4995 0.074999999999999997
r7126 n4994 n4995 0.140625
r7127 n4935 n4996 0.375
r7128 n4995 n4996 0.09375
r7129 n4936 n4997 0.037499999999999999
r7130 n4996 n4997 0.171875
r7131 n4937 n4998 0.074999999999999997
r7132 n4938 n4999 0.0625
r7133 n4998 n4999 0.171875
r7134 n4939 n5000 0.1875
r7135 n4999 n5000 0.125
r7136 n4940 n5001 0.022058823529411766
r7137 n5000 n5001 0.296875
r7138 n4941 n5002 0.028846153846153848
r7139 n5001 n5002 0.46875
r7140 n4942 n5003 0.1875
r7141 n5002 n5003 0.234375
r7142 n4943 n5004 0.1875
r7143 n5003 n5004 0.0625
r7144 n4944 n5005 0.09375
r7145 n5004 n5005 0.09375
r7146 n4945 n5006 0.074999999999999997
r7147 n5005 n5006 0.140625
r7148 n4946 n5007 0.037499999999999999
r7149 n4947 n5008 0.014999999999999999
r7150 n5007 n5008 0.546875
r7151 n4948 n5009 0.375
r7152 n5008 n5009 0.40625
r7153 n4949 n5010 0.013392857142857142
r7154 n5009 n5010 0.453125
r7155 n4950 n5011 0.375
r7156 n5010 n5011 0.453125
r7157 n4951 n5012 0.014999999999999999
r7158 n5011 n5012 0.40625
r7159 n4952 n5013 0.037499999999999999
r7160 n5012 n5013 0.546875
r7161 n4953 n5014 0.022058823529411766
r7162 n4954 n5015 0.0234375
r7163 n5014 n5015 1.03125
r7164 n4955 n5016 0.1875
r7165 n5015 n5016 0.5625
r7166 n4956 n5017 0.012500000000000001
r7167 n5016 n5017 1
r7168 n4957 n5018 0.1875
r7169 n5017 n5018 1
r7170 n4958 n5019 0.0234375
r7171 n5018 n5019 0.5625
r7172 n4959 n5020 0.022058823529411766
r7173 n5019 n5020 1.03125
r7174 n4960 n5021 0.037499999999999999
r7175 n5020 n5021 0.84375
r7176 n4961 n5022 0.0091463414634146336
r7177 n5021 n5022 1.59375
r7178 n4962 n5023 0.0091463414634146336
r7179 n5022 n5023 2.5625
r7180 n4963 n5024 0.0091463414634146336
r7181 n5023 n5024 2.5625
r7182 n4964 n5025 0.011029411764705883
r7183 n5024 n5025 2.34375
r7184 n4965 n5026 0.013686131386861315
r7185 n5025 n5026 1.91875
r7186 n4966 n5027 0.01358695652173913
r7187 n5026 n5027 1.71875
r7188 n4967 n5028 0.011029411764705883
r7189 n5027 n5028 1.925
r7190 n4968 n5029 0.028846153846153848
r7191 n5028 n5029 1.46875
r7192 n4969 n5030 0.0093749999999999997
r7193 n5029 n5030 1.65625
r7194 n4970 n5031 0.375
r7195 n5030 n5031 1.28125
r7196 n4971 n5032 0.011363636363636364
r7197 n5031 n5032 1.0625
r7198 n4972 n5033 0.375
r7199 n5032 n5033 1.0625
r7200 n4973 n5034 0.016304347826086956
r7201 n5033 n5034 0.75
r7202 n4974 n5035 0.09375
r7203 n5034 n5035 0.84375
r7204 n4975 n5036 0.0625
r7205 n5035 n5036 0.3125
r7206 n4976 n5037 0.074999999999999997
r7207 n5036 n5037 0.34375
r7208 n4977 n5038 0.375
r7209 n5037 n5038 0.1875
r7210 n4978 n5039 0.028846153846153848
r7211 n5038 n5039 0.4375
r7212 n4979 n5040 0.037499999999999999
r7213 n5039 n5040 0.71875
r7214 n4980 n5041 0.074999999999999997
r7215 n5040 n5041 0.46875
r7216 n4981 n5042 0.074999999999999997
r7217 n5041 n5042 0.3125
r7218 n4982 n5043 0.375
r7219 n5042 n5043 0.1875
r7220 n4983 n5044 0.125
r7221 n5043 n5044 0.125
r7222 n4984 n5045 0.375
r7223 n5044 n5045 0.125
r7224 n4985 n5046 0.041666666666666664
r7225 n5045 n5046 0.3125
r7226 n4986 n5047 0.037499999999999999
r7227 n5046 n5047 0.59375
r7228 n4987 n5048 0.074999999999999997
r7229 n5047 n5048 0.46875
r7230 n4988 n5049 0.074999999999999997
r7231 n5048 n5049 0.3125
r7232 n4989 n5050 0.375
r7233 n5049 n5050 0.1875
r7234 n4990 n5051 0.1875
r7235 n5050 n5051 0.09375
r7236 n4991 n5052 0.375
r7237 n5051 n5052 0.09375
r7238 n4992 n5053 0.375
r7239 n5052 n5053 0.0625
r7240 n4993 n5054 0.375
r7241 n5053 n5054 0.0625
r7242 n4994 n5055 0.09375
r7243 n5054 n5055 0.15625
r7244 n4995 n5056 0.074999999999999997
r7245 n5055 n5056 0.28125
r7246 n4996 n5057 0.375
r7247 n5056 n5057 0.1875
r7248 n4997 n5058 0.037499999999999999
r7249 n5057 n5058 0.34375
r7250 n4998 n5059 0.074999999999999997
r7251 n4999 n5060 0.0625
r7252 n5059 n5060 0.34375
r7253 n5000 n5061 0.1875
r7254 n5060 n5061 0.25
r7255 n5001 n5062 0.022058823529411766
r7256 n5061 n5062 0.59375
r7257 n5002 n5063 0.028846153846153848
r7258 n5062 n5063 0.9375
r7259 n5003 n5064 0.1875
r7260 n5063 n5064 0.46875
r7261 n5004 n5065 0.1875
r7262 n5064 n5065 0.125
r7263 n5005 n5066 0.09375
r7264 n5065 n5066 0.1875
r7265 n5006 n5067 0.074999999999999997
r7266 n5066 n5067 0.28125
r7267 n5007 n5068 0.037499999999999999
r7268 n5008 n5069 0.014999999999999999
r7269 n5068 n5069 1.09375
r7270 n5009 n5070 0.375
r7271 n5069 n5070 0.8125
r7272 n5010 n5071 0.013392857142857142
r7273 n5070 n5071 0.90625
r7274 n5011 n5072 0.375
r7275 n5071 n5072 0.90625
r7276 n5012 n5073 0.014999999999999999
r7277 n5072 n5073 0.8125
r7278 n5013 n5074 0.037499999999999999
r7279 n5073 n5074 1.09375
r7280 n5014 n5075 0.011029411764705883
r7281 n5015 n5076 0.01171875
r7282 n5075 n5076 2.0625
r7283 n5016 n5077 0.09375
r7284 n5076 n5077 1.125
r7285 n5017 n5078 0.0062500000000000003
r7286 n5077 n5078 2
r7287 n5018 n5079 0.09375
r7288 n5078 n5079 2
r7289 n5019 n5080 0.01171875
r7290 n5079 n5080 1.125
r7291 n5020 n5081 0.011029411764705883
r7292 n5080 n5081 2.0625
r7293 n5021 n5082 0.018749999999999999
r7294 n5081 n5082 1.6875
r7295 n5022 n5083 0.0045731707317073168
r7296 n5082 n5083 3.1875
r7297 n5023 n5084 0.0045731707317073168
r7298 n5083 n5084 5.125
r7299 n5024 n5085 0.0045731707317073168
r7300 n5084 n5085 5.125
r7301 n5025 n5086 0.0055147058823529415
r7302 n5085 n5086 4.6875
r7303 n5026 n5087 0.0068430656934306573
r7304 n5086 n5087 3.8374999999999999
r7305 n5027 n5088 0.006793478260869565
r7306 n5087 n5088 3.4375
r7307 n5028 n5089 0.0055147058823529415
r7308 n5088 n5089 3.8500000000000001
r7309 n5029 n5090 0.014423076923076924
r7310 n5089 n5090 2.9375
r7311 n5030 n5091 0.0046874999999999998
r7312 n5090 n5091 3.3125
r7313 n5031 n5092 0.1875
r7314 n5091 n5092 2.5625
r7315 n5032 n5093 0.005681818181818182
r7316 n5092 n5093 2.125
r7317 n5033 n5094 0.1875
r7318 n5093 n5094 2.125
r7319 n5034 n5095 0.008152173913043478
r7320 n5094 n5095 1.5
r7321 n5035 n5096 0.046875
r7322 n5095 n5096 1.6875
r7323 n5036 n5097 0.03125
r7324 n5096 n5097 0.625
r7325 n5037 n5098 0.037499999999999999
r7326 n5097 n5098 0.6875
r7327 n5038 n5099 0.1875
r7328 n5098 n5099 0.375
r7329 n5039 n5100 0.014423076923076924
r7330 n5099 n5100 0.875
r7331 n5040 n5101 0.018749999999999999
r7332 n5100 n5101 1.4375
r7333 n5041 n5102 0.037499999999999999
r7334 n5101 n5102 0.9375
r7335 n5042 n5103 0.037499999999999999
r7336 n5102 n5103 0.625
r7337 n5043 n5104 0.1875
r7338 n5103 n5104 0.375
r7339 n5044 n5105 0.0625
r7340 n5104 n5105 0.25
r7341 n5045 n5106 0.1875
r7342 n5105 n5106 0.25
r7343 n5046 n5107 0.020833333333333332
r7344 n5106 n5107 0.625
r7345 n5047 n5108 0.018749999999999999
r7346 n5107 n5108 1.1875
r7347 n5048 n5109 0.037499999999999999
r7348 n5108 n5109 0.9375
r7349 n5049 n5110 0.037499999999999999
r7350 n5109 n5110 0.625
r7351 n5050 n5111 0.1875
r7352 n5110 n5111 0.375
r7353 n5051 n5112 0.09375
r7354 n5111 n5112 0.1875
r7355 n5052 n5113 0.1875
r7356 n5112 n5113 0.1875
r7357 n5053 n5114 0.1875
r7358 n5113 n5114 0.125
r7359 n5054 n5115 0.1875
r7360 n5114 n5115 0.125
r7361 n5055 n5116 0.046875
r7362 n5115 n5116 0.3125
r7363 n5056 n5117 0.037499999999999999
r7364 n5116 n5117 0.5625
r7365 n5057 n5118 0.1875
r7366 n5117 n5118 0.375
r7367 n5058 n5119 0.018749999999999999
r7368 n5118 n5119 0.6875
r7369 n5059 n5120 0.037499999999999999
r7370 n5060 n5121 0.03125
r7371 n5120 n5121 0.6875
r7372 n5061 n5122 0.09375
r7373 n5121 n5122 0.5
r7374 n5062 n5123 0.011029411764705883
r7375 n5122 n5123 1.1875
r7376 n5063 n5124 0.014423076923076924
r7377 n5123 n5124 1.875
r7378 n5064 n5125 0.09375
r7379 n5124 n5125 0.9375
r7380 n5065 n5126 0.09375
r7381 n5125 n5126 0.25
r7382 n5066 n5127 0.046875
r7383 n5126 n5127 0.375
r7384 n5067 n5128 0.037499999999999999
r7385 n5127 n5128 0.5625
r7386 n5068 n5129 0.018749999999999999
r7387 n5069 n5130 0.0074999999999999997
r7388 n5129 n5130 2.1875
r7389 n5070 n5131 0.1875
r7390 n5130 n5131 1.625
r7391 n5071 n5132 0.0066964285714285711
r7392 n5131 n5132 1.8125
r7393 n5072 n5133 0.1875
r7394 n5132 n5133 1.8125
r7395 n5073 n5134 0.0074999999999999997
r7396 n5133 n5134 1.625
r7397 n5074 n5135 0.018749999999999999
r7398 n5134 n5135 2.1875
r7399 n5075 n5136 0.018382352941176471
r7400 n5076 n5137 0.01953125
r7401 n5136 n5137 0.515625
r7402 n5077 n5138 0.15625
r7403 n5137 n5138 0.28125
r7404 n5078 n5139 0.010416666666666666
r7405 n5138 n5139 0.5
r7406 n5079 n5140 0.15625
r7407 n5139 n5140 0.5
r7408 n5080 n5141 0.01953125
r7409 n5140 n5141 0.28125
r7410 n5081 n5142 0.018382352941176471
r7411 n5141 n5142 0.515625
r7412 n5082 n5143 0.03125
r7413 n5142 n5143 0.421875
r7414 n5083 n5144 0.007621951219512195
r7415 n5143 n5144 0.796875
r7416 n5084 n5145 0.007621951219512195
r7417 n5144 n5145 1.28125
r7418 n5085 n5146 0.007621951219512195
r7419 n5145 n5146 1.28125
r7420 n5086 n5147 0.0091911764705882356
r7421 n5146 n5147 1.171875
r7422 n5087 n5148 0.011405109489051095
r7423 n5147 n5148 0.95937499999999998
r7424 n5088 n5149 0.011322463768115942
r7425 n5148 n5149 0.859375
r7426 n5089 n5150 0.0091911764705882356
r7427 n5149 n5150 0.96250000000000002
r7428 n5090 n5151 0.02403846153846154
r7429 n5150 n5151 0.734375
r7430 n5091 n5152 0.0078125
r7431 n5151 n5152 0.828125
r7432 n5092 n5153 0.3125
r7433 n5152 n5153 0.640625
r7434 n5093 n5154 0.00946969696969697
r7435 n5153 n5154 0.53125
r7436 n5094 n5155 0.3125
r7437 n5154 n5155 0.53125
r7438 n5095 n5156 0.01358695652173913
r7439 n5155 n5156 0.375
r7440 n5096 n5157 0.078125
r7441 n5156 n5157 0.421875
r7442 n5097 n5158 0.052083333333333336
r7443 n5157 n5158 0.15625
r7444 n5098 n5159 0.0625
r7445 n5158 n5159 0.171875
r7446 n5099 n5160 0.3125
r7447 n5159 n5160 0.09375
r7448 n5100 n5161 0.02403846153846154
r7449 n5160 n5161 0.21875
r7450 n5101 n5162 0.03125
r7451 n5161 n5162 0.359375
r7452 n5102 n5163 0.0625
r7453 n5162 n5163 0.234375
r7454 n5103 n5164 0.0625
r7455 n5163 n5164 0.15625
r7456 n5104 n5165 0.3125
r7457 n5164 n5165 0.09375
r7458 n5105 n5166 0.10416666666666667
r7459 n5165 n5166 0.0625
r7460 n5106 n5167 0.3125
r7461 n5166 n5167 0.0625
r7462 n5107 n5168 0.034722222222222224
r7463 n5167 n5168 0.15625
r7464 n5108 n5169 0.03125
r7465 n5168 n5169 0.296875
r7466 n5109 n5170 0.0625
r7467 n5169 n5170 0.234375
r7468 n5110 n5171 0.0625
r7469 n5170 n5171 0.15625
r7470 n5111 n5172 0.3125
r7471 n5171 n5172 0.09375
r7472 n5112 n5173 0.15625
r7473 n5172 n5173 0.046875
r7474 n5113 n5174 0.3125
r7475 n5173 n5174 0.046875
r7476 n5114 n5175 0.3125
r7477 n5174 n5175 0.03125
r7478 n5115 n5176 0.3125
r7479 n5175 n5176 0.03125
r7480 n5116 n5177 0.078125
r7481 n5176 n5177 0.078125
r7482 n5117 n5178 0.0625
r7483 n5177 n5178 0.140625
r7484 n5118 n5179 0.3125
r7485 n5178 n5179 0.09375
r7486 n5119 n5180 0.03125
r7487 n5179 n5180 0.171875
r7488 n5181 n5182 0.1875
r7489 n5120 n5183 0.0625
r7490 n5182 n5183 0.203125
r7491 n5121 n5184 0.052083333333333336
r7492 n5183 n5184 0.171875
r7493 n5122 n5185 0.15625
r7494 n5184 n5185 0.125
r7495 n5123 n5186 0.018382352941176471
r7496 n5185 n5186 0.296875
r7497 n5124 n5187 0.02403846153846154
r7498 n5186 n5187 0.46875
r7499 n5125 n5188 0.15625
r7500 n5187 n5188 0.234375
r7501 n5126 n5189 0.15625
r7502 n5188 n5189 0.0625
r7503 n5127 n5190 0.078125
r7504 n5189 n5190 0.09375
r7505 n5128 n5191 0.0625
r7506 n5190 n5191 0.140625
r7507 n5191 n5192 0.203125
r7508 n5192 n5193 0.1875
r7509 n5129 n5194 0.03125
r7510 n5130 n5195 0.012500000000000001
r7511 n5194 n5195 0.546875
r7512 n5131 n5196 0.3125
r7513 n5195 n5196 0.40625
r7514 n5132 n5197 0.011160714285714286
r7515 n5196 n5197 0.453125
r7516 n5133 n5198 0.3125
r7517 n5197 n5198 0.453125
r7518 n5134 n5199 0.012500000000000001
r7519 n5198 n5199 0.40625
r7520 n5135 n5200 0.03125
r7521 n5199 n5200 0.546875
r7522 n5136 n5201 0.022058823529411766
r7523 n5137 n5202 0.0234375
r7524 n5201 n5202 1.03125
r7525 n5138 n5203 0.1875
r7526 n5202 n5203 0.5625
r7527 n5139 n5204 0.012500000000000001
r7528 n5203 n5204 1
r7529 n5140 n5205 0.1875
r7530 n5204 n5205 1
r7531 n5141 n5206 0.0234375
r7532 n5205 n5206 0.5625
r7533 n5142 n5207 0.022058823529411766
r7534 n5206 n5207 1.03125
r7535 n5162 n5208 0.037499999999999999
r7536 n5163 n5209 0.074999999999999997
r7537 n5208 n5209 0.46875
r7538 n5164 n5210 0.074999999999999997
r7539 n5209 n5210 0.3125
r7540 n5165 n5211 0.375
r7541 n5210 n5211 0.1875
r7542 n5166 n5212 0.125
r7543 n5211 n5212 0.125
r7544 n5167 n5213 0.375
r7545 n5212 n5213 0.125
r7546 n5168 n5214 0.041666666666666664
r7547 n5213 n5214 0.3125
r7548 n5169 n5215 0.037499999999999999
r7549 n5214 n5215 0.59375
r7550 n5170 n5216 0.074999999999999997
r7551 n5215 n5216 0.46875
r7552 n5171 n5217 0.074999999999999997
r7553 n5216 n5217 0.3125
r7554 n5172 n5218 0.375
r7555 n5217 n5218 0.1875
r7556 n5173 n5219 0.1875
r7557 n5218 n5219 0.09375
r7558 n5174 n5220 0.375
r7559 n5219 n5220 0.09375
r7560 n5175 n5221 0.375
r7561 n5220 n5221 0.0625
r7562 n5176 n5222 0.375
r7563 n5221 n5222 0.0625
r7564 n5177 n5223 0.09375
r7565 n5222 n5223 0.15625
r7566 n5178 n5224 0.074999999999999997
r7567 n5223 n5224 0.28125
r7568 n5179 n5225 0.375
r7569 n5224 n5225 0.1875
r7570 n5180 n5226 0.037499999999999999
r7571 n5225 n5226 0.34375
r7572 n5181 n5227 0.09375
r7573 n5182 n5228 0.046875
r7574 n5227 n5228 0.375
r7575 n5183 n5229 0.074999999999999997
r7576 n5228 n5229 0.40625
r7577 n5184 n5230 0.0625
r7578 n5229 n5230 0.34375
r7579 n5185 n5231 0.1875
r7580 n5230 n5231 0.25
r7581 n5186 n5232 0.022058823529411766
r7582 n5231 n5232 0.59375
r7583 n5187 n5233 0.028846153846153848
r7584 n5232 n5233 0.9375
r7585 n5188 n5234 0.1875
r7586 n5233 n5234 0.46875
r7587 n5189 n5235 0.1875
r7588 n5234 n5235 0.125
r7589 n5190 n5236 0.09375
r7590 n5235 n5236 0.1875
r7591 n5191 n5237 0.074999999999999997
r7592 n5236 n5237 0.28125
r7593 n5192 n5238 0.046875
r7594 n5237 n5238 0.40625
r7595 n5193 n5239 0.09375
r7596 n5238 n5239 0.375
r7597 n5194 n5240 0.037499999999999999
r7598 n5195 n5241 0.014999999999999999
r7599 n5240 n5241 1.09375
r7600 n5196 n5242 0.375
r7601 n5241 n5242 0.8125
r7602 n5197 n5243 0.013392857142857142
r7603 n5242 n5243 0.90625
r7604 n5198 n5244 0.375
r7605 n5243 n5244 0.90625
r7606 n5199 n5245 0.014999999999999999
r7607 n5244 n5245 0.8125
r7608 n5200 n5246 0.037499999999999999
r7609 n5245 n5246 1.09375
r7610 n5201 n5247 0.025735294117647058
r7611 n5202 n5248 0.02734375
r7612 n5247 n5248 0.41249999999999998
r7613 n5203 n5249 0.21875
r7614 n5248 n5249 0.22500000000000001
r7615 n5204 n5250 0.014583333333333334
r7616 n5249 n5250 0.40000000000000002
r7617 n5205 n5251 0.21875
r7618 n5250 n5251 0.40000000000000002
r7619 n5206 n5252 0.02734375
r7620 n5251 n5252 0.22500000000000001
r7621 n5207 n5253 0.025735294117647058
r7622 n5252 n5253 0.41249999999999998
r7623 n5227 n5254 0.109375
r7624 n5228 n5255 0.0546875
r7625 n5254 n5255 0.14999999999999999
r7626 n5229 n5256 0.087499999999999994
r7627 n5255 n5256 0.16250000000000001
r7628 n5230 n5257 0.072916666666666671
r7629 n5256 n5257 0.13750000000000001
r7630 n5231 n5258 0.21875
r7631 n5257 n5258 0.10000000000000001
r7632 n5232 n5259 0.025735294117647058
r7633 n5258 n5259 0.23749999999999999
r7634 n5233 n5260 0.033653846153846152
r7635 n5259 n5260 0.375
r7636 n5234 n5261 0.21875
r7637 n5260 n5261 0.1875
r7638 n5235 n5262 0.21875
r7639 n5261 n5262 0.050000000000000003
r7640 n5236 n5263 0.109375
r7641 n5262 n5263 0.074999999999999997
r7642 n5237 n5264 0.087499999999999994
r7643 n5263 n5264 0.1125
r7644 n5238 n5265 0.0546875
r7645 n5264 n5265 0.16250000000000001
r7646 n5239 n5266 0.109375
r7647 n5265 n5266 0.14999999999999999
r7648 n5240 n5267 0.043749999999999997
r7649 n5241 n5268 0.017500000000000002
r7650 n5267 n5268 0.4375
r7651 n5242 n5269 0.4375
r7652 n5268 n5269 0.32500000000000001
r7653 n5243 n5270 0.015625
r7654 n5269 n5270 0.36249999999999999
r7655 n5244 n5271 0.4375
r7656 n5270 n5271 0.36249999999999999
r7657 n5245 n5272 0.017500000000000002
r7658 n5271 n5272 0.32500000000000001
r7659 n5246 n5273 0.043749999999999997
r7660 n5272 n5273 0.4375
r7661 n5247 n5274 0.025735294117647058
r7662 n5248 n5275 0.02734375
r7663 n5274 n5275 1.03125
r7664 n5249 n5276 0.21875
r7665 n5275 n5276 0.5625
r7666 n5250 n5277 0.014583333333333334
r7667 n5276 n5277 1
r7668 n5251 n5278 0.21875
r7669 n5277 n5278 1
r7670 n5252 n5279 0.02734375
r7671 n5278 n5279 0.5625
r7672 n5253 n5280 0.025735294117647058
r7673 n5279 n5280 1.03125
r7674 n5254 n5281 0.109375
r7675 n5255 n5282 0.0546875
r7676 n5281 n5282 0.375
r7677 n5256 n5283 0.087499999999999994
r7678 n5282 n5283 0.40625
r7679 n5257 n5284 0.072916666666666671
r7680 n5283 n5284 0.34375
r7681 n5258 n5285 0.21875
r7682 n5284 n5285 0.25
r7683 n5259 n5286 0.025735294117647058
r7684 n5285 n5286 0.59375
r7685 n5260 n5287 0.033653846153846152
r7686 n5286 n5287 0.9375
r7687 n5261 n5288 0.21875
r7688 n5287 n5288 0.46875
r7689 n5262 n5289 0.21875
r7690 n5288 n5289 0.125
r7691 n5263 n5290 0.109375
r7692 n5289 n5290 0.1875
r7693 n5264 n5291 0.087499999999999994
r7694 n5290 n5291 0.28125
r7695 n5265 n5292 0.0546875
r7696 n5291 n5292 0.40625
r7697 n5266 n5293 0.109375
r7698 n5292 n5293 0.375
r7699 n5267 n5294 0.043749999999999997
r7700 n5268 n5295 0.017500000000000002
r7701 n5294 n5295 1.09375
r7702 n5269 n5296 0.4375
r7703 n5295 n5296 0.8125
r7704 n5270 n5297 0.015625
r7705 n5296 n5297 0.90625
r7706 n5271 n5298 0.4375
r7707 n5297 n5298 0.90625
r7708 n5272 n5299 0.017500000000000002
r7709 n5298 n5299 0.8125
r7710 n5273 n5300 0.043749999999999997
r7711 n5299 n5300 1.09375
r7712 n5274 n5301 0.014705882352941176
r7713 n5275 n5302 0.015625
r7714 n5301 n5302 1.03125
r7715 n5276 n5303 0.125
r7716 n5302 n5303 0.5625
r7717 n5277 n5304 0.0083333333333333332
r7718 n5303 n5304 1
r7719 n5278 n5305 0.125
r7720 n5304 n5305 1
r7721 n5279 n5306 0.015625
r7722 n5305 n5306 0.5625
r7723 n5280 n5307 0.014705882352941176
r7724 n5306 n5307 1.03125
r7725 n5281 n5308 0.0625
r7726 n5282 n5309 0.03125
r7727 n5308 n5309 0.375
r7728 n5283 n5310 0.050000000000000003
r7729 n5309 n5310 0.40625
r7730 n5284 n5311 0.041666666666666664
r7731 n5310 n5311 0.34375
r7732 n5285 n5312 0.125
r7733 n5311 n5312 0.25
r7734 n5286 n5313 0.014705882352941176
r7735 n5312 n5313 0.59375
r7736 n5287 n5314 0.019230769230769232
r7737 n5313 n5314 0.9375
r7738 n5288 n5315 0.125
r7739 n5314 n5315 0.46875
r7740 n5289 n5316 0.125
r7741 n5315 n5316 0.125
r7742 n5290 n5317 0.0625
r7743 n5316 n5317 0.1875
r7744 n5291 n5318 0.050000000000000003
r7745 n5317 n5318 0.28125
r7746 n5292 n5319 0.03125
r7747 n5318 n5319 0.40625
r7748 n5293 n5320 0.0625
r7749 n5319 n5320 0.375
r7750 n5294 n5321 0.025000000000000001
r7751 n5295 n5322 0.01
r7752 n5321 n5322 1.09375
r7753 n5296 n5323 0.25
r7754 n5322 n5323 0.8125
r7755 n5297 n5324 0.0089285714285714281
r7756 n5323 n5324 0.90625
r7757 n5298 n5325 0.25
r7758 n5324 n5325 0.90625
r7759 n5299 n5326 0.01
r7760 n5325 n5326 0.8125
r7761 n5300 n5327 0.025000000000000001
r7762 n5326 n5327 1.09375
r7763 n5301 n5328 0.11029411764705882
r7764 n5302 n5329 0.1171875
r7765 n5328 n5329 0.073660714285714288
r7766 n5303 n5330 0.9375
r7767 n5329 n5330 0.040178571428571432
r7768 n5304 n5331 0.0625
r7769 n5330 n5331 0.071428571428571425
r7770 n5305 n5332 0.9375
r7771 n5331 n5332 0.071428571428571425
r7772 n5306 n5333 0.1171875
r7773 n5332 n5333 0.040178571428571432
r7774 n5307 n5334 0.11029411764705882
r7775 n5333 n5334 0.073660714285714288
r7776 n5308 n5335 0.46875
r7777 n5309 n5336 0.234375
r7778 n5335 n5336 0.026785714285714284
r7779 n5310 n5337 0.375
r7780 n5336 n5337 0.029017857142857144
r7781 n5311 n5338 0.3125
r7782 n5337 n5338 0.024553571428571428
r7783 n5312 n5339 0.9375
r7784 n5338 n5339 0.017857142857142856
r7785 n5313 n5340 0.11029411764705882
r7786 n5339 n5340 0.042410714285714288
r7787 n5314 n5341 0.14423076923076922
r7788 n5340 n5341 0.066964285714285712
r7789 n5315 n5342 0.9375
r7790 n5341 n5342 0.033482142857142856
r7791 n5316 n5343 0.9375
r7792 n5342 n5343 0.0089285714285714281
r7793 n5317 n5344 0.46875
r7794 n5343 n5344 0.013392857142857142
r7795 n5318 n5345 0.375
r7796 n5344 n5345 0.020089285714285716
r7797 n5319 n5346 0.234375
r7798 n5345 n5346 0.029017857142857144
r7799 n5320 n5347 0.46875
r7800 n5346 n5347 0.026785714285714284
r7801 n5321 n5348 0.1875
r7802 n5322 n5349 0.074999999999999997
r7803 n5348 n5349 0.078125
r7804 n5323 n5350 1.875
r7805 n5349 n5350 0.058035714285714288
r7806 n5324 n5351 0.066964285714285712
r7807 n5350 n5351 0.064732142857142863
r7808 n5325 n5352 1.875
r7809 n5351 n5352 0.064732142857142863
r7810 n5326 n5353 0.074999999999999997
r7811 n5352 n5353 0.058035714285714288
r7812 n5327 n5354 0.1875
r7813 n5353 n5354 0.078125
r7814 n5328 n5355 0.11029411764705882
r7815 n5329 n5356 0.1171875
r7816 n5355 n5356 1.03125
r7817 n5330 n5357 0.9375
r7818 n5356 n5357 0.5625
r7819 n5331 n5358 0.0625
r7820 n5357 n5358 1
r7821 n5332 n5359 0.9375
r7822 n5358 n5359 1
r7823 n5333 n5360 0.1171875
r7824 n5359 n5360 0.5625
r7825 n5334 n5361 0.11029411764705882
r7826 n5360 n5361 1.03125
r7827 n5362 n5363 0.46875
r7828 n5363 n5364 0.3125
r7829 n5364 n5365 0.1875
r7830 n5365 n5366 0.125
r7831 n5366 n5367 0.125
r7832 n5367 n5368 0.3125
r7833 n5368 n5369 0.59375
r7834 n5369 n5370 0.46875
r7835 n5370 n5371 0.3125
r7836 n5371 n5372 0.1875
r7837 n5372 n5373 0.09375
r7838 n5373 n5374 0.09375
r7839 n5374 n5375 0.0625
r7840 n5375 n5376 0.0625
r7841 n5376 n5377 0.15625
r7842 n5377 n5378 0.28125
r7843 n5378 n5379 0.1875
r7844 n5379 n5380 0.34375
r7845 n5335 n5381 0.46875
r7846 n5336 n5382 0.234375
r7847 n5381 n5382 0.375
r7848 n5337 n5383 0.375
r7849 n5382 n5383 0.40625
r7850 n5338 n5384 0.3125
r7851 n5383 n5384 0.34375
r7852 n5339 n5385 0.9375
r7853 n5384 n5385 0.25
r7854 n5340 n5386 0.11029411764705882
r7855 n5385 n5386 0.59375
r7856 n5341 n5387 0.14423076923076922
r7857 n5386 n5387 0.9375
r7858 n5342 n5388 0.9375
r7859 n5387 n5388 0.46875
r7860 n5343 n5389 0.9375
r7861 n5388 n5389 0.125
r7862 n5344 n5390 0.46875
r7863 n5389 n5390 0.1875
r7864 n5345 n5391 0.375
r7865 n5390 n5391 0.28125
r7866 n5346 n5392 0.234375
r7867 n5391 n5392 0.40625
r7868 n5347 n5393 0.46875
r7869 n5392 n5393 0.375
r7870 n5348 n5394 0.1875
r7871 n5349 n5395 0.074999999999999997
r7872 n5394 n5395 1.09375
r7873 n5350 n5396 1.875
r7874 n5395 n5396 0.8125
r7875 n5351 n5397 0.066964285714285712
r7876 n5396 n5397 0.90625
r7877 n5352 n5398 1.875
r7878 n5397 n5398 0.90625
r7879 n5353 n5399 0.074999999999999997
r7880 n5398 n5399 0.8125
r7881 n5354 n5400 0.1875
r7882 n5399 n5400 1.09375
r7883 n5355 n5401 0.014705882352941176
r7884 n5356 n5402 0.015625
r7885 n5401 n5402 1.03125
r7886 n5357 n5403 0.125
r7887 n5402 n5403 0.5625
r7888 n5358 n5404 0.0083333333333333332
r7889 n5403 n5404 1
r7890 n5359 n5405 0.125
r7891 n5404 n5405 1
r7892 n5360 n5406 0.015625
r7893 n5405 n5406 0.5625
r7894 n5361 n5407 0.014705882352941176
r7895 n5406 n5407 1.03125
r7896 n5362 n5408 0.025000000000000001
r7897 n5363 n5409 0.050000000000000003
r7898 n5408 n5409 0.46875
r7899 n5364 n5410 0.050000000000000003
r7900 n5409 n5410 0.3125
r7901 n5365 n5411 0.25
r7902 n5410 n5411 0.1875
r7903 n5366 n5412 0.083333333333333329
r7904 n5411 n5412 0.125
r7905 n5367 n5413 0.25
r7906 n5412 n5413 0.125
r7907 n5368 n5414 0.027777777777777776
r7908 n5413 n5414 0.3125
r7909 n5369 n5415 0.025000000000000001
r7910 n5414 n5415 0.59375
r7911 n5370 n5416 0.050000000000000003
r7912 n5415 n5416 0.46875
r7913 n5371 n5417 0.050000000000000003
r7914 n5416 n5417 0.3125
r7915 n5372 n5418 0.25
r7916 n5417 n5418 0.1875
r7917 n5373 n5419 0.125
r7918 n5418 n5419 0.09375
r7919 n5374 n5420 0.25
r7920 n5419 n5420 0.09375
r7921 n5375 n5421 0.25
r7922 n5420 n5421 0.0625
r7923 n5376 n5422 0.25
r7924 n5421 n5422 0.0625
r7925 n5377 n5423 0.0625
r7926 n5422 n5423 0.15625
r7927 n5378 n5424 0.050000000000000003
r7928 n5423 n5424 0.28125
r7929 n5379 n5425 0.25
r7930 n5424 n5425 0.1875
r7931 n5380 n5426 0.025000000000000001
r7932 n5425 n5426 0.34375
r7933 n5381 n5427 0.0625
r7934 n5382 n5428 0.03125
r7935 n5427 n5428 0.375
r7936 n5383 n5429 0.050000000000000003
r7937 n5428 n5429 0.40625
r7938 n5384 n5430 0.041666666666666664
r7939 n5429 n5430 0.34375
r7940 n5385 n5431 0.125
r7941 n5430 n5431 0.25
r7942 n5386 n5432 0.014705882352941176
r7943 n5431 n5432 0.59375
r7944 n5387 n5433 0.019230769230769232
r7945 n5432 n5433 0.9375
r7946 n5388 n5434 0.125
r7947 n5433 n5434 0.46875
r7948 n5389 n5435 0.125
r7949 n5434 n5435 0.125
r7950 n5390 n5436 0.0625
r7951 n5435 n5436 0.1875
r7952 n5391 n5437 0.050000000000000003
r7953 n5436 n5437 0.28125
r7954 n5392 n5438 0.03125
r7955 n5437 n5438 0.40625
r7956 n5393 n5439 0.0625
r7957 n5438 n5439 0.375
r7958 n5394 n5440 0.025000000000000001
r7959 n5395 n5441 0.01
r7960 n5440 n5441 1.09375
r7961 n5396 n5442 0.25
r7962 n5441 n5442 0.8125
r7963 n5397 n5443 0.0089285714285714281
r7964 n5442 n5443 0.90625
r7965 n5398 n5444 0.25
r7966 n5443 n5444 0.90625
r7967 n5399 n5445 0.01
r7968 n5444 n5445 0.8125
r7969 n5400 n5446 0.025000000000000001
r7970 n5445 n5446 1.09375
r7971 n5401 n5447 0.014705882352941176
r7972 n5402 n5448 0.015625
r7973 n5447 n5448 1.03125
r7974 n5403 n5449 0.125
r7975 n5448 n5449 0.5625
r7976 n5404 n5450 0.0083333333333333332
r7977 n5449 n5450 1
r7978 n5405 n5451 0.125
r7979 n5450 n5451 1
r7980 n5406 n5452 0.015625
r7981 n5451 n5452 0.5625
r7982 n5407 n5453 0.014705882352941176
r7983 n5452 n5453 1.03125
r7984 n5408 n5454 0.025000000000000001
r7985 n5409 n5455 0.050000000000000003
r7986 n5454 n5455 0.46875
r7987 n5410 n5456 0.050000000000000003
r7988 n5455 n5456 0.3125
r7989 n5411 n5457 0.25
r7990 n5456 n5457 0.1875
r7991 n5412 n5458 0.083333333333333329
r7992 n5457 n5458 0.125
r7993 n5413 n5459 0.25
r7994 n5458 n5459 0.125
r7995 n5414 n5460 0.027777777777777776
r7996 n5459 n5460 0.3125
r7997 n5415 n5461 0.025000000000000001
r7998 n5460 n5461 0.59375
r7999 n5416 n5462 0.050000000000000003
r8000 n5461 n5462 0.46875
r8001 n5417 n5463 0.050000000000000003
r8002 n5462 n5463 0.3125
r8003 n5418 n5464 0.25
r8004 n5463 n5464 0.1875
r8005 n5419 n5465 0.125
r8006 n5464 n5465 0.09375
r8007 n5420 n5466 0.25
r8008 n5465 n5466 0.09375
r8009 n5421 n5467 0.25
r8010 n5466 n5467 0.0625
r8011 n5422 n5468 0.25
r8012 n5467 n5468 0.0625
r8013 n5423 n5469 0.0625
r8014 n5468 n5469 0.15625
r8015 n5424 n5470 0.050000000000000003
r8016 n5469 n5470 0.28125
r8017 n5425 n5471 0.25
r8018 n5470 n5471 0.1875
r8019 n5426 n5472 0.025000000000000001
r8020 n5471 n5472 0.34375
r8021 n5427 n5473 0.0625
r8022 n5428 n5474 0.03125
r8023 n5473 n5474 0.375
r8024 n5429 n5475 0.050000000000000003
r8025 n5474 n5475 0.40625
r8026 n5430 n5476 0.041666666666666664
r8027 n5475 n5476 0.34375
r8028 n5431 n5477 0.125
r8029 n5476 n5477 0.25
r8030 n5432 n5478 0.014705882352941176
r8031 n5477 n5478 0.59375
r8032 n5433 n5479 0.019230769230769232
r8033 n5478 n5479 0.9375
r8034 n5434 n5480 0.125
r8035 n5479 n5480 0.46875
r8036 n5435 n5481 0.125
r8037 n5480 n5481 0.125
r8038 n5436 n5482 0.0625
r8039 n5481 n5482 0.1875
r8040 n5437 n5483 0.050000000000000003
r8041 n5482 n5483 0.28125
r8042 n5438 n5484 0.03125
r8043 n5483 n5484 0.40625
r8044 n5439 n5485 0.0625
r8045 n5484 n5485 0.375
r8046 n5440 n5486 0.025000000000000001
r8047 n5441 n5487 0.01
r8048 n5486 n5487 1.09375
r8049 n5442 n5488 0.25
r8050 n5487 n5488 0.8125
r8051 n5443 n5489 0.0089285714285714281
r8052 n5488 n5489 0.90625
r8053 n5444 n5490 0.25
r8054 n5489 n5490 0.90625
r8055 n5445 n5491 0.01
r8056 n5490 n5491 0.8125
r8057 n5446 n5492 0.025000000000000001
r8058 n5491 n5492 1.09375
r8059 n5447 n5493 0.022058823529411766
r8060 n5448 n5494 0.0234375
r8061 n5493 n5494 0.515625
r8062 n5449 n5495 0.1875
r8063 n5494 n5495 0.28125
r8064 n5450 n5496 0.012500000000000001
r8065 n5495 n5496 0.5
r8066 n5451 n5497 0.1875
r8067 n5496 n5497 0.5
r8068 n5452 n5498 0.0234375
r8069 n5497 n5498 0.28125
r8070 n5453 n5499 0.022058823529411766
r8071 n5498 n5499 0.515625
r8072 n5454 n5500 0.037499999999999999
r8073 n5455 n5501 0.074999999999999997
r8074 n5500 n5501 0.234375
r8075 n5456 n5502 0.074999999999999997
r8076 n5501 n5502 0.15625
r8077 n5457 n5503 0.375
r8078 n5502 n5503 0.09375
r8079 n5458 n5504 0.125
r8080 n5503 n5504 0.0625
r8081 n5459 n5505 0.375
r8082 n5504 n5505 0.0625
r8083 n5460 n5506 0.041666666666666664
r8084 n5505 n5506 0.15625
r8085 n5461 n5507 0.037499999999999999
r8086 n5506 n5507 0.296875
r8087 n5462 n5508 0.074999999999999997
r8088 n5507 n5508 0.234375
r8089 n5463 n5509 0.074999999999999997
r8090 n5508 n5509 0.15625
r8091 n5464 n5510 0.375
r8092 n5509 n5510 0.09375
r8093 n5465 n5511 0.1875
r8094 n5510 n5511 0.046875
r8095 n5466 n5512 0.375
r8096 n5511 n5512 0.046875
r8097 n5467 n5513 0.375
r8098 n5512 n5513 0.03125
r8099 n5468 n5514 0.375
r8100 n5513 n5514 0.03125
r8101 n5469 n5515 0.09375
r8102 n5514 n5515 0.078125
r8103 n5470 n5516 0.074999999999999997
r8104 n5515 n5516 0.140625
r8105 n5471 n5517 0.375
r8106 n5516 n5517 0.09375
r8107 n5472 n5518 0.037499999999999999
r8108 n5517 n5518 0.171875
r8109 n5473 n5519 0.09375
r8110 n5474 n5520 0.046875
r8111 n5519 n5520 0.1875
r8112 n5475 n5521 0.074999999999999997
r8113 n5520 n5521 0.203125
r8114 n5476 n5522 0.0625
r8115 n5521 n5522 0.171875
r8116 n5477 n5523 0.1875
r8117 n5522 n5523 0.125
r8118 n5478 n5524 0.022058823529411766
r8119 n5523 n5524 0.296875
r8120 n5479 n5525 0.028846153846153848
r8121 n5524 n5525 0.46875
r8122 n5480 n5526 0.1875
r8123 n5525 n5526 0.234375
r8124 n5481 n5527 0.1875
r8125 n5526 n5527 0.0625
r8126 n5482 n5528 0.09375
r8127 n5527 n5528 0.09375
r8128 n5483 n5529 0.074999999999999997
r8129 n5528 n5529 0.140625
r8130 n5484 n5530 0.046875
r8131 n5529 n5530 0.203125
r8132 n5485 n5531 0.09375
r8133 n5530 n5531 0.1875
r8134 n5486 n5532 0.037499999999999999
r8135 n5487 n5533 0.014999999999999999
r8136 n5532 n5533 0.546875
r8137 n5488 n5534 0.375
r8138 n5533 n5534 0.40625
r8139 n5489 n5535 0.013392857142857142
r8140 n5534 n5535 0.453125
r8141 n5490 n5536 0.375
r8142 n5535 n5536 0.453125
r8143 n5491 n5537 0.014999999999999999
r8144 n5536 n5537 0.40625
r8145 n5492 n5538 0.037499999999999999
r8146 n5537 n5538 0.546875
r8147 n5493 n5539 0.040441176470588237
r8148 n5494 n5540 0.04296875
r8149 n5539 n5540 0.29464285714285715
r8150 n5495 n5541 0.34375
r8151 n5540 n5541 0.16071428571428573
r8152 n5496 n5542 0.022916666666666665
r8153 n5541 n5542 0.2857142857142857
r8154 n5497 n5543 0.34375
r8155 n5542 n5543 0.2857142857142857
r8156 n5498 n5544 0.04296875
r8157 n5543 n5544 0.16071428571428573
r8158 n5499 n5545 0.040441176470588237
r8159 n5544 n5545 0.29464285714285715
r8160 n5500 n5546 0.068750000000000006
r8161 n5501 n5547 0.13750000000000001
r8162 n5546 n5547 0.13392857142857142
r8163 n5502 n5548 0.13750000000000001
r8164 n5547 n5548 0.089285714285714288
r8165 n5503 n5549 0.6875
r8166 n5548 n5549 0.053571428571428568
r8167 n5504 n5550 0.22916666666666666
r8168 n5549 n5550 0.035714285714285712
r8169 n5505 n5551 0.6875
r8170 n5550 n5551 0.035714285714285712
r8171 n5506 n5552 0.076388888888888895
r8172 n5551 n5552 0.089285714285714288
r8173 n5507 n5553 0.068750000000000006
r8174 n5552 n5553 0.16964285714285715
r8175 n5508 n5554 0.13750000000000001
r8176 n5553 n5554 0.13392857142857142
r8177 n5509 n5555 0.13750000000000001
r8178 n5554 n5555 0.089285714285714288
r8179 n5510 n5556 0.6875
r8180 n5555 n5556 0.053571428571428568
r8181 n5511 n5557 0.34375
r8182 n5556 n5557 0.026785714285714284
r8183 n5512 n5558 0.6875
r8184 n5557 n5558 0.026785714285714284
r8185 n5513 n5559 0.6875
r8186 n5558 n5559 0.017857142857142856
r8187 n5514 n5560 0.6875
r8188 n5559 n5560 0.017857142857142856
r8189 n5515 n5561 0.171875
r8190 n5560 n5561 0.044642857142857144
r8191 n5516 n5562 0.13750000000000001
r8192 n5561 n5562 0.080357142857142863
r8193 n5517 n5563 0.6875
r8194 n5562 n5563 0.053571428571428568
r8195 n5518 n5564 0.068750000000000006
r8196 n5563 n5564 0.098214285714285712
r8197 n5519 n5565 0.171875
r8198 n5520 n5566 0.0859375
r8199 n5565 n5566 0.10714285714285714
r8200 n5521 n5567 0.13750000000000001
r8201 n5566 n5567 0.11607142857142858
r8202 n5522 n5568 0.11458333333333333
r8203 n5567 n5568 0.098214285714285712
r8204 n5523 n5569 0.34375
r8205 n5568 n5569 0.071428571428571425
r8206 n5524 n5570 0.040441176470588237
r8207 n5569 n5570 0.16964285714285715
r8208 n5525 n5571 0.052884615384615384
r8209 n5570 n5571 0.26785714285714285
r8210 n5526 n5572 0.34375
r8211 n5571 n5572 0.13392857142857142
r8212 n5527 n5573 0.34375
r8213 n5572 n5573 0.035714285714285712
r8214 n5528 n5574 0.171875
r8215 n5573 n5574 0.053571428571428568
r8216 n5529 n5575 0.13750000000000001
r8217 n5574 n5575 0.080357142857142863
r8218 n5530 n5576 0.0859375
r8219 n5575 n5576 0.11607142857142858
r8220 n5531 n5577 0.171875
r8221 n5576 n5577 0.10714285714285714
r8222 n5532 n5578 0.068750000000000006
r8223 n5533 n5579 0.0275
r8224 n5578 n5579 0.3125
r8225 n5534 n5580 0.6875
r8226 n5579 n5580 0.23214285714285715
r8227 n5535 n5581 0.024553571428571428
r8228 n5580 n5581 0.25892857142857145
r8229 n5536 n5582 0.6875
r8230 n5581 n5582 0.25892857142857145
r8231 n5537 n5583 0.0275
r8232 n5582 n5583 0.23214285714285715
r8233 n5538 n5584 0.068750000000000006
r8234 n5583 n5584 0.3125
r8235 n5539 n5585 0.036764705882352942
r8236 n5540 n5586 0.0390625
r8237 n5585 n5586 0.6875
r8238 n5541 n5587 0.3125
r8239 n5586 n5587 0.375
r8240 n5542 n5588 0.020833333333333332
r8241 n5587 n5588 0.66666666666666663
r8242 n5543 n5589 0.3125
r8243 n5588 n5589 0.66666666666666663
r8244 n5544 n5590 0.0390625
r8245 n5589 n5590 0.375
r8246 n5545 n5591 0.036764705882352942
r8247 n5590 n5591 0.6875
r8248 n5546 n5592 0.0625
r8249 n5547 n5593 0.125
r8250 n5592 n5593 0.3125
r8251 n5548 n5594 0.125
r8252 n5593 n5594 0.20833333333333334
r8253 n5549 n5595 0.625
r8254 n5594 n5595 0.125
r8255 n5550 n5596 0.20833333333333334
r8256 n5595 n5596 0.083333333333333329
r8257 n5551 n5597 0.625
r8258 n5596 n5597 0.083333333333333329
r8259 n5552 n5598 0.069444444444444448
r8260 n5597 n5598 0.20833333333333334
r8261 n5553 n5599 0.0625
r8262 n5598 n5599 0.39583333333333331
r8263 n5554 n5600 0.125
r8264 n5599 n5600 0.3125
r8265 n5555 n5601 0.125
r8266 n5600 n5601 0.20833333333333334
r8267 n5556 n5602 0.625
r8268 n5601 n5602 0.125
r8269 n5557 n5603 0.3125
r8270 n5602 n5603 0.0625
r8271 n5558 n5604 0.625
r8272 n5603 n5604 0.0625
r8273 n5559 n5605 0.625
r8274 n5604 n5605 0.041666666666666664
r8275 n5560 n5606 0.625
r8276 n5605 n5606 0.041666666666666664
r8277 n5561 n5607 0.15625
r8278 n5606 n5607 0.10416666666666667
r8279 n5562 n5608 0.125
r8280 n5607 n5608 0.1875
r8281 n5563 n5609 0.625
r8282 n5608 n5609 0.125
r8283 n5564 n5610 0.0625
r8284 n5609 n5610 0.22916666666666666
r8285 n5578 n5611 0.0625
r8286 n5579 n5612 0.025000000000000001
r8287 n5611 n5612 0.72916666666666663
r8288 n5580 n5613 0.625
r8289 n5612 n5613 0.54166666666666663
r8290 n5581 n5614 0.022321428571428572
r8291 n5613 n5614 0.60416666666666663
r8292 n5582 n5615 0.625
r8293 n5614 n5615 0.60416666666666663
r8294 n5583 n5616 0.025000000000000001
r8295 n5615 n5616 0.54166666666666663
r8296 n5584 n5617 0.0625
r8297 n5616 n5617 0.72916666666666663
r8298 n5585 n5618 0.022058823529411766
r8299 n5586 n5619 0.0234375
r8300 n5618 n5619 0.6875
r8301 n5587 n5620 0.1875
r8302 n5619 n5620 0.375
r8303 n5588 n5621 0.012500000000000001
r8304 n5620 n5621 0.66666666666666663
r8305 n5589 n5622 0.1875
r8306 n5621 n5622 0.66666666666666663
r8307 n5590 n5623 0.0234375
r8308 n5622 n5623 0.375
r8309 n5591 n5624 0.022058823529411766
r8310 n5623 n5624 0.6875
r8311 n5592 n5625 0.037499999999999999
r8312 n5593 n5626 0.074999999999999997
r8313 n5625 n5626 0.3125
r8314 n5594 n5627 0.074999999999999997
r8315 n5626 n5627 0.20833333333333334
r8316 n5595 n5628 0.375
r8317 n5627 n5628 0.125
r8318 n5596 n5629 0.125
r8319 n5628 n5629 0.083333333333333329
r8320 n5597 n5630 0.375
r8321 n5629 n5630 0.083333333333333329
r8322 n5598 n5631 0.041666666666666664
r8323 n5630 n5631 0.20833333333333334
r8324 n5599 n5632 0.037499999999999999
r8325 n5631 n5632 0.39583333333333331
r8326 n5600 n5633 0.074999999999999997
r8327 n5632 n5633 0.3125
r8328 n5601 n5634 0.074999999999999997
r8329 n5633 n5634 0.20833333333333334
r8330 n5602 n5635 0.375
r8331 n5634 n5635 0.125
r8332 n5603 n5636 0.1875
r8333 n5635 n5636 0.0625
r8334 n5604 n5637 0.375
r8335 n5636 n5637 0.0625
r8336 n5605 n5638 0.375
r8337 n5637 n5638 0.041666666666666664
r8338 n5606 n5639 0.375
r8339 n5638 n5639 0.041666666666666664
r8340 n5607 n5640 0.09375
r8341 n5639 n5640 0.10416666666666667
r8342 n5608 n5641 0.074999999999999997
r8343 n5640 n5641 0.1875
r8344 n5609 n5642 0.375
r8345 n5641 n5642 0.125
r8346 n5610 n5643 0.037499999999999999
r8347 n5642 n5643 0.22916666666666666
r8348 n5611 n5644 0.037499999999999999
r8349 n5612 n5645 0.014999999999999999
r8350 n5644 n5645 0.72916666666666663
r8351 n5613 n5646 0.375
r8352 n5645 n5646 0.54166666666666663
r8353 n5614 n5647 0.013392857142857142
r8354 n5646 n5647 0.60416666666666663
r8355 n5615 n5648 0.375
r8356 n5647 n5648 0.60416666666666663
r8357 n5616 n5649 0.014999999999999999
r8358 n5648 n5649 0.54166666666666663
r8359 n5617 n5650 0.037499999999999999
r8360 n5649 n5650 0.72916666666666663
r8361 n5618 n5651 0.018382352941176471
r8362 n5619 n5652 0.01953125
r8363 n5651 n5652 1.03125
r8364 n5620 n5653 0.15625
r8365 n5652 n5653 0.5625
r8366 n5621 n5654 0.010416666666666666
r8367 n5653 n5654 1
r8368 n5622 n5655 0.15625
r8369 n5654 n5655 1
r8370 n5623 n5656 0.01953125
r8371 n5655 n5656 0.5625
r8372 n5624 n5657 0.018382352941176471
r8373 n5656 n5657 1.03125
r8374 n5625 n5658 0.03125
r8375 n5626 n5659 0.0625
r8376 n5658 n5659 0.46875
r8377 n5627 n5660 0.0625
r8378 n5659 n5660 0.3125
r8379 n5628 n5661 0.3125
r8380 n5660 n5661 0.1875
r8381 n5629 n5662 0.10416666666666667
r8382 n5661 n5662 0.125
r8383 n5630 n5663 0.3125
r8384 n5662 n5663 0.125
r8385 n5631 n5664 0.034722222222222224
r8386 n5663 n5664 0.3125
r8387 n5632 n5665 0.03125
r8388 n5664 n5665 0.59375
r8389 n5633 n5666 0.0625
r8390 n5665 n5666 0.46875
r8391 n5634 n5667 0.0625
r8392 n5666 n5667 0.3125
r8393 n5635 n5668 0.3125
r8394 n5667 n5668 0.1875
r8395 n5636 n5669 0.15625
r8396 n5668 n5669 0.09375
r8397 n5637 n5670 0.3125
r8398 n5669 n5670 0.09375
r8399 n5638 n5671 0.3125
r8400 n5670 n5671 0.0625
r8401 n5639 n5672 0.3125
r8402 n5671 n5672 0.0625
r8403 n5640 n5673 0.078125
r8404 n5672 n5673 0.15625
r8405 n5641 n5674 0.0625
r8406 n5673 n5674 0.28125
r8407 n5642 n5675 0.3125
r8408 n5674 n5675 0.1875
r8409 n5643 n5676 0.03125
r8410 n5675 n5676 0.34375
r8411 n5644 n5677 0.03125
r8412 n5645 n5678 0.012500000000000001
r8413 n5677 n5678 1.09375
r8414 n5646 n5679 0.3125
r8415 n5678 n5679 0.8125
r8416 n5647 n5680 0.011160714285714286
r8417 n5679 n5680 0.90625
r8418 n5648 n5681 0.3125
r8419 n5680 n5681 0.90625
r8420 n5649 n5682 0.012500000000000001
r8421 n5681 n5682 0.8125
r8422 n5650 n5683 0.03125
r8423 n5682 n5683 1.09375
r8424 n5651 n5684 0.0625
r8425 n5652 n5685 0.06640625
r8426 n5684 n5685 0.13750000000000001
r8427 n5653 n5686 0.53125
r8428 n5685 n5686 0.074999999999999997
r8429 n5654 n5687 0.035416666666666666
r8430 n5686 n5687 0.13333333333333333
r8431 n5655 n5688 0.53125
r8432 n5687 n5688 0.13333333333333333
r8433 n5656 n5689 0.06640625
r8434 n5688 n5689 0.074999999999999997
r8435 n5657 n5690 0.0625
r8436 n5689 n5690 0.13750000000000001
r8437 n5658 n5691 0.10625
r8438 n5659 n5692 0.21249999999999999
r8439 n5691 n5692 0.0625
r8440 n5660 n5693 0.21249999999999999
r8441 n5692 n5693 0.041666666666666664
r8442 n5661 n5694 1.0625
r8443 n5693 n5694 0.025000000000000001
r8444 n5662 n5695 0.35416666666666669
r8445 n5694 n5695 0.016666666666666666
r8446 n5663 n5696 1.0625
r8447 n5695 n5696 0.016666666666666666
r8448 n5664 n5697 0.11805555555555555
r8449 n5696 n5697 0.041666666666666664
r8450 n5665 n5698 0.10625
r8451 n5697 n5698 0.079166666666666663
r8452 n5666 n5699 0.21249999999999999
r8453 n5698 n5699 0.0625
r8454 n5667 n5700 0.21249999999999999
r8455 n5699 n5700 0.041666666666666664
r8456 n5668 n5701 1.0625
r8457 n5700 n5701 0.025000000000000001
r8458 n5669 n5702 0.53125
r8459 n5701 n5702 0.012500000000000001
r8460 n5670 n5703 1.0625
r8461 n5702 n5703 0.012500000000000001
r8462 n5671 n5704 1.0625
r8463 n5703 n5704 0.0083333333333333332
r8464 n5672 n5705 1.0625
r8465 n5704 n5705 0.0083333333333333332
r8466 n5673 n5706 0.265625
r8467 n5705 n5706 0.020833333333333332
r8468 n5674 n5707 0.21249999999999999
r8469 n5706 n5707 0.037499999999999999
r8470 n5675 n5708 1.0625
r8471 n5707 n5708 0.025000000000000001
r8472 n5676 n5709 0.10625
r8473 n5708 n5709 0.04583333333333333
r8474 n5677 n5710 0.10625
r8475 n5678 n5711 0.042500000000000003
r8476 n5710 n5711 0.14583333333333334
r8477 n5679 n5712 1.0625
r8478 n5711 n5712 0.10833333333333334
r8479 n5680 n5713 0.037946428571428568
r8480 n5712 n5713 0.12083333333333333
r8481 n5681 n5714 1.0625
r8482 n5713 n5714 0.12083333333333333
r8483 n5682 n5715 0.042500000000000003
r8484 n5714 n5715 0.10833333333333334
r8485 n5683 n5716 0.10625
r8486 n5715 n5716 0.14583333333333334
r8487 n5684 n5717 0.11029411764705882
r8488 n5685 n5718 0.1171875
r8489 n5717 n5718 0.13750000000000001
r8490 n5686 n5719 0.9375
r8491 n5718 n5719 0.074999999999999997
r8492 n5687 n5720 0.0625
r8493 n5719 n5720 0.13333333333333333
r8494 n5688 n5721 0.9375
r8495 n5720 n5721 0.13333333333333333
r8496 n5689 n5722 0.1171875
r8497 n5721 n5722 0.074999999999999997
r8498 n5690 n5723 0.11029411764705882
r8499 n5722 n5723 0.13750000000000001
r8500 n5691 n5724 0.1875
r8501 n5692 n5725 0.375
r8502 n5724 n5725 0.0625
r8503 n5693 n5726 0.375
r8504 n5725 n5726 0.041666666666666664
r8505 n5694 n5727 1.875
r8506 n5726 n5727 0.025000000000000001
r8507 n5695 n5728 0.625
r8508 n5727 n5728 0.016666666666666666
r8509 n5696 n5729 1.875
r8510 n5728 n5729 0.016666666666666666
r8511 n5697 n5730 0.20833333333333334
r8512 n5729 n5730 0.041666666666666664
r8513 n5698 n5731 0.1875
r8514 n5730 n5731 0.079166666666666663
r8515 n5699 n5732 0.375
r8516 n5731 n5732 0.0625
r8517 n5700 n5733 0.375
r8518 n5732 n5733 0.041666666666666664
r8519 n5701 n5734 1.875
r8520 n5733 n5734 0.025000000000000001
r8521 n5702 n5735 0.9375
r8522 n5734 n5735 0.012500000000000001
r8523 n5703 n5736 1.875
r8524 n5735 n5736 0.012500000000000001
r8525 n5704 n5737 1.875
r8526 n5736 n5737 0.0083333333333333332
r8527 n5705 n5738 1.875
r8528 n5737 n5738 0.0083333333333333332
r8529 n5706 n5739 0.46875
r8530 n5738 n5739 0.020833333333333332
r8531 n5707 n5740 0.375
r8532 n5739 n5740 0.037499999999999999
r8533 n5708 n5741 1.875
r8534 n5740 n5741 0.025000000000000001
r8535 n5709 n5742 0.1875
r8536 n5741 n5742 0.04583333333333333
r8537 n5710 n5743 0.1875
r8538 n5711 n5744 0.074999999999999997
r8539 n5743 n5744 0.14583333333333334
r8540 n5712 n5745 1.875
r8541 n5744 n5745 0.10833333333333334
r8542 n5713 n5746 0.066964285714285712
r8543 n5745 n5746 0.12083333333333333
r8544 n5714 n5747 1.875
r8545 n5746 n5747 0.12083333333333333
r8546 n5715 n5748 0.074999999999999997
r8547 n5747 n5748 0.10833333333333334
r8548 n5716 n5749 0.1875
r8549 n5748 n5749 0.14583333333333334
r8550 n5717 n5750 0.0625
r8551 n5718 n5751 0.06640625
r8552 n5750 n5751 1.03125
r8553 n5719 n5752 0.53125
r8554 n5751 n5752 0.5625
r8555 n5720 n5753 0.035416666666666666
r8556 n5752 n5753 1
r8557 n5721 n5754 0.53125
r8558 n5753 n5754 1
r8559 n5722 n5755 0.06640625
r8560 n5754 n5755 0.5625
r8561 n5723 n5756 0.0625
r8562 n5755 n5756 1.03125
r8563 n5724 n5757 0.10625
r8564 n5725 n5758 0.21249999999999999
r8565 n5757 n5758 0.46875
r8566 n5726 n5759 0.21249999999999999
r8567 n5758 n5759 0.3125
r8568 n5727 n5760 1.0625
r8569 n5759 n5760 0.1875
r8570 n5728 n5761 0.35416666666666669
r8571 n5760 n5761 0.125
r8572 n5729 n5762 1.0625
r8573 n5761 n5762 0.125
r8574 n5730 n5763 0.11805555555555555
r8575 n5762 n5763 0.3125
r8576 n5731 n5764 0.10625
r8577 n5763 n5764 0.59375
r8578 n5732 n5765 0.21249999999999999
r8579 n5764 n5765 0.46875
r8580 n5733 n5766 0.21249999999999999
r8581 n5765 n5766 0.3125
r8582 n5734 n5767 1.0625
r8583 n5766 n5767 0.1875
r8584 n5735 n5768 0.53125
r8585 n5767 n5768 0.09375
r8586 n5736 n5769 1.0625
r8587 n5768 n5769 0.09375
r8588 n5737 n5770 1.0625
r8589 n5769 n5770 0.0625
r8590 n5738 n5771 1.0625
r8591 n5770 n5771 0.0625
r8592 n5739 n5772 0.265625
r8593 n5771 n5772 0.15625
r8594 n5740 n5773 0.21249999999999999
r8595 n5772 n5773 0.28125
r8596 n5741 n5774 1.0625
r8597 n5773 n5774 0.1875
r8598 n5742 n5775 0.10625
r8599 n5774 n5775 0.34375
r8600 n5743 n5776 0.10625
r8601 n5744 n5777 0.042500000000000003
r8602 n5776 n5777 1.09375
r8603 n5745 n5778 1.0625
r8604 n5777 n5778 0.8125
r8605 n5746 n5779 0.037946428571428568
r8606 n5778 n5779 0.90625
r8607 n5747 n5780 1.0625
r8608 n5779 n5780 0.90625
r8609 n5748 n5781 0.042500000000000003
r8610 n5780 n5781 0.8125
r8611 n5749 n5782 0.10625
r8612 n5781 n5782 1.09375
r8613 n5750 n5783 0.018382352941176471
r8614 n5751 n5784 0.01953125
r8615 n5783 n5784 0.6875
r8616 n5752 n5785 0.15625
r8617 n5784 n5785 0.375
r8618 n5753 n5786 0.010416666666666666
r8619 n5785 n5786 0.66666666666666663
r8620 n5754 n5787 0.15625
r8621 n5786 n5787 0.66666666666666663
r8622 n5755 n5788 0.01953125
r8623 n5787 n5788 0.375
r8624 n5756 n5789 0.018382352941176471
r8625 n5788 n5789 0.6875
r8626 n5757 n5790 0.03125
r8627 n5758 n5791 0.0625
r8628 n5790 n5791 0.3125
r8629 n5759 n5792 0.0625
r8630 n5791 n5792 0.20833333333333334
r8631 n5760 n5793 0.3125
r8632 n5792 n5793 0.125
r8633 n5761 n5794 0.10416666666666667
r8634 n5793 n5794 0.083333333333333329
r8635 n5762 n5795 0.3125
r8636 n5794 n5795 0.083333333333333329
r8637 n5763 n5796 0.034722222222222224
r8638 n5795 n5796 0.20833333333333334
r8639 n5764 n5797 0.03125
r8640 n5796 n5797 0.39583333333333331
r8641 n5765 n5798 0.0625
r8642 n5797 n5798 0.3125
r8643 n5766 n5799 0.0625
r8644 n5798 n5799 0.20833333333333334
r8645 n5767 n5800 0.3125
r8646 n5799 n5800 0.125
r8647 n5768 n5801 0.15625
r8648 n5800 n5801 0.0625
r8649 n5769 n5802 0.3125
r8650 n5801 n5802 0.0625
r8651 n5770 n5803 0.3125
r8652 n5802 n5803 0.041666666666666664
r8653 n5771 n5804 0.3125
r8654 n5803 n5804 0.041666666666666664
r8655 n5772 n5805 0.078125
r8656 n5804 n5805 0.10416666666666667
r8657 n5773 n5806 0.0625
r8658 n5805 n5806 0.1875
r8659 n5774 n5807 0.3125
r8660 n5806 n5807 0.125
r8661 n5775 n5808 0.03125
r8662 n5807 n5808 0.22916666666666666
r8663 n5776 n5809 0.03125
r8664 n5777 n5810 0.012500000000000001
r8665 n5809 n5810 0.72916666666666663
r8666 n5778 n5811 0.3125
r8667 n5810 n5811 0.54166666666666663
r8668 n5779 n5812 0.011160714285714286
r8669 n5811 n5812 0.60416666666666663
r8670 n5780 n5813 0.3125
r8671 n5812 n5813 0.60416666666666663
r8672 n5781 n5814 0.012500000000000001
r8673 n5813 n5814 0.54166666666666663
r8674 n5782 n5815 0.03125
r8675 n5814 n5815 0.72916666666666663
r8676 n5783 n5816 0.022058823529411766
r8677 n5784 n5817 0.0234375
r8678 n5816 n5817 0.6875
r8679 n5785 n5818 0.1875
r8680 n5817 n5818 0.375
r8681 n5786 n5819 0.012500000000000001
r8682 n5818 n5819 0.66666666666666663
r8683 n5787 n5820 0.1875
r8684 n5819 n5820 0.66666666666666663
r8685 n5788 n5821 0.0234375
r8686 n5820 n5821 0.375
r8687 n5789 n5822 0.022058823529411766
r8688 n5821 n5822 0.6875
r8689 n5790 n5823 0.037499999999999999
r8690 n5791 n5824 0.074999999999999997
r8691 n5823 n5824 0.3125
r8692 n5792 n5825 0.074999999999999997
r8693 n5824 n5825 0.20833333333333334
r8694 n5793 n5826 0.375
r8695 n5825 n5826 0.125
r8696 n5794 n5827 0.125
r8697 n5826 n5827 0.083333333333333329
r8698 n5795 n5828 0.375
r8699 n5827 n5828 0.083333333333333329
r8700 n5796 n5829 0.041666666666666664
r8701 n5828 n5829 0.20833333333333334
r8702 n5797 n5830 0.037499999999999999
r8703 n5829 n5830 0.39583333333333331
r8704 n5798 n5831 0.074999999999999997
r8705 n5830 n5831 0.3125
r8706 n5799 n5832 0.074999999999999997
r8707 n5831 n5832 0.20833333333333334
r8708 n5800 n5833 0.375
r8709 n5832 n5833 0.125
r8710 n5801 n5834 0.1875
r8711 n5833 n5834 0.0625
r8712 n5802 n5835 0.375
r8713 n5834 n5835 0.0625
r8714 n5803 n5836 0.375
r8715 n5835 n5836 0.041666666666666664
r8716 n5804 n5837 0.375
r8717 n5836 n5837 0.041666666666666664
r8718 n5805 n5838 0.09375
r8719 n5837 n5838 0.10416666666666667
r8720 n5806 n5839 0.074999999999999997
r8721 n5838 n5839 0.1875
r8722 n5807 n5840 0.375
r8723 n5839 n5840 0.125
r8724 n5808 n5841 0.037499999999999999
r8725 n5840 n5841 0.22916666666666666
r8726 n5809 n5842 0.037499999999999999
r8727 n5810 n5843 0.014999999999999999
r8728 n5842 n5843 0.72916666666666663
r8729 n5811 n5844 0.375
r8730 n5843 n5844 0.54166666666666663
r8731 n5812 n5845 0.013392857142857142
r8732 n5844 n5845 0.60416666666666663
r8733 n5813 n5846 0.375
r8734 n5845 n5846 0.60416666666666663
r8735 n5814 n5847 0.014999999999999999
r8736 n5846 n5847 0.54166666666666663
r8737 n5815 n5848 0.037499999999999999
r8738 n5847 n5848 0.72916666666666663
r8739 n5816 n5849 0.036764705882352942
r8740 n5817 n5850 0.0390625
r8741 n5849 n5850 0.29464285714285715
r8742 n5818 n5851 0.3125
r8743 n5850 n5851 0.16071428571428573
r8744 n5819 n5852 0.020833333333333332
r8745 n5851 n5852 0.2857142857142857
r8746 n5820 n5853 0.3125
r8747 n5852 n5853 0.2857142857142857
r8748 n5821 n5854 0.0390625
r8749 n5853 n5854 0.16071428571428573
r8750 n5822 n5855 0.036764705882352942
r8751 n5854 n5855 0.29464285714285715
r8752 n5823 n5856 0.0625
r8753 n5824 n5857 0.125
r8754 n5856 n5857 0.13392857142857142
r8755 n5825 n5858 0.125
r8756 n5857 n5858 0.089285714285714288
r8757 n5826 n5859 0.625
r8758 n5858 n5859 0.053571428571428568
r8759 n5827 n5860 0.20833333333333334
r8760 n5859 n5860 0.035714285714285712
r8761 n5828 n5861 0.625
r8762 n5860 n5861 0.035714285714285712
r8763 n5829 n5862 0.069444444444444448
r8764 n5861 n5862 0.089285714285714288
r8765 n5830 n5863 0.0625
r8766 n5862 n5863 0.16964285714285715
r8767 n5831 n5864 0.125
r8768 n5863 n5864 0.13392857142857142
r8769 n5832 n5865 0.125
r8770 n5864 n5865 0.089285714285714288
r8771 n5833 n5866 0.625
r8772 n5865 n5866 0.053571428571428568
r8773 n5834 n5867 0.3125
r8774 n5866 n5867 0.026785714285714284
r8775 n5835 n5868 0.625
r8776 n5867 n5868 0.026785714285714284
r8777 n5836 n5869 0.625
r8778 n5868 n5869 0.017857142857142856
r8779 n5837 n5870 0.625
r8780 n5869 n5870 0.017857142857142856
r8781 n5838 n5871 0.15625
r8782 n5870 n5871 0.044642857142857144
r8783 n5839 n5872 0.125
r8784 n5871 n5872 0.080357142857142863
r8785 n5840 n5873 0.625
r8786 n5872 n5873 0.053571428571428568
r8787 n5841 n5874 0.0625
r8788 n5873 n5874 0.098214285714285712
r8789 n5842 n5875 0.0625
r8790 n5843 n5876 0.025000000000000001
r8791 n5875 n5876 0.3125
r8792 n5844 n5877 0.625
r8793 n5876 n5877 0.23214285714285715
r8794 n5845 n5878 0.022321428571428572
r8795 n5877 n5878 0.25892857142857145
r8796 n5846 n5879 0.625
r8797 n5878 n5879 0.25892857142857145
r8798 n5847 n5880 0.025000000000000001
r8799 n5879 n5880 0.23214285714285715
r8800 n5848 n5881 0.0625
r8801 n5880 n5881 0.3125
r8802 n5849 n5882 0.05514705882352941
r8803 n5850 n5883 0.05859375
r8804 n5882 n5883 0.2578125
r8805 n5851 n5884 0.46875
r8806 n5883 n5884 0.140625
r8807 n5852 n5885 0.03125
r8808 n5884 n5885 0.25
r8809 n5853 n5886 0.46875
r8810 n5885 n5886 0.25
r8811 n5854 n5887 0.05859375
r8812 n5886 n5887 0.140625
r8813 n5855 n5888 0.05514705882352941
r8814 n5887 n5888 0.2578125
r8815 n5856 n5889 0.09375
r8816 n5857 n5890 0.1875
r8817 n5889 n5890 0.1171875
r8818 n5858 n5891 0.1875
r8819 n5890 n5891 0.078125
r8820 n5859 n5892 0.9375
r8821 n5891 n5892 0.046875
r8822 n5860 n5893 0.3125
r8823 n5892 n5893 0.03125
r8824 n5861 n5894 0.9375
r8825 n5893 n5894 0.03125
r8826 n5862 n5895 0.10416666666666667
r8827 n5894 n5895 0.078125
r8828 n5863 n5896 0.09375
r8829 n5895 n5896 0.1484375
r8830 n5864 n5897 0.1875
r8831 n5896 n5897 0.1171875
r8832 n5865 n5898 0.1875
r8833 n5897 n5898 0.078125
r8834 n5866 n5899 0.9375
r8835 n5898 n5899 0.046875
r8836 n5867 n5900 0.46875
r8837 n5899 n5900 0.0234375
r8838 n5868 n5901 0.9375
r8839 n5900 n5901 0.0234375
r8840 n5869 n5902 0.9375
r8841 n5901 n5902 0.015625
r8842 n5870 n5903 0.9375
r8843 n5902 n5903 0.015625
r8844 n5871 n5904 0.234375
r8845 n5903 n5904 0.0390625
r8846 n5872 n5905 0.1875
r8847 n5904 n5905 0.0703125
r8848 n5873 n5906 0.9375
r8849 n5905 n5906 0.046875
r8850 n5874 n5907 0.09375
r8851 n5906 n5907 0.0859375
r8852 n5875 n5908 0.09375
r8853 n5876 n5909 0.037499999999999999
r8854 n5908 n5909 0.2734375
r8855 n5877 n5910 0.9375
r8856 n5909 n5910 0.203125
r8857 n5878 n5911 0.033482142857142856
r8858 n5910 n5911 0.2265625
r8859 n5879 n5912 0.9375
r8860 n5911 n5912 0.2265625
r8861 n5880 n5913 0.037499999999999999
r8862 n5912 n5913 0.203125
r8863 n5881 n5914 0.09375
r8864 n5913 n5914 0.2734375
r8865 n5882 n5915 0.036764705882352942
r8866 n5883 n5916 0.0390625
r8867 n5915 n5916 1.03125
r8868 n5884 n5917 0.3125
r8869 n5916 n5917 0.5625
r8870 n5885 n5918 0.020833333333333332
r8871 n5917 n5918 1
r8872 n5886 n5919 0.3125
r8873 n5918 n5919 1
r8874 n5887 n5920 0.0390625
r8875 n5919 n5920 0.5625
r8876 n5888 n5921 0.036764705882352942
r8877 n5920 n5921 1.03125
r8878 n5889 n5922 0.0625
r8879 n5890 n5923 0.125
r8880 n5922 n5923 0.46875
r8881 n5891 n5924 0.125
r8882 n5923 n5924 0.3125
r8883 n5892 n5925 0.625
r8884 n5924 n5925 0.1875
r8885 n5893 n5926 0.20833333333333334
r8886 n5925 n5926 0.125
r8887 n5894 n5927 0.625
r8888 n5926 n5927 0.125
r8889 n5895 n5928 0.069444444444444448
r8890 n5927 n5928 0.3125
r8891 n5896 n5929 0.0625
r8892 n5928 n5929 0.59375
r8893 n5897 n5930 0.125
r8894 n5929 n5930 0.46875
r8895 n5898 n5931 0.125
r8896 n5930 n5931 0.3125
r8897 n5899 n5932 0.625
r8898 n5931 n5932 0.1875
r8899 n5900 n5933 0.3125
r8900 n5932 n5933 0.09375
r8901 n5901 n5934 0.625
r8902 n5933 n5934 0.09375
r8903 n5902 n5935 0.625
r8904 n5934 n5935 0.0625
r8905 n5903 n5936 0.625
r8906 n5935 n5936 0.0625
r8907 n5904 n5937 0.15625
r8908 n5936 n5937 0.15625
r8909 n5905 n5938 0.125
r8910 n5937 n5938 0.28125
r8911 n5906 n5939 0.625
r8912 n5938 n5939 0.1875
r8913 n5907 n5940 0.0625
r8914 n5939 n5940 0.34375
r8915 n5908 n5941 0.0625
r8916 n5909 n5942 0.025000000000000001
r8917 n5941 n5942 1.09375
r8918 n5910 n5943 0.625
r8919 n5942 n5943 0.8125
r8920 n5911 n5944 0.022321428571428572
r8921 n5943 n5944 0.90625
r8922 n5912 n5945 0.625
r8923 n5944 n5945 0.90625
r8924 n5913 n5946 0.025000000000000001
r8925 n5945 n5946 0.8125
r8926 n5914 n5947 0.0625
r8927 n5946 n5947 1.09375
r8928 n5915 n5948 0.125
r8929 n5916 n5949 0.1328125
r8930 n5948 n5949 0.064453125
r8931 n5917 n5950 1.0625
r8932 n5949 n5950 0.03515625
r8933 n5918 n5951 0.070833333333333331
r8934 n5950 n5951 0.0625
r8935 n5919 n5952 1.0625
r8936 n5951 n5952 0.0625
r8937 n5920 n5953 0.1328125
r8938 n5952 n5953 0.03515625
r8939 n5921 n5954 0.125
r8940 n5953 n5954 0.064453125
r8941 n5941 n5955 0.21249999999999999
r8942 n5942 n5956 0.085000000000000006
r8943 n5955 n5956 0.068359375
r8944 n5943 n5957 2.125
r8945 n5956 n5957 0.05078125
r8946 n5944 n5958 0.075892857142857137
r8947 n5957 n5958 0.056640625
r8948 n5945 n5959 2.125
r8949 n5958 n5959 0.056640625
r8950 n5946 n5960 0.085000000000000006
r8951 n5959 n5960 0.05078125
r8952 n5947 n5961 0.21249999999999999
r8953 n5960 n5961 0.068359375
r8954 n5948 n5962 0.29044117647058826
r8955 n5949 n5963 0.30859375
r8956 n5962 n5963 0.043882978723404256
r8957 n5950 n5964 2.46875
r8958 n5963 n5964 0.023936170212765957
r8959 n5951 n5965 0.16458333333333333
r8960 n5964 n5965 0.042553191489361701
r8961 n5952 n5966 2.46875
r8962 n5965 n5966 0.042553191489361701
r8963 n5953 n5967 0.30859375
r8964 n5966 n5967 0.023936170212765957
r8965 n5954 n5968 0.29044117647058826
r8966 n5967 n5968 0.043882978723404256
r8967 n5955 n5969 0.49375000000000002
r8968 n5956 n5970 0.19750000000000001
r8969 n5969 n5970 0.046542553191489359
r8970 n5957 n5971 4.9375
r8971 n5970 n5971 0.034574468085106384
r8972 n5958 n5972 0.17633928571428573
r8973 n5971 n5972 0.038563829787234043
r8974 n5959 n5973 4.9375
r8975 n5972 n5973 0.038563829787234043
r8976 n5960 n5974 0.19750000000000001
r8977 n5973 n5974 0.034574468085106384
r8978 n5961 n5975 0.49375000000000002
r8979 n5974 n5975 0.046542553191489359
r8980 n5962 n5976 0.29779411764705882
r8981 n5963 n5977 0.31640625
r8982 n5976 n5977 0.060661764705882353
r8983 n5964 n5978 2.53125
r8984 n5977 n5978 0.033088235294117647
r8985 n5965 n5979 0.16875000000000001
r8986 n5978 n5979 0.058823529411764705
r8987 n5966 n5980 2.53125
r8988 n5979 n5980 0.058823529411764705
r8989 n5967 n5981 0.31640625
r8990 n5980 n5981 0.033088235294117647
r8991 n5968 n5982 0.29779411764705882
r8992 n5981 n5982 0.060661764705882353
r8993 n5969 n5983 0.50624999999999998
r8994 n5970 n5984 0.20250000000000001
r8995 n5983 n5984 0.064338235294117641
r8996 n5971 n5985 5.0625
r8997 n5984 n5985 0.04779411764705882
r8998 n5972 n5986 0.18080357142857142
r8999 n5985 n5986 0.053308823529411763
r9000 n5973 n5987 5.0625
r9001 n5986 n5987 0.053308823529411763
r9002 n5974 n5988 0.20250000000000001
r9003 n5987 n5988 0.04779411764705882
r9004 n5975 n5989 0.50624999999999998
r9005 n5988 n5989 0.064338235294117641
r9006 n5976 n5990 0.30367647058823527
r9007 n5977 n5991 0.32265624999999998
r9008 n5990 n5991 0.042438271604938273
r9009 n5978 n5992 2.5812499999999998
r9010 n5991 n5992 0.023148148148148147
r9011 n5979 n5993 0.17208333333333334
r9012 n5992 n5993 0.041152263374485597
r9013 n5980 n5994 2.5812499999999998
r9014 n5993 n5994 0.041152263374485597
r9015 n5981 n5995 0.32265624999999998
r9016 n5994 n5995 0.023148148148148147
r9017 n5982 n5996 0.30367647058823527
r9018 n5995 n5996 0.042438271604938273
r9019 n5983 n5997 0.51624999999999999
r9020 n5984 n5998 0.20649999999999999
r9021 n5997 n5998 0.045010288065843625
r9022 n5985 n5999 5.1624999999999996
r9023 n5998 n5999 0.033436213991769548
r9024 n5986 n6000 0.18437500000000001
r9025 n5999 n6000 0.037294238683127569
r9026 n5987 n6001 5.1624999999999996
r9027 n6000 n6001 0.037294238683127569
r9028 n5988 n6002 0.20649999999999999
r9029 n6001 n6002 0.033436213991769548
r9030 n5989 n6003 0.51624999999999999
r9031 n6002 n6003 0.045010288065843625
r9032 n5990 n6004 0.35808823529411765
r9033 n5991 n6005 0.38046875000000002
r9034 n6004 n6005 0.042264344262295084
r9035 n5992 n6006 3.0437500000000002
r9036 n6005 n6006 0.023053278688524591
r9037 n5993 n6007 0.20291666666666666
r9038 n6006 n6007 0.040983606557377046
r9039 n5994 n6008 3.0437500000000002
r9040 n6007 n6008 0.040983606557377046
r9041 n5995 n6009 0.38046875000000002
r9042 n6008 n6009 0.023053278688524591
r9043 n5996 n6010 0.35808823529411765
r9044 n6009 n6010 0.042264344262295084
r9045 n5997 n6011 0.60875000000000001
r9046 n5998 n6012 0.24349999999999999
r9047 n6011 n6012 0.044825819672131145
r9048 n5999 n6013 6.0875000000000004
r9049 n6012 n6013 0.033299180327868855
r9050 n6000 n6014 0.21741071428571429
r9051 n6013 n6014 0.037141393442622954
r9052 n6001 n6015 6.0875000000000004
r9053 n6014 n6015 0.037141393442622954
r9054 n6002 n6016 0.24349999999999999
r9055 n6015 n6016 0.033299180327868855
r9056 n6003 n6017 0.60875000000000001
r9057 n6016 n6017 0.044825819672131145
r9058 n6004 n6018 0.35808823529411765
r9059 n6005 n6019 0.38046875000000002
r9060 n6018 n6019 0.042438271604938273
r9061 n6006 n6020 3.0437500000000002
r9062 n6019 n6020 0.023148148148148147
r9063 n6007 n6021 0.20291666666666666
r9064 n6020 n6021 0.041152263374485597
r9065 n6008 n6022 3.0437500000000002
r9066 n6021 n6022 0.041152263374485597
r9067 n6009 n6023 0.38046875000000002
r9068 n6022 n6023 0.023148148148148147
r9069 n6010 n6024 0.35808823529411765
r9070 n6023 n6024 0.042438271604938273
r9071 n6011 n6025 0.60875000000000001
r9072 n6012 n6026 0.24349999999999999
r9073 n6025 n6026 0.045010288065843625
r9074 n6013 n6027 6.0875000000000004
r9075 n6026 n6027 0.033436213991769548
r9076 n6014 n6028 0.21741071428571429
r9077 n6027 n6028 0.037294238683127569
r9078 n6015 n6029 6.0875000000000004
r9079 n6028 n6029 0.037294238683127569
r9080 n6016 n6030 0.24349999999999999
r9081 n6029 n6030 0.033436213991769548
r9082 n6017 n6031 0.60875000000000001
r9083 n6030 n6031 0.045010288065843625
r9084 n6018 n6032 0.3573529411764706
r9085 n6019 n6033 0.37968750000000001
r9086 n6032 n6033 0.042438271604938273
r9087 n6020 n6034 3.0375000000000001
r9088 n6033 n6034 0.023148148148148147
r9089 n6021 n6035 0.20250000000000001
r9090 n6034 n6035 0.041152263374485597
r9091 n6022 n6036 3.0375000000000001
r9092 n6035 n6036 0.041152263374485597
r9093 n6023 n6037 0.37968750000000001
r9094 n6036 n6037 0.023148148148148147
r9095 n6024 n6038 0.3573529411764706
r9096 n6037 n6038 0.042438271604938273
r9097 n6025 n6039 0.60750000000000004
r9098 n6026 n6040 0.24299999999999999
r9099 n6039 n6040 0.045010288065843625
r9100 n6027 n6041 6.0750000000000002
r9101 n6040 n6041 0.033436213991769548
r9102 n6028 n6042 0.21696428571428572
r9103 n6041 n6042 0.037294238683127569
r9104 n6029 n6043 6.0750000000000002
r9105 n6042 n6043 0.037294238683127569
r9106 n6030 n6044 0.24299999999999999
r9107 n6043 n6044 0.033436213991769548
r9108 n6031 n6045 0.60750000000000004
r9109 n6044 n6045 0.045010288065843625
r9110 n6032 n6046 0.35808823529411765
r9111 n6033 n6047 0.38046875000000002
r9112 n6046 n6047 0.042264344262295084
r9113 n6034 n6048 3.0437500000000002
r9114 n6047 n6048 0.023053278688524591
r9115 n6035 n6049 0.20291666666666666
r9116 n6048 n6049 0.040983606557377046
r9117 n6036 n6050 3.0437500000000002
r9118 n6049 n6050 0.040983606557377046
r9119 n6037 n6051 0.38046875000000002
r9120 n6050 n6051 0.023053278688524591
r9121 n6038 n6052 0.35808823529411765
r9122 n6051 n6052 0.042264344262295084
r9123 n6039 n6053 0.60875000000000001
r9124 n6040 n6054 0.24349999999999999
r9125 n6053 n6054 0.044825819672131145
r9126 n6041 n6055 6.0875000000000004
r9127 n6054 n6055 0.033299180327868855
r9128 n6042 n6056 0.21741071428571429
r9129 n6055 n6056 0.037141393442622954
r9130 n6043 n6057 6.0875000000000004
r9131 n6056 n6057 0.037141393442622954
r9132 n6044 n6058 0.24349999999999999
r9133 n6057 n6058 0.033299180327868855
r9134 n6045 n6059 0.60875000000000001
r9135 n6058 n6059 0.044825819672131145
r9136 n6046 n6060 0.35808823529411765
r9137 n6047 n6061 0.38046875000000002
r9138 n6060 n6061 0.042438271604938273
r9139 n6048 n6062 3.0437500000000002
r9140 n6061 n6062 0.023148148148148147
r9141 n6049 n6063 0.20291666666666666
r9142 n6062 n6063 0.041152263374485597
r9143 n6050 n6064 3.0437500000000002
r9144 n6063 n6064 0.041152263374485597
r9145 n6051 n6065 0.38046875000000002
r9146 n6064 n6065 0.023148148148148147
r9147 n6052 n6066 0.35808823529411765
r9148 n6065 n6066 0.042438271604938273
r9149 n6053 n6067 0.60875000000000001
r9150 n6054 n6068 0.24349999999999999
r9151 n6067 n6068 0.045010288065843625
r9152 n6055 n6069 6.0875000000000004
r9153 n6068 n6069 0.033436213991769548
r9154 n6056 n6070 0.21741071428571429
r9155 n6069 n6070 0.037294238683127569
r9156 n6057 n6071 6.0875000000000004
r9157 n6070 n6071 0.037294238683127569
r9158 n6058 n6072 0.24349999999999999
r9159 n6071 n6072 0.033436213991769548
r9160 n6059 n6073 0.60875000000000001
r9161 n6072 n6073 0.045010288065843625
r9162 n6060 n6074 0.18602941176470589
r9163 n6061 n6075 0.19765625000000001
r9164 n6074 n6075 1.03125
r9165 n6062 n6076 1.58125
r9166 n6075 n6076 0.5625
r9167 n6063 n6077 0.10541666666666667
r9168 n6076 n6077 1
r9169 n6064 n6078 1.58125
r9170 n6077 n6078 1
r9171 n6065 n6079 0.19765625000000001
r9172 n6078 n6079 0.5625
r9173 n6066 n6080 0.18602941176470589
r9174 n6079 n6080 1.03125
r9175 n6081 n6082 0.78125
r9176 n6082 n6083 1
r9177 n6083 n6084 1
r9178 n6084 n6085 0.78125
r9179 n6067 n6086 0.31624999999999998
r9180 n6068 n6087 0.1265
r9181 n6086 n6087 1.09375
r9182 n6069 n6088 3.1625000000000001
r9183 n6087 n6088 0.8125
r9184 n6070 n6089 0.11294642857142857
r9185 n6088 n6089 0.90625
r9186 n6071 n6090 3.1625000000000001
r9187 n6089 n6090 0.90625
r9188 n6072 n6091 0.1265
r9189 n6090 n6091 0.8125
r9190 n6073 n6092 0.31624999999999998
r9191 n6091 n6092 1.09375
r9192 n6074 n6093 0.04779411764705882
r9193 n6075 n6094 0.05078125
r9194 n6093 n6094 0.1875
r9195 n6076 n6095 0.40625
r9196 n6094 n6095 0.10227272727272728
r9197 n6077 n6096 0.027083333333333334
r9198 n6095 n6096 0.18181818181818182
r9199 n6078 n6097 0.40625
r9200 n6096 n6097 0.18181818181818182
r9201 n6079 n6098 0.05078125
r9202 n6097 n6098 0.10227272727272728
r9203 n6080 n6099 0.04779411764705882
r9204 n6098 n6099 0.1875
r9205 n6099 n6100 0.15340909090909091
r9206 n6100 n6101 0.28977272727272729
r9207 n6101 n6102 0.46590909090909088
r9208 n6102 n6103 0.46590909090909088
r9209 n6103 n6104 0.42613636363636365
r9210 n6104 n6105 0.34886363636363638
r9211 n6105 n6106 0.3125
r9212 n6106 n6107 0.34999999999999998
r9213 n6107 n6108 0.26704545454545453
r9214 n6108 n6109 0.30113636363636365
r9215 n6109 n6110 0.23295454545454544
r9216 n6110 n6111 0.19318181818181818
r9217 n6111 n6112 0.19318181818181818
r9218 n6112 n6113 0.13636363636363635
r9219 n6113 n6114 0.15340909090909091
r9220 n6114 n6115 0.056818181818181816
r9221 n6115 n6116 0.0625
r9222 n6116 n6117 0.034090909090909088
r9223 n6117 n6118 0.079545454545454544
r9224 n6118 n6119 0.13068181818181818
r9225 n6119 n6120 0.085227272727272721
r9226 n6120 n6121 0.056818181818181816
r9227 n6121 n6122 0.034090909090909088
r9228 n6122 n6123 0.022727272727272728
r9229 n6123 n6124 0.022727272727272728
r9230 n6124 n6125 0.056818181818181816
r9231 n6125 n6126 0.10795454545454546
r9232 n6126 n6127 0.085227272727272721
r9233 n6127 n6128 0.056818181818181816
r9234 n6128 n6129 0.034090909090909088
r9235 n6129 n6130 0.017045454545454544
r9236 n6130 n6131 0.017045454545454544
r9237 n6131 n6132 0.011363636363636364
r9238 n6132 n6133 0.011363636363636364
r9239 n6133 n6134 0.028409090909090908
r9240 n6134 n6135 0.05113636363636364
r9241 n6135 n6136 0.034090909090909088
r9242 n6136 n6137 0.0625
r9243 n6137 n6138 0.073863636363636367
r9244 n6138 n6139 0.05113636363636364
r9245 n6139 n6140 0.045454545454545456
r9246 n6140 n6141 0.017045454545454544
r9247 n6141 n6142 0.011363636363636364
r9248 n6142 n6143 0.039772727272727272
r9249 n6143 n6144 0.0625
r9250 n6144 n6145 0.034090909090909088
r9251 n6145 n6146 0.028409090909090908
r9252 n6146 n6147 0.05113636363636364
r9253 n6147 n6148 0.045454545454545456
r9254 n6148 n6149 0.056818181818181816
r9255 n6149 n6150 0.073863636363636367
r9256 n6150 n6151 0.090909090909090912
r9257 n6151 n6152 0.079545454545454544
r9258 n6152 n6153 0.0625
r9259 n6153 n6154 0.090909090909090912
r9260 n6154 n6155 0.073863636363636367
r9261 n6155 n6156 0.068181818181818177
r9262 n6156 n6157 0.073863636363636367
r9263 n6157 n6158 0.0625
r9264 n6158 n6159 0.045454545454545456
r9265 n6159 n6160 0.10795454545454546
r9266 n6160 n6161 0.17045454545454544
r9267 n6161 n6162 0.085227272727272721
r9268 n6162 n6163 0.022727272727272728
r9269 n6163 n6164 0.034090909090909088
r9270 n6164 n6165 0.05113636363636364
r9271 n6165 n6166 0.073863636363636367
r9272 n6166 n6167 0.068181818181818177
r9273 n6167 n6168 0.096590909090909088
r9274 n6168 n6169 0.11363636363636363
r9275 n6169 n6170 0.19318181818181818
r9276 n6170 n6171 0.16477272727272727
r9277 n6171 n6172 0.039772727272727272
r9278 n6172 n6173 0.18181818181818182
r9279 n6173 n6174 0.16477272727272727
r9280 n6174 n6175 0.19318181818181818
r9281 n6175 n6176 0.375
r9282 n6176 n6177 0.38636363636363635
r9283 n6177 n6178 0.38636363636363635
r9284 n6178 n6179 0.38636363636363635
r9285 n6179 n6180 0.38636363636363635
r9286 n6180 n6181 0.38636363636363635
r9287 n6181 n6182 0.38636363636363635
r9288 n6182 n6183 0.38636363636363635
r9289 n6183 n6184 0.38636363636363635
r9290 n6184 n6185 0.38636363636363635
r9291 n6185 n6186 0.38636363636363635
r9292 n6186 n6187 0.38636363636363635
r9293 n6187 n6188 0.38636363636363635
r9294 n6188 n6189 0.38636363636363635
r9295 n6189 n6190 0.38636363636363635
r9296 n6190 n6191 0.38636363636363635
r9297 n6191 n6192 0.38636363636363635
r9298 n6192 n6193 0.38636363636363635
r9299 n6193 n6194 0.38636363636363635
r9300 n6194 n6195 0.38636363636363635
r9301 n6195 n6196 0.38636363636363635
r9302 n6196 n6197 0.38636363636363635
r9303 n6197 n6198 0.25568181818181818
r9304 n6081 n6199 0.035326086956521736
r9305 n6198 n6199 0.19318181818181818
r9306 n6082 n6200 0.40625
r9307 n6199 n6200 0.14204545454545456
r9308 n6083 n6201 0.027083333333333334
r9309 n6200 n6201 0.18181818181818182
r9310 n6084 n6202 0.40625
r9311 n6201 n6202 0.18181818181818182
r9312 n6085 n6203 0.035326086956521736
r9313 n6202 n6203 0.14204545454545456
r9314 n6086 n6204 0.081250000000000003
r9315 n6087 n6205 0.032500000000000001
r9316 n6204 n6205 0.19886363636363635
r9317 n6088 n6206 0.8125
r9318 n6205 n6206 0.14772727272727273
r9319 n6089 n6207 0.029017857142857144
r9320 n6206 n6207 0.16477272727272727
r9321 n6090 n6208 0.8125
r9322 n6207 n6208 0.16477272727272727
r9323 n6091 n6209 0.032500000000000001
r9324 n6208 n6209 0.14772727272727273
r9325 n6092 n6210 0.081250000000000003
r9326 n6209 n6210 0.19886363636363635
r9327 n6093 n6211 0.04779411764705882
r9328 n6094 n6212 0.05078125
r9329 n6211 n6212 1.03125
r9330 n6095 n6213 0.40625
r9331 n6212 n6213 0.5625
r9332 n6096 n6214 0.027083333333333334
r9333 n6213 n6214 1
r9334 n6097 n6215 0.40625
r9335 n6214 n6215 1
r9336 n6098 n6216 0.05078125
r9337 n6215 n6216 0.5625
r9338 n6099 n6217 0.04779411764705882
r9339 n6216 n6217 1.03125
r9340 n6100 n6218 0.081250000000000003
r9341 n6217 n6218 0.84375
r9342 n6101 n6219 0.019817073170731708
r9343 n6218 n6219 1.59375
r9344 n6102 n6220 0.019817073170731708
r9345 n6219 n6220 2.5625
r9346 n6103 n6221 0.019817073170731708
r9347 n6220 n6221 2.5625
r9348 n6104 n6222 0.02389705882352941
r9349 n6221 n6222 2.34375
r9350 n6105 n6223 0.029653284671532845
r9351 n6222 n6223 1.91875
r9352 n6106 n6224 0.029438405797101448
r9353 n6223 n6224 1.71875
r9354 n6107 n6225 0.02389705882352941
r9355 n6224 n6225 1.925
r9356 n6108 n6226 0.0625
r9357 n6225 n6226 1.46875
r9358 n6109 n6227 0.020312500000000001
r9359 n6226 n6227 1.65625
r9360 n6110 n6228 0.8125
r9361 n6227 n6228 1.28125
r9362 n6111 n6229 0.02462121212121212
r9363 n6228 n6229 1.0625
r9364 n6112 n6230 0.8125
r9365 n6229 n6230 1.0625
r9366 n6113 n6231 0.035326086956521736
r9367 n6230 n6231 0.75
r9368 n6114 n6232 0.203125
r9369 n6231 n6232 0.84375
r9370 n6115 n6233 0.13541666666666666
r9371 n6232 n6233 0.3125
r9372 n6116 n6234 0.16250000000000001
r9373 n6233 n6234 0.34375
r9374 n6117 n6235 0.8125
r9375 n6234 n6235 0.1875
r9376 n6118 n6236 0.0625
r9377 n6235 n6236 0.4375
r9378 n6119 n6237 0.081250000000000003
r9379 n6236 n6237 0.71875
r9380 n6120 n6238 0.16250000000000001
r9381 n6237 n6238 0.46875
r9382 n6121 n6239 0.16250000000000001
r9383 n6238 n6239 0.3125
r9384 n6122 n6240 0.8125
r9385 n6239 n6240 0.1875
r9386 n6123 n6241 0.27083333333333331
r9387 n6240 n6241 0.125
r9388 n6124 n6242 0.8125
r9389 n6241 n6242 0.125
r9390 n6125 n6243 0.090277777777777776
r9391 n6242 n6243 0.3125
r9392 n6126 n6244 0.081250000000000003
r9393 n6243 n6244 0.59375
r9394 n6127 n6245 0.16250000000000001
r9395 n6244 n6245 0.46875
r9396 n6128 n6246 0.16250000000000001
r9397 n6245 n6246 0.3125
r9398 n6129 n6247 0.8125
r9399 n6246 n6247 0.1875
r9400 n6130 n6248 0.40625
r9401 n6247 n6248 0.09375
r9402 n6131 n6249 0.8125
r9403 n6248 n6249 0.09375
r9404 n6132 n6250 0.8125
r9405 n6249 n6250 0.0625
r9406 n6133 n6251 0.8125
r9407 n6250 n6251 0.0625
r9408 n6134 n6252 0.203125
r9409 n6251 n6252 0.15625
r9410 n6135 n6253 0.16250000000000001
r9411 n6252 n6253 0.28125
r9412 n6136 n6254 0.8125
r9413 n6253 n6254 0.1875
r9414 n6137 n6255 0.081250000000000003
r9415 n6254 n6255 0.34375
r9416 n6138 n6256 0.27083333333333331
r9417 n6255 n6256 0.40625
r9418 n6139 n6257 0.13541666666666666
r9419 n6256 n6257 0.28125
r9420 n6140 n6258 0.40625
r9421 n6257 n6258 0.25
r9422 n6141 n6259 0.8125
r9423 n6258 n6259 0.09375
r9424 n6142 n6260 0.8125
r9425 n6259 n6260 0.0625
r9426 n6143 n6261 0.13541666666666666
r9427 n6260 n6261 0.21875
r9428 n6144 n6262 0.16250000000000001
r9429 n6261 n6262 0.34375
r9430 n6145 n6263 0.8125
r9431 n6262 n6263 0.1875
r9432 n6146 n6264 0.203125
r9433 n6263 n6264 0.15625
r9434 n6147 n6265 0.16250000000000001
r9435 n6264 n6265 0.28125
r9436 n6148 n6266 0.27083333333333331
r9437 n6265 n6266 0.25
r9438 n6149 n6267 0.11607142857142858
r9439 n6266 n6267 0.3125
r9440 n6150 n6268 0.13541666666666666
r9441 n6267 n6268 0.40625
r9442 n6151 n6269 0.081250000000000003
r9443 n6268 n6269 0.5
r9444 n6152 n6270 0.203125
r9445 n6269 n6270 0.4375
r9446 n6153 n6271 0.11607142857142858
r9447 n6270 n6271 0.34375
r9448 n6154 n6272 0.090277777777777776
r9449 n6271 n6272 0.5
r9450 n6155 n6273 0.203125
r9451 n6272 n6273 0.40625
r9452 n6156 n6274 0.1015625
r9453 n6273 n6274 0.375
r9454 n6157 n6275 0.16250000000000001
r9455 n6274 n6275 0.40625
r9456 n6158 n6276 0.13541666666666666
r9457 n6275 n6276 0.34375
r9458 n6159 n6277 0.40625
r9459 n6276 n6277 0.25
r9460 n6160 n6278 0.04779411764705882
r9461 n6277 n6278 0.59375
r9462 n6161 n6279 0.0625
r9463 n6278 n6279 0.9375
r9464 n6162 n6280 0.40625
r9465 n6279 n6280 0.46875
r9466 n6163 n6281 0.40625
r9467 n6280 n6281 0.125
r9468 n6164 n6282 0.203125
r9469 n6281 n6282 0.1875
r9470 n6165 n6283 0.16250000000000001
r9471 n6282 n6283 0.28125
r9472 n6166 n6284 0.1015625
r9473 n6283 n6284 0.40625
r9474 n6167 n6285 0.203125
r9475 n6284 n6285 0.375
r9476 n6168 n6286 0.0625
r9477 n6285 n6286 0.53125
r9478 n6169 n6287 0.11607142857142858
r9479 n6286 n6287 0.625
r9480 n6170 n6288 0.030092592592592591
r9481 n6287 n6288 1.0625
r9482 n6171 n6289 0.40625
r9483 n6288 n6289 0.90625
r9484 n6172 n6290 0.16250000000000001
r9485 n6289 n6290 0.21875
r9486 n6173 n6291 0.030092592592592591
r9487 n6290 n6291 1
r9488 n6174 n6292 0.40625
r9489 n6291 n6292 0.90625
r9490 n6175 n6293 0.025390625
r9491 n6292 n6293 1.0625
r9492 n6176 n6294 0.02389705882352941
r9493 n6293 n6294 2.0625
r9494 n6177 n6295 0.02389705882352941
r9495 n6294 n6295 2.125
r9496 n6178 n6296 0.02389705882352941
r9497 n6295 n6296 2.125
r9498 n6179 n6297 0.02389705882352941
r9499 n6296 n6297 2.125
r9500 n6180 n6298 0.02389705882352941
r9501 n6297 n6298 2.125
r9502 n6181 n6299 0.02389705882352941
r9503 n6298 n6299 2.125
r9504 n6182 n6300 0.02389705882352941
r9505 n6299 n6300 2.125
r9506 n6183 n6301 0.02389705882352941
r9507 n6300 n6301 2.125
r9508 n6184 n6302 0.02389705882352941
r9509 n6301 n6302 2.125
r9510 n6185 n6303 0.02389705882352941
r9511 n6302 n6303 2.125
r9512 n6186 n6304 0.02389705882352941
r9513 n6303 n6304 2.125
r9514 n6187 n6305 0.02389705882352941
r9515 n6304 n6305 2.125
r9516 n6188 n6306 0.02389705882352941
r9517 n6305 n6306 2.125
r9518 n6189 n6307 0.02389705882352941
r9519 n6306 n6307 2.125
r9520 n6190 n6308 0.02389705882352941
r9521 n6307 n6308 2.125
r9522 n6191 n6309 0.02389705882352941
r9523 n6308 n6309 2.125
r9524 n6192 n6310 0.02389705882352941
r9525 n6309 n6310 2.125
r9526 n6193 n6311 0.02389705882352941
r9527 n6310 n6311 2.125
r9528 n6194 n6312 0.02389705882352941
r9529 n6311 n6312 2.125
r9530 n6195 n6313 0.02389705882352941
r9531 n6312 n6313 2.125
r9532 n6196 n6314 0.02389705882352941
r9533 n6313 n6314 2.125
r9534 n6197 n6315 0.02389705882352941
r9535 n6314 n6315 2.125
r9536 n6198 n6316 0.073863636363636367
r9537 n6315 n6316 1.40625
r9538 n6199 n6317 0.035326086956521736
r9539 n6316 n6317 1.0625
r9540 n6200 n6318 0.40625
r9541 n6317 n6318 0.78125
r9542 n6201 n6319 0.027083333333333334
r9543 n6318 n6319 1
r9544 n6202 n6320 0.40625
r9545 n6319 n6320 1
r9546 n6203 n6321 0.035326086956521736
r9547 n6320 n6321 0.78125
r9548 n6204 n6322 0.081250000000000003
r9549 n6205 n6323 0.032500000000000001
r9550 n6322 n6323 1.09375
r9551 n6206 n6324 0.8125
r9552 n6323 n6324 0.8125
r9553 n6207 n6325 0.029017857142857144
r9554 n6324 n6325 0.90625
r9555 n6208 n6326 0.8125
r9556 n6325 n6326 0.90625
r9557 n6209 n6327 0.032500000000000001
r9558 n6326 n6327 0.8125
r9559 n6210 n6328 0.081250000000000003
r9560 n6327 n6328 1.09375
r9561 n6211 n6329 0.11764705882352941
r9562 n6212 n6330 0.125
r9563 n6329 n6330 0.068750000000000006
r9564 n6213 n6331 1
r9565 n6330 n6331 0.037499999999999999
r9566 n6214 n6332 0.066666666666666666
r9567 n6331 n6332 0.066666666666666666
r9568 n6215 n6333 1
r9569 n6332 n6333 0.066666666666666666
r9570 n6216 n6334 0.125
r9571 n6333 n6334 0.037499999999999999
r9572 n6217 n6335 0.11764705882352941
r9573 n6334 n6335 0.068750000000000006
r9574 n6218 n6336 0.20000000000000001
r9575 n6335 n6336 0.056250000000000001
r9576 n6219 n6337 0.04878048780487805
r9577 n6336 n6337 0.10625
r9578 n6220 n6338 0.04878048780487805
r9579 n6337 n6338 0.17083333333333334
r9580 n6221 n6339 0.04878048780487805
r9581 n6338 n6339 0.17083333333333334
r9582 n6222 n6340 0.058823529411764705
r9583 n6339 n6340 0.15625
r9584 n6223 n6341 0.072992700729927001
r9585 n6340 n6341 0.12791666666666668
r9586 n6224 n6342 0.072463768115942032
r9587 n6341 n6342 0.11458333333333333
r9588 n6225 n6343 0.058823529411764705
r9589 n6342 n6343 0.12833333333333333
r9590 n6226 n6344 0.15384615384615385
r9591 n6343 n6344 0.097916666666666666
r9592 n6227 n6345 0.050000000000000003
r9593 n6344 n6345 0.11041666666666666
r9594 n6228 n6346 2
r9595 n6345 n6346 0.085416666666666669
r9596 n6229 n6347 0.060606060606060608
r9597 n6346 n6347 0.070833333333333331
r9598 n6230 n6348 2
r9599 n6347 n6348 0.070833333333333331
r9600 n6231 n6349 0.086956521739130432
r9601 n6348 n6349 0.050000000000000003
r9602 n6232 n6350 0.5
r9603 n6349 n6350 0.056250000000000001
r9604 n6233 n6351 0.33333333333333331
r9605 n6350 n6351 0.020833333333333332
r9606 n6234 n6352 0.40000000000000002
r9607 n6351 n6352 0.022916666666666665
r9608 n6235 n6353 2
r9609 n6352 n6353 0.012500000000000001
r9610 n6236 n6354 0.15384615384615385
r9611 n6353 n6354 0.029166666666666667
r9612 n6237 n6355 0.20000000000000001
r9613 n6354 n6355 0.04791666666666667
r9614 n6238 n6356 0.40000000000000002
r9615 n6355 n6356 0.03125
r9616 n6239 n6357 0.40000000000000002
r9617 n6356 n6357 0.020833333333333332
r9618 n6240 n6358 2
r9619 n6357 n6358 0.012500000000000001
r9620 n6241 n6359 0.66666666666666663
r9621 n6358 n6359 0.0083333333333333332
r9622 n6242 n6360 2
r9623 n6359 n6360 0.0083333333333333332
r9624 n6243 n6361 0.22222222222222221
r9625 n6360 n6361 0.020833333333333332
r9626 n6244 n6362 0.20000000000000001
r9627 n6361 n6362 0.039583333333333331
r9628 n6245 n6363 0.40000000000000002
r9629 n6362 n6363 0.03125
r9630 n6246 n6364 0.40000000000000002
r9631 n6363 n6364 0.020833333333333332
r9632 n6247 n6365 2
r9633 n6364 n6365 0.012500000000000001
r9634 n6248 n6366 1
r9635 n6365 n6366 0.0062500000000000003
r9636 n6249 n6367 2
r9637 n6366 n6367 0.0062500000000000003
r9638 n6250 n6368 2
r9639 n6367 n6368 0.0041666666666666666
r9640 n6251 n6369 2
r9641 n6368 n6369 0.0041666666666666666
r9642 n6252 n6370 0.5
r9643 n6369 n6370 0.010416666666666666
r9644 n6253 n6371 0.40000000000000002
r9645 n6370 n6371 0.018749999999999999
r9646 n6254 n6372 2
r9647 n6371 n6372 0.012500000000000001
r9648 n6255 n6373 0.20000000000000001
r9649 n6372 n6373 0.022916666666666665
r9650 n6256 n6374 0.66666666666666663
r9651 n6373 n6374 0.027083333333333334
r9652 n6257 n6375 0.33333333333333331
r9653 n6374 n6375 0.018749999999999999
r9654 n6258 n6376 1
r9655 n6375 n6376 0.016666666666666666
r9656 n6259 n6377 2
r9657 n6376 n6377 0.0062500000000000003
r9658 n6260 n6378 2
r9659 n6377 n6378 0.0041666666666666666
r9660 n6261 n6379 0.33333333333333331
r9661 n6378 n6379 0.014583333333333334
r9662 n6262 n6380 0.40000000000000002
r9663 n6379 n6380 0.022916666666666665
r9664 n6263 n6381 2
r9665 n6380 n6381 0.012500000000000001
r9666 n6264 n6382 0.5
r9667 n6381 n6382 0.010416666666666666
r9668 n6265 n6383 0.40000000000000002
r9669 n6382 n6383 0.018749999999999999
r9670 n6266 n6384 0.66666666666666663
r9671 n6383 n6384 0.016666666666666666
r9672 n6267 n6385 0.2857142857142857
r9673 n6384 n6385 0.020833333333333332
r9674 n6268 n6386 0.33333333333333331
r9675 n6385 n6386 0.027083333333333334
r9676 n6269 n6387 0.20000000000000001
r9677 n6386 n6387 0.033333333333333333
r9678 n6270 n6388 0.5
r9679 n6387 n6388 0.029166666666666667
r9680 n6271 n6389 0.2857142857142857
r9681 n6388 n6389 0.022916666666666665
r9682 n6272 n6390 0.22222222222222221
r9683 n6389 n6390 0.033333333333333333
r9684 n6273 n6391 0.5
r9685 n6390 n6391 0.027083333333333334
r9686 n6274 n6392 0.25
r9687 n6391 n6392 0.025000000000000001
r9688 n6275 n6393 0.40000000000000002
r9689 n6392 n6393 0.027083333333333334
r9690 n6276 n6394 0.33333333333333331
r9691 n6393 n6394 0.022916666666666665
r9692 n6277 n6395 1
r9693 n6394 n6395 0.016666666666666666
r9694 n6278 n6396 0.11764705882352941
r9695 n6395 n6396 0.039583333333333331
r9696 n6279 n6397 0.15384615384615385
r9697 n6396 n6397 0.0625
r9698 n6280 n6398 1
r9699 n6397 n6398 0.03125
r9700 n6281 n6399 1
r9701 n6398 n6399 0.0083333333333333332
r9702 n6282 n6400 0.5
r9703 n6399 n6400 0.012500000000000001
r9704 n6283 n6401 0.40000000000000002
r9705 n6400 n6401 0.018749999999999999
r9706 n6284 n6402 0.25
r9707 n6401 n6402 0.027083333333333334
r9708 n6285 n6403 0.5
r9709 n6402 n6403 0.025000000000000001
r9710 n6286 n6404 0.15384615384615385
r9711 n6403 n6404 0.035416666666666666
r9712 n6287 n6405 0.2857142857142857
r9713 n6404 n6405 0.041666666666666664
r9714 n6288 n6406 0.07407407407407407
r9715 n6405 n6406 0.070833333333333331
r9716 n6289 n6407 1
r9717 n6406 n6407 0.060416666666666667
r9718 n6290 n6408 0.40000000000000002
r9719 n6407 n6408 0.014583333333333334
r9720 n6291 n6409 0.07407407407407407
r9721 n6408 n6409 0.066666666666666666
r9722 n6292 n6410 1
r9723 n6409 n6410 0.060416666666666667
r9724 n6293 n6411 0.0625
r9725 n6410 n6411 0.070833333333333331
r9726 n6294 n6412 0.058823529411764705
r9727 n6411 n6412 0.13750000000000001
r9728 n6295 n6413 0.058823529411764705
r9729 n6412 n6413 0.14166666666666666
r9730 n6296 n6414 0.058823529411764705
r9731 n6413 n6414 0.14166666666666666
r9732 n6297 n6415 0.058823529411764705
r9733 n6414 n6415 0.14166666666666666
r9734 n6298 n6416 0.058823529411764705
r9735 n6415 n6416 0.14166666666666666
r9736 n6299 n6417 0.058823529411764705
r9737 n6416 n6417 0.14166666666666666
r9738 n6300 n6418 0.058823529411764705
r9739 n6417 n6418 0.14166666666666666
r9740 n6301 n6419 0.058823529411764705
r9741 n6418 n6419 0.14166666666666666
r9742 n6302 n6420 0.058823529411764705
r9743 n6419 n6420 0.14166666666666666
r9744 n6303 n6421 0.058823529411764705
r9745 n6420 n6421 0.14166666666666666
r9746 n6304 n6422 0.058823529411764705
r9747 n6421 n6422 0.14166666666666666
r9748 n6305 n6423 0.058823529411764705
r9749 n6422 n6423 0.14166666666666666
r9750 n6306 n6424 0.058823529411764705
r9751 n6423 n6424 0.14166666666666666
r9752 n6307 n6425 0.058823529411764705
r9753 n6424 n6425 0.14166666666666666
r9754 n6308 n6426 0.058823529411764705
r9755 n6425 n6426 0.14166666666666666
r9756 n6309 n6427 0.058823529411764705
r9757 n6426 n6427 0.14166666666666666
r9758 n6310 n6428 0.058823529411764705
r9759 n6427 n6428 0.14166666666666666
r9760 n6311 n6429 0.058823529411764705
r9761 n6428 n6429 0.14166666666666666
r9762 n6312 n6430 0.058823529411764705
r9763 n6429 n6430 0.14166666666666666
r9764 n6313 n6431 0.058823529411764705
r9765 n6430 n6431 0.14166666666666666
r9766 n6314 n6432 0.058823529411764705
r9767 n6431 n6432 0.14166666666666666
r9768 n6315 n6433 0.058823529411764705
r9769 n6432 n6433 0.14166666666666666
r9770 n6316 n6434 0.18181818181818182
r9771 n6433 n6434 0.09375
r9772 n6317 n6435 0.086956521739130432
r9773 n6434 n6435 0.070833333333333331
r9774 n6318 n6436 1
r9775 n6435 n6436 0.052083333333333336
r9776 n6319 n6437 0.066666666666666666
r9777 n6436 n6437 0.066666666666666666
r9778 n6320 n6438 1
r9779 n6437 n6438 0.066666666666666666
r9780 n6321 n6439 0.086956521739130432
r9781 n6438 n6439 0.052083333333333336
r9782 n6322 n6440 0.20000000000000001
r9783 n6323 n6441 0.080000000000000002
r9784 n6440 n6441 0.072916666666666671
r9785 n6324 n6442 2
r9786 n6441 n6442 0.054166666666666669
r9787 n6325 n6443 0.071428571428571425
r9788 n6442 n6443 0.060416666666666667
r9789 n6326 n6444 2
r9790 n6443 n6444 0.060416666666666667
r9791 n6327 n6445 0.080000000000000002
r9792 n6444 n6445 0.054166666666666669
r9793 n6328 n6446 0.20000000000000001
r9794 n6445 n6446 0.072916666666666671
r9795 n6329 n6447 0.11764705882352941
r9796 n6330 n6448 0.125
r9797 n6447 n6448 1.03125
r9798 n6331 n6449 1
r9799 n6448 n6449 0.5625
r9800 n6332 n6450 0.066666666666666666
r9801 n6449 n6450 1
r9802 n6333 n6451 1
r9803 n6450 n6451 1
r9804 n6334 n6452 0.125
r9805 n6451 n6452 0.5625
r9806 n6335 n6453 0.11764705882352941
r9807 n6452 n6453 1.03125
r9808 n6336 n6454 0.20000000000000001
r9809 n6453 n6454 0.84375
r9810 n6337 n6455 0.04878048780487805
r9811 n6454 n6455 1.59375
r9812 n6338 n6456 0.04878048780487805
r9813 n6455 n6456 2.5625
r9814 n6339 n6457 0.04878048780487805
r9815 n6456 n6457 2.5625
r9816 n6340 n6458 0.058823529411764705
r9817 n6457 n6458 2.34375
r9818 n6341 n6459 0.072992700729927001
r9819 n6458 n6459 1.91875
r9820 n6342 n6460 0.072463768115942032
r9821 n6459 n6460 1.71875
r9822 n6343 n6461 0.058823529411764705
r9823 n6460 n6461 1.925
r9824 n6344 n6462 0.15384615384615385
r9825 n6461 n6462 1.46875
r9826 n6345 n6463 0.050000000000000003
r9827 n6462 n6463 1.65625
r9828 n6346 n6464 2
r9829 n6463 n6464 1.28125
r9830 n6347 n6465 0.060606060606060608
r9831 n6464 n6465 1.0625
r9832 n6348 n6466 2
r9833 n6465 n6466 1.0625
r9834 n6349 n6467 0.086956521739130432
r9835 n6466 n6467 0.75
r9836 n6350 n6468 0.5
r9837 n6467 n6468 0.84375
r9838 n6351 n6469 0.33333333333333331
r9839 n6468 n6469 0.3125
r9840 n6352 n6470 0.40000000000000002
r9841 n6469 n6470 0.34375
r9842 n6353 n6471 2
r9843 n6470 n6471 0.1875
r9844 n6354 n6472 0.15384615384615385
r9845 n6471 n6472 0.4375
r9846 n6355 n6473 0.20000000000000001
r9847 n6472 n6473 0.71875
r9848 n6356 n6474 0.40000000000000002
r9849 n6473 n6474 0.46875
r9850 n6357 n6475 0.40000000000000002
r9851 n6474 n6475 0.3125
r9852 n6358 n6476 2
r9853 n6475 n6476 0.1875
r9854 n6359 n6477 0.66666666666666663
r9855 n6476 n6477 0.125
r9856 n6360 n6478 2
r9857 n6477 n6478 0.125
r9858 n6361 n6479 0.22222222222222221
r9859 n6478 n6479 0.3125
r9860 n6362 n6480 0.20000000000000001
r9861 n6479 n6480 0.59375
r9862 n6363 n6481 0.40000000000000002
r9863 n6480 n6481 0.46875
r9864 n6364 n6482 0.40000000000000002
r9865 n6481 n6482 0.3125
r9866 n6365 n6483 2
r9867 n6482 n6483 0.1875
r9868 n6366 n6484 1
r9869 n6483 n6484 0.09375
r9870 n6367 n6485 2
r9871 n6484 n6485 0.09375
r9872 n6368 n6486 2
r9873 n6485 n6486 0.0625
r9874 n6369 n6487 2
r9875 n6486 n6487 0.0625
r9876 n6370 n6488 0.5
r9877 n6487 n6488 0.15625
r9878 n6371 n6489 0.40000000000000002
r9879 n6488 n6489 0.28125
r9880 n6372 n6490 2
r9881 n6489 n6490 0.1875
r9882 n6373 n6491 0.20000000000000001
r9883 n6490 n6491 0.34375
r9884 n6374 n6492 0.66666666666666663
r9885 n6491 n6492 0.40625
r9886 n6375 n6493 0.33333333333333331
r9887 n6492 n6493 0.28125
r9888 n6376 n6494 1
r9889 n6493 n6494 0.25
r9890 n6377 n6495 2
r9891 n6494 n6495 0.09375
r9892 n6378 n6496 2
r9893 n6495 n6496 0.0625
r9894 n6379 n6497 0.33333333333333331
r9895 n6496 n6497 0.21875
r9896 n6380 n6498 0.40000000000000002
r9897 n6497 n6498 0.34375
r9898 n6381 n6499 2
r9899 n6498 n6499 0.1875
r9900 n6382 n6500 0.5
r9901 n6499 n6500 0.15625
r9902 n6383 n6501 0.40000000000000002
r9903 n6500 n6501 0.28125
r9904 n6384 n6502 0.66666666666666663
r9905 n6501 n6502 0.25
r9906 n6385 n6503 0.2857142857142857
r9907 n6502 n6503 0.3125
r9908 n6386 n6504 0.33333333333333331
r9909 n6503 n6504 0.40625
r9910 n6387 n6505 0.20000000000000001
r9911 n6504 n6505 0.5
r9912 n6388 n6506 0.5
r9913 n6505 n6506 0.4375
r9914 n6389 n6507 0.2857142857142857
r9915 n6506 n6507 0.34375
r9916 n6390 n6508 0.22222222222222221
r9917 n6507 n6508 0.5
r9918 n6391 n6509 0.5
r9919 n6508 n6509 0.40625
r9920 n6392 n6510 0.25
r9921 n6509 n6510 0.375
r9922 n6393 n6511 0.40000000000000002
r9923 n6510 n6511 0.40625
r9924 n6394 n6512 0.33333333333333331
r9925 n6511 n6512 0.34375
r9926 n6395 n6513 1
r9927 n6512 n6513 0.25
r9928 n6396 n6514 0.11764705882352941
r9929 n6513 n6514 0.59375
r9930 n6397 n6515 0.15384615384615385
r9931 n6514 n6515 0.9375
r9932 n6398 n6516 1
r9933 n6515 n6516 0.46875
r9934 n6399 n6517 1
r9935 n6516 n6517 0.125
r9936 n6400 n6518 0.5
r9937 n6517 n6518 0.1875
r9938 n6401 n6519 0.40000000000000002
r9939 n6518 n6519 0.28125
r9940 n6402 n6520 0.25
r9941 n6519 n6520 0.40625
r9942 n6403 n6521 0.5
r9943 n6520 n6521 0.375
r9944 n6404 n6522 0.15384615384615385
r9945 n6521 n6522 0.53125
r9946 n6405 n6523 0.2857142857142857
r9947 n6522 n6523 0.625
r9948 n6406 n6524 0.07407407407407407
r9949 n6523 n6524 1.0625
r9950 n6407 n6525 1
r9951 n6524 n6525 0.90625
r9952 n6408 n6526 0.40000000000000002
r9953 n6525 n6526 0.21875
r9954 n6409 n6527 0.07407407407407407
r9955 n6526 n6527 1
r9956 n6410 n6528 1
r9957 n6527 n6528 0.90625
r9958 n6411 n6529 0.0625
r9959 n6528 n6529 1.0625
r9960 n6412 n6530 0.058823529411764705
r9961 n6529 n6530 2.0625
r9962 n6413 n6531 0.058823529411764705
r9963 n6530 n6531 2.125
r9964 n6414 n6532 0.058823529411764705
r9965 n6531 n6532 2.125
r9966 n6415 n6533 0.058823529411764705
r9967 n6532 n6533 2.125
r9968 n6416 n6534 0.058823529411764705
r9969 n6533 n6534 2.125
r9970 n6417 n6535 0.058823529411764705
r9971 n6534 n6535 2.125
r9972 n6418 n6536 0.058823529411764705
r9973 n6535 n6536 2.125
r9974 n6419 n6537 0.058823529411764705
r9975 n6536 n6537 2.125
r9976 n6420 n6538 0.058823529411764705
r9977 n6537 n6538 2.125
r9978 n6421 n6539 0.058823529411764705
r9979 n6538 n6539 2.125
r9980 n6422 n6540 0.058823529411764705
r9981 n6539 n6540 2.125
r9982 n6423 n6541 0.058823529411764705
r9983 n6540 n6541 2.125
r9984 n6424 n6542 0.058823529411764705
r9985 n6541 n6542 2.125
r9986 n6425 n6543 0.058823529411764705
r9987 n6542 n6543 2.125
r9988 n6426 n6544 0.058823529411764705
r9989 n6543 n6544 2.125
r9990 n6427 n6545 0.058823529411764705
r9991 n6544 n6545 2.125
r9992 n6428 n6546 0.058823529411764705
r9993 n6545 n6546 2.125
r9994 n6429 n6547 0.058823529411764705
r9995 n6546 n6547 2.125
r9996 n6430 n6548 0.058823529411764705
r9997 n6547 n6548 2.125
r9998 n6431 n6549 0.058823529411764705
r9999 n6548 n6549 2.125
r10000 n6432 n6550 0.058823529411764705
r10001 n6549 n6550 2.125
r10002 n6433 n6551 0.058823529411764705
r10003 n6550 n6551 2.125
r10004 n6434 n6552 0.18181818181818182
r10005 n6551 n6552 1.40625
r10006 n6435 n6553 0.086956521739130432
r10007 n6552 n6553 1.0625
r10008 n6436 n6554 1
r10009 n6553 n6554 0.78125
r10010 n6437 n6555 0.066666666666666666
r10011 n6554 n6555 1
r10012 n6438 n6556 1
r10013 n6555 n6556 1
r10014 n6439 n6557 0.086956521739130432
r10015 n6556 n6557 0.78125
r10016 n6440 n6558 0.20000000000000001
r10017 n6441 n6559 0.080000000000000002
r10018 n6558 n6559 1.09375
r10019 n6442 n6560 2
r10020 n6559 n6560 0.8125
r10021 n6443 n6561 0.071428571428571425
r10022 n6560 n6561 0.90625
r10023 n6444 n6562 2
r10024 n6561 n6562 0.90625
r10025 n6445 n6563 0.080000000000000002
r10026 n6562 n6563 0.8125
r10027 n6446 n6564 0.20000000000000001
r10028 n6563 n6564 1.09375
r10029 n6447 n6565 0.04779411764705882
r10030 n6448 n6566 0.05078125
r10031 n6565 n6566 0.1875
r10032 n6449 n6567 0.40625
r10033 n6566 n6567 0.10227272727272728
r10034 n6450 n6568 0.027083333333333334
r10035 n6567 n6568 0.18181818181818182
r10036 n6451 n6569 0.40625
r10037 n6568 n6569 0.18181818181818182
r10038 n6452 n6570 0.05078125
r10039 n6569 n6570 0.10227272727272728
r10040 n6453 n6571 0.04779411764705882
r10041 n6570 n6571 0.1875
r10042 n6454 n6572 0.081250000000000003
r10043 n6571 n6572 0.15340909090909091
r10044 n6455 n6573 0.019817073170731708
r10045 n6572 n6573 0.28977272727272729
r10046 n6456 n6574 0.019817073170731708
r10047 n6573 n6574 0.46590909090909088
r10048 n6457 n6575 0.019817073170731708
r10049 n6574 n6575 0.46590909090909088
r10050 n6458 n6576 0.02389705882352941
r10051 n6575 n6576 0.42613636363636365
r10052 n6459 n6577 0.029653284671532845
r10053 n6576 n6577 0.34886363636363638
r10054 n6460 n6578 0.029438405797101448
r10055 n6577 n6578 0.3125
r10056 n6461 n6579 0.02389705882352941
r10057 n6578 n6579 0.34999999999999998
r10058 n6462 n6580 0.0625
r10059 n6579 n6580 0.26704545454545453
r10060 n6463 n6581 0.020312500000000001
r10061 n6580 n6581 0.30113636363636365
r10062 n6464 n6582 0.8125
r10063 n6581 n6582 0.23295454545454544
r10064 n6465 n6583 0.02462121212121212
r10065 n6582 n6583 0.19318181818181818
r10066 n6466 n6584 0.8125
r10067 n6583 n6584 0.19318181818181818
r10068 n6467 n6585 0.035326086956521736
r10069 n6584 n6585 0.13636363636363635
r10070 n6468 n6586 0.203125
r10071 n6585 n6586 0.15340909090909091
r10072 n6469 n6587 0.13541666666666666
r10073 n6586 n6587 0.056818181818181816
r10074 n6470 n6588 0.16250000000000001
r10075 n6587 n6588 0.0625
r10076 n6471 n6589 0.8125
r10077 n6588 n6589 0.034090909090909088
r10078 n6472 n6590 0.0625
r10079 n6589 n6590 0.079545454545454544
r10080 n6473 n6591 0.081250000000000003
r10081 n6590 n6591 0.13068181818181818
r10082 n6474 n6592 0.16250000000000001
r10083 n6591 n6592 0.085227272727272721
r10084 n6475 n6593 0.16250000000000001
r10085 n6592 n6593 0.056818181818181816
r10086 n6476 n6594 0.8125
r10087 n6593 n6594 0.034090909090909088
r10088 n6477 n6595 0.27083333333333331
r10089 n6594 n6595 0.022727272727272728
r10090 n6478 n6596 0.8125
r10091 n6595 n6596 0.022727272727272728
r10092 n6479 n6597 0.090277777777777776
r10093 n6596 n6597 0.056818181818181816
r10094 n6480 n6598 0.081250000000000003
r10095 n6597 n6598 0.10795454545454546
r10096 n6481 n6599 0.16250000000000001
r10097 n6598 n6599 0.085227272727272721
r10098 n6482 n6600 0.16250000000000001
r10099 n6599 n6600 0.056818181818181816
r10100 n6483 n6601 0.8125
r10101 n6600 n6601 0.034090909090909088
r10102 n6484 n6602 0.40625
r10103 n6601 n6602 0.017045454545454544
r10104 n6485 n6603 0.8125
r10105 n6602 n6603 0.017045454545454544
r10106 n6486 n6604 0.8125
r10107 n6603 n6604 0.011363636363636364
r10108 n6487 n6605 0.8125
r10109 n6604 n6605 0.011363636363636364
r10110 n6488 n6606 0.203125
r10111 n6605 n6606 0.028409090909090908
r10112 n6489 n6607 0.16250000000000001
r10113 n6606 n6607 0.05113636363636364
r10114 n6490 n6608 0.8125
r10115 n6607 n6608 0.034090909090909088
r10116 n6491 n6609 0.081250000000000003
r10117 n6608 n6609 0.0625
r10118 n6492 n6610 0.27083333333333331
r10119 n6609 n6610 0.073863636363636367
r10120 n6493 n6611 0.13541666666666666
r10121 n6610 n6611 0.05113636363636364
r10122 n6494 n6612 0.40625
r10123 n6611 n6612 0.045454545454545456
r10124 n6495 n6613 0.8125
r10125 n6612 n6613 0.017045454545454544
r10126 n6496 n6614 0.8125
r10127 n6613 n6614 0.011363636363636364
r10128 n6497 n6615 0.13541666666666666
r10129 n6614 n6615 0.039772727272727272
r10130 n6498 n6616 0.16250000000000001
r10131 n6615 n6616 0.0625
r10132 n6499 n6617 0.8125
r10133 n6616 n6617 0.034090909090909088
r10134 n6500 n6618 0.203125
r10135 n6617 n6618 0.028409090909090908
r10136 n6501 n6619 0.16250000000000001
r10137 n6618 n6619 0.05113636363636364
r10138 n6502 n6620 0.27083333333333331
r10139 n6619 n6620 0.045454545454545456
r10140 n6503 n6621 0.11607142857142858
r10141 n6620 n6621 0.056818181818181816
r10142 n6504 n6622 0.13541666666666666
r10143 n6621 n6622 0.073863636363636367
r10144 n6505 n6623 0.081250000000000003
r10145 n6622 n6623 0.090909090909090912
r10146 n6506 n6624 0.203125
r10147 n6623 n6624 0.079545454545454544
r10148 n6507 n6625 0.11607142857142858
r10149 n6624 n6625 0.0625
r10150 n6508 n6626 0.090277777777777776
r10151 n6625 n6626 0.090909090909090912
r10152 n6509 n6627 0.203125
r10153 n6626 n6627 0.073863636363636367
r10154 n6510 n6628 0.1015625
r10155 n6627 n6628 0.068181818181818177
r10156 n6511 n6629 0.16250000000000001
r10157 n6628 n6629 0.073863636363636367
r10158 n6512 n6630 0.13541666666666666
r10159 n6629 n6630 0.0625
r10160 n6513 n6631 0.40625
r10161 n6630 n6631 0.045454545454545456
r10162 n6514 n6632 0.04779411764705882
r10163 n6631 n6632 0.10795454545454546
r10164 n6515 n6633 0.0625
r10165 n6632 n6633 0.17045454545454544
r10166 n6516 n6634 0.40625
r10167 n6633 n6634 0.085227272727272721
r10168 n6517 n6635 0.40625
r10169 n6634 n6635 0.022727272727272728
r10170 n6518 n6636 0.203125
r10171 n6635 n6636 0.034090909090909088
r10172 n6519 n6637 0.16250000000000001
r10173 n6636 n6637 0.05113636363636364
r10174 n6520 n6638 0.1015625
r10175 n6637 n6638 0.073863636363636367
r10176 n6521 n6639 0.203125
r10177 n6638 n6639 0.068181818181818177
r10178 n6522 n6640 0.0625
r10179 n6639 n6640 0.096590909090909088
r10180 n6523 n6641 0.11607142857142858
r10181 n6640 n6641 0.11363636363636363
r10182 n6524 n6642 0.030092592592592591
r10183 n6641 n6642 0.19318181818181818
r10184 n6525 n6643 0.40625
r10185 n6642 n6643 0.16477272727272727
r10186 n6526 n6644 0.16250000000000001
r10187 n6643 n6644 0.039772727272727272
r10188 n6527 n6645 0.030092592592592591
r10189 n6644 n6645 0.18181818181818182
r10190 n6528 n6646 0.40625
r10191 n6645 n6646 0.16477272727272727
r10192 n6529 n6647 0.025390625
r10193 n6646 n6647 0.19318181818181818
r10194 n6530 n6648 0.02389705882352941
r10195 n6647 n6648 0.375
r10196 n6531 n6649 0.02389705882352941
r10197 n6648 n6649 0.38636363636363635
r10198 n6532 n6650 0.02389705882352941
r10199 n6649 n6650 0.38636363636363635
r10200 n6533 n6651 0.02389705882352941
r10201 n6650 n6651 0.38636363636363635
r10202 n6534 n6652 0.02389705882352941
r10203 n6651 n6652 0.38636363636363635
r10204 n6535 n6653 0.02389705882352941
r10205 n6652 n6653 0.38636363636363635
r10206 n6536 n6654 0.02389705882352941
r10207 n6653 n6654 0.38636363636363635
r10208 n6537 n6655 0.02389705882352941
r10209 n6654 n6655 0.38636363636363635
r10210 n6538 n6656 0.02389705882352941
r10211 n6655 n6656 0.38636363636363635
r10212 n6539 n6657 0.02389705882352941
r10213 n6656 n6657 0.38636363636363635
r10214 n6540 n6658 0.02389705882352941
r10215 n6657 n6658 0.38636363636363635
r10216 n6541 n6659 0.02389705882352941
r10217 n6658 n6659 0.38636363636363635
r10218 n6542 n6660 0.02389705882352941
r10219 n6659 n6660 0.38636363636363635
r10220 n6543 n6661 0.02389705882352941
r10221 n6660 n6661 0.38636363636363635
r10222 n6544 n6662 0.02389705882352941
r10223 n6661 n6662 0.38636363636363635
r10224 n6545 n6663 0.02389705882352941
r10225 n6662 n6663 0.38636363636363635
r10226 n6546 n6664 0.02389705882352941
r10227 n6663 n6664 0.38636363636363635
r10228 n6547 n6665 0.02389705882352941
r10229 n6664 n6665 0.38636363636363635
r10230 n6548 n6666 0.02389705882352941
r10231 n6665 n6666 0.38636363636363635
r10232 n6549 n6667 0.02389705882352941
r10233 n6666 n6667 0.38636363636363635
r10234 n6550 n6668 0.02389705882352941
r10235 n6667 n6668 0.38636363636363635
r10236 n6551 n6669 0.02389705882352941
r10237 n6668 n6669 0.38636363636363635
r10238 n6552 n6670 0.073863636363636367
r10239 n6669 n6670 0.25568181818181818
r10240 n6553 n6671 0.035326086956521736
r10241 n6670 n6671 0.19318181818181818
r10242 n6554 n6672 0.40625
r10243 n6671 n6672 0.14204545454545456
r10244 n6555 n6673 0.027083333333333334
r10245 n6672 n6673 0.18181818181818182
r10246 n6556 n6674 0.40625
r10247 n6673 n6674 0.18181818181818182
r10248 n6557 n6675 0.035326086956521736
r10249 n6674 n6675 0.14204545454545456
r10250 n6558 n6676 0.081250000000000003
r10251 n6559 n6677 0.032500000000000001
r10252 n6676 n6677 0.19886363636363635
r10253 n6560 n6678 0.8125
r10254 n6677 n6678 0.14772727272727273
r10255 n6561 n6679 0.029017857142857144
r10256 n6678 n6679 0.16477272727272727
r10257 n6562 n6680 0.8125
r10258 n6679 n6680 0.16477272727272727
r10259 n6563 n6681 0.032500000000000001
r10260 n6680 n6681 0.14772727272727273
r10261 n6564 n6682 0.081250000000000003
r10262 n6681 n6682 0.19886363636363635
r10263 n6565 n6683 0.04779411764705882
r10264 n6566 n6684 0.05078125
r10265 n6683 n6684 1.03125
r10266 n6567 n6685 0.40625
r10267 n6684 n6685 0.5625
r10268 n6568 n6686 0.027083333333333334
r10269 n6685 n6686 1
r10270 n6569 n6687 0.40625
r10271 n6686 n6687 1
r10272 n6570 n6688 0.05078125
r10273 n6687 n6688 0.5625
r10274 n6571 n6689 0.04779411764705882
r10275 n6688 n6689 1.03125
r10276 n6671 n6690 0.035326086956521736
r10277 n6672 n6691 0.40625
r10278 n6690 n6691 0.78125
r10279 n6673 n6692 0.027083333333333334
r10280 n6691 n6692 1
r10281 n6674 n6693 0.40625
r10282 n6692 n6693 1
r10283 n6675 n6694 0.035326086956521736
r10284 n6693 n6694 0.78125
r10285 n6676 n6695 0.081250000000000003
r10286 n6677 n6696 0.032500000000000001
r10287 n6695 n6696 1.09375
r10288 n6678 n6697 0.8125
r10289 n6696 n6697 0.8125
r10290 n6679 n6698 0.029017857142857144
r10291 n6697 n6698 0.90625
r10292 n6680 n6699 0.8125
r10293 n6698 n6699 0.90625
r10294 n6681 n6700 0.032500000000000001
r10295 n6699 n6700 0.8125
r10296 n6682 n6701 0.081250000000000003
r10297 n6700 n6701 1.09375
r10298 n6683 n6702 0.13088235294117648
r10299 n6684 n6703 0.13906250000000001
r10300 n6702 n6703 0.061383928571428568
r10301 n6685 n6704 1.1125
r10302 n6703 n6704 0.033482142857142856
r10303 n6686 n6705 0.074166666666666672
r10304 n6704 n6705 0.059523809523809521
r10305 n6687 n6706 1.1125
r10306 n6705 n6706 0.059523809523809521
r10307 n6688 n6707 0.13906250000000001
r10308 n6706 n6707 0.033482142857142856
r10309 n6689 n6708 0.13088235294117648
r10310 n6707 n6708 0.061383928571428568
r10311 n6695 n6709 0.2225
r10312 n6696 n6710 0.088999999999999996
r10313 n6709 n6710 0.065104166666666671
r10314 n6697 n6711 2.2250000000000001
r10315 n6710 n6711 0.04836309523809524
r10316 n6698 n6712 0.07946428571428571
r10317 n6711 n6712 0.053943452380952384
r10318 n6699 n6713 2.2250000000000001
r10319 n6712 n6713 0.053943452380952384
r10320 n6700 n6714 0.088999999999999996
r10321 n6713 n6714 0.04836309523809524
r10322 n6701 n6715 0.2225
r10323 n6714 n6715 0.065104166666666671
r10324 n6702 n6716 0.24632352941176472
r10325 n6703 n6717 0.26171875
r10326 n6716 n6717 0.061751497005988025
r10327 n6704 n6718 2.09375
r10328 n6717 n6718 0.033682634730538924
r10329 n6705 n6719 0.13958333333333334
r10330 n6718 n6719 0.059880239520958084
r10331 n6706 n6720 2.09375
r10332 n6719 n6720 0.059880239520958084
r10333 n6707 n6721 0.26171875
r10334 n6720 n6721 0.033682634730538924
r10335 n6708 n6722 0.24632352941176472
r10336 n6721 n6722 0.061751497005988025
r10337 n6709 n6723 0.41875000000000001
r10338 n6710 n6724 0.16750000000000001
r10339 n6723 n6724 0.0654940119760479
r10340 n6711 n6725 4.1875
r10341 n6724 n6725 0.048652694610778445
r10342 n6712 n6726 0.14955357142857142
r10343 n6725 n6726 0.054266467065868261
r10344 n6713 n6727 4.1875
r10345 n6726 n6727 0.054266467065868261
r10346 n6714 n6728 0.16750000000000001
r10347 n6727 n6728 0.048652694610778445
r10348 n6715 n6729 0.41875000000000001
r10349 n6728 n6729 0.0654940119760479
r10350 n6716 n6730 0.16323529411764706
r10351 n6717 n6731 0.17343749999999999
r10352 n6730 n6731 0.1875
r10353 n6718 n6732 1.3875
r10354 n6731 n6732 0.10227272727272728
r10355 n6719 n6733 0.092499999999999999
r10356 n6732 n6733 0.18181818181818182
r10357 n6720 n6734 1.3875
r10358 n6733 n6734 0.18181818181818182
r10359 n6721 n6735 0.17343749999999999
r10360 n6734 n6735 0.10227272727272728
r10361 n6722 n6736 0.16323529411764706
r10362 n6735 n6736 0.1875
r10363 n6723 n6737 0.27750000000000002
r10364 n6724 n6738 0.111
r10365 n6737 n6738 0.19886363636363635
r10366 n6725 n6739 2.7749999999999999
r10367 n6738 n6739 0.14772727272727273
r10368 n6726 n6740 0.099107142857142852
r10369 n6739 n6740 0.16477272727272727
r10370 n6727 n6741 2.7749999999999999
r10371 n6740 n6741 0.16477272727272727
r10372 n6728 n6742 0.111
r10373 n6741 n6742 0.14772727272727273
r10374 n6729 n6743 0.27750000000000002
r10375 n6742 n6743 0.19886363636363635
r10376 n6730 n6744 0.07720588235294118
r10377 n6731 n6745 0.08203125
r10378 n6744 n6745 0.20624999999999999
r10379 n6732 n6746 0.65625
r10380 n6745 n6746 0.1125
r10381 n6733 n6747 0.043749999999999997
r10382 n6746 n6747 0.20000000000000001
r10383 n6734 n6748 0.65625
r10384 n6747 n6748 0.20000000000000001
r10385 n6735 n6749 0.08203125
r10386 n6748 n6749 0.1125
r10387 n6736 n6750 0.07720588235294118
r10388 n6749 n6750 0.20624999999999999
r10389 n6751 n6752 0.0625
r10390 n6752 n6753 0.037499999999999999
r10391 n6753 n6754 0.018749999999999999
r10392 n6754 n6755 0.018749999999999999
r10393 n6755 n6756 0.012500000000000001
r10394 n6756 n6757 0.012500000000000001
r10395 n6757 n6758 0.03125
r10396 n6758 n6759 0.056250000000000001
r10397 n6759 n6760 0.037499999999999999
r10398 n6760 n6761 0.068750000000000006
r10399 n6761 n6762 0.081250000000000003
r10400 n6762 n6763 0.056250000000000001
r10401 n6763 n6764 0.050000000000000003
r10402 n6764 n6765 0.018749999999999999
r10403 n6765 n6766 0.012500000000000001
r10404 n6766 n6767 0.043749999999999997
r10405 n6767 n6768 0.068750000000000006
r10406 n6768 n6769 0.037499999999999999
r10407 n6769 n6770 0.03125
r10408 n6770 n6771 0.056250000000000001
r10409 n6771 n6772 0.050000000000000003
r10410 n6772 n6773 0.0625
r10411 n6737 n6774 0.13125000000000001
r10412 n6738 n6775 0.052499999999999998
r10413 n6774 n6775 0.21875
r10414 n6739 n6776 1.3125
r10415 n6775 n6776 0.16250000000000001
r10416 n6740 n6777 0.046875
r10417 n6776 n6777 0.18124999999999999
r10418 n6741 n6778 1.3125
r10419 n6777 n6778 0.18124999999999999
r10420 n6742 n6779 0.052499999999999998
r10421 n6778 n6779 0.16250000000000001
r10422 n6743 n6780 0.13125000000000001
r10423 n6779 n6780 0.21875
r10424 n6744 n6781 0.044117647058823532
r10425 n6745 n6782 0.046875
r10426 n6781 n6782 1.03125
r10427 n6746 n6783 0.375
r10428 n6782 n6783 0.5625
r10429 n6747 n6784 0.025000000000000001
r10430 n6783 n6784 1
r10431 n6748 n6785 0.375
r10432 n6784 n6785 1
r10433 n6749 n6786 0.046875
r10434 n6785 n6786 0.5625
r10435 n6750 n6787 0.044117647058823532
r10436 n6786 n6787 1.03125
r10437 n6751 n6788 0.14999999999999999
r10438 n6752 n6789 0.14999999999999999
r10439 n6788 n6789 0.3125
r10440 n6753 n6790 0.75
r10441 n6789 n6790 0.1875
r10442 n6754 n6791 0.375
r10443 n6790 n6791 0.09375
r10444 n6755 n6792 0.75
r10445 n6791 n6792 0.09375
r10446 n6756 n6793 0.75
r10447 n6792 n6793 0.0625
r10448 n6757 n6794 0.75
r10449 n6793 n6794 0.0625
r10450 n6758 n6795 0.1875
r10451 n6794 n6795 0.15625
r10452 n6759 n6796 0.14999999999999999
r10453 n6795 n6796 0.28125
r10454 n6760 n6797 0.75
r10455 n6796 n6797 0.1875
r10456 n6761 n6798 0.074999999999999997
r10457 n6797 n6798 0.34375
r10458 n6762 n6799 0.25
r10459 n6798 n6799 0.40625
r10460 n6763 n6800 0.125
r10461 n6799 n6800 0.28125
r10462 n6764 n6801 0.375
r10463 n6800 n6801 0.25
r10464 n6765 n6802 0.75
r10465 n6801 n6802 0.09375
r10466 n6766 n6803 0.75
r10467 n6802 n6803 0.0625
r10468 n6767 n6804 0.125
r10469 n6803 n6804 0.21875
r10470 n6768 n6805 0.14999999999999999
r10471 n6804 n6805 0.34375
r10472 n6769 n6806 0.75
r10473 n6805 n6806 0.1875
r10474 n6770 n6807 0.1875
r10475 n6806 n6807 0.15625
r10476 n6771 n6808 0.14999999999999999
r10477 n6807 n6808 0.28125
r10478 n6772 n6809 0.25
r10479 n6808 n6809 0.25
r10480 n6773 n6810 0.10714285714285714
r10481 n6809 n6810 0.3125
r10482 n6811 n6812 0.78125
r10483 n6812 n6813 1.0625
r10484 n6813 n6814 0.9375
r10485 n6814 n6815 1.0625
r10486 n6815 n6816 0.78125
r10487 n6774 n6817 0.074999999999999997
r10488 n6775 n6818 0.029999999999999999
r10489 n6817 n6818 1.09375
r10490 n6776 n6819 0.75
r10491 n6818 n6819 0.8125
r10492 n6777 n6820 0.026785714285714284
r10493 n6819 n6820 0.90625
r10494 n6778 n6821 0.75
r10495 n6820 n6821 0.90625
r10496 n6779 n6822 0.029999999999999999
r10497 n6821 n6822 0.8125
r10498 n6780 n6823 0.074999999999999997
r10499 n6822 n6823 1.09375
r10500 n6781 n6824 0.018382352941176471
r10501 n6782 n6825 0.01953125
r10502 n6824 n6825 0.6875
r10503 n6783 n6826 0.15625
r10504 n6825 n6826 0.375
r10505 n6784 n6827 0.010416666666666666
r10506 n6826 n6827 0.66666666666666663
r10507 n6785 n6828 0.15625
r10508 n6827 n6828 0.66666666666666663
r10509 n6786 n6829 0.01953125
r10510 n6828 n6829 0.375
r10511 n6787 n6830 0.018382352941176471
r10512 n6829 n6830 0.6875
r10513 n6788 n6831 0.0625
r10514 n6789 n6832 0.0625
r10515 n6831 n6832 0.20833333333333334
r10516 n6790 n6833 0.3125
r10517 n6832 n6833 0.125
r10518 n6791 n6834 0.15625
r10519 n6833 n6834 0.0625
r10520 n6792 n6835 0.3125
r10521 n6834 n6835 0.0625
r10522 n6793 n6836 0.3125
r10523 n6835 n6836 0.041666666666666664
r10524 n6794 n6837 0.3125
r10525 n6836 n6837 0.041666666666666664
r10526 n6795 n6838 0.078125
r10527 n6837 n6838 0.10416666666666667
r10528 n6796 n6839 0.0625
r10529 n6838 n6839 0.1875
r10530 n6797 n6840 0.3125
r10531 n6839 n6840 0.125
r10532 n6798 n6841 0.03125
r10533 n6840 n6841 0.22916666666666666
r10534 n6799 n6842 0.10416666666666667
r10535 n6841 n6842 0.27083333333333331
r10536 n6800 n6843 0.052083333333333336
r10537 n6842 n6843 0.1875
r10538 n6801 n6844 0.15625
r10539 n6843 n6844 0.16666666666666666
r10540 n6802 n6845 0.3125
r10541 n6844 n6845 0.0625
r10542 n6803 n6846 0.3125
r10543 n6845 n6846 0.041666666666666664
r10544 n6804 n6847 0.052083333333333336
r10545 n6846 n6847 0.14583333333333334
r10546 n6805 n6848 0.0625
r10547 n6847 n6848 0.22916666666666666
r10548 n6806 n6849 0.3125
r10549 n6848 n6849 0.125
r10550 n6807 n6850 0.078125
r10551 n6849 n6850 0.10416666666666667
r10552 n6808 n6851 0.0625
r10553 n6850 n6851 0.1875
r10554 n6809 n6852 0.10416666666666667
r10555 n6851 n6852 0.16666666666666666
r10556 n6810 n6853 0.044642857142857144
r10557 n6852 n6853 0.20833333333333334
r10558 n6811 n6854 0.044642857142857144
r10559 n6812 n6855 0.017361111111111112
r10560 n6854 n6855 0.52083333333333337
r10561 n6813 n6856 0.01953125
r10562 n6855 n6856 0.70833333333333337
r10563 n6814 n6857 0.022321428571428572
r10564 n6856 n6857 0.625
r10565 n6815 n6858 0.015625
r10566 n6857 n6858 0.70833333333333337
r10567 n6816 n6859 0.0625
r10568 n6858 n6859 0.52083333333333337
r10569 n6859 n6860 0.70833333333333337
r10570 n6860 n6861 1.3125
r10571 n6861 n6862 1.4166666666666667
r10572 n6862 n6863 1.4166666666666667
r10573 n6863 n6864 1.5416666666666667
r10574 n6864 n6865 1.5416666666666667
r10575 n6865 n6866 1.4166666666666667
r10576 n6866 n6867 1.4166666666666667
r10577 n6867 n6868 1.0625
r10578 n6868 n6869 0.70833333333333337
r10579 n6869 n6870 1.2083333333333333
r10580 n6870 n6871 1.7083333333333333
r10581 n6871 n6872 1.7083333333333333
r10582 n6872 n6873 1.0625
r10583 n6817 n6874 0.03125
r10584 n6873 n6874 0.41666666666666669
r10585 n6818 n6875 0.012500000000000001
r10586 n6874 n6875 0.72916666666666663
r10587 n6819 n6876 0.3125
r10588 n6875 n6876 0.54166666666666663
r10589 n6820 n6877 0.011160714285714286
r10590 n6876 n6877 0.60416666666666663
r10591 n6821 n6878 0.3125
r10592 n6877 n6878 0.60416666666666663
r10593 n6822 n6879 0.012500000000000001
r10594 n6878 n6879 0.54166666666666663
r10595 n6823 n6880 0.03125
r10596 n6879 n6880 0.72916666666666663
r10597 n6824 n6881 0.029411764705882353
r10598 n6825 n6882 0.03125
r10599 n6881 n6882 0.41249999999999998
r10600 n6826 n6883 0.25
r10601 n6882 n6883 0.22500000000000001
r10602 n6827 n6884 0.016666666666666666
r10603 n6883 n6884 0.40000000000000002
r10604 n6828 n6885 0.25
r10605 n6884 n6885 0.40000000000000002
r10606 n6829 n6886 0.03125
r10607 n6885 n6886 0.22500000000000001
r10608 n6830 n6887 0.029411764705882353
r10609 n6886 n6887 0.41249999999999998
r10610 n6831 n6888 0.10000000000000001
r10611 n6832 n6889 0.10000000000000001
r10612 n6888 n6889 0.125
r10613 n6833 n6890 0.5
r10614 n6889 n6890 0.074999999999999997
r10615 n6834 n6891 0.25
r10616 n6890 n6891 0.037499999999999999
r10617 n6835 n6892 0.5
r10618 n6891 n6892 0.037499999999999999
r10619 n6836 n6893 0.5
r10620 n6892 n6893 0.025000000000000001
r10621 n6837 n6894 0.5
r10622 n6893 n6894 0.025000000000000001
r10623 n6838 n6895 0.125
r10624 n6894 n6895 0.0625
r10625 n6839 n6896 0.10000000000000001
r10626 n6895 n6896 0.1125
r10627 n6840 n6897 0.5
r10628 n6896 n6897 0.074999999999999997
r10629 n6841 n6898 0.050000000000000003
r10630 n6897 n6898 0.13750000000000001
r10631 n6842 n6899 0.16666666666666666
r10632 n6898 n6899 0.16250000000000001
r10633 n6843 n6900 0.083333333333333329
r10634 n6899 n6900 0.1125
r10635 n6844 n6901 0.25
r10636 n6900 n6901 0.10000000000000001
r10637 n6845 n6902 0.5
r10638 n6901 n6902 0.037499999999999999
r10639 n6846 n6903 0.5
r10640 n6902 n6903 0.025000000000000001
r10641 n6847 n6904 0.083333333333333329
r10642 n6903 n6904 0.087499999999999994
r10643 n6848 n6905 0.10000000000000001
r10644 n6904 n6905 0.13750000000000001
r10645 n6849 n6906 0.5
r10646 n6905 n6906 0.074999999999999997
r10647 n6850 n6907 0.125
r10648 n6906 n6907 0.0625
r10649 n6851 n6908 0.10000000000000001
r10650 n6907 n6908 0.1125
r10651 n6852 n6909 0.16666666666666666
r10652 n6908 n6909 0.10000000000000001
r10653 n6853 n6910 0.071428571428571425
r10654 n6909 n6910 0.125
r10655 n6854 n6911 0.071428571428571425
r10656 n6855 n6912 0.027777777777777776
r10657 n6911 n6912 0.3125
r10658 n6856 n6913 0.03125
r10659 n6912 n6913 0.42499999999999999
r10660 n6857 n6914 0.035714285714285712
r10661 n6913 n6914 0.375
r10662 n6858 n6915 0.025000000000000001
r10663 n6914 n6915 0.42499999999999999
r10664 n6859 n6916 0.10000000000000001
r10665 n6915 n6916 0.3125
r10666 n6860 n6917 0.017241379310344827
r10667 n6916 n6917 0.42499999999999999
r10668 n6861 n6918 0.014705882352941176
r10669 n6917 n6918 0.78749999999999998
r10670 n6862 n6919 0.014705882352941176
r10671 n6918 n6919 0.84999999999999998
r10672 n6863 n6920 0.014705882352941176
r10673 n6919 n6920 0.84999999999999998
r10674 n6864 n6921 0.012500000000000001
r10675 n6920 n6921 0.92500000000000004
r10676 n6865 n6922 0.014705882352941176
r10677 n6921 n6922 0.92500000000000004
r10678 n6866 n6923 0.014705882352941176
r10679 n6922 n6923 0.84999999999999998
r10680 n6867 n6924 0.014705882352941176
r10681 n6923 n6924 0.84999999999999998
r10682 n6868 n6925 0.029411764705882353
r10683 n6924 n6925 0.63749999999999996
r10684 n6869 n6926 0.029411764705882353
r10685 n6925 n6926 0.42499999999999999
r10686 n6870 n6927 0.012195121951219513
r10687 n6926 n6927 0.72499999999999998
r10688 n6871 n6928 0.012195121951219513
r10689 n6927 n6928 1.0249999999999999
r10690 n6872 n6929 0.012195121951219513
r10691 n6928 n6929 1.0249999999999999
r10692 n6873 n6930 0.050000000000000003
r10693 n6929 n6930 0.63749999999999996
r10694 n6874 n6931 0.050000000000000003
r10695 n6930 n6931 0.25
r10696 n6875 n6932 0.02
r10697 n6931 n6932 0.4375
r10698 n6876 n6933 0.5
r10699 n6932 n6933 0.32500000000000001
r10700 n6877 n6934 0.017857142857142856
r10701 n6933 n6934 0.36249999999999999
r10702 n6878 n6935 0.5
r10703 n6934 n6935 0.36249999999999999
r10704 n6879 n6936 0.02
r10705 n6935 n6936 0.32500000000000001
r10706 n6880 n6937 0.050000000000000003
r10707 n6936 n6937 0.4375
r10708 n6881 n6938 0.029411764705882353
r10709 n6882 n6939 0.03125
r10710 n6938 n6939 0.6875
r10711 n6883 n6940 0.25
r10712 n6939 n6940 0.375
r10713 n6884 n6941 0.016666666666666666
r10714 n6940 n6941 0.66666666666666663
r10715 n6885 n6942 0.25
r10716 n6941 n6942 0.66666666666666663
r10717 n6886 n6943 0.03125
r10718 n6942 n6943 0.375
r10719 n6887 n6944 0.029411764705882353
r10720 n6943 n6944 0.6875
r10721 n6888 n6945 0.10000000000000001
r10722 n6889 n6946 0.10000000000000001
r10723 n6945 n6946 0.20833333333333334
r10724 n6890 n6947 0.5
r10725 n6946 n6947 0.125
r10726 n6891 n6948 0.25
r10727 n6947 n6948 0.0625
r10728 n6892 n6949 0.5
r10729 n6948 n6949 0.0625
r10730 n6893 n6950 0.5
r10731 n6949 n6950 0.041666666666666664
r10732 n6894 n6951 0.5
r10733 n6950 n6951 0.041666666666666664
r10734 n6895 n6952 0.125
r10735 n6951 n6952 0.10416666666666667
r10736 n6896 n6953 0.10000000000000001
r10737 n6952 n6953 0.1875
r10738 n6897 n6954 0.5
r10739 n6953 n6954 0.125
r10740 n6898 n6955 0.050000000000000003
r10741 n6954 n6955 0.22916666666666666
r10742 n6899 n6956 0.16666666666666666
r10743 n6955 n6956 0.27083333333333331
r10744 n6900 n6957 0.083333333333333329
r10745 n6956 n6957 0.1875
r10746 n6901 n6958 0.25
r10747 n6957 n6958 0.16666666666666666
r10748 n6902 n6959 0.5
r10749 n6958 n6959 0.0625
r10750 n6903 n6960 0.5
r10751 n6959 n6960 0.041666666666666664
r10752 n6904 n6961 0.083333333333333329
r10753 n6960 n6961 0.14583333333333334
r10754 n6905 n6962 0.10000000000000001
r10755 n6961 n6962 0.22916666666666666
r10756 n6906 n6963 0.5
r10757 n6962 n6963 0.125
r10758 n6907 n6964 0.125
r10759 n6963 n6964 0.10416666666666667
r10760 n6908 n6965 0.10000000000000001
r10761 n6964 n6965 0.1875
r10762 n6909 n6966 0.16666666666666666
r10763 n6965 n6966 0.16666666666666666
r10764 n6910 n6967 0.071428571428571425
r10765 n6966 n6967 0.20833333333333334
r10766 n6911 n6968 0.071428571428571425
r10767 n6912 n6969 0.027777777777777776
r10768 n6968 n6969 0.52083333333333337
r10769 n6913 n6970 0.03125
r10770 n6969 n6970 0.70833333333333337
r10771 n6914 n6971 0.035714285714285712
r10772 n6970 n6971 0.625
r10773 n6915 n6972 0.025000000000000001
r10774 n6971 n6972 0.70833333333333337
r10775 n6916 n6973 0.10000000000000001
r10776 n6972 n6973 0.52083333333333337
r10777 n6917 n6974 0.017241379310344827
r10778 n6973 n6974 0.70833333333333337
r10779 n6918 n6975 0.014705882352941176
r10780 n6974 n6975 1.3125
r10781 n6919 n6976 0.014705882352941176
r10782 n6975 n6976 1.4166666666666667
r10783 n6920 n6977 0.014705882352941176
r10784 n6976 n6977 1.4166666666666667
r10785 n6921 n6978 0.012500000000000001
r10786 n6977 n6978 1.5416666666666667
r10787 n6922 n6979 0.014705882352941176
r10788 n6978 n6979 1.5416666666666667
r10789 n6923 n6980 0.014705882352941176
r10790 n6979 n6980 1.4166666666666667
r10791 n6924 n6981 0.014705882352941176
r10792 n6980 n6981 1.4166666666666667
r10793 n6925 n6982 0.029411764705882353
r10794 n6981 n6982 1.0625
r10795 n6926 n6983 0.029411764705882353
r10796 n6982 n6983 0.70833333333333337
r10797 n6927 n6984 0.012195121951219513
r10798 n6983 n6984 1.2083333333333333
r10799 n6928 n6985 0.012195121951219513
r10800 n6984 n6985 1.7083333333333333
r10801 n6929 n6986 0.012195121951219513
r10802 n6985 n6986 1.7083333333333333
r10803 n6930 n6987 0.050000000000000003
r10804 n6986 n6987 1.0625
r10805 n6931 n6988 0.050000000000000003
r10806 n6987 n6988 0.41666666666666669
r10807 n6932 n6989 0.02
r10808 n6988 n6989 0.72916666666666663
r10809 n6933 n6990 0.5
r10810 n6989 n6990 0.54166666666666663
r10811 n6934 n6991 0.017857142857142856
r10812 n6990 n6991 0.60416666666666663
r10813 n6935 n6992 0.5
r10814 n6991 n6992 0.60416666666666663
r10815 n6936 n6993 0.02
r10816 n6992 n6993 0.54166666666666663
r10817 n6937 n6994 0.050000000000000003
r10818 n6993 n6994 0.72916666666666663
r10819 n6938 n6995 0.018382352941176471
r10820 n6939 n6996 0.01953125
r10821 n6995 n6996 1.03125
r10822 n6940 n6997 0.15625
r10823 n6996 n6997 0.5625
r10824 n6941 n6998 0.010416666666666666
r10825 n6997 n6998 1
r10826 n6942 n6999 0.15625
r10827 n6998 n6999 1
r10828 n6943 n7000 0.01953125
r10829 n6999 n7000 0.5625
r10830 n6944 n7001 0.018382352941176471
r10831 n7000 n7001 1.03125
r10832 n6945 n7002 0.0625
r10833 n6946 n7003 0.0625
r10834 n7002 n7003 0.3125
r10835 n6947 n7004 0.3125
r10836 n7003 n7004 0.1875
r10837 n6948 n7005 0.15625
r10838 n7004 n7005 0.09375
r10839 n6949 n7006 0.3125
r10840 n7005 n7006 0.09375
r10841 n6950 n7007 0.3125
r10842 n7006 n7007 0.0625
r10843 n6951 n7008 0.3125
r10844 n7007 n7008 0.0625
r10845 n6952 n7009 0.078125
r10846 n7008 n7009 0.15625
r10847 n6953 n7010 0.0625
r10848 n7009 n7010 0.28125
r10849 n6954 n7011 0.3125
r10850 n7010 n7011 0.1875
r10851 n6955 n7012 0.03125
r10852 n7011 n7012 0.34375
r10853 n6956 n7013 0.10416666666666667
r10854 n7012 n7013 0.40625
r10855 n6957 n7014 0.052083333333333336
r10856 n7013 n7014 0.28125
r10857 n6958 n7015 0.15625
r10858 n7014 n7015 0.25
r10859 n6959 n7016 0.3125
r10860 n7015 n7016 0.09375
r10861 n6960 n7017 0.3125
r10862 n7016 n7017 0.0625
r10863 n6961 n7018 0.052083333333333336
r10864 n7017 n7018 0.21875
r10865 n6962 n7019 0.0625
r10866 n7018 n7019 0.34375
r10867 n6963 n7020 0.3125
r10868 n7019 n7020 0.1875
r10869 n6964 n7021 0.078125
r10870 n7020 n7021 0.15625
r10871 n6965 n7022 0.0625
r10872 n7021 n7022 0.28125
r10873 n6966 n7023 0.10416666666666667
r10874 n7022 n7023 0.25
r10875 n6967 n7024 0.044642857142857144
r10876 n7023 n7024 0.3125
r10877 n6968 n7025 0.044642857142857144
r10878 n6969 n7026 0.017361111111111112
r10879 n7025 n7026 0.78125
r10880 n6970 n7027 0.01953125
r10881 n7026 n7027 1.0625
r10882 n6971 n7028 0.022321428571428572
r10883 n7027 n7028 0.9375
r10884 n6972 n7029 0.015625
r10885 n7028 n7029 1.0625
r10886 n6973 n7030 0.0625
r10887 n7029 n7030 0.78125
r10888 n6974 n7031 0.010775862068965518
r10889 n7030 n7031 1.0625
r10890 n6975 n7032 0.0091911764705882356
r10891 n7031 n7032 1.96875
r10892 n6976 n7033 0.0091911764705882356
r10893 n7032 n7033 2.125
r10894 n6977 n7034 0.0091911764705882356
r10895 n7033 n7034 2.125
r10896 n6978 n7035 0.0078125
r10897 n7034 n7035 2.3125
r10898 n6979 n7036 0.0091911764705882356
r10899 n7035 n7036 2.3125
r10900 n6980 n7037 0.0091911764705882356
r10901 n7036 n7037 2.125
r10902 n6981 n7038 0.0091911764705882356
r10903 n7037 n7038 2.125
r10904 n6982 n7039 0.018382352941176471
r10905 n7038 n7039 1.59375
r10906 n6983 n7040 0.018382352941176471
r10907 n7039 n7040 1.0625
r10908 n6984 n7041 0.007621951219512195
r10909 n7040 n7041 1.8125
r10910 n6985 n7042 0.007621951219512195
r10911 n7041 n7042 2.5625
r10912 n6986 n7043 0.007621951219512195
r10913 n7042 n7043 2.5625
r10914 n6987 n7044 0.03125
r10915 n7043 n7044 1.59375
r10916 n6988 n7045 0.03125
r10917 n7044 n7045 0.625
r10918 n6989 n7046 0.012500000000000001
r10919 n7045 n7046 1.09375
r10920 n6990 n7047 0.3125
r10921 n7046 n7047 0.8125
r10922 n6991 n7048 0.011160714285714286
r10923 n7047 n7048 0.90625
r10924 n6992 n7049 0.3125
r10925 n7048 n7049 0.90625
r10926 n6993 n7050 0.012500000000000001
r10927 n7049 n7050 0.8125
r10928 n6994 n7051 0.03125
r10929 n7050 n7051 1.09375
r10930 n6995 n7052 0.11764705882352941
r10931 n6996 n7053 0.125
r10932 n7052 n7053 0.068750000000000006
r10933 n6997 n7054 1
r10934 n7053 n7054 0.037499999999999999
r10935 n6998 n7055 0.066666666666666666
r10936 n7054 n7055 0.066666666666666666
r10937 n6999 n7056 1
r10938 n7055 n7056 0.066666666666666666
r10939 n7000 n7057 0.125
r10940 n7056 n7057 0.037499999999999999
r10941 n7001 n7058 0.11764705882352941
r10942 n7057 n7058 0.068750000000000006
r10943 n7002 n7059 0.40000000000000002
r10944 n7003 n7060 0.40000000000000002
r10945 n7059 n7060 0.020833333333333332
r10946 n7004 n7061 2
r10947 n7060 n7061 0.012500000000000001
r10948 n7005 n7062 1
r10949 n7061 n7062 0.0062500000000000003
r10950 n7006 n7063 2
r10951 n7062 n7063 0.0062500000000000003
r10952 n7007 n7064 2
r10953 n7063 n7064 0.0041666666666666666
r10954 n7008 n7065 2
r10955 n7064 n7065 0.0041666666666666666
r10956 n7009 n7066 0.5
r10957 n7065 n7066 0.010416666666666666
r10958 n7010 n7067 0.40000000000000002
r10959 n7066 n7067 0.018749999999999999
r10960 n7011 n7068 2
r10961 n7067 n7068 0.012500000000000001
r10962 n7012 n7069 0.20000000000000001
r10963 n7068 n7069 0.022916666666666665
r10964 n7013 n7070 0.66666666666666663
r10965 n7069 n7070 0.027083333333333334
r10966 n7014 n7071 0.33333333333333331
r10967 n7070 n7071 0.018749999999999999
r10968 n7015 n7072 1
r10969 n7071 n7072 0.016666666666666666
r10970 n7016 n7073 2
r10971 n7072 n7073 0.0062500000000000003
r10972 n7017 n7074 2
r10973 n7073 n7074 0.0041666666666666666
r10974 n7018 n7075 0.33333333333333331
r10975 n7074 n7075 0.014583333333333334
r10976 n7019 n7076 0.40000000000000002
r10977 n7075 n7076 0.022916666666666665
r10978 n7020 n7077 2
r10979 n7076 n7077 0.012500000000000001
r10980 n7021 n7078 0.5
r10981 n7077 n7078 0.010416666666666666
r10982 n7022 n7079 0.40000000000000002
r10983 n7078 n7079 0.018749999999999999
r10984 n7023 n7080 0.66666666666666663
r10985 n7079 n7080 0.016666666666666666
r10986 n7024 n7081 0.2857142857142857
r10987 n7080 n7081 0.020833333333333332
r10988 n7025 n7082 0.2857142857142857
r10989 n7026 n7083 0.1111111111111111
r10990 n7082 n7083 0.052083333333333336
r10991 n7027 n7084 0.125
r10992 n7083 n7084 0.070833333333333331
r10993 n7028 n7085 0.14285714285714285
r10994 n7084 n7085 0.0625
r10995 n7029 n7086 0.10000000000000001
r10996 n7085 n7086 0.070833333333333331
r10997 n7030 n7087 0.40000000000000002
r10998 n7086 n7087 0.052083333333333336
r10999 n7031 n7088 0.068965517241379309
r11000 n7087 n7088 0.070833333333333331
r11001 n7032 n7089 0.058823529411764705
r11002 n7088 n7089 0.13125000000000001
r11003 n7033 n7090 0.058823529411764705
r11004 n7089 n7090 0.14166666666666666
r11005 n7034 n7091 0.058823529411764705
r11006 n7090 n7091 0.14166666666666666
r11007 n7035 n7092 0.050000000000000003
r11008 n7091 n7092 0.15416666666666667
r11009 n7036 n7093 0.058823529411764705
r11010 n7092 n7093 0.15416666666666667
r11011 n7037 n7094 0.058823529411764705
r11012 n7093 n7094 0.14166666666666666
r11013 n7038 n7095 0.058823529411764705
r11014 n7094 n7095 0.14166666666666666
r11015 n7039 n7096 0.11764705882352941
r11016 n7095 n7096 0.10625
r11017 n7040 n7097 0.11764705882352941
r11018 n7096 n7097 0.070833333333333331
r11019 n7041 n7098 0.04878048780487805
r11020 n7097 n7098 0.12083333333333333
r11021 n7042 n7099 0.04878048780487805
r11022 n7098 n7099 0.17083333333333334
r11023 n7043 n7100 0.04878048780487805
r11024 n7099 n7100 0.17083333333333334
r11025 n7044 n7101 0.20000000000000001
r11026 n7100 n7101 0.10625
r11027 n7045 n7102 0.20000000000000001
r11028 n7101 n7102 0.041666666666666664
r11029 n7046 n7103 0.080000000000000002
r11030 n7102 n7103 0.072916666666666671
r11031 n7047 n7104 2
r11032 n7103 n7104 0.054166666666666669
r11033 n7048 n7105 0.071428571428571425
r11034 n7104 n7105 0.060416666666666667
r11035 n7049 n7106 2
r11036 n7105 n7106 0.060416666666666667
r11037 n7050 n7107 0.080000000000000002
r11038 n7106 n7107 0.054166666666666669
r11039 n7051 n7108 0.20000000000000001
r11040 n7107 n7108 0.072916666666666671
r11041 n7052 n7109 0.11764705882352941
r11042 n7053 n7110 0.125
r11043 n7109 n7110 1.03125
r11044 n7054 n7111 1
r11045 n7110 n7111 0.5625
r11046 n7055 n7112 0.066666666666666666
r11047 n7111 n7112 1
r11048 n7056 n7113 1
r11049 n7112 n7113 1
r11050 n7057 n7114 0.125
r11051 n7113 n7114 0.5625
r11052 n7058 n7115 0.11764705882352941
r11053 n7114 n7115 1.03125
r11054 n7059 n7116 0.40000000000000002
r11055 n7060 n7117 0.40000000000000002
r11056 n7116 n7117 0.3125
r11057 n7061 n7118 2
r11058 n7117 n7118 0.1875
r11059 n7062 n7119 1
r11060 n7118 n7119 0.09375
r11061 n7063 n7120 2
r11062 n7119 n7120 0.09375
r11063 n7064 n7121 2
r11064 n7120 n7121 0.0625
r11065 n7065 n7122 2
r11066 n7121 n7122 0.0625
r11067 n7066 n7123 0.5
r11068 n7122 n7123 0.15625
r11069 n7067 n7124 0.40000000000000002
r11070 n7123 n7124 0.28125
r11071 n7068 n7125 2
r11072 n7124 n7125 0.1875
r11073 n7069 n7126 0.20000000000000001
r11074 n7125 n7126 0.34375
r11075 n7070 n7127 0.66666666666666663
r11076 n7126 n7127 0.40625
r11077 n7071 n7128 0.33333333333333331
r11078 n7127 n7128 0.28125
r11079 n7072 n7129 1
r11080 n7128 n7129 0.25
r11081 n7073 n7130 2
r11082 n7129 n7130 0.09375
r11083 n7074 n7131 2
r11084 n7130 n7131 0.0625
r11085 n7075 n7132 0.33333333333333331
r11086 n7131 n7132 0.21875
r11087 n7076 n7133 0.40000000000000002
r11088 n7132 n7133 0.34375
r11089 n7077 n7134 2
r11090 n7133 n7134 0.1875
r11091 n7078 n7135 0.5
r11092 n7134 n7135 0.15625
r11093 n7079 n7136 0.40000000000000002
r11094 n7135 n7136 0.28125
r11095 n7080 n7137 0.66666666666666663
r11096 n7136 n7137 0.25
r11097 n7081 n7138 0.2857142857142857
r11098 n7137 n7138 0.3125
r11099 n7082 n7139 0.2857142857142857
r11100 n7083 n7140 0.1111111111111111
r11101 n7139 n7140 0.78125
r11102 n7084 n7141 0.125
r11103 n7140 n7141 1.0625
r11104 n7085 n7142 0.14285714285714285
r11105 n7141 n7142 0.9375
r11106 n7086 n7143 0.10000000000000001
r11107 n7142 n7143 1.0625
r11108 n7087 n7144 0.40000000000000002
r11109 n7143 n7144 0.78125
r11110 n7088 n7145 0.068965517241379309
r11111 n7144 n7145 1.0625
r11112 n7089 n7146 0.058823529411764705
r11113 n7145 n7146 1.96875
r11114 n7090 n7147 0.058823529411764705
r11115 n7146 n7147 2.125
r11116 n7091 n7148 0.058823529411764705
r11117 n7147 n7148 2.125
r11118 n7092 n7149 0.050000000000000003
r11119 n7148 n7149 2.3125
r11120 n7093 n7150 0.058823529411764705
r11121 n7149 n7150 2.3125
r11122 n7094 n7151 0.058823529411764705
r11123 n7150 n7151 2.125
r11124 n7095 n7152 0.058823529411764705
r11125 n7151 n7152 2.125
r11126 n7096 n7153 0.11764705882352941
r11127 n7152 n7153 1.59375
r11128 n7097 n7154 0.11764705882352941
r11129 n7153 n7154 1.0625
r11130 n7098 n7155 0.04878048780487805
r11131 n7154 n7155 1.8125
r11132 n7099 n7156 0.04878048780487805
r11133 n7155 n7156 2.5625
r11134 n7100 n7157 0.04878048780487805
r11135 n7156 n7157 2.5625
r11136 n7101 n7158 0.20000000000000001
r11137 n7157 n7158 1.59375
r11138 n7102 n7159 0.20000000000000001
r11139 n7158 n7159 0.625
r11140 n7103 n7160 0.080000000000000002
r11141 n7159 n7160 1.09375
r11142 n7104 n7161 2
r11143 n7160 n7161 0.8125
r11144 n7105 n7162 0.071428571428571425
r11145 n7161 n7162 0.90625
r11146 n7106 n7163 2
r11147 n7162 n7163 0.90625
r11148 n7107 n7164 0.080000000000000002
r11149 n7163 n7164 0.8125
r11150 n7108 n7165 0.20000000000000001
r11151 n7164 n7165 1.09375
r11152 n7109 n7166 0.018382352941176471
r11153 n7110 n7167 0.01953125
r11154 n7166 n7167 0.6875
r11155 n7111 n7168 0.15625
r11156 n7167 n7168 0.375
r11157 n7112 n7169 0.010416666666666666
r11158 n7168 n7169 0.66666666666666663
r11159 n7113 n7170 0.15625
r11160 n7169 n7170 0.66666666666666663
r11161 n7114 n7171 0.01953125
r11162 n7170 n7171 0.375
r11163 n7115 n7172 0.018382352941176471
r11164 n7171 n7172 0.6875
r11165 n7116 n7173 0.0625
r11166 n7117 n7174 0.0625
r11167 n7173 n7174 0.20833333333333334
r11168 n7118 n7175 0.3125
r11169 n7174 n7175 0.125
r11170 n7119 n7176 0.15625
r11171 n7175 n7176 0.0625
r11172 n7120 n7177 0.3125
r11173 n7176 n7177 0.0625
r11174 n7121 n7178 0.3125
r11175 n7177 n7178 0.041666666666666664
r11176 n7122 n7179 0.3125
r11177 n7178 n7179 0.041666666666666664
r11178 n7123 n7180 0.078125
r11179 n7179 n7180 0.10416666666666667
r11180 n7124 n7181 0.0625
r11181 n7180 n7181 0.1875
r11182 n7125 n7182 0.3125
r11183 n7181 n7182 0.125
r11184 n7126 n7183 0.03125
r11185 n7182 n7183 0.22916666666666666
r11186 n7127 n7184 0.10416666666666667
r11187 n7183 n7184 0.27083333333333331
r11188 n7128 n7185 0.052083333333333336
r11189 n7184 n7185 0.1875
r11190 n7129 n7186 0.15625
r11191 n7185 n7186 0.16666666666666666
r11192 n7130 n7187 0.3125
r11193 n7186 n7187 0.0625
r11194 n7131 n7188 0.3125
r11195 n7187 n7188 0.041666666666666664
r11196 n7132 n7189 0.052083333333333336
r11197 n7188 n7189 0.14583333333333334
r11198 n7133 n7190 0.0625
r11199 n7189 n7190 0.22916666666666666
r11200 n7134 n7191 0.3125
r11201 n7190 n7191 0.125
r11202 n7135 n7192 0.078125
r11203 n7191 n7192 0.10416666666666667
r11204 n7136 n7193 0.0625
r11205 n7192 n7193 0.1875
r11206 n7137 n7194 0.10416666666666667
r11207 n7193 n7194 0.16666666666666666
r11208 n7138 n7195 0.044642857142857144
r11209 n7194 n7195 0.20833333333333334
r11210 n7139 n7196 0.044642857142857144
r11211 n7140 n7197 0.017361111111111112
r11212 n7196 n7197 0.52083333333333337
r11213 n7141 n7198 0.01953125
r11214 n7197 n7198 0.70833333333333337
r11215 n7142 n7199 0.022321428571428572
r11216 n7198 n7199 0.625
r11217 n7143 n7200 0.015625
r11218 n7199 n7200 0.70833333333333337
r11219 n7144 n7201 0.0625
r11220 n7200 n7201 0.52083333333333337
r11221 n7145 n7202 0.010775862068965518
r11222 n7201 n7202 0.70833333333333337
r11223 n7146 n7203 0.0091911764705882356
r11224 n7202 n7203 1.3125
r11225 n7147 n7204 0.0091911764705882356
r11226 n7203 n7204 1.4166666666666667
r11227 n7148 n7205 0.0091911764705882356
r11228 n7204 n7205 1.4166666666666667
r11229 n7149 n7206 0.0078125
r11230 n7205 n7206 1.5416666666666667
r11231 n7150 n7207 0.0091911764705882356
r11232 n7206 n7207 1.5416666666666667
r11233 n7151 n7208 0.0091911764705882356
r11234 n7207 n7208 1.4166666666666667
r11235 n7152 n7209 0.0091911764705882356
r11236 n7208 n7209 1.4166666666666667
r11237 n7153 n7210 0.018382352941176471
r11238 n7209 n7210 1.0625
r11239 n7154 n7211 0.018382352941176471
r11240 n7210 n7211 0.70833333333333337
r11241 n7155 n7212 0.007621951219512195
r11242 n7211 n7212 1.2083333333333333
r11243 n7156 n7213 0.007621951219512195
r11244 n7212 n7213 1.7083333333333333
r11245 n7157 n7214 0.007621951219512195
r11246 n7213 n7214 1.7083333333333333
r11247 n7158 n7215 0.03125
r11248 n7214 n7215 1.0625
r11249 n7159 n7216 0.03125
r11250 n7215 n7216 0.41666666666666669
r11251 n7160 n7217 0.012500000000000001
r11252 n7216 n7217 0.72916666666666663
r11253 n7161 n7218 0.3125
r11254 n7217 n7218 0.54166666666666663
r11255 n7162 n7219 0.011160714285714286
r11256 n7218 n7219 0.60416666666666663
r11257 n7163 n7220 0.3125
r11258 n7219 n7220 0.60416666666666663
r11259 n7164 n7221 0.012500000000000001
r11260 n7220 n7221 0.54166666666666663
r11261 n7165 n7222 0.03125
r11262 n7221 n7222 0.72916666666666663
r11263 n7166 n7223 0.029411764705882353
r11264 n7167 n7224 0.03125
r11265 n7223 n7224 0.41249999999999998
r11266 n7168 n7225 0.25
r11267 n7224 n7225 0.22500000000000001
r11268 n7169 n7226 0.016666666666666666
r11269 n7225 n7226 0.40000000000000002
r11270 n7170 n7227 0.25
r11271 n7226 n7227 0.40000000000000002
r11272 n7171 n7228 0.03125
r11273 n7227 n7228 0.22500000000000001
r11274 n7172 n7229 0.029411764705882353
r11275 n7228 n7229 0.41249999999999998
r11276 n7173 n7230 0.10000000000000001
r11277 n7174 n7231 0.10000000000000001
r11278 n7230 n7231 0.125
r11279 n7175 n7232 0.5
r11280 n7231 n7232 0.074999999999999997
r11281 n7176 n7233 0.25
r11282 n7232 n7233 0.037499999999999999
r11283 n7177 n7234 0.5
r11284 n7233 n7234 0.037499999999999999
r11285 n7178 n7235 0.5
r11286 n7234 n7235 0.025000000000000001
r11287 n7179 n7236 0.5
r11288 n7235 n7236 0.025000000000000001
r11289 n7180 n7237 0.125
r11290 n7236 n7237 0.0625
r11291 n7181 n7238 0.10000000000000001
r11292 n7237 n7238 0.1125
r11293 n7182 n7239 0.5
r11294 n7238 n7239 0.074999999999999997
r11295 n7183 n7240 0.050000000000000003
r11296 n7239 n7240 0.13750000000000001
r11297 n7184 n7241 0.16666666666666666
r11298 n7240 n7241 0.16250000000000001
r11299 n7185 n7242 0.083333333333333329
r11300 n7241 n7242 0.1125
r11301 n7186 n7243 0.25
r11302 n7242 n7243 0.10000000000000001
r11303 n7187 n7244 0.5
r11304 n7243 n7244 0.037499999999999999
r11305 n7188 n7245 0.5
r11306 n7244 n7245 0.025000000000000001
r11307 n7189 n7246 0.083333333333333329
r11308 n7245 n7246 0.087499999999999994
r11309 n7190 n7247 0.10000000000000001
r11310 n7246 n7247 0.13750000000000001
r11311 n7191 n7248 0.5
r11312 n7247 n7248 0.074999999999999997
r11313 n7192 n7249 0.125
r11314 n7248 n7249 0.0625
r11315 n7193 n7250 0.10000000000000001
r11316 n7249 n7250 0.1125
r11317 n7194 n7251 0.16666666666666666
r11318 n7250 n7251 0.10000000000000001
r11319 n7195 n7252 0.071428571428571425
r11320 n7251 n7252 0.125
r11321 n7196 n7253 0.071428571428571425
r11322 n7197 n7254 0.027777777777777776
r11323 n7253 n7254 0.3125
r11324 n7198 n7255 0.03125
r11325 n7254 n7255 0.42499999999999999
r11326 n7199 n7256 0.035714285714285712
r11327 n7255 n7256 0.375
r11328 n7200 n7257 0.025000000000000001
r11329 n7256 n7257 0.42499999999999999
r11330 n7201 n7258 0.10000000000000001
r11331 n7257 n7258 0.3125
r11332 n7202 n7259 0.017241379310344827
r11333 n7258 n7259 0.42499999999999999
r11334 n7203 n7260 0.014705882352941176
r11335 n7259 n7260 0.78749999999999998
r11336 n7204 n7261 0.014705882352941176
r11337 n7260 n7261 0.84999999999999998
r11338 n7205 n7262 0.014705882352941176
r11339 n7261 n7262 0.84999999999999998
r11340 n7206 n7263 0.012500000000000001
r11341 n7262 n7263 0.92500000000000004
r11342 n7207 n7264 0.014705882352941176
r11343 n7263 n7264 0.92500000000000004
r11344 n7208 n7265 0.014705882352941176
r11345 n7264 n7265 0.84999999999999998
r11346 n7209 n7266 0.014705882352941176
r11347 n7265 n7266 0.84999999999999998
r11348 n7210 n7267 0.029411764705882353
r11349 n7266 n7267 0.63749999999999996
r11350 n7211 n7268 0.029411764705882353
r11351 n7267 n7268 0.42499999999999999
r11352 n7212 n7269 0.012195121951219513
r11353 n7268 n7269 0.72499999999999998
r11354 n7213 n7270 0.012195121951219513
r11355 n7269 n7270 1.0249999999999999
r11356 n7214 n7271 0.012195121951219513
r11357 n7270 n7271 1.0249999999999999
r11358 n7215 n7272 0.050000000000000003
r11359 n7271 n7272 0.63749999999999996
r11360 n7216 n7273 0.050000000000000003
r11361 n7272 n7273 0.25
r11362 n7217 n7274 0.02
r11363 n7273 n7274 0.4375
r11364 n7218 n7275 0.5
r11365 n7274 n7275 0.32500000000000001
r11366 n7219 n7276 0.017857142857142856
r11367 n7275 n7276 0.36249999999999999
r11368 n7220 n7277 0.5
r11369 n7276 n7277 0.36249999999999999
r11370 n7221 n7278 0.02
r11371 n7277 n7278 0.32500000000000001
r11372 n7222 n7279 0.050000000000000003
r11373 n7278 n7279 0.4375
r11374 n7223 n7280 0.029411764705882353
r11375 n7224 n7281 0.03125
r11376 n7280 n7281 0.6875
r11377 n7225 n7282 0.25
r11378 n7281 n7282 0.375
r11379 n7226 n7283 0.016666666666666666
r11380 n7282 n7283 0.66666666666666663
r11381 n7227 n7284 0.25
r11382 n7283 n7284 0.66666666666666663
r11383 n7228 n7285 0.03125
r11384 n7284 n7285 0.375
r11385 n7229 n7286 0.029411764705882353
r11386 n7285 n7286 0.6875
r11387 n7230 n7287 0.10000000000000001
r11388 n7231 n7288 0.10000000000000001
r11389 n7287 n7288 0.20833333333333334
r11390 n7232 n7289 0.5
r11391 n7288 n7289 0.125
r11392 n7233 n7290 0.25
r11393 n7289 n7290 0.0625
r11394 n7234 n7291 0.5
r11395 n7290 n7291 0.0625
r11396 n7235 n7292 0.5
r11397 n7291 n7292 0.041666666666666664
r11398 n7236 n7293 0.5
r11399 n7292 n7293 0.041666666666666664
r11400 n7237 n7294 0.125
r11401 n7293 n7294 0.10416666666666667
r11402 n7238 n7295 0.10000000000000001
r11403 n7294 n7295 0.1875
r11404 n7239 n7296 0.5
r11405 n7295 n7296 0.125
r11406 n7240 n7297 0.050000000000000003
r11407 n7296 n7297 0.22916666666666666
r11408 n7241 n7298 0.16666666666666666
r11409 n7297 n7298 0.27083333333333331
r11410 n7242 n7299 0.083333333333333329
r11411 n7298 n7299 0.1875
r11412 n7243 n7300 0.25
r11413 n7299 n7300 0.16666666666666666
r11414 n7244 n7301 0.5
r11415 n7300 n7301 0.0625
r11416 n7245 n7302 0.5
r11417 n7301 n7302 0.041666666666666664
r11418 n7246 n7303 0.083333333333333329
r11419 n7302 n7303 0.14583333333333334
r11420 n7247 n7304 0.10000000000000001
r11421 n7303 n7304 0.22916666666666666
r11422 n7248 n7305 0.5
r11423 n7304 n7305 0.125
r11424 n7249 n7306 0.125
r11425 n7305 n7306 0.10416666666666667
r11426 n7250 n7307 0.10000000000000001
r11427 n7306 n7307 0.1875
r11428 n7251 n7308 0.16666666666666666
r11429 n7307 n7308 0.16666666666666666
r11430 n7252 n7309 0.071428571428571425
r11431 n7308 n7309 0.20833333333333334
r11432 n7253 n7310 0.071428571428571425
r11433 n7254 n7311 0.027777777777777776
r11434 n7310 n7311 0.52083333333333337
r11435 n7255 n7312 0.03125
r11436 n7311 n7312 0.70833333333333337
r11437 n7256 n7313 0.035714285714285712
r11438 n7312 n7313 0.625
r11439 n7257 n7314 0.025000000000000001
r11440 n7313 n7314 0.70833333333333337
r11441 n7258 n7315 0.10000000000000001
r11442 n7314 n7315 0.52083333333333337
r11443 n7259 n7316 0.017241379310344827
r11444 n7315 n7316 0.70833333333333337
r11445 n7260 n7317 0.014705882352941176
r11446 n7316 n7317 1.3125
r11447 n7261 n7318 0.014705882352941176
r11448 n7317 n7318 1.4166666666666667
r11449 n7262 n7319 0.014705882352941176
r11450 n7318 n7319 1.4166666666666667
r11451 n7263 n7320 0.012500000000000001
r11452 n7319 n7320 1.5416666666666667
r11453 n7264 n7321 0.014705882352941176
r11454 n7320 n7321 1.5416666666666667
r11455 n7265 n7322 0.014705882352941176
r11456 n7321 n7322 1.4166666666666667
r11457 n7266 n7323 0.014705882352941176
r11458 n7322 n7323 1.4166666666666667
r11459 n7267 n7324 0.029411764705882353
r11460 n7323 n7324 1.0625
r11461 n7268 n7325 0.029411764705882353
r11462 n7324 n7325 0.70833333333333337
r11463 n7269 n7326 0.012195121951219513
r11464 n7325 n7326 1.2083333333333333
r11465 n7270 n7327 0.012195121951219513
r11466 n7326 n7327 1.7083333333333333
r11467 n7271 n7328 0.012195121951219513
r11468 n7327 n7328 1.7083333333333333
r11469 n7272 n7329 0.050000000000000003
r11470 n7328 n7329 1.0625
r11471 n7273 n7330 0.050000000000000003
r11472 n7329 n7330 0.41666666666666669
r11473 n7274 n7331 0.02
r11474 n7330 n7331 0.72916666666666663
r11475 n7275 n7332 0.5
r11476 n7331 n7332 0.54166666666666663
r11477 n7276 n7333 0.017857142857142856
r11478 n7332 n7333 0.60416666666666663
r11479 n7277 n7334 0.5
r11480 n7333 n7334 0.60416666666666663
r11481 n7278 n7335 0.02
r11482 n7334 n7335 0.54166666666666663
r11483 n7279 n7336 0.050000000000000003
r11484 n7335 n7336 0.72916666666666663
r11485 n7280 n7337 0.018382352941176471
r11486 n7281 n7338 0.01953125
r11487 n7337 n7338 1.03125
r11488 n7282 n7339 0.15625
r11489 n7338 n7339 0.5625
r11490 n7283 n7340 0.010416666666666666
r11491 n7339 n7340 1
r11492 n7284 n7341 0.15625
r11493 n7340 n7341 1
r11494 n7285 n7342 0.01953125
r11495 n7341 n7342 0.5625
r11496 n7286 n7343 0.018382352941176471
r11497 n7342 n7343 1.03125
r11498 n7287 n7344 0.0625
r11499 n7288 n7345 0.0625
r11500 n7344 n7345 0.3125
r11501 n7289 n7346 0.3125
r11502 n7345 n7346 0.1875
r11503 n7290 n7347 0.15625
r11504 n7346 n7347 0.09375
r11505 n7291 n7348 0.3125
r11506 n7347 n7348 0.09375
r11507 n7292 n7349 0.3125
r11508 n7348 n7349 0.0625
r11509 n7293 n7350 0.3125
r11510 n7349 n7350 0.0625
r11511 n7294 n7351 0.078125
r11512 n7350 n7351 0.15625
r11513 n7295 n7352 0.0625
r11514 n7351 n7352 0.28125
r11515 n7296 n7353 0.3125
r11516 n7352 n7353 0.1875
r11517 n7297 n7354 0.03125
r11518 n7353 n7354 0.34375
r11519 n7298 n7355 0.10416666666666667
r11520 n7354 n7355 0.40625
r11521 n7299 n7356 0.052083333333333336
r11522 n7355 n7356 0.28125
r11523 n7300 n7357 0.15625
r11524 n7356 n7357 0.25
r11525 n7301 n7358 0.3125
r11526 n7357 n7358 0.09375
r11527 n7302 n7359 0.3125
r11528 n7358 n7359 0.0625
r11529 n7303 n7360 0.052083333333333336
r11530 n7359 n7360 0.21875
r11531 n7304 n7361 0.0625
r11532 n7360 n7361 0.34375
r11533 n7305 n7362 0.3125
r11534 n7361 n7362 0.1875
r11535 n7306 n7363 0.078125
r11536 n7362 n7363 0.15625
r11537 n7307 n7364 0.0625
r11538 n7363 n7364 0.28125
r11539 n7308 n7365 0.10416666666666667
r11540 n7364 n7365 0.25
r11541 n7309 n7366 0.044642857142857144
r11542 n7365 n7366 0.3125
r11543 n7310 n7367 0.044642857142857144
r11544 n7311 n7368 0.017361111111111112
r11545 n7367 n7368 0.78125
r11546 n7312 n7369 0.01953125
r11547 n7368 n7369 1.0625
r11548 n7313 n7370 0.022321428571428572
r11549 n7369 n7370 0.9375
r11550 n7314 n7371 0.015625
r11551 n7370 n7371 1.0625
r11552 n7315 n7372 0.0625
r11553 n7371 n7372 0.78125
r11554 n7330 n7373 0.03125
r11555 n7331 n7374 0.012500000000000001
r11556 n7373 n7374 1.09375
r11557 n7332 n7375 0.3125
r11558 n7374 n7375 0.8125
r11559 n7333 n7376 0.011160714285714286
r11560 n7375 n7376 0.90625
r11561 n7334 n7377 0.3125
r11562 n7376 n7377 0.90625
r11563 n7335 n7378 0.012500000000000001
r11564 n7377 n7378 0.8125
r11565 n7336 n7379 0.03125
r11566 n7378 n7379 1.09375
r11567 n7337 n7380 0.044117647058823532
r11568 n7338 n7381 0.046875
r11569 n7380 n7381 0.20624999999999999
r11570 n7339 n7382 0.375
r11571 n7381 n7382 0.1125
r11572 n7340 n7383 0.025000000000000001
r11573 n7382 n7383 0.20000000000000001
r11574 n7341 n7384 0.375
r11575 n7383 n7384 0.20000000000000001
r11576 n7342 n7385 0.046875
r11577 n7384 n7385 0.1125
r11578 n7343 n7386 0.044117647058823532
r11579 n7385 n7386 0.20624999999999999
r11580 n7344 n7387 0.14999999999999999
r11581 n7345 n7388 0.14999999999999999
r11582 n7387 n7388 0.0625
r11583 n7346 n7389 0.75
r11584 n7388 n7389 0.037499999999999999
r11585 n7347 n7390 0.375
r11586 n7389 n7390 0.018749999999999999
r11587 n7348 n7391 0.75
r11588 n7390 n7391 0.018749999999999999
r11589 n7349 n7392 0.75
r11590 n7391 n7392 0.012500000000000001
r11591 n7350 n7393 0.75
r11592 n7392 n7393 0.012500000000000001
r11593 n7351 n7394 0.1875
r11594 n7393 n7394 0.03125
r11595 n7352 n7395 0.14999999999999999
r11596 n7394 n7395 0.056250000000000001
r11597 n7353 n7396 0.75
r11598 n7395 n7396 0.037499999999999999
r11599 n7354 n7397 0.074999999999999997
r11600 n7396 n7397 0.068750000000000006
r11601 n7355 n7398 0.25
r11602 n7397 n7398 0.081250000000000003
r11603 n7356 n7399 0.125
r11604 n7398 n7399 0.056250000000000001
r11605 n7357 n7400 0.375
r11606 n7399 n7400 0.050000000000000003
r11607 n7358 n7401 0.75
r11608 n7400 n7401 0.018749999999999999
r11609 n7359 n7402 0.75
r11610 n7401 n7402 0.012500000000000001
r11611 n7360 n7403 0.125
r11612 n7402 n7403 0.043749999999999997
r11613 n7361 n7404 0.14999999999999999
r11614 n7403 n7404 0.068750000000000006
r11615 n7362 n7405 0.75
r11616 n7404 n7405 0.037499999999999999
r11617 n7363 n7406 0.1875
r11618 n7405 n7406 0.03125
r11619 n7364 n7407 0.14999999999999999
r11620 n7406 n7407 0.056250000000000001
r11621 n7365 n7408 0.25
r11622 n7407 n7408 0.050000000000000003
r11623 n7366 n7409 0.10714285714285714
r11624 n7408 n7409 0.0625
r11625 n7373 n7410 0.074999999999999997
r11626 n7374 n7411 0.029999999999999999
r11627 n7410 n7411 0.21875
r11628 n7375 n7412 0.75
r11629 n7411 n7412 0.16250000000000001
r11630 n7376 n7413 0.026785714285714284
r11631 n7412 n7413 0.18124999999999999
r11632 n7377 n7414 0.75
r11633 n7413 n7414 0.18124999999999999
r11634 n7378 n7415 0.029999999999999999
r11635 n7414 n7415 0.16250000000000001
r11636 n7379 n7416 0.074999999999999997
r11637 n7415 n7416 0.21875
r11638 n7380 n7417 0.07720588235294118
r11639 n7381 n7418 0.08203125
r11640 n7417 n7418 0.1875
r11641 n7382 n7419 0.65625
r11642 n7418 n7419 0.10227272727272728
r11643 n7383 n7420 0.043749999999999997
r11644 n7419 n7420 0.18181818181818182
r11645 n7384 n7421 0.65625
r11646 n7420 n7421 0.18181818181818182
r11647 n7385 n7422 0.08203125
r11648 n7421 n7422 0.10227272727272728
r11649 n7386 n7423 0.07720588235294118
r11650 n7422 n7423 0.1875
r11651 n7410 n7424 0.13125000000000001
r11652 n7411 n7425 0.052499999999999998
r11653 n7424 n7425 0.19886363636363635
r11654 n7412 n7426 1.3125
r11655 n7425 n7426 0.14772727272727273
r11656 n7413 n7427 0.046875
r11657 n7426 n7427 0.16477272727272727
r11658 n7414 n7428 1.3125
r11659 n7427 n7428 0.16477272727272727
r11660 n7415 n7429 0.052499999999999998
r11661 n7428 n7429 0.14772727272727273
r11662 n7416 n7430 0.13125000000000001
r11663 n7429 n7430 0.19886363636363635
r11664 n7417 n7431 0.1875
r11665 n7418 n7432 0.19921875
r11666 n7431 n7432 0.051562499999999997
r11667 n7419 n7433 1.59375
r11668 n7432 n7433 0.028125000000000001
r11669 n7420 n7434 0.10625
r11670 n7433 n7434 0.050000000000000003
r11671 n7421 n7435 1.59375
r11672 n7434 n7435 0.050000000000000003
r11673 n7422 n7436 0.19921875
r11674 n7435 n7436 0.028125000000000001
r11675 n7423 n7437 0.1875
r11676 n7436 n7437 0.051562499999999997
r11677 n7424 n7438 0.31874999999999998
r11678 n7425 n7439 0.1275
r11679 n7438 n7439 0.0546875
r11680 n7426 n7440 3.1875
r11681 n7439 n7440 0.040625000000000001
r11682 n7427 n7441 0.11383928571428571
r11683 n7440 n7441 0.045312499999999999
r11684 n7428 n7442 3.1875
r11685 n7441 n7442 0.045312499999999999
r11686 n7429 n7443 0.1275
r11687 n7442 n7443 0.040625000000000001
r11688 n7430 n7444 0.31874999999999998
r11689 n7443 n7444 0.0546875
r11690 n7431 n7445 0.29411764705882354
r11691 n7432 n7446 0.3125
r11692 n7445 n7446 0.051562499999999997
r11693 n7433 n7447 2.5
r11694 n7446 n7447 0.028125000000000001
r11695 n7434 n7448 0.16666666666666666
r11696 n7447 n7448 0.050000000000000003
r11697 n7435 n7449 2.5
r11698 n7448 n7449 0.050000000000000003
r11699 n7436 n7450 0.3125
r11700 n7449 n7450 0.028125000000000001
r11701 n7437 n7451 0.29411764705882354
r11702 n7450 n7451 0.051562499999999997
r11703 n7438 n7452 0.5
r11704 n7439 n7453 0.20000000000000001
r11705 n7452 n7453 0.0546875
r11706 n7440 n7454 5
r11707 n7453 n7454 0.040625000000000001
r11708 n7441 n7455 0.17857142857142858
r11709 n7454 n7455 0.045312499999999999
r11710 n7442 n7456 5
r11711 n7455 n7456 0.045312499999999999
r11712 n7443 n7457 0.20000000000000001
r11713 n7456 n7457 0.040625000000000001
r11714 n7444 n7458 0.5
r11715 n7457 n7458 0.0546875
r11716 n7445 n7459 0.27205882352941174
r11717 n7446 n7460 0.2890625
r11718 n7459 n7460 0.060661764705882353
r11719 n7447 n7461 2.3125
r11720 n7460 n7461 0.033088235294117647
r11721 n7448 n7462 0.15416666666666667
r11722 n7461 n7462 0.058823529411764705
r11723 n7449 n7463 2.3125
r11724 n7462 n7463 0.058823529411764705
r11725 n7450 n7464 0.2890625
r11726 n7463 n7464 0.033088235294117647
r11727 n7451 n7465 0.27205882352941174
r11728 n7464 n7465 0.060661764705882353
r11729 n7452 n7466 0.46250000000000002
r11730 n7453 n7467 0.185
r11731 n7466 n7467 0.064338235294117641
r11732 n7454 n7468 4.625
r11733 n7467 n7468 0.04779411764705882
r11734 n7455 n7469 0.16517857142857142
r11735 n7468 n7469 0.053308823529411763
r11736 n7456 n7470 4.625
r11737 n7469 n7470 0.053308823529411763
r11738 n7457 n7471 0.185
r11739 n7470 n7471 0.04779411764705882
r11740 n7458 n7472 0.46250000000000002
r11741 n7471 n7472 0.064338235294117641
r11742 n7459 n7473 0.28602941176470587
r11743 n7460 n7474 0.30390624999999999
r11744 n7473 n7474 0.047089041095890412
r11745 n7461 n7475 2.4312499999999999
r11746 n7474 n7475 0.025684931506849314
r11747 n7462 n7476 0.16208333333333333
r11748 n7475 n7476 0.045662100456621002
r11749 n7463 n7477 2.4312499999999999
r11750 n7476 n7477 0.045662100456621002
r11751 n7464 n7478 0.30390624999999999
r11752 n7477 n7478 0.025684931506849314
r11753 n7465 n7479 0.28602941176470587
r11754 n7478 n7479 0.047089041095890412
r11755 n7466 n7480 0.48625000000000002
r11756 n7467 n7481 0.19450000000000001
r11757 n7480 n7481 0.049942922374429224
r11758 n7468 n7482 4.8624999999999998
r11759 n7481 n7482 0.037100456621004564
r11760 n7469 n7483 0.17366071428571428
r11761 n7482 n7483 0.041381278538812787
r11762 n7470 n7484 4.8624999999999998
r11763 n7483 n7484 0.041381278538812787
r11764 n7471 n7485 0.19450000000000001
r11765 n7484 n7485 0.037100456621004564
r11766 n7472 n7486 0.48625000000000002
r11767 n7485 n7486 0.049942922374429224
r11768 n7473 n7487 0.32132352941176473
r11769 n7474 n7488 0.34140625000000002
r11770 n7487 n7488 0.047305045871559634
r11771 n7475 n7489 2.7312500000000002
r11772 n7488 n7489 0.025802752293577983
r11773 n7476 n7490 0.18208333333333335
r11774 n7489 n7490 0.045871559633027525
r11775 n7477 n7491 2.7312500000000002
r11776 n7490 n7491 0.045871559633027525
r11777 n7478 n7492 0.34140625000000002
r11778 n7491 n7492 0.025802752293577983
r11779 n7479 n7493 0.32132352941176473
r11780 n7492 n7493 0.047305045871559634
r11781 n7480 n7494 0.54625000000000001
r11782 n7481 n7495 0.2185
r11783 n7494 n7495 0.050172018348623851
r11784 n7482 n7496 5.4625000000000004
r11785 n7495 n7496 0.037270642201834861
r11786 n7483 n7497 0.19508928571428572
r11787 n7496 n7497 0.041571100917431193
r11788 n7484 n7498 5.4625000000000004
r11789 n7497 n7498 0.041571100917431193
r11790 n7485 n7499 0.2185
r11791 n7498 n7499 0.037270642201834861
r11792 n7486 n7500 0.54625000000000001
r11793 n7499 n7500 0.050172018348623851
r11794 n7487 n7501 0.32132352941176473
r11795 n7488 n7502 0.34140625000000002
r11796 n7501 n7502 0.047089041095890412
r11797 n7489 n7503 2.7312500000000002
r11798 n7502 n7503 0.025684931506849314
r11799 n7490 n7504 0.18208333333333335
r11800 n7503 n7504 0.045662100456621002
r11801 n7491 n7505 2.7312500000000002
r11802 n7504 n7505 0.045662100456621002
r11803 n7492 n7506 0.34140625000000002
r11804 n7505 n7506 0.025684931506849314
r11805 n7493 n7507 0.32132352941176473
r11806 n7506 n7507 0.047089041095890412
r11807 n7494 n7508 0.54625000000000001
r11808 n7495 n7509 0.2185
r11809 n7508 n7509 0.049942922374429224
r11810 n7496 n7510 5.4625000000000004
r11811 n7509 n7510 0.037100456621004564
r11812 n7497 n7511 0.19508928571428572
r11813 n7510 n7511 0.041381278538812787
r11814 n7498 n7512 5.4625000000000004
r11815 n7511 n7512 0.041381278538812787
r11816 n7499 n7513 0.2185
r11817 n7512 n7513 0.037100456621004564
r11818 n7500 n7514 0.54625000000000001
r11819 n7513 n7514 0.049942922374429224
r11820 n7501 n7515 0.32205882352941179
r11821 n7502 n7516 0.34218749999999998
r11822 n7515 n7516 0.047089041095890412
r11823 n7503 n7517 2.7374999999999998
r11824 n7516 n7517 0.025684931506849314
r11825 n7504 n7518 0.1825
r11826 n7517 n7518 0.045662100456621002
r11827 n7505 n7519 2.7374999999999998
r11828 n7518 n7519 0.045662100456621002
r11829 n7506 n7520 0.34218749999999998
r11830 n7519 n7520 0.025684931506849314
r11831 n7507 n7521 0.32205882352941179
r11832 n7520 n7521 0.047089041095890412
r11833 n7508 n7522 0.54749999999999999
r11834 n7509 n7523 0.219
r11835 n7522 n7523 0.049942922374429224
r11836 n7510 n7524 5.4749999999999996
r11837 n7523 n7524 0.037100456621004564
r11838 n7511 n7525 0.19553571428571428
r11839 n7524 n7525 0.041381278538812787
r11840 n7512 n7526 5.4749999999999996
r11841 n7525 n7526 0.041381278538812787
r11842 n7513 n7527 0.219
r11843 n7526 n7527 0.037100456621004564
r11844 n7514 n7528 0.54749999999999999
r11845 n7527 n7528 0.049942922374429224
r11846 n7515 n7529 0.29558823529411765
r11847 n7516 n7530 0.31406250000000002
r11848 n7529 n7530 0.056352459016393443
r11849 n7517 n7531 2.5125000000000002
r11850 n7530 n7531 0.030737704918032786
r11851 n7518 n7532 0.16750000000000001
r11852 n7531 n7532 0.054644808743169397
r11853 n7519 n7533 2.5125000000000002
r11854 n7532 n7533 0.054644808743169397
r11855 n7520 n7534 0.31406250000000002
r11856 n7533 n7534 0.030737704918032786
r11857 n7521 n7535 0.29558823529411765
r11858 n7534 n7535 0.056352459016393443
r11859 n7522 n7536 0.50249999999999995
r11860 n7523 n7537 0.20100000000000001
r11861 n7536 n7537 0.059767759562841527
r11862 n7524 n7538 5.0250000000000004
r11863 n7537 n7538 0.044398907103825137
r11864 n7525 n7539 0.17946428571428572
r11865 n7538 n7539 0.049521857923497267
r11866 n7526 n7540 5.0250000000000004
r11867 n7539 n7540 0.049521857923497267
r11868 n7527 n7541 0.20100000000000001
r11869 n7540 n7541 0.044398907103825137
r11870 n7528 n7542 0.50249999999999995
r11871 n7541 n7542 0.059767759562841527
r11872 n7529 n7543 0.26985294117647057
r11873 n7530 n7544 0.28671875000000002
r11874 n7543 n7544 0.056046195652173912
r11875 n7531 n7545 2.2937500000000002
r11876 n7544 n7545 0.030570652173913044
r11877 n7532 n7546 0.15291666666666667
r11878 n7545 n7546 0.05434782608695652
r11879 n7533 n7547 2.2937500000000002
r11880 n7546 n7547 0.05434782608695652
r11881 n7534 n7548 0.28671875000000002
r11882 n7547 n7548 0.030570652173913044
r11883 n7535 n7549 0.26985294117647057
r11884 n7548 n7549 0.056046195652173912
r11885 n7536 n7550 0.45874999999999999
r11886 n7537 n7551 0.1835
r11887 n7550 n7551 0.059442934782608696
r11888 n7538 n7552 4.5875000000000004
r11889 n7551 n7552 0.044157608695652176
r11890 n7539 n7553 0.16383928571428572
r11891 n7552 n7553 0.049252717391304345
r11892 n7540 n7554 4.5875000000000004
r11893 n7553 n7554 0.049252717391304345
r11894 n7541 n7555 0.1835
r11895 n7554 n7555 0.044157608695652176
r11896 n7542 n7556 0.45874999999999999
r11897 n7555 n7556 0.059442934782608696
r11898 n7543 n7557 0.26985294117647057
r11899 n7544 n7558 0.28671875000000002
r11900 n7557 n7558 0.056352459016393443
r11901 n7545 n7559 2.2937500000000002
r11902 n7558 n7559 0.030737704918032786
r11903 n7546 n7560 0.15291666666666667
r11904 n7559 n7560 0.054644808743169397
r11905 n7547 n7561 2.2937500000000002
r11906 n7560 n7561 0.054644808743169397
r11907 n7548 n7562 0.28671875000000002
r11908 n7561 n7562 0.030737704918032786
r11909 n7549 n7563 0.26985294117647057
r11910 n7562 n7563 0.056352459016393443
r11911 n7550 n7564 0.45874999999999999
r11912 n7551 n7565 0.1835
r11913 n7564 n7565 0.059767759562841527
r11914 n7552 n7566 4.5875000000000004
r11915 n7565 n7566 0.044398907103825137
r11916 n7553 n7567 0.16383928571428572
r11917 n7566 n7567 0.049521857923497267
r11918 n7554 n7568 4.5875000000000004
r11919 n7567 n7568 0.049521857923497267
r11920 n7555 n7569 0.1835
r11921 n7568 n7569 0.044398907103825137
r11922 n7556 n7570 0.45874999999999999
r11923 n7569 n7570 0.059767759562841527
r11924 n7571 n7572 0.17624999999999999
r11925 n7572 n7573 0.11750000000000001
r11926 n7573 n7574 0.070499999999999993
r11927 n7574 n7575 0.047
r11928 n7575 n7576 0.047
r11929 n7576 n7577 0.11750000000000001
r11930 n7577 n7578 0.22325
r11931 n7578 n7579 0.17624999999999999
r11932 n7579 n7580 0.11750000000000001
r11933 n7580 n7581 0.070499999999999993
r11934 n7581 n7582 0.035249999999999997
r11935 n7582 n7583 0.035249999999999997
r11936 n7583 n7584 0.0235
r11937 n7584 n7585 0.0235
r11938 n7585 n7586 0.058750000000000004
r11939 n7586 n7587 0.10575000000000001
r11940 n7587 n7588 0.070499999999999993
r11941 n7588 n7589 0.12925
r11942 n7571 n7590 0.0093999999999999986
r11943 n7572 n7591 0.018799999999999997
r11944 n7590 n7591 0.17624999999999999
r11945 n7573 n7592 0.018799999999999997
r11946 n7591 n7592 0.11750000000000001
r11947 n7574 n7593 0.094
r11948 n7592 n7593 0.070499999999999993
r11949 n7575 n7594 0.031333333333333331
r11950 n7593 n7594 0.047
r11951 n7576 n7595 0.094
r11952 n7594 n7595 0.047
r11953 n7577 n7596 0.010444444444444444
r11954 n7595 n7596 0.11750000000000001
r11955 n7578 n7597 0.0093999999999999986
r11956 n7596 n7597 0.22325
r11957 n7579 n7598 0.018799999999999997
r11958 n7597 n7598 0.17624999999999999
r11959 n7580 n7599 0.018799999999999997
r11960 n7598 n7599 0.11750000000000001
r11961 n7581 n7600 0.094
r11962 n7599 n7600 0.070499999999999993
r11963 n7582 n7601 0.047
r11964 n7600 n7601 0.035249999999999997
r11965 n7583 n7602 0.094
r11966 n7601 n7602 0.035249999999999997
r11967 n7584 n7603 0.094
r11968 n7602 n7603 0.0235
r11969 n7585 n7604 0.094
r11970 n7603 n7604 0.0235
r11971 n7586 n7605 0.0235
r11972 n7604 n7605 0.058750000000000004
r11973 n7587 n7606 0.018799999999999997
r11974 n7605 n7606 0.10575000000000001
r11975 n7588 n7607 0.094
r11976 n7606 n7607 0.070499999999999993
r11977 n7589 n7608 0.0093999999999999986
r11978 n7607 n7608 0.12925
r11979 n7590 n7609 0.0093999999999999986
r11980 n7591 n7610 0.018799999999999997
r11981 n7609 n7610 0.17624999999999999
r11982 n7592 n7611 0.018799999999999997
r11983 n7610 n7611 0.11750000000000001
r11984 n7593 n7612 0.094
r11985 n7611 n7612 0.070499999999999993
r11986 n7594 n7613 0.031333333333333331
r11987 n7612 n7613 0.047
r11988 n7595 n7614 0.094
r11989 n7613 n7614 0.047
r11990 n7596 n7615 0.010444444444444444
r11991 n7614 n7615 0.11750000000000001
r11992 n7597 n7616 0.0093999999999999986
r11993 n7615 n7616 0.22325
r11994 n7598 n7617 0.018799999999999997
r11995 n7616 n7617 0.17624999999999999
r11996 n7599 n7618 0.018799999999999997
r11997 n7617 n7618 0.11750000000000001
r11998 n7600 n7619 0.094
r11999 n7618 n7619 0.070499999999999993
r12000 n7601 n7620 0.047
r12001 n7619 n7620 0.035249999999999997
r12002 n7602 n7621 0.094
r12003 n7620 n7621 0.035249999999999997
r12004 n7603 n7622 0.094
r12005 n7621 n7622 0.0235
r12006 n7604 n7623 0.094
r12007 n7622 n7623 0.0235
r12008 n7605 n7624 0.0235
r12009 n7623 n7624 0.058750000000000004
r12010 n7606 n7625 0.018799999999999997
r12011 n7624 n7625 0.10575000000000001
r12012 n7607 n7626 0.094
r12013 n7625 n7626 0.070499999999999993
r12014 n7608 n7627 0.0093999999999999986
r12015 n7626 n7627 0.12925
r12016 n7609 n7628 0.0141
r12017 n7610 n7629 0.028199999999999999
r12018 n7628 n7629 0.088124999999999995
r12019 n7611 n7630 0.028199999999999999
r12020 n7629 n7630 0.058750000000000004
r12021 n7612 n7631 0.14099999999999999
r12022 n7630 n7631 0.035249999999999997
r12023 n7613 n7632 0.047
r12024 n7631 n7632 0.0235
r12025 n7614 n7633 0.14099999999999999
r12026 n7632 n7633 0.0235
r12027 n7615 n7634 0.015666666666666666
r12028 n7633 n7634 0.058750000000000004
r12029 n7616 n7635 0.0141
r12030 n7634 n7635 0.111625
r12031 n7617 n7636 0.028199999999999999
r12032 n7635 n7636 0.088124999999999995
r12033 n7618 n7637 0.028199999999999999
r12034 n7636 n7637 0.058750000000000004
r12035 n7619 n7638 0.14099999999999999
r12036 n7637 n7638 0.035249999999999997
r12037 n7620 n7639 0.070499999999999993
r12038 n7638 n7639 0.017624999999999998
r12039 n7621 n7640 0.14099999999999999
r12040 n7639 n7640 0.017624999999999998
r12041 n7622 n7641 0.14099999999999999
r12042 n7640 n7641 0.01175
r12043 n7623 n7642 0.14099999999999999
r12044 n7641 n7642 0.01175
r12045 n7624 n7643 0.035249999999999997
r12046 n7642 n7643 0.029375000000000002
r12047 n7625 n7644 0.028199999999999999
r12048 n7643 n7644 0.052875000000000005
r12049 n7626 n7645 0.14099999999999999
r12050 n7644 n7645 0.035249999999999997
r12051 n7627 n7646 0.0141
r12052 n7645 n7646 0.064625000000000002
r12053 n7628 n7647 0.025849999999999998
r12054 n7629 n7648 0.051699999999999996
r12055 n7647 n7648 0.050357142857142857
r12056 n7630 n7649 0.051699999999999996
r12057 n7648 n7649 0.033571428571428572
r12058 n7631 n7650 0.25850000000000001
r12059 n7649 n7650 0.020142857142857143
r12060 n7632 n7651 0.086166666666666669
r12061 n7650 n7651 0.013428571428571429
r12062 n7633 n7652 0.25850000000000001
r12063 n7651 n7652 0.013428571428571429
r12064 n7634 n7653 0.028722222222222222
r12065 n7652 n7653 0.033571428571428572
r12066 n7635 n7654 0.025849999999999998
r12067 n7653 n7654 0.063785714285714279
r12068 n7636 n7655 0.051699999999999996
r12069 n7654 n7655 0.050357142857142857
r12070 n7637 n7656 0.051699999999999996
r12071 n7655 n7656 0.033571428571428572
r12072 n7638 n7657 0.25850000000000001
r12073 n7656 n7657 0.020142857142857143
r12074 n7639 n7658 0.12925
r12075 n7657 n7658 0.010071428571428571
r12076 n7640 n7659 0.25850000000000001
r12077 n7658 n7659 0.010071428571428571
r12078 n7641 n7660 0.25850000000000001
r12079 n7659 n7660 0.0067142857142857143
r12080 n7642 n7661 0.25850000000000001
r12081 n7660 n7661 0.0067142857142857143
r12082 n7643 n7662 0.064625000000000002
r12083 n7661 n7662 0.016785714285714286
r12084 n7644 n7663 0.051699999999999996
r12085 n7662 n7663 0.030214285714285718
r12086 n7645 n7664 0.25850000000000001
r12087 n7663 n7664 0.020142857142857143
r12088 n7646 n7665 0.025849999999999998
r12089 n7664 n7665 0.036928571428571429
r12090 n7647 n7666 0.0235
r12091 n7648 n7667 0.047
r12092 n7666 n7667 0.11749999999999999
r12093 n7649 n7668 0.047
r12094 n7667 n7668 0.078333333333333338
r12095 n7650 n7669 0.23500000000000001
r12096 n7668 n7669 0.047
r12097 n7651 n7670 0.078333333333333338
r12098 n7669 n7670 0.031333333333333331
r12099 n7652 n7671 0.23500000000000001
r12100 n7670 n7671 0.031333333333333331
r12101 n7653 n7672 0.026111111111111113
r12102 n7671 n7672 0.078333333333333338
r12103 n7654 n7673 0.0235
r12104 n7672 n7673 0.14883333333333332
r12105 n7655 n7674 0.047
r12106 n7673 n7674 0.11749999999999999
r12107 n7656 n7675 0.047
r12108 n7674 n7675 0.078333333333333338
r12109 n7657 n7676 0.23500000000000001
r12110 n7675 n7676 0.047
r12111 n7658 n7677 0.11750000000000001
r12112 n7676 n7677 0.0235
r12113 n7659 n7678 0.23500000000000001
r12114 n7677 n7678 0.0235
r12115 n7660 n7679 0.23500000000000001
r12116 n7678 n7679 0.015666666666666666
r12117 n7661 n7680 0.23500000000000001
r12118 n7679 n7680 0.015666666666666666
r12119 n7662 n7681 0.058750000000000004
r12120 n7680 n7681 0.039166666666666669
r12121 n7663 n7682 0.047
r12122 n7681 n7682 0.070500000000000007
r12123 n7664 n7683 0.23500000000000001
r12124 n7682 n7683 0.047
r12125 n7665 n7684 0.0235
r12126 n7683 n7684 0.086166666666666669
r12127 n7666 n7685 0.0141
r12128 n7667 n7686 0.028199999999999999
r12129 n7685 n7686 0.11749999999999999
r12130 n7668 n7687 0.028199999999999999
r12131 n7686 n7687 0.078333333333333338
r12132 n7669 n7688 0.14099999999999999
r12133 n7687 n7688 0.047
r12134 n7670 n7689 0.047
r12135 n7688 n7689 0.031333333333333331
r12136 n7671 n7690 0.14099999999999999
r12137 n7689 n7690 0.031333333333333331
r12138 n7672 n7691 0.015666666666666666
r12139 n7690 n7691 0.078333333333333338
r12140 n7673 n7692 0.0141
r12141 n7691 n7692 0.14883333333333332
r12142 n7674 n7693 0.028199999999999999
r12143 n7692 n7693 0.11749999999999999
r12144 n7675 n7694 0.028199999999999999
r12145 n7693 n7694 0.078333333333333338
r12146 n7676 n7695 0.14099999999999999
r12147 n7694 n7695 0.047
r12148 n7677 n7696 0.070499999999999993
r12149 n7695 n7696 0.0235
r12150 n7678 n7697 0.14099999999999999
r12151 n7696 n7697 0.0235
r12152 n7679 n7698 0.14099999999999999
r12153 n7697 n7698 0.015666666666666666
r12154 n7680 n7699 0.14099999999999999
r12155 n7698 n7699 0.015666666666666666
r12156 n7681 n7700 0.035249999999999997
r12157 n7699 n7700 0.039166666666666669
r12158 n7682 n7701 0.028199999999999999
r12159 n7700 n7701 0.070500000000000007
r12160 n7683 n7702 0.14099999999999999
r12161 n7701 n7702 0.047
r12162 n7684 n7703 0.0141
r12163 n7702 n7703 0.086166666666666669
r12164 n7685 n7704 0.01175
r12165 n7686 n7705 0.0235
r12166 n7704 n7705 0.17624999999999999
r12167 n7687 n7706 0.0235
r12168 n7705 n7706 0.11750000000000001
r12169 n7688 n7707 0.11750000000000001
r12170 n7706 n7707 0.070499999999999993
r12171 n7689 n7708 0.039166666666666669
r12172 n7707 n7708 0.047
r12173 n7690 n7709 0.11750000000000001
r12174 n7708 n7709 0.047
r12175 n7691 n7710 0.013055555555555556
r12176 n7709 n7710 0.11750000000000001
r12177 n7692 n7711 0.01175
r12178 n7710 n7711 0.22325
r12179 n7693 n7712 0.0235
r12180 n7711 n7712 0.17624999999999999
r12181 n7694 n7713 0.0235
r12182 n7712 n7713 0.11750000000000001
r12183 n7695 n7714 0.11750000000000001
r12184 n7713 n7714 0.070499999999999993
r12185 n7696 n7715 0.058750000000000004
r12186 n7714 n7715 0.035249999999999997
r12187 n7697 n7716 0.11750000000000001
r12188 n7715 n7716 0.035249999999999997
r12189 n7698 n7717 0.11750000000000001
r12190 n7716 n7717 0.0235
r12191 n7699 n7718 0.11750000000000001
r12192 n7717 n7718 0.0235
r12193 n7700 n7719 0.029375000000000002
r12194 n7718 n7719 0.058750000000000004
r12195 n7701 n7720 0.0235
r12196 n7719 n7720 0.10575000000000001
r12197 n7702 n7721 0.11750000000000001
r12198 n7720 n7721 0.070499999999999993
r12199 n7703 n7722 0.01175
r12200 n7721 n7722 0.12925
r12201 n7704 n7723 0.039949999999999999
r12202 n7705 n7724 0.079899999999999999
r12203 n7723 n7724 0.0235
r12204 n7706 n7725 0.079899999999999999
r12205 n7724 n7725 0.015666666666666666
r12206 n7707 n7726 0.39950000000000002
r12207 n7725 n7726 0.0093999999999999986
r12208 n7708 n7727 0.13316666666666668
r12209 n7726 n7727 0.006266666666666666
r12210 n7709 n7728 0.39950000000000002
r12211 n7727 n7728 0.006266666666666666
r12212 n7710 n7729 0.044388888888888887
r12213 n7728 n7729 0.015666666666666666
r12214 n7711 n7730 0.039949999999999999
r12215 n7729 n7730 0.029766666666666667
r12216 n7712 n7731 0.079899999999999999
r12217 n7730 n7731 0.0235
r12218 n7713 n7732 0.079899999999999999
r12219 n7731 n7732 0.015666666666666666
r12220 n7714 n7733 0.39950000000000002
r12221 n7732 n7733 0.0093999999999999986
r12222 n7715 n7734 0.19975000000000001
r12223 n7733 n7734 0.0046999999999999993
r12224 n7716 n7735 0.39950000000000002
r12225 n7734 n7735 0.0046999999999999993
r12226 n7717 n7736 0.39950000000000002
r12227 n7735 n7736 0.003133333333333333
r12228 n7718 n7737 0.39950000000000002
r12229 n7736 n7737 0.003133333333333333
r12230 n7719 n7738 0.099875000000000005
r12231 n7737 n7738 0.0078333333333333328
r12232 n7720 n7739 0.079899999999999999
r12233 n7738 n7739 0.014100000000000001
r12234 n7721 n7740 0.39950000000000002
r12235 n7739 n7740 0.0093999999999999986
r12236 n7722 n7741 0.039949999999999999
r12237 n7740 n7741 0.017233333333333333
r12238 n7723 n7742 0.070499999999999993
r12239 n7724 n7743 0.14099999999999999
r12240 n7742 n7743 0.0235
r12241 n7725 n7744 0.14099999999999999
r12242 n7743 n7744 0.015666666666666666
r12243 n7726 n7745 0.70499999999999996
r12244 n7744 n7745 0.0093999999999999986
r12245 n7727 n7746 0.23499999999999999
r12246 n7745 n7746 0.006266666666666666
r12247 n7728 n7747 0.70499999999999996
r12248 n7746 n7747 0.006266666666666666
r12249 n7729 n7748 0.078333333333333338
r12250 n7747 n7748 0.015666666666666666
r12251 n7730 n7749 0.070499999999999993
r12252 n7748 n7749 0.029766666666666667
r12253 n7731 n7750 0.14099999999999999
r12254 n7749 n7750 0.0235
r12255 n7732 n7751 0.14099999999999999
r12256 n7750 n7751 0.015666666666666666
r12257 n7733 n7752 0.70499999999999996
r12258 n7751 n7752 0.0093999999999999986
r12259 n7734 n7753 0.35249999999999998
r12260 n7752 n7753 0.0046999999999999993
r12261 n7735 n7754 0.70499999999999996
r12262 n7753 n7754 0.0046999999999999993
r12263 n7736 n7755 0.70499999999999996
r12264 n7754 n7755 0.003133333333333333
r12265 n7737 n7756 0.70499999999999996
r12266 n7755 n7756 0.003133333333333333
r12267 n7738 n7757 0.17624999999999999
r12268 n7756 n7757 0.0078333333333333328
r12269 n7739 n7758 0.14099999999999999
r12270 n7757 n7758 0.014100000000000001
r12271 n7740 n7759 0.70499999999999996
r12272 n7758 n7759 0.0093999999999999986
r12273 n7741 n7760 0.070499999999999993
r12274 n7759 n7760 0.017233333333333333
r12275 n7742 n7761 0.039949999999999999
r12276 n7743 n7762 0.079899999999999999
r12277 n7761 n7762 0.17624999999999999
r12278 n7744 n7763 0.079899999999999999
r12279 n7762 n7763 0.11750000000000001
r12280 n7745 n7764 0.39950000000000002
r12281 n7763 n7764 0.070499999999999993
r12282 n7746 n7765 0.13316666666666668
r12283 n7764 n7765 0.047
r12284 n7747 n7766 0.39950000000000002
r12285 n7765 n7766 0.047
r12286 n7748 n7767 0.044388888888888887
r12287 n7766 n7767 0.11750000000000001
r12288 n7749 n7768 0.039949999999999999
r12289 n7767 n7768 0.22325
r12290 n7750 n7769 0.079899999999999999
r12291 n7768 n7769 0.17624999999999999
r12292 n7751 n7770 0.079899999999999999
r12293 n7769 n7770 0.11750000000000001
r12294 n7752 n7771 0.39950000000000002
r12295 n7770 n7771 0.070499999999999993
r12296 n7753 n7772 0.19975000000000001
r12297 n7771 n7772 0.035249999999999997
r12298 n7754 n7773 0.39950000000000002
r12299 n7772 n7773 0.035249999999999997
r12300 n7755 n7774 0.39950000000000002
r12301 n7773 n7774 0.0235
r12302 n7756 n7775 0.39950000000000002
r12303 n7774 n7775 0.0235
r12304 n7757 n7776 0.099875000000000005
r12305 n7775 n7776 0.058750000000000004
r12306 n7758 n7777 0.079899999999999999
r12307 n7776 n7777 0.10575000000000001
r12308 n7759 n7778 0.39950000000000002
r12309 n7777 n7778 0.070499999999999993
r12310 n7760 n7779 0.039949999999999999
r12311 n7778 n7779 0.12925
r12312 n7761 n7780 0.01175
r12313 n7762 n7781 0.0235
r12314 n7780 n7781 0.11749999999999999
r12315 n7763 n7782 0.0235
r12316 n7781 n7782 0.078333333333333338
r12317 n7764 n7783 0.11750000000000001
r12318 n7782 n7783 0.047
r12319 n7765 n7784 0.039166666666666669
r12320 n7783 n7784 0.031333333333333331
r12321 n7766 n7785 0.11750000000000001
r12322 n7784 n7785 0.031333333333333331
r12323 n7767 n7786 0.013055555555555556
r12324 n7785 n7786 0.078333333333333338
r12325 n7768 n7787 0.01175
r12326 n7786 n7787 0.14883333333333332
r12327 n7769 n7788 0.0235
r12328 n7787 n7788 0.11749999999999999
r12329 n7770 n7789 0.0235
r12330 n7788 n7789 0.078333333333333338
r12331 n7771 n7790 0.11750000000000001
r12332 n7789 n7790 0.047
r12333 n7772 n7791 0.058750000000000004
r12334 n7790 n7791 0.0235
r12335 n7773 n7792 0.11750000000000001
r12336 n7791 n7792 0.0235
r12337 n7774 n7793 0.11750000000000001
r12338 n7792 n7793 0.015666666666666666
r12339 n7775 n7794 0.11750000000000001
r12340 n7793 n7794 0.015666666666666666
r12341 n7776 n7795 0.029375000000000002
r12342 n7794 n7795 0.039166666666666669
r12343 n7777 n7796 0.0235
r12344 n7795 n7796 0.070500000000000007
r12345 n7778 n7797 0.11750000000000001
r12346 n7796 n7797 0.047
r12347 n7779 n7798 0.01175
r12348 n7797 n7798 0.086166666666666669
r12349 n7780 n7799 0.0141
r12350 n7781 n7800 0.028199999999999999
r12351 n7799 n7800 0.11749999999999999
r12352 n7782 n7801 0.028199999999999999
r12353 n7800 n7801 0.078333333333333338
r12354 n7783 n7802 0.14099999999999999
r12355 n7801 n7802 0.047
r12356 n7784 n7803 0.047
r12357 n7802 n7803 0.031333333333333331
r12358 n7785 n7804 0.14099999999999999
r12359 n7803 n7804 0.031333333333333331
r12360 n7786 n7805 0.015666666666666666
r12361 n7804 n7805 0.078333333333333338
r12362 n7787 n7806 0.0141
r12363 n7805 n7806 0.14883333333333332
r12364 n7788 n7807 0.028199999999999999
r12365 n7806 n7807 0.11749999999999999
r12366 n7789 n7808 0.028199999999999999
r12367 n7807 n7808 0.078333333333333338
r12368 n7790 n7809 0.14099999999999999
r12369 n7808 n7809 0.047
r12370 n7791 n7810 0.070499999999999993
r12371 n7809 n7810 0.0235
r12372 n7792 n7811 0.14099999999999999
r12373 n7810 n7811 0.0235
r12374 n7793 n7812 0.14099999999999999
r12375 n7811 n7812 0.015666666666666666
r12376 n7794 n7813 0.14099999999999999
r12377 n7812 n7813 0.015666666666666666
r12378 n7795 n7814 0.035249999999999997
r12379 n7813 n7814 0.039166666666666669
r12380 n7796 n7815 0.028199999999999999
r12381 n7814 n7815 0.070500000000000007
r12382 n7797 n7816 0.14099999999999999
r12383 n7815 n7816 0.047
r12384 n7798 n7817 0.0141
r12385 n7816 n7817 0.086166666666666669
r12386 n7799 n7818 0.0235
r12387 n7800 n7819 0.047
r12388 n7818 n7819 0.050357142857142857
r12389 n7801 n7820 0.047
r12390 n7819 n7820 0.033571428571428572
r12391 n7802 n7821 0.23500000000000001
r12392 n7820 n7821 0.020142857142857143
r12393 n7803 n7822 0.078333333333333338
r12394 n7821 n7822 0.013428571428571429
r12395 n7804 n7823 0.23500000000000001
r12396 n7822 n7823 0.013428571428571429
r12397 n7805 n7824 0.026111111111111113
r12398 n7823 n7824 0.033571428571428572
r12399 n7806 n7825 0.0235
r12400 n7824 n7825 0.063785714285714279
r12401 n7807 n7826 0.047
r12402 n7825 n7826 0.050357142857142857
r12403 n7808 n7827 0.047
r12404 n7826 n7827 0.033571428571428572
r12405 n7809 n7828 0.23500000000000001
r12406 n7827 n7828 0.020142857142857143
r12407 n7810 n7829 0.11750000000000001
r12408 n7828 n7829 0.010071428571428571
r12409 n7811 n7830 0.23500000000000001
r12410 n7829 n7830 0.010071428571428571
r12411 n7812 n7831 0.23500000000000001
r12412 n7830 n7831 0.0067142857142857143
r12413 n7813 n7832 0.23500000000000001
r12414 n7831 n7832 0.0067142857142857143
r12415 n7814 n7833 0.058750000000000004
r12416 n7832 n7833 0.016785714285714286
r12417 n7815 n7834 0.047
r12418 n7833 n7834 0.030214285714285718
r12419 n7816 n7835 0.23500000000000001
r12420 n7834 n7835 0.020142857142857143
r12421 n7817 n7836 0.0235
r12422 n7835 n7836 0.036928571428571429
r12423 n7818 n7837 0.035249999999999997
r12424 n7819 n7838 0.070499999999999993
r12425 n7837 n7838 0.044062499999999998
r12426 n7820 n7839 0.070499999999999993
r12427 n7838 n7839 0.029375000000000002
r12428 n7821 n7840 0.35249999999999998
r12429 n7839 n7840 0.017624999999999998
r12430 n7822 n7841 0.11749999999999999
r12431 n7840 n7841 0.01175
r12432 n7823 n7842 0.35249999999999998
r12433 n7841 n7842 0.01175
r12434 n7824 n7843 0.039166666666666669
r12435 n7842 n7843 0.029375000000000002
r12436 n7825 n7844 0.035249999999999997
r12437 n7843 n7844 0.055812500000000001
r12438 n7826 n7845 0.070499999999999993
r12439 n7844 n7845 0.044062499999999998
r12440 n7827 n7846 0.070499999999999993
r12441 n7845 n7846 0.029375000000000002
r12442 n7828 n7847 0.35249999999999998
r12443 n7846 n7847 0.017624999999999998
r12444 n7829 n7848 0.17624999999999999
r12445 n7847 n7848 0.0088124999999999992
r12446 n7830 n7849 0.35249999999999998
r12447 n7848 n7849 0.0088124999999999992
r12448 n7831 n7850 0.35249999999999998
r12449 n7849 n7850 0.005875
r12450 n7832 n7851 0.35249999999999998
r12451 n7850 n7851 0.005875
r12452 n7833 n7852 0.088124999999999995
r12453 n7851 n7852 0.014687500000000001
r12454 n7834 n7853 0.070499999999999993
r12455 n7852 n7853 0.026437500000000003
r12456 n7835 n7854 0.35249999999999998
r12457 n7853 n7854 0.017624999999999998
r12458 n7836 n7855 0.035249999999999997
r12459 n7854 n7855 0.032312500000000001
r12460 n7837 n7856 0.0235
r12461 n7838 n7857 0.047
r12462 n7856 n7857 0.17624999999999999
r12463 n7839 n7858 0.047
r12464 n7857 n7858 0.11750000000000001
r12465 n7840 n7859 0.23500000000000001
r12466 n7858 n7859 0.070499999999999993
r12467 n7841 n7860 0.078333333333333338
r12468 n7859 n7860 0.047
r12469 n7842 n7861 0.23500000000000001
r12470 n7860 n7861 0.047
r12471 n7843 n7862 0.026111111111111113
r12472 n7861 n7862 0.11750000000000001
r12473 n7844 n7863 0.0235
r12474 n7862 n7863 0.22325
r12475 n7845 n7864 0.047
r12476 n7863 n7864 0.17624999999999999
r12477 n7846 n7865 0.047
r12478 n7864 n7865 0.11750000000000001
r12479 n7847 n7866 0.23500000000000001
r12480 n7865 n7866 0.070499999999999993
r12481 n7848 n7867 0.11750000000000001
r12482 n7866 n7867 0.035249999999999997
r12483 n7849 n7868 0.23500000000000001
r12484 n7867 n7868 0.035249999999999997
r12485 n7850 n7869 0.23500000000000001
r12486 n7868 n7869 0.0235
r12487 n7851 n7870 0.23500000000000001
r12488 n7869 n7870 0.0235
r12489 n7852 n7871 0.058750000000000004
r12490 n7870 n7871 0.058750000000000004
r12491 n7853 n7872 0.047
r12492 n7871 n7872 0.10575000000000001
r12493 n7854 n7873 0.23500000000000001
r12494 n7872 n7873 0.070499999999999993
r12495 n7855 n7874 0.0235
r12496 n7873 n7874 0.12925
r12497 n7857 n7875 0.1598
r12498 n7858 n7876 0.1598
r12499 n7875 n7876 0.0073437500000000005
r12500 n7859 n7877 0.79900000000000004
r12501 n7876 n7877 0.0044062499999999996
r12502 n7860 n7878 0.26633333333333337
r12503 n7877 n7878 0.0029375
r12504 n7861 n7879 0.79900000000000004
r12505 n7878 n7879 0.0029375
r12506 n7862 n7880 0.088777777777777775
r12507 n7879 n7880 0.0073437500000000005
r12508 n7863 n7881 0.079899999999999999
r12509 n7880 n7881 0.013953125
r12510 n7864 n7882 0.1598
r12511 n7881 n7882 0.011015624999999999
r12512 n7865 n7883 0.1598
r12513 n7882 n7883 0.0073437500000000005
r12514 n7866 n7884 0.79900000000000004
r12515 n7883 n7884 0.0044062499999999996
r12516 n7867 n7885 0.39950000000000002
r12517 n7884 n7885 0.0022031249999999998
r12518 n7868 n7886 0.79900000000000004
r12519 n7885 n7886 0.0022031249999999998
r12520 n7869 n7887 0.79900000000000004
r12521 n7886 n7887 0.00146875
r12522 n7870 n7888 0.79900000000000004
r12523 n7887 n7888 0.00146875
r12524 n7871 n7889 0.19975000000000001
r12525 n7888 n7889 0.0036718750000000002
r12526 n7872 n7890 0.1598
r12527 n7889 n7890 0.0066093750000000007
r12528 n7873 n7891 0.79900000000000004
r12529 n7890 n7891 0.0044062499999999996
r12530 n7875 n7892 0.37130000000000002
r12531 n7876 n7893 0.37130000000000002
r12532 n7892 n7893 0.0050000000000000001
r12533 n7877 n7894 1.8565
r12534 n7893 n7894 0.0029999999999999996
r12535 n7878 n7895 0.61883333333333335
r12536 n7894 n7895 0.002
r12537 n7879 n7896 1.8565
r12538 n7895 n7896 0.002
r12539 n7880 n7897 0.20627777777777778
r12540 n7896 n7897 0.0050000000000000001
r12541 n7881 n7898 0.18565000000000001
r12542 n7897 n7898 0.0094999999999999998
r12543 n7882 n7899 0.37130000000000002
r12544 n7898 n7899 0.0074999999999999997
r12545 n7883 n7900 0.37130000000000002
r12546 n7899 n7900 0.0050000000000000001
r12547 n7884 n7901 1.8565
r12548 n7900 n7901 0.0029999999999999996
r12549 n7885 n7902 0.92825000000000002
r12550 n7901 n7902 0.0014999999999999998
r12551 n7886 n7903 1.8565
r12552 n7902 n7903 0.0014999999999999998
r12553 n7887 n7904 1.8565
r12554 n7903 n7904 0.001
r12555 n7888 n7905 1.8565
r12556 n7904 n7905 0.001
r12557 n7889 n7906 0.46412500000000001
r12558 n7905 n7906 0.0025000000000000001
r12559 n7890 n7907 0.37130000000000002
r12560 n7906 n7907 0.0045000000000000005
r12561 n7891 n7908 1.8565
r12562 n7907 n7908 0.0029999999999999996
r12563 n7892 n7909 0.38069999999999998
r12564 n7893 n7910 0.38069999999999998
r12565 n7909 n7910 0.0069117647058823534
r12566 n7894 n7911 1.9035
r12567 n7910 n7911 0.0041470588235294117
r12568 n7895 n7912 0.63449999999999995
r12569 n7911 n7912 0.0027647058823529408
r12570 n7896 n7913 1.9035
r12571 n7912 n7913 0.0027647058823529408
r12572 n7897 n7914 0.21149999999999999
r12573 n7913 n7914 0.0069117647058823534
r12574 n7898 n7915 0.19034999999999999
r12575 n7914 n7915 0.01313235294117647
r12576 n7899 n7916 0.38069999999999998
r12577 n7915 n7916 0.010367647058823528
r12578 n7900 n7917 0.38069999999999998
r12579 n7916 n7917 0.0069117647058823534
r12580 n7901 n7918 1.9035
r12581 n7917 n7918 0.0041470588235294117
r12582 n7902 n7919 0.95174999999999998
r12583 n7918 n7919 0.0020735294117647058
r12584 n7903 n7920 1.9035
r12585 n7919 n7920 0.0020735294117647058
r12586 n7904 n7921 1.9035
r12587 n7920 n7921 0.0013823529411764704
r12588 n7905 n7922 1.9035
r12589 n7921 n7922 0.0013823529411764704
r12590 n7906 n7923 0.47587499999999999
r12591 n7922 n7923 0.0034558823529411767
r12592 n7907 n7924 0.38069999999999998
r12593 n7923 n7924 0.0062205882352941184
r12594 n7908 n7925 1.9035
r12595 n7924 n7925 0.0041470588235294117
r12596 n7909 n7926 0.38822000000000001
r12597 n7910 n7927 0.38822000000000001
r12598 n7926 n7927 0.0048353909465020575
r12599 n7911 n7928 1.9411
r12600 n7927 n7928 0.0029012345679012342
r12601 n7912 n7929 0.64703333333333335
r12602 n7928 n7929 0.001934156378600823
r12603 n7913 n7930 1.9411
r12604 n7929 n7930 0.001934156378600823
r12605 n7914 n7931 0.2156777777777778
r12606 n7930 n7931 0.0048353909465020575
r12607 n7915 n7932 0.19411
r12608 n7931 n7932 0.009187242798353909
r12609 n7916 n7933 0.38822000000000001
r12610 n7932 n7933 0.0072530864197530862
r12611 n7917 n7934 0.38822000000000001
r12612 n7933 n7934 0.0048353909465020575
r12613 n7918 n7935 1.9411
r12614 n7934 n7935 0.0029012345679012342
r12615 n7919 n7936 0.97055000000000002
r12616 n7935 n7936 0.0014506172839506171
r12617 n7920 n7937 1.9411
r12618 n7936 n7937 0.0014506172839506171
r12619 n7921 n7938 1.9411
r12620 n7937 n7938 0.00096707818930041151
r12621 n7922 n7939 1.9411
r12622 n7938 n7939 0.00096707818930041151
r12623 n7923 n7940 0.48527500000000001
r12624 n7939 n7940 0.0024176954732510287
r12625 n7924 n7941 0.38822000000000001
r12626 n7940 n7941 0.0043518518518518524
r12627 n7925 n7942 1.9411
r12628 n7941 n7942 0.0029012345679012342
r12629 n7926 n7943 0.45777999999999996
r12630 n7927 n7944 0.45777999999999996
r12631 n7943 n7944 0.0048155737704918032
r12632 n7928 n7945 2.2888999999999999
r12633 n7944 n7945 0.0028893442622950818
r12634 n7929 n7946 0.76296666666666668
r12635 n7945 n7946 0.0019262295081967213
r12636 n7930 n7947 2.2888999999999999
r12637 n7946 n7947 0.0019262295081967213
r12638 n7931 n7948 0.25432222222222223
r12639 n7947 n7948 0.0048155737704918032
r12640 n7932 n7949 0.22888999999999998
r12641 n7948 n7949 0.0091495901639344259
r12642 n7933 n7950 0.45777999999999996
r12643 n7949 n7950 0.0072233606557377044
r12644 n7934 n7951 0.45777999999999996
r12645 n7950 n7951 0.0048155737704918032
r12646 n7935 n7952 2.2888999999999999
r12647 n7951 n7952 0.0028893442622950818
r12648 n7936 n7953 1.14445
r12649 n7952 n7953 0.0014446721311475409
r12650 n7937 n7954 2.2888999999999999
r12651 n7953 n7954 0.0014446721311475409
r12652 n7938 n7955 2.2888999999999999
r12653 n7954 n7955 0.00096311475409836063
r12654 n7939 n7956 2.2888999999999999
r12655 n7955 n7956 0.00096311475409836063
r12656 n7940 n7957 0.57222499999999998
r12657 n7956 n7957 0.0024077868852459016
r12658 n7941 n7958 0.45777999999999996
r12659 n7957 n7958 0.0043340163934426235
r12660 n7942 n7959 2.2888999999999999
r12661 n7958 n7959 0.0028893442622950818
r12662 n7943 n7960 0.45777999999999996
r12663 n7944 n7961 0.45777999999999996
r12664 n7960 n7961 0.0048353909465020575
r12665 n7945 n7962 2.2888999999999999
r12666 n7961 n7962 0.0029012345679012342
r12667 n7946 n7963 0.76296666666666668
r12668 n7962 n7963 0.001934156378600823
r12669 n7947 n7964 2.2888999999999999
r12670 n7963 n7964 0.001934156378600823
r12671 n7948 n7965 0.25432222222222223
r12672 n7964 n7965 0.0048353909465020575
r12673 n7949 n7966 0.22888999999999998
r12674 n7965 n7966 0.009187242798353909
r12675 n7950 n7967 0.45777999999999996
r12676 n7966 n7967 0.0072530864197530862
r12677 n7951 n7968 0.45777999999999996
r12678 n7967 n7968 0.0048353909465020575
r12679 n7952 n7969 2.2888999999999999
r12680 n7968 n7969 0.0029012345679012342
r12681 n7953 n7970 1.14445
r12682 n7969 n7970 0.0014506172839506171
r12683 n7954 n7971 2.2888999999999999
r12684 n7970 n7971 0.0014506172839506171
r12685 n7955 n7972 2.2888999999999999
r12686 n7971 n7972 0.00096707818930041151
r12687 n7956 n7973 2.2888999999999999
r12688 n7972 n7973 0.00096707818930041151
r12689 n7957 n7974 0.57222499999999998
r12690 n7973 n7974 0.0024176954732510287
r12691 n7958 n7975 0.45777999999999996
r12692 n7974 n7975 0.0043518518518518524
r12693 n7959 n7976 2.2888999999999999
r12694 n7975 n7976 0.0029012345679012342
r12695 n7960 n7977 0.45683999999999997
r12696 n7961 n7978 0.45683999999999997
r12697 n7977 n7978 0.0048353909465020575
r12698 n7962 n7979 2.2841999999999998
r12699 n7978 n7979 0.0029012345679012342
r12700 n7963 n7980 0.76139999999999997
r12701 n7979 n7980 0.001934156378600823
r12702 n7964 n7981 2.2841999999999998
r12703 n7980 n7981 0.001934156378600823
r12704 n7965 n7982 0.25379999999999997
r12705 n7981 n7982 0.0048353909465020575
r12706 n7966 n7983 0.22841999999999998
r12707 n7982 n7983 0.009187242798353909
r12708 n7967 n7984 0.45683999999999997
r12709 n7983 n7984 0.0072530864197530862
r12710 n7968 n7985 0.45683999999999997
r12711 n7984 n7985 0.0048353909465020575
r12712 n7969 n7986 2.2841999999999998
r12713 n7985 n7986 0.0029012345679012342
r12714 n7970 n7987 1.1420999999999999
r12715 n7986 n7987 0.0014506172839506171
r12716 n7971 n7988 2.2841999999999998
r12717 n7987 n7988 0.0014506172839506171
r12718 n7972 n7989 2.2841999999999998
r12719 n7988 n7989 0.00096707818930041151
r12720 n7973 n7990 2.2841999999999998
r12721 n7989 n7990 0.00096707818930041151
r12722 n7974 n7991 0.57104999999999995
r12723 n7990 n7991 0.0024176954732510287
r12724 n7975 n7992 0.45683999999999997
r12725 n7991 n7992 0.0043518518518518524
r12726 n7976 n7993 2.2841999999999998
r12727 n7992 n7993 0.0029012345679012342
r12728 n7977 n7994 0.45777999999999996
r12729 n7978 n7995 0.45777999999999996
r12730 n7994 n7995 0.0048155737704918032
r12731 n7979 n7996 2.2888999999999999
r12732 n7995 n7996 0.0028893442622950818
r12733 n7980 n7997 0.76296666666666668
r12734 n7996 n7997 0.0019262295081967213
r12735 n7981 n7998 2.2888999999999999
r12736 n7997 n7998 0.0019262295081967213
r12737 n7982 n7999 0.25432222222222223
r12738 n7998 n7999 0.0048155737704918032
r12739 n7983 n8000 0.22888999999999998
r12740 n7999 n8000 0.0091495901639344259
r12741 n7984 n8001 0.45777999999999996
r12742 n8000 n8001 0.0072233606557377044
r12743 n7985 n8002 0.45777999999999996
r12744 n8001 n8002 0.0048155737704918032
r12745 n7986 n8003 2.2888999999999999
r12746 n8002 n8003 0.0028893442622950818
r12747 n7987 n8004 1.14445
r12748 n8003 n8004 0.0014446721311475409
r12749 n7988 n8005 2.2888999999999999
r12750 n8004 n8005 0.0014446721311475409
r12751 n7989 n8006 2.2888999999999999
r12752 n8005 n8006 0.00096311475409836063
r12753 n7990 n8007 2.2888999999999999
r12754 n8006 n8007 0.00096311475409836063
r12755 n7991 n8008 0.57222499999999998
r12756 n8007 n8008 0.0024077868852459016
r12757 n7992 n8009 0.45777999999999996
r12758 n8008 n8009 0.0043340163934426235
r12759 n7993 n8010 2.2888999999999999
r12760 n8009 n8010 0.0028893442622950818
r12761 n7994 n8011 0.45777999999999996
r12762 n7995 n8012 0.45777999999999996
r12763 n8011 n8012 0.0048353909465020575
r12764 n7996 n8013 2.2888999999999999
r12765 n8012 n8013 0.0029012345679012342
r12766 n7997 n8014 0.76296666666666668
r12767 n8013 n8014 0.001934156378600823
r12768 n7998 n8015 2.2888999999999999
r12769 n8014 n8015 0.001934156378600823
r12770 n7999 n8016 0.25432222222222223
r12771 n8015 n8016 0.0048353909465020575
r12772 n8000 n8017 0.22888999999999998
r12773 n8016 n8017 0.009187242798353909
r12774 n8001 n8018 0.45777999999999996
r12775 n8017 n8018 0.0072530864197530862
r12776 n8002 n8019 0.45777999999999996
r12777 n8018 n8019 0.0048353909465020575
r12778 n8003 n8020 2.2888999999999999
r12779 n8019 n8020 0.0029012345679012342
r12780 n8004 n8021 1.14445
r12781 n8020 n8021 0.0014506172839506171
r12782 n8005 n8022 2.2888999999999999
r12783 n8021 n8022 0.0014506172839506171
r12784 n8006 n8023 2.2888999999999999
r12785 n8022 n8023 0.00096707818930041151
r12786 n8007 n8024 2.2888999999999999
r12787 n8023 n8024 0.00096707818930041151
r12788 n8008 n8025 0.57222499999999998
r12789 n8024 n8025 0.0024176954732510287
r12790 n8009 n8026 0.45777999999999996
r12791 n8025 n8026 0.0043518518518518524
r12792 n8010 n8027 2.2888999999999999
r12793 n8026 n8027 0.0029012345679012342
r12794 n8011 n8028 0.23782
r12795 n8012 n8029 0.23782
r12796 n8028 n8029 0.11750000000000001
r12797 n8013 n8030 1.1891
r12798 n8029 n8030 0.070499999999999993
r12799 n8014 n8031 0.39636666666666664
r12800 n8030 n8031 0.047
r12801 n8015 n8032 1.1891
r12802 n8031 n8032 0.047
r12803 n8016 n8033 0.13212222222222222
r12804 n8032 n8033 0.11750000000000001
r12805 n8017 n8034 0.11891
r12806 n8033 n8034 0.22325
r12807 n8018 n8035 0.23782
r12808 n8034 n8035 0.17624999999999999
r12809 n8019 n8036 0.23782
r12810 n8035 n8036 0.11750000000000001
r12811 n8020 n8037 1.1891
r12812 n8036 n8037 0.070499999999999993
r12813 n8021 n8038 0.59455000000000002
r12814 n8037 n8038 0.035249999999999997
r12815 n8022 n8039 1.1891
r12816 n8038 n8039 0.035249999999999997
r12817 n8023 n8040 1.1891
r12818 n8039 n8040 0.0235
r12819 n8024 n8041 1.1891
r12820 n8040 n8041 0.0235
r12821 n8025 n8042 0.29727500000000001
r12822 n8041 n8042 0.058750000000000004
r12823 n8026 n8043 0.23782
r12824 n8042 n8043 0.10575000000000001
r12825 n8027 n8044 1.1891
r12826 n8043 n8044 0.070499999999999993
r12827 n8028 n8045 0.061100000000000002
r12828 n8029 n8046 0.061100000000000002
r12829 n8045 n8046 0.021363636363636366
r12830 n8030 n8047 0.30549999999999999
r12831 n8046 n8047 0.012818181818181817
r12832 n8031 n8048 0.10183333333333335
r12833 n8047 n8048 0.0085454545454545453
r12834 n8032 n8049 0.30549999999999999
r12835 n8048 n8049 0.0085454545454545453
r12836 n8033 n8050 0.033944444444444444
r12837 n8049 n8050 0.021363636363636366
r12838 n8034 n8051 0.030550000000000001
r12839 n8050 n8051 0.040590909090909087
r12840 n8035 n8052 0.061100000000000002
r12841 n8051 n8052 0.032045454545454544
r12842 n8036 n8053 0.061100000000000002
r12843 n8052 n8053 0.021363636363636366
r12844 n8037 n8054 0.30549999999999999
r12845 n8053 n8054 0.012818181818181817
r12846 n8038 n8055 0.15275
r12847 n8054 n8055 0.0064090909090909086
r12848 n8039 n8056 0.30549999999999999
r12849 n8055 n8056 0.0064090909090909086
r12850 n8040 n8057 0.30549999999999999
r12851 n8056 n8057 0.0042727272727272727
r12852 n8041 n8058 0.30549999999999999
r12853 n8057 n8058 0.0042727272727272727
r12854 n8042 n8059 0.076374999999999998
r12855 n8058 n8059 0.010681818181818183
r12856 n8043 n8060 0.061100000000000002
r12857 n8059 n8060 0.019227272727272728
r12858 n8044 n8061 0.30549999999999999
r12859 n8060 n8061 0.012818181818181817
r12860 n8045 n8062 0.061100000000000002
r12861 n8046 n8063 0.061100000000000002
r12862 n8062 n8063 0.11750000000000001
r12863 n8047 n8064 0.30549999999999999
r12864 n8063 n8064 0.070499999999999993
r12865 n8048 n8065 0.10183333333333335
r12866 n8064 n8065 0.047
r12867 n8049 n8066 0.30549999999999999
r12868 n8065 n8066 0.047
r12869 n8050 n8067 0.033944444444444444
r12870 n8066 n8067 0.11750000000000001
r12871 n8051 n8068 0.030550000000000001
r12872 n8067 n8068 0.22325
r12873 n8052 n8069 0.061100000000000002
r12874 n8068 n8069 0.17624999999999999
r12875 n8053 n8070 0.061100000000000002
r12876 n8069 n8070 0.11750000000000001
r12877 n8054 n8071 0.30549999999999999
r12878 n8070 n8071 0.070499999999999993
r12879 n8055 n8072 0.15275
r12880 n8071 n8072 0.035249999999999997
r12881 n8056 n8073 0.30549999999999999
r12882 n8072 n8073 0.035249999999999997
r12883 n8057 n8074 0.30549999999999999
r12884 n8073 n8074 0.0235
r12885 n8058 n8075 0.30549999999999999
r12886 n8074 n8075 0.0235
r12887 n8059 n8076 0.076374999999999998
r12888 n8075 n8076 0.058750000000000004
r12889 n8060 n8077 0.061100000000000002
r12890 n8076 n8077 0.10575000000000001
r12891 n8061 n8078 0.30549999999999999
r12892 n8077 n8078 0.070499999999999993
r12893 n8062 n8079 0.15039999999999998
r12894 n8063 n8080 0.15039999999999998
r12895 n8079 n8080 0.0078333333333333328
r12896 n8064 n8081 0.752
r12897 n8080 n8081 0.0046999999999999993
r12898 n8065 n8082 0.25066666666666665
r12899 n8081 n8082 0.003133333333333333
r12900 n8066 n8083 0.752
r12901 n8082 n8083 0.003133333333333333
r12902 n8067 n8084 0.08355555555555555
r12903 n8083 n8084 0.0078333333333333328
r12904 n8068 n8085 0.075199999999999989
r12905 n8084 n8085 0.014883333333333333
r12906 n8069 n8086 0.15039999999999998
r12907 n8085 n8086 0.01175
r12908 n8070 n8087 0.15039999999999998
r12909 n8086 n8087 0.0078333333333333328
r12910 n8071 n8088 0.752
r12911 n8087 n8088 0.0046999999999999993
r12912 n8072 n8089 0.376
r12913 n8088 n8089 0.0023499999999999997
r12914 n8073 n8090 0.752
r12915 n8089 n8090 0.0023499999999999997
r12916 n8074 n8091 0.752
r12917 n8090 n8091 0.0015666666666666665
r12918 n8075 n8092 0.752
r12919 n8091 n8092 0.0015666666666666665
r12920 n8076 n8093 0.188
r12921 n8092 n8093 0.0039166666666666664
r12922 n8077 n8094 0.15039999999999998
r12923 n8093 n8094 0.0070500000000000007
r12924 n8078 n8095 0.752
r12925 n8094 n8095 0.0046999999999999993
r12926 n8079 n8096 0.15039999999999998
r12927 n8080 n8097 0.15039999999999998
r12928 n8096 n8097 0.11750000000000001
r12929 n8081 n8098 0.752
r12930 n8097 n8098 0.070499999999999993
r12931 n8082 n8099 0.25066666666666665
r12932 n8098 n8099 0.047
r12933 n8083 n8100 0.752
r12934 n8099 n8100 0.047
r12935 n8084 n8101 0.08355555555555555
r12936 n8100 n8101 0.11750000000000001
r12937 n8085 n8102 0.075199999999999989
r12938 n8101 n8102 0.22325
r12939 n8086 n8103 0.15039999999999998
r12940 n8102 n8103 0.17624999999999999
r12941 n8087 n8104 0.15039999999999998
r12942 n8103 n8104 0.11750000000000001
r12943 n8088 n8105 0.752
r12944 n8104 n8105 0.070499999999999993
r12945 n8089 n8106 0.376
r12946 n8105 n8106 0.035249999999999997
r12947 n8090 n8107 0.752
r12948 n8106 n8107 0.035249999999999997
r12949 n8091 n8108 0.752
r12950 n8107 n8108 0.0235
r12951 n8092 n8109 0.752
r12952 n8108 n8109 0.0235
r12953 n8093 n8110 0.188
r12954 n8109 n8110 0.058750000000000004
r12955 n8094 n8111 0.15039999999999998
r12956 n8110 n8111 0.10575000000000001
r12957 n8095 n8112 0.752
r12958 n8111 n8112 0.070499999999999993
r12959 n8096 n8113 0.061100000000000002
r12960 n8097 n8114 0.061100000000000002
r12961 n8113 n8114 0.021363636363636366
r12962 n8098 n8115 0.30549999999999999
r12963 n8114 n8115 0.012818181818181817
r12964 n8099 n8116 0.10183333333333335
r12965 n8115 n8116 0.0085454545454545453
r12966 n8100 n8117 0.30549999999999999
r12967 n8116 n8117 0.0085454545454545453
r12968 n8101 n8118 0.033944444444444444
r12969 n8117 n8118 0.021363636363636366
r12970 n8102 n8119 0.030550000000000001
r12971 n8118 n8119 0.040590909090909087
r12972 n8103 n8120 0.061100000000000002
r12973 n8119 n8120 0.032045454545454544
r12974 n8104 n8121 0.061100000000000002
r12975 n8120 n8121 0.021363636363636366
r12976 n8105 n8122 0.30549999999999999
r12977 n8121 n8122 0.012818181818181817
r12978 n8106 n8123 0.15275
r12979 n8122 n8123 0.0064090909090909086
r12980 n8107 n8124 0.30549999999999999
r12981 n8123 n8124 0.0064090909090909086
r12982 n8108 n8125 0.30549999999999999
r12983 n8124 n8125 0.0042727272727272727
r12984 n8109 n8126 0.30549999999999999
r12985 n8125 n8126 0.0042727272727272727
r12986 n8110 n8127 0.076374999999999998
r12987 n8126 n8127 0.010681818181818183
r12988 n8111 n8128 0.061100000000000002
r12989 n8127 n8128 0.019227272727272728
r12990 n8112 n8129 0.30549999999999999
r12991 n8128 n8129 0.012818181818181817
r12992 n8113 n8130 0.061100000000000002
r12993 n8114 n8131 0.061100000000000002
r12994 n8130 n8131 0.11750000000000001
r12995 n8115 n8132 0.30549999999999999
r12996 n8131 n8132 0.070499999999999993
r12997 n8116 n8133 0.10183333333333335
r12998 n8132 n8133 0.047
r12999 n8117 n8134 0.30549999999999999
r13000 n8133 n8134 0.047
r13001 n8118 n8135 0.033944444444444444
r13002 n8134 n8135 0.11750000000000001
r13003 n8119 n8136 0.030550000000000001
r13004 n8135 n8136 0.22325
r13005 n8120 n8137 0.061100000000000002
r13006 n8136 n8137 0.17624999999999999
r13007 n8121 n8138 0.061100000000000002
r13008 n8137 n8138 0.11750000000000001
r13009 n8122 n8139 0.30549999999999999
r13010 n8138 n8139 0.070499999999999993
r13011 n8123 n8140 0.15275
r13012 n8139 n8140 0.035249999999999997
r13013 n8124 n8141 0.30549999999999999
r13014 n8140 n8141 0.035249999999999997
r13015 n8125 n8142 0.30549999999999999
r13016 n8141 n8142 0.0235
r13017 n8126 n8143 0.30549999999999999
r13018 n8142 n8143 0.0235
r13019 n8127 n8144 0.076374999999999998
r13020 n8143 n8144 0.058750000000000004
r13021 n8128 n8145 0.061100000000000002
r13022 n8144 n8145 0.10575000000000001
r13023 n8129 n8146 0.30549999999999999
r13024 n8145 n8146 0.070499999999999993
r13025 n8130 n8147 0.16732
r13026 n8131 n8148 0.16732
r13027 n8147 n8148 0.0069940476190476194
r13028 n8132 n8149 0.83660000000000001
r13029 n8148 n8149 0.0041964285714285714
r13030 n8133 n8150 0.27886666666666665
r13031 n8149 n8150 0.0027976190476190475
r13032 n8134 n8151 0.83660000000000001
r13033 n8150 n8151 0.0027976190476190475
r13034 n8135 n8152 0.092955555555555555
r13035 n8151 n8152 0.0069940476190476194
r13036 n8136 n8153 0.083659999999999998
r13037 n8152 n8153 0.013288690476190477
r13038 n8137 n8154 0.16732
r13039 n8153 n8154 0.010491071428571428
r13040 n8138 n8155 0.16732
r13041 n8154 n8155 0.0069940476190476194
r13042 n8139 n8156 0.83660000000000001
r13043 n8155 n8156 0.0041964285714285714
r13044 n8140 n8157 0.41830000000000001
r13045 n8156 n8157 0.0020982142857142857
r13046 n8141 n8158 0.83660000000000001
r13047 n8157 n8158 0.0020982142857142857
r13048 n8142 n8159 0.83660000000000001
r13049 n8158 n8159 0.0013988095238095237
r13050 n8143 n8160 0.83660000000000001
r13051 n8159 n8160 0.0013988095238095237
r13052 n8144 n8161 0.20915
r13053 n8160 n8161 0.0034970238095238097
r13054 n8145 n8162 0.16732
r13055 n8161 n8162 0.006294642857142858
r13056 n8146 n8163 0.83660000000000001
r13057 n8162 n8163 0.0041964285714285714
r13058 n8147 n8164 0.31489999999999996
r13059 n8148 n8165 0.31489999999999996
r13060 n8164 n8165 0.0070359281437125751
r13061 n8149 n8166 1.5745
r13062 n8165 n8166 0.0042215568862275449
r13063 n8150 n8167 0.52483333333333326
r13064 n8166 n8167 0.0028143712574850298
r13065 n8151 n8168 1.5745
r13066 n8167 n8168 0.0028143712574850298
r13067 n8152 n8169 0.17494444444444443
r13068 n8168 n8169 0.0070359281437125751
r13069 n8153 n8170 0.15744999999999998
r13070 n8169 n8170 0.013368263473053891
r13071 n8154 n8171 0.31489999999999996
r13072 n8170 n8171 0.010553892215568862
r13073 n8155 n8172 0.31489999999999996
r13074 n8171 n8172 0.0070359281437125751
r13075 n8156 n8173 1.5745
r13076 n8172 n8173 0.0042215568862275449
r13077 n8157 n8174 0.78725000000000001
r13078 n8173 n8174 0.0021107784431137725
r13079 n8158 n8175 1.5745
r13080 n8174 n8175 0.0021107784431137725
r13081 n8159 n8176 1.5745
r13082 n8175 n8176 0.0014071856287425149
r13083 n8160 n8177 1.5745
r13084 n8176 n8177 0.0014071856287425149
r13085 n8161 n8178 0.393625
r13086 n8177 n8178 0.0035179640718562876
r13087 n8162 n8179 0.31489999999999996
r13088 n8178 n8179 0.0063323353293413178
r13089 n8163 n8180 1.5745
r13090 n8179 n8180 0.0042215568862275449
r13091 n8164 n8181 0.20867999999999998
r13092 n8165 n8182 0.20867999999999998
r13093 n8181 n8182 0.021363636363636366
r13094 n8166 n8183 1.0433999999999999
r13095 n8182 n8183 0.012818181818181817
r13096 n8167 n8184 0.3478
r13097 n8183 n8184 0.0085454545454545453
r13098 n8168 n8185 1.0433999999999999
r13099 n8184 n8185 0.0085454545454545453
r13100 n8169 n8186 0.11593333333333332
r13101 n8185 n8186 0.021363636363636366
r13102 n8170 n8187 0.10433999999999999
r13103 n8186 n8187 0.040590909090909087
r13104 n8171 n8188 0.20867999999999998
r13105 n8187 n8188 0.032045454545454544
r13106 n8172 n8189 0.20867999999999998
r13107 n8188 n8189 0.021363636363636366
r13108 n8173 n8190 1.0433999999999999
r13109 n8189 n8190 0.012818181818181817
r13110 n8174 n8191 0.52169999999999994
r13111 n8190 n8191 0.0064090909090909086
r13112 n8175 n8192 1.0433999999999999
r13113 n8191 n8192 0.0064090909090909086
r13114 n8176 n8193 1.0433999999999999
r13115 n8192 n8193 0.0042727272727272727
r13116 n8177 n8194 1.0433999999999999
r13117 n8193 n8194 0.0042727272727272727
r13118 n8178 n8195 0.26084999999999997
r13119 n8194 n8195 0.010681818181818183
r13120 n8179 n8196 0.20867999999999998
r13121 n8195 n8196 0.019227272727272728
r13122 n8180 n8197 1.0433999999999999
r13123 n8196 n8197 0.012818181818181817
r13124 n8181 n8198 0.098699999999999996
r13125 n8182 n8199 0.098699999999999996
r13126 n8198 n8199 0.0235
r13127 n8183 n8200 0.49349999999999994
r13128 n8199 n8200 0.0141
r13129 n8184 n8201 0.16449999999999998
r13130 n8200 n8201 0.0093999999999999986
r13131 n8185 n8202 0.49349999999999994
r13132 n8201 n8202 0.0093999999999999986
r13133 n8186 n8203 0.054833333333333331
r13134 n8202 n8203 0.0235
r13135 n8187 n8204 0.049349999999999998
r13136 n8203 n8204 0.044649999999999995
r13137 n8188 n8205 0.098699999999999996
r13138 n8204 n8205 0.035249999999999997
r13139 n8189 n8206 0.098699999999999996
r13140 n8205 n8206 0.0235
r13141 n8190 n8207 0.49349999999999994
r13142 n8206 n8207 0.0141
r13143 n8191 n8208 0.24674999999999997
r13144 n8207 n8208 0.0070499999999999998
r13145 n8192 n8209 0.49349999999999994
r13146 n8208 n8209 0.0070499999999999998
r13147 n8193 n8210 0.49349999999999994
r13148 n8209 n8210 0.0046999999999999993
r13149 n8194 n8211 0.49349999999999994
r13150 n8210 n8211 0.0046999999999999993
r13151 n8195 n8212 0.12337499999999998
r13152 n8211 n8212 0.01175
r13153 n8196 n8213 0.098699999999999996
r13154 n8212 n8213 0.021150000000000002
r13155 n8197 n8214 0.49349999999999994
r13156 n8213 n8214 0.0141
r13157 n8214 n8215 0.025849999999999998
r13158 n8215 n8216 0.030550000000000001
r13159 n8216 n8217 0.021150000000000002
r13160 n8217 n8218 0.018799999999999997
r13161 n8218 n8219 0.0070499999999999998
r13162 n8219 n8220 0.0046999999999999993
r13163 n8220 n8221 0.016449999999999999
r13164 n8221 n8222 0.025849999999999998
r13165 n8222 n8223 0.0141
r13166 n8223 n8224 0.01175
r13167 n8224 n8225 0.021150000000000002
r13168 n8225 n8226 0.018799999999999997
r13169 n8226 n8227 0.0235
r13170 n8198 n8228 0.056399999999999999
r13171 n8199 n8229 0.056399999999999999
r13172 n8228 n8229 0.11750000000000001
r13173 n8200 n8230 0.28199999999999997
r13174 n8229 n8230 0.070499999999999993
r13175 n8201 n8231 0.094
r13176 n8230 n8231 0.047
r13177 n8202 n8232 0.28199999999999997
r13178 n8231 n8232 0.047
r13179 n8203 n8233 0.031333333333333331
r13180 n8232 n8233 0.11750000000000001
r13181 n8204 n8234 0.028199999999999999
r13182 n8233 n8234 0.22325
r13183 n8205 n8235 0.056399999999999999
r13184 n8234 n8235 0.17624999999999999
r13185 n8206 n8236 0.056399999999999999
r13186 n8235 n8236 0.11750000000000001
r13187 n8207 n8237 0.28199999999999997
r13188 n8236 n8237 0.070499999999999993
r13189 n8208 n8238 0.14099999999999999
r13190 n8237 n8238 0.035249999999999997
r13191 n8209 n8239 0.28199999999999997
r13192 n8238 n8239 0.035249999999999997
r13193 n8210 n8240 0.28199999999999997
r13194 n8239 n8240 0.0235
r13195 n8211 n8241 0.28199999999999997
r13196 n8240 n8241 0.0235
r13197 n8212 n8242 0.070499999999999993
r13198 n8241 n8242 0.058750000000000004
r13199 n8213 n8243 0.056399999999999999
r13200 n8242 n8243 0.10575000000000001
r13201 n8214 n8244 0.28199999999999997
r13202 n8243 n8244 0.070499999999999993
r13203 n8215 n8245 0.028199999999999999
r13204 n8244 n8245 0.12925
r13205 n8216 n8246 0.094
r13206 n8245 n8246 0.15275
r13207 n8217 n8247 0.047
r13208 n8246 n8247 0.10575000000000001
r13209 n8218 n8248 0.14099999999999999
r13210 n8247 n8248 0.094
r13211 n8219 n8249 0.28199999999999997
r13212 n8248 n8249 0.035249999999999997
r13213 n8220 n8250 0.28199999999999997
r13214 n8249 n8250 0.0235
r13215 n8221 n8251 0.047
r13216 n8250 n8251 0.082250000000000004
r13217 n8222 n8252 0.056399999999999999
r13218 n8251 n8252 0.12925
r13219 n8223 n8253 0.28199999999999997
r13220 n8252 n8253 0.070499999999999993
r13221 n8224 n8254 0.070499999999999993
r13222 n8253 n8254 0.058750000000000004
r13223 n8225 n8255 0.056399999999999999
r13224 n8254 n8255 0.10575000000000001
r13225 n8226 n8256 0.094
r13226 n8255 n8256 0.094
r13227 n8227 n8257 0.040285714285714286
r13228 n8256 n8257 0.11750000000000001
r13229 n8228 n8258 0.0235
r13230 n8229 n8259 0.0235
r13231 n8258 n8259 0.078333333333333338
r13232 n8230 n8260 0.11750000000000001
r13233 n8259 n8260 0.047
r13234 n8231 n8261 0.039166666666666669
r13235 n8260 n8261 0.031333333333333331
r13236 n8232 n8262 0.11750000000000001
r13237 n8261 n8262 0.031333333333333331
r13238 n8233 n8263 0.013055555555555556
r13239 n8262 n8263 0.078333333333333338
r13240 n8234 n8264 0.01175
r13241 n8263 n8264 0.14883333333333332
r13242 n8235 n8265 0.0235
r13243 n8264 n8265 0.11749999999999999
r13244 n8236 n8266 0.0235
r13245 n8265 n8266 0.078333333333333338
r13246 n8237 n8267 0.11750000000000001
r13247 n8266 n8267 0.047
r13248 n8238 n8268 0.058750000000000004
r13249 n8267 n8268 0.0235
r13250 n8239 n8269 0.11750000000000001
r13251 n8268 n8269 0.0235
r13252 n8240 n8270 0.11750000000000001
r13253 n8269 n8270 0.015666666666666666
r13254 n8241 n8271 0.11750000000000001
r13255 n8270 n8271 0.015666666666666666
r13256 n8242 n8272 0.029375000000000002
r13257 n8271 n8272 0.039166666666666669
r13258 n8243 n8273 0.0235
r13259 n8272 n8273 0.070500000000000007
r13260 n8244 n8274 0.11750000000000001
r13261 n8273 n8274 0.047
r13262 n8245 n8275 0.01175
r13263 n8274 n8275 0.086166666666666669
r13264 n8246 n8276 0.039166666666666669
r13265 n8275 n8276 0.10183333333333335
r13266 n8247 n8277 0.019583333333333335
r13267 n8276 n8277 0.070500000000000007
r13268 n8248 n8278 0.058750000000000004
r13269 n8277 n8278 0.062666666666666662
r13270 n8249 n8279 0.11750000000000001
r13271 n8278 n8279 0.0235
r13272 n8250 n8280 0.11750000000000001
r13273 n8279 n8280 0.015666666666666666
r13274 n8251 n8281 0.019583333333333335
r13275 n8280 n8281 0.054833333333333331
r13276 n8252 n8282 0.0235
r13277 n8281 n8282 0.086166666666666669
r13278 n8253 n8283 0.11750000000000001
r13279 n8282 n8283 0.047
r13280 n8254 n8284 0.029375000000000002
r13281 n8283 n8284 0.039166666666666669
r13282 n8255 n8285 0.0235
r13283 n8284 n8285 0.070500000000000007
r13284 n8256 n8286 0.039166666666666669
r13285 n8285 n8286 0.062666666666666662
r13286 n8257 n8287 0.016785714285714286
r13287 n8286 n8287 0.078333333333333338
r13288 n8258 n8288 0.037599999999999995
r13289 n8259 n8289 0.037599999999999995
r13290 n8288 n8289 0.047
r13291 n8260 n8290 0.188
r13292 n8289 n8290 0.028199999999999999
r13293 n8261 n8291 0.062666666666666662
r13294 n8290 n8291 0.018799999999999997
r13295 n8262 n8292 0.188
r13296 n8291 n8292 0.018799999999999997
r13297 n8263 n8293 0.020888888888888887
r13298 n8292 n8293 0.047
r13299 n8264 n8294 0.018799999999999997
r13300 n8293 n8294 0.08929999999999999
r13301 n8265 n8295 0.037599999999999995
r13302 n8294 n8295 0.070499999999999993
r13303 n8266 n8296 0.037599999999999995
r13304 n8295 n8296 0.047
r13305 n8267 n8297 0.188
r13306 n8296 n8297 0.028199999999999999
r13307 n8268 n8298 0.094
r13308 n8297 n8298 0.0141
r13309 n8269 n8299 0.188
r13310 n8298 n8299 0.0141
r13311 n8270 n8300 0.188
r13312 n8299 n8300 0.0093999999999999986
r13313 n8271 n8301 0.188
r13314 n8300 n8301 0.0093999999999999986
r13315 n8272 n8302 0.047
r13316 n8301 n8302 0.0235
r13317 n8273 n8303 0.037599999999999995
r13318 n8302 n8303 0.042300000000000004
r13319 n8274 n8304 0.188
r13320 n8303 n8304 0.028199999999999999
r13321 n8275 n8305 0.018799999999999997
r13322 n8304 n8305 0.051699999999999996
r13323 n8276 n8306 0.062666666666666662
r13324 n8305 n8306 0.061100000000000002
r13325 n8277 n8307 0.031333333333333331
r13326 n8306 n8307 0.042300000000000004
r13327 n8278 n8308 0.094
r13328 n8307 n8308 0.037599999999999995
r13329 n8279 n8309 0.188
r13330 n8308 n8309 0.0141
r13331 n8280 n8310 0.188
r13332 n8309 n8310 0.0093999999999999986
r13333 n8281 n8311 0.031333333333333331
r13334 n8310 n8311 0.032899999999999999
r13335 n8282 n8312 0.037599999999999995
r13336 n8311 n8312 0.051699999999999996
r13337 n8283 n8313 0.188
r13338 n8312 n8313 0.028199999999999999
r13339 n8284 n8314 0.047
r13340 n8313 n8314 0.0235
r13341 n8285 n8315 0.037599999999999995
r13342 n8314 n8315 0.042300000000000004
r13343 n8286 n8316 0.062666666666666662
r13344 n8315 n8316 0.037599999999999995
r13345 n8287 n8317 0.026857142857142857
r13346 n8316 n8317 0.047
r13347 n8288 n8318 0.037599999999999995
r13348 n8289 n8319 0.037599999999999995
r13349 n8318 n8319 0.078333333333333338
r13350 n8290 n8320 0.188
r13351 n8319 n8320 0.047
r13352 n8291 n8321 0.062666666666666662
r13353 n8320 n8321 0.031333333333333331
r13354 n8292 n8322 0.188
r13355 n8321 n8322 0.031333333333333331
r13356 n8293 n8323 0.020888888888888887
r13357 n8322 n8323 0.078333333333333338
r13358 n8294 n8324 0.018799999999999997
r13359 n8323 n8324 0.14883333333333332
r13360 n8295 n8325 0.037599999999999995
r13361 n8324 n8325 0.11749999999999999
r13362 n8296 n8326 0.037599999999999995
r13363 n8325 n8326 0.078333333333333338
r13364 n8297 n8327 0.188
r13365 n8326 n8327 0.047
r13366 n8298 n8328 0.094
r13367 n8327 n8328 0.0235
r13368 n8299 n8329 0.188
r13369 n8328 n8329 0.0235
r13370 n8300 n8330 0.188
r13371 n8329 n8330 0.015666666666666666
r13372 n8301 n8331 0.188
r13373 n8330 n8331 0.015666666666666666
r13374 n8302 n8332 0.047
r13375 n8331 n8332 0.039166666666666669
r13376 n8303 n8333 0.037599999999999995
r13377 n8332 n8333 0.070500000000000007
r13378 n8304 n8334 0.188
r13379 n8333 n8334 0.047
r13380 n8305 n8335 0.018799999999999997
r13381 n8334 n8335 0.086166666666666669
r13382 n8306 n8336 0.062666666666666662
r13383 n8335 n8336 0.10183333333333335
r13384 n8307 n8337 0.031333333333333331
r13385 n8336 n8337 0.070500000000000007
r13386 n8308 n8338 0.094
r13387 n8337 n8338 0.062666666666666662
r13388 n8309 n8339 0.188
r13389 n8338 n8339 0.0235
r13390 n8310 n8340 0.188
r13391 n8339 n8340 0.015666666666666666
r13392 n8311 n8341 0.031333333333333331
r13393 n8340 n8341 0.054833333333333331
r13394 n8312 n8342 0.037599999999999995
r13395 n8341 n8342 0.086166666666666669
r13396 n8313 n8343 0.188
r13397 n8342 n8343 0.047
r13398 n8314 n8344 0.047
r13399 n8343 n8344 0.039166666666666669
r13400 n8315 n8345 0.037599999999999995
r13401 n8344 n8345 0.070500000000000007
r13402 n8316 n8346 0.062666666666666662
r13403 n8345 n8346 0.062666666666666662
r13404 n8317 n8347 0.026857142857142857
r13405 n8346 n8347 0.078333333333333338
r13406 n8318 n8348 0.0235
r13407 n8319 n8349 0.0235
r13408 n8348 n8349 0.11750000000000001
r13409 n8320 n8350 0.11750000000000001
r13410 n8349 n8350 0.070499999999999993
r13411 n8321 n8351 0.039166666666666669
r13412 n8350 n8351 0.047
r13413 n8322 n8352 0.11750000000000001
r13414 n8351 n8352 0.047
r13415 n8323 n8353 0.013055555555555556
r13416 n8352 n8353 0.11750000000000001
r13417 n8324 n8354 0.01175
r13418 n8353 n8354 0.22325
r13419 n8325 n8355 0.0235
r13420 n8354 n8355 0.17624999999999999
r13421 n8326 n8356 0.0235
r13422 n8355 n8356 0.11750000000000001
r13423 n8327 n8357 0.11750000000000001
r13424 n8356 n8357 0.070499999999999993
r13425 n8328 n8358 0.058750000000000004
r13426 n8357 n8358 0.035249999999999997
r13427 n8329 n8359 0.11750000000000001
r13428 n8358 n8359 0.035249999999999997
r13429 n8330 n8360 0.11750000000000001
r13430 n8359 n8360 0.0235
r13431 n8331 n8361 0.11750000000000001
r13432 n8360 n8361 0.0235
r13433 n8332 n8362 0.029375000000000002
r13434 n8361 n8362 0.058750000000000004
r13435 n8333 n8363 0.0235
r13436 n8362 n8363 0.10575000000000001
r13437 n8334 n8364 0.11750000000000001
r13438 n8363 n8364 0.070499999999999993
r13439 n8335 n8365 0.01175
r13440 n8364 n8365 0.12925
r13441 n8336 n8366 0.039166666666666669
r13442 n8365 n8366 0.15275
r13443 n8337 n8367 0.019583333333333335
r13444 n8366 n8367 0.10575000000000001
r13445 n8338 n8368 0.058750000000000004
r13446 n8367 n8368 0.094
r13447 n8339 n8369 0.11750000000000001
r13448 n8368 n8369 0.035249999999999997
r13449 n8340 n8370 0.11750000000000001
r13450 n8369 n8370 0.0235
r13451 n8341 n8371 0.019583333333333335
r13452 n8370 n8371 0.082250000000000004
r13453 n8342 n8372 0.0235
r13454 n8371 n8372 0.12925
r13455 n8343 n8373 0.11750000000000001
r13456 n8372 n8373 0.070499999999999993
r13457 n8344 n8374 0.029375000000000002
r13458 n8373 n8374 0.058750000000000004
r13459 n8345 n8375 0.0235
r13460 n8374 n8375 0.10575000000000001
r13461 n8346 n8376 0.039166666666666669
r13462 n8375 n8376 0.094
r13463 n8347 n8377 0.016785714285714286
r13464 n8376 n8377 0.11750000000000001
r13465 n8348 n8378 0.15039999999999998
r13466 n8349 n8379 0.15039999999999998
r13467 n8378 n8379 0.0078333333333333328
r13468 n8350 n8380 0.752
r13469 n8379 n8380 0.0046999999999999993
r13470 n8351 n8381 0.25066666666666665
r13471 n8380 n8381 0.003133333333333333
r13472 n8352 n8382 0.752
r13473 n8381 n8382 0.003133333333333333
r13474 n8353 n8383 0.08355555555555555
r13475 n8382 n8383 0.0078333333333333328
r13476 n8354 n8384 0.075199999999999989
r13477 n8383 n8384 0.014883333333333333
r13478 n8355 n8385 0.15039999999999998
r13479 n8384 n8385 0.01175
r13480 n8356 n8386 0.15039999999999998
r13481 n8385 n8386 0.0078333333333333328
r13482 n8357 n8387 0.752
r13483 n8386 n8387 0.0046999999999999993
r13484 n8358 n8388 0.376
r13485 n8387 n8388 0.0023499999999999997
r13486 n8359 n8389 0.752
r13487 n8388 n8389 0.0023499999999999997
r13488 n8360 n8390 0.752
r13489 n8389 n8390 0.0015666666666666665
r13490 n8361 n8391 0.752
r13491 n8390 n8391 0.0015666666666666665
r13492 n8362 n8392 0.188
r13493 n8391 n8392 0.0039166666666666664
r13494 n8363 n8393 0.15039999999999998
r13495 n8392 n8393 0.0070500000000000007
r13496 n8364 n8394 0.752
r13497 n8393 n8394 0.0046999999999999993
r13498 n8365 n8395 0.075199999999999989
r13499 n8394 n8395 0.0086166666666666666
r13500 n8366 n8396 0.25066666666666665
r13501 n8395 n8396 0.010183333333333334
r13502 n8367 n8397 0.12533333333333332
r13503 n8396 n8397 0.0070500000000000007
r13504 n8368 n8398 0.376
r13505 n8397 n8398 0.006266666666666666
r13506 n8369 n8399 0.752
r13507 n8398 n8399 0.0023499999999999997
r13508 n8370 n8400 0.752
r13509 n8399 n8400 0.0015666666666666665
r13510 n8371 n8401 0.12533333333333332
r13511 n8400 n8401 0.0054833333333333331
r13512 n8372 n8402 0.15039999999999998
r13513 n8401 n8402 0.0086166666666666666
r13514 n8373 n8403 0.752
r13515 n8402 n8403 0.0046999999999999993
r13516 n8374 n8404 0.188
r13517 n8403 n8404 0.0039166666666666664
r13518 n8375 n8405 0.15039999999999998
r13519 n8404 n8405 0.0070500000000000007
r13520 n8376 n8406 0.25066666666666665
r13521 n8405 n8406 0.006266666666666666
r13522 n8377 n8407 0.10742857142857143
r13523 n8406 n8407 0.0078333333333333328
r13524 n8378 n8408 0.15039999999999998
r13525 n8379 n8409 0.15039999999999998
r13526 n8408 n8409 0.11750000000000001
r13527 n8380 n8410 0.752
r13528 n8409 n8410 0.070499999999999993
r13529 n8381 n8411 0.25066666666666665
r13530 n8410 n8411 0.047
r13531 n8382 n8412 0.752
r13532 n8411 n8412 0.047
r13533 n8383 n8413 0.08355555555555555
r13534 n8412 n8413 0.11750000000000001
r13535 n8384 n8414 0.075199999999999989
r13536 n8413 n8414 0.22325
r13537 n8385 n8415 0.15039999999999998
r13538 n8414 n8415 0.17624999999999999
r13539 n8386 n8416 0.15039999999999998
r13540 n8415 n8416 0.11750000000000001
r13541 n8387 n8417 0.752
r13542 n8416 n8417 0.070499999999999993
r13543 n8388 n8418 0.376
r13544 n8417 n8418 0.035249999999999997
r13545 n8389 n8419 0.752
r13546 n8418 n8419 0.035249999999999997
r13547 n8390 n8420 0.752
r13548 n8419 n8420 0.0235
r13549 n8391 n8421 0.752
r13550 n8420 n8421 0.0235
r13551 n8392 n8422 0.188
r13552 n8421 n8422 0.058750000000000004
r13553 n8393 n8423 0.15039999999999998
r13554 n8422 n8423 0.10575000000000001
r13555 n8394 n8424 0.752
r13556 n8423 n8424 0.070499999999999993
r13557 n8395 n8425 0.075199999999999989
r13558 n8424 n8425 0.12925
r13559 n8396 n8426 0.25066666666666665
r13560 n8425 n8426 0.15275
r13561 n8397 n8427 0.12533333333333332
r13562 n8426 n8427 0.10575000000000001
r13563 n8398 n8428 0.376
r13564 n8427 n8428 0.094
r13565 n8399 n8429 0.752
r13566 n8428 n8429 0.035249999999999997
r13567 n8400 n8430 0.752
r13568 n8429 n8430 0.0235
r13569 n8401 n8431 0.12533333333333332
r13570 n8430 n8431 0.082250000000000004
r13571 n8402 n8432 0.15039999999999998
r13572 n8431 n8432 0.12925
r13573 n8403 n8433 0.752
r13574 n8432 n8433 0.070499999999999993
r13575 n8404 n8434 0.188
r13576 n8433 n8434 0.058750000000000004
r13577 n8405 n8435 0.15039999999999998
r13578 n8434 n8435 0.10575000000000001
r13579 n8406 n8436 0.25066666666666665
r13580 n8435 n8436 0.094
r13581 n8407 n8437 0.10742857142857143
r13582 n8436 n8437 0.11750000000000001
r13583 n8408 n8438 0.0235
r13584 n8409 n8439 0.0235
r13585 n8438 n8439 0.078333333333333338
r13586 n8410 n8440 0.11750000000000001
r13587 n8439 n8440 0.047
r13588 n8411 n8441 0.039166666666666669
r13589 n8440 n8441 0.031333333333333331
r13590 n8412 n8442 0.11750000000000001
r13591 n8441 n8442 0.031333333333333331
r13592 n8413 n8443 0.013055555555555556
r13593 n8442 n8443 0.078333333333333338
r13594 n8414 n8444 0.01175
r13595 n8443 n8444 0.14883333333333332
r13596 n8415 n8445 0.0235
r13597 n8444 n8445 0.11749999999999999
r13598 n8416 n8446 0.0235
r13599 n8445 n8446 0.078333333333333338
r13600 n8417 n8447 0.11750000000000001
r13601 n8446 n8447 0.047
r13602 n8418 n8448 0.058750000000000004
r13603 n8447 n8448 0.0235
r13604 n8419 n8449 0.11750000000000001
r13605 n8448 n8449 0.0235
r13606 n8420 n8450 0.11750000000000001
r13607 n8449 n8450 0.015666666666666666
r13608 n8421 n8451 0.11750000000000001
r13609 n8450 n8451 0.015666666666666666
r13610 n8422 n8452 0.029375000000000002
r13611 n8451 n8452 0.039166666666666669
r13612 n8423 n8453 0.0235
r13613 n8452 n8453 0.070500000000000007
r13614 n8424 n8454 0.11750000000000001
r13615 n8453 n8454 0.047
r13616 n8425 n8455 0.01175
r13617 n8454 n8455 0.086166666666666669
r13618 n8426 n8456 0.039166666666666669
r13619 n8455 n8456 0.10183333333333335
r13620 n8427 n8457 0.019583333333333335
r13621 n8456 n8457 0.070500000000000007
r13622 n8428 n8458 0.058750000000000004
r13623 n8457 n8458 0.062666666666666662
r13624 n8429 n8459 0.11750000000000001
r13625 n8458 n8459 0.0235
r13626 n8430 n8460 0.11750000000000001
r13627 n8459 n8460 0.015666666666666666
r13628 n8431 n8461 0.019583333333333335
r13629 n8460 n8461 0.054833333333333331
r13630 n8432 n8462 0.0235
r13631 n8461 n8462 0.086166666666666669
r13632 n8433 n8463 0.11750000000000001
r13633 n8462 n8463 0.047
r13634 n8434 n8464 0.029375000000000002
r13635 n8463 n8464 0.039166666666666669
r13636 n8435 n8465 0.0235
r13637 n8464 n8465 0.070500000000000007
r13638 n8436 n8466 0.039166666666666669
r13639 n8465 n8466 0.062666666666666662
r13640 n8437 n8467 0.016785714285714286
r13641 n8466 n8467 0.078333333333333338
r13642 n8438 n8468 0.037599999999999995
r13643 n8439 n8469 0.037599999999999995
r13644 n8468 n8469 0.047
r13645 n8440 n8470 0.188
r13646 n8469 n8470 0.028199999999999999
r13647 n8441 n8471 0.062666666666666662
r13648 n8470 n8471 0.018799999999999997
r13649 n8442 n8472 0.188
r13650 n8471 n8472 0.018799999999999997
r13651 n8443 n8473 0.020888888888888887
r13652 n8472 n8473 0.047
r13653 n8444 n8474 0.018799999999999997
r13654 n8473 n8474 0.08929999999999999
r13655 n8445 n8475 0.037599999999999995
r13656 n8474 n8475 0.070499999999999993
r13657 n8446 n8476 0.037599999999999995
r13658 n8475 n8476 0.047
r13659 n8447 n8477 0.188
r13660 n8476 n8477 0.028199999999999999
r13661 n8448 n8478 0.094
r13662 n8477 n8478 0.0141
r13663 n8449 n8479 0.188
r13664 n8478 n8479 0.0141
r13665 n8450 n8480 0.188
r13666 n8479 n8480 0.0093999999999999986
r13667 n8451 n8481 0.188
r13668 n8480 n8481 0.0093999999999999986
r13669 n8452 n8482 0.047
r13670 n8481 n8482 0.0235
r13671 n8453 n8483 0.037599999999999995
r13672 n8482 n8483 0.042300000000000004
r13673 n8454 n8484 0.188
r13674 n8483 n8484 0.028199999999999999
r13675 n8455 n8485 0.018799999999999997
r13676 n8484 n8485 0.051699999999999996
r13677 n8456 n8486 0.062666666666666662
r13678 n8485 n8486 0.061100000000000002
r13679 n8457 n8487 0.031333333333333331
r13680 n8486 n8487 0.042300000000000004
r13681 n8458 n8488 0.094
r13682 n8487 n8488 0.037599999999999995
r13683 n8459 n8489 0.188
r13684 n8488 n8489 0.0141
r13685 n8460 n8490 0.188
r13686 n8489 n8490 0.0093999999999999986
r13687 n8461 n8491 0.031333333333333331
r13688 n8490 n8491 0.032899999999999999
r13689 n8462 n8492 0.037599999999999995
r13690 n8491 n8492 0.051699999999999996
r13691 n8463 n8493 0.188
r13692 n8492 n8493 0.028199999999999999
r13693 n8464 n8494 0.047
r13694 n8493 n8494 0.0235
r13695 n8465 n8495 0.037599999999999995
r13696 n8494 n8495 0.042300000000000004
r13697 n8466 n8496 0.062666666666666662
r13698 n8495 n8496 0.037599999999999995
r13699 n8467 n8497 0.026857142857142857
r13700 n8496 n8497 0.047
r13701 n8468 n8498 0.037599999999999995
r13702 n8469 n8499 0.037599999999999995
r13703 n8498 n8499 0.078333333333333338
r13704 n8470 n8500 0.188
r13705 n8499 n8500 0.047
r13706 n8471 n8501 0.062666666666666662
r13707 n8500 n8501 0.031333333333333331
r13708 n8472 n8502 0.188
r13709 n8501 n8502 0.031333333333333331
r13710 n8473 n8503 0.020888888888888887
r13711 n8502 n8503 0.078333333333333338
r13712 n8474 n8504 0.018799999999999997
r13713 n8503 n8504 0.14883333333333332
r13714 n8475 n8505 0.037599999999999995
r13715 n8504 n8505 0.11749999999999999
r13716 n8476 n8506 0.037599999999999995
r13717 n8505 n8506 0.078333333333333338
r13718 n8477 n8507 0.188
r13719 n8506 n8507 0.047
r13720 n8478 n8508 0.094
r13721 n8507 n8508 0.0235
r13722 n8479 n8509 0.188
r13723 n8508 n8509 0.0235
r13724 n8480 n8510 0.188
r13725 n8509 n8510 0.015666666666666666
r13726 n8481 n8511 0.188
r13727 n8510 n8511 0.015666666666666666
r13728 n8482 n8512 0.047
r13729 n8511 n8512 0.039166666666666669
r13730 n8483 n8513 0.037599999999999995
r13731 n8512 n8513 0.070500000000000007
r13732 n8484 n8514 0.188
r13733 n8513 n8514 0.047
r13734 n8485 n8515 0.018799999999999997
r13735 n8514 n8515 0.086166666666666669
r13736 n8486 n8516 0.062666666666666662
r13737 n8515 n8516 0.10183333333333335
r13738 n8487 n8517 0.031333333333333331
r13739 n8516 n8517 0.070500000000000007
r13740 n8488 n8518 0.094
r13741 n8517 n8518 0.062666666666666662
r13742 n8489 n8519 0.188
r13743 n8518 n8519 0.0235
r13744 n8490 n8520 0.188
r13745 n8519 n8520 0.015666666666666666
r13746 n8491 n8521 0.031333333333333331
r13747 n8520 n8521 0.054833333333333331
r13748 n8492 n8522 0.037599999999999995
r13749 n8521 n8522 0.086166666666666669
r13750 n8493 n8523 0.188
r13751 n8522 n8523 0.047
r13752 n8494 n8524 0.047
r13753 n8523 n8524 0.039166666666666669
r13754 n8495 n8525 0.037599999999999995
r13755 n8524 n8525 0.070500000000000007
r13756 n8496 n8526 0.062666666666666662
r13757 n8525 n8526 0.062666666666666662
r13758 n8497 n8527 0.026857142857142857
r13759 n8526 n8527 0.078333333333333338
r13760 n8498 n8528 0.0235
r13761 n8499 n8529 0.0235
r13762 n8528 n8529 0.11750000000000001
r13763 n8500 n8530 0.11750000000000001
r13764 n8529 n8530 0.070499999999999993
r13765 n8501 n8531 0.039166666666666669
r13766 n8530 n8531 0.047
r13767 n8502 n8532 0.11750000000000001
r13768 n8531 n8532 0.047
r13769 n8503 n8533 0.013055555555555556
r13770 n8532 n8533 0.11750000000000001
r13771 n8504 n8534 0.01175
r13772 n8533 n8534 0.22325
r13773 n8505 n8535 0.0235
r13774 n8534 n8535 0.17624999999999999
r13775 n8506 n8536 0.0235
r13776 n8535 n8536 0.11750000000000001
r13777 n8507 n8537 0.11750000000000001
r13778 n8536 n8537 0.070499999999999993
r13779 n8508 n8538 0.058750000000000004
r13780 n8537 n8538 0.035249999999999997
r13781 n8509 n8539 0.11750000000000001
r13782 n8538 n8539 0.035249999999999997
r13783 n8510 n8540 0.11750000000000001
r13784 n8539 n8540 0.0235
r13785 n8511 n8541 0.11750000000000001
r13786 n8540 n8541 0.0235
r13787 n8512 n8542 0.029375000000000002
r13788 n8541 n8542 0.058750000000000004
r13789 n8513 n8543 0.0235
r13790 n8542 n8543 0.10575000000000001
r13791 n8514 n8544 0.11750000000000001
r13792 n8543 n8544 0.070499999999999993
r13793 n8515 n8545 0.01175
r13794 n8544 n8545 0.12925
r13795 n8516 n8546 0.039166666666666669
r13796 n8545 n8546 0.15275
r13797 n8517 n8547 0.019583333333333335
r13798 n8546 n8547 0.10575000000000001
r13799 n8518 n8548 0.058750000000000004
r13800 n8547 n8548 0.094
r13801 n8519 n8549 0.11750000000000001
r13802 n8548 n8549 0.035249999999999997
r13803 n8520 n8550 0.11750000000000001
r13804 n8549 n8550 0.0235
r13805 n8521 n8551 0.019583333333333335
r13806 n8550 n8551 0.082250000000000004
r13807 n8522 n8552 0.0235
r13808 n8551 n8552 0.12925
r13809 n8523 n8553 0.11750000000000001
r13810 n8552 n8553 0.070499999999999993
r13811 n8524 n8554 0.029375000000000002
r13812 n8553 n8554 0.058750000000000004
r13813 n8525 n8555 0.0235
r13814 n8554 n8555 0.10575000000000001
r13815 n8526 n8556 0.039166666666666669
r13816 n8555 n8556 0.094
r13817 n8527 n8557 0.016785714285714286
r13818 n8556 n8557 0.11750000000000001
r13819 n8535 n8558 0.056399999999999999
r13820 n8536 n8559 0.056399999999999999
r13821 n8558 n8559 0.0235
r13822 n8537 n8560 0.28199999999999997
r13823 n8559 n8560 0.0141
r13824 n8538 n8561 0.14099999999999999
r13825 n8560 n8561 0.0070499999999999998
r13826 n8539 n8562 0.28199999999999997
r13827 n8561 n8562 0.0070499999999999998
r13828 n8540 n8563 0.28199999999999997
r13829 n8562 n8563 0.0046999999999999993
r13830 n8541 n8564 0.28199999999999997
r13831 n8563 n8564 0.0046999999999999993
r13832 n8542 n8565 0.070499999999999993
r13833 n8564 n8565 0.01175
r13834 n8543 n8566 0.056399999999999999
r13835 n8565 n8566 0.021150000000000002
r13836 n8544 n8567 0.28199999999999997
r13837 n8566 n8567 0.0141
r13838 n8545 n8568 0.028199999999999999
r13839 n8567 n8568 0.025849999999999998
r13840 n8546 n8569 0.094
r13841 n8568 n8569 0.030550000000000001
r13842 n8547 n8570 0.047
r13843 n8569 n8570 0.021150000000000002
r13844 n8548 n8571 0.14099999999999999
r13845 n8570 n8571 0.018799999999999997
r13846 n8549 n8572 0.28199999999999997
r13847 n8571 n8572 0.0070499999999999998
r13848 n8550 n8573 0.28199999999999997
r13849 n8572 n8573 0.0046999999999999993
r13850 n8551 n8574 0.047
r13851 n8573 n8574 0.016449999999999999
r13852 n8552 n8575 0.056399999999999999
r13853 n8574 n8575 0.025849999999999998
r13854 n8553 n8576 0.28199999999999997
r13855 n8575 n8576 0.0141
r13856 n8554 n8577 0.070499999999999993
r13857 n8576 n8577 0.01175
r13858 n8555 n8578 0.056399999999999999
r13859 n8577 n8578 0.021150000000000002
r13860 n8556 n8579 0.094
r13861 n8578 n8579 0.018799999999999997
r13862 n8557 n8580 0.040285714285714286
r13863 n8579 n8580 0.0235
r13864 n8560 n8581 0.49349999999999994
r13865 n8561 n8582 0.24674999999999997
r13866 n8581 n8582 0.0064090909090909086
r13867 n8562 n8583 0.49349999999999994
r13868 n8582 n8583 0.0064090909090909086
r13869 n8563 n8584 0.49349999999999994
r13870 n8583 n8584 0.0042727272727272727
r13871 n8564 n8585 0.49349999999999994
r13872 n8584 n8585 0.0042727272727272727
r13873 n8565 n8586 0.12337499999999998
r13874 n8585 n8586 0.010681818181818183
r13875 n8566 n8587 0.098699999999999996
r13876 n8586 n8587 0.019227272727272728
r13877 n8567 n8588 0.49349999999999994
r13878 n8587 n8588 0.012818181818181817
r13879 n8568 n8589 0.049349999999999998
r13880 n8588 n8589 0.0235
r13881 n8569 n8590 0.16449999999999998
r13882 n8589 n8590 0.027772727272727275
r13883 n8570 n8591 0.08224999999999999
r13884 n8590 n8591 0.019227272727272728
r13885 n8571 n8592 0.24674999999999997
r13886 n8591 n8592 0.017090909090909091
r13887 n8572 n8593 0.49349999999999994
r13888 n8592 n8593 0.0064090909090909086
r13889 n8573 n8594 0.49349999999999994
r13890 n8593 n8594 0.0042727272727272727
r13891 n8574 n8595 0.08224999999999999
r13892 n8594 n8595 0.014954545454545455
r13893 n8575 n8596 0.098699999999999996
r13894 n8595 n8596 0.0235
r13895 n8576 n8597 0.49349999999999994
r13896 n8596 n8597 0.012818181818181817
r13897 n8577 n8598 0.12337499999999998
r13898 n8597 n8598 0.010681818181818183
r13899 n8578 n8599 0.098699999999999996
r13900 n8598 n8599 0.019227272727272728
r13901 n8581 n8600 1.1984999999999999
r13902 n8582 n8601 0.59924999999999995
r13903 n8600 n8601 0.0017625
r13904 n8583 n8602 1.1984999999999999
r13905 n8601 n8602 0.0017625
r13906 n8584 n8603 1.1984999999999999
r13907 n8602 n8603 0.0011749999999999998
r13908 n8585 n8604 1.1984999999999999
r13909 n8603 n8604 0.0011749999999999998
r13910 n8586 n8605 0.29962499999999997
r13911 n8604 n8605 0.0029375
r13912 n8587 n8606 0.2397
r13913 n8605 n8606 0.0052875000000000005
r13914 n8588 n8607 1.1984999999999999
r13915 n8606 n8607 0.0035249999999999999
r13916 n8589 n8608 0.11985
r13917 n8607 n8608 0.0064624999999999995
r13918 n8590 n8609 0.39949999999999997
r13919 n8608 n8609 0.0076375000000000002
r13920 n8591 n8610 0.19974999999999998
r13921 n8609 n8610 0.0052875000000000005
r13922 n8592 n8611 0.59924999999999995
r13923 n8610 n8611 0.0046999999999999993
r13924 n8593 n8612 1.1984999999999999
r13925 n8611 n8612 0.0017625
r13926 n8594 n8613 1.1984999999999999
r13927 n8612 n8613 0.0011749999999999998
r13928 n8595 n8614 0.19974999999999998
r13929 n8613 n8614 0.0041124999999999998
r13930 n8596 n8615 0.2397
r13931 n8614 n8615 0.0064624999999999995
r13932 n8597 n8616 1.1984999999999999
r13933 n8615 n8616 0.0035249999999999999
r13934 n8598 n8617 0.29962499999999997
r13935 n8616 n8617 0.0029375
r13936 n8599 n8618 0.2397
r13937 n8617 n8618 0.0052875000000000005
r13938 n8600 n8619 1.8800000000000001
r13939 n8601 n8620 0.94000000000000006
r13940 n8619 n8620 0.0017625
r13941 n8602 n8621 1.8800000000000001
r13942 n8620 n8621 0.0017625
r13943 n8603 n8622 1.8800000000000001
r13944 n8621 n8622 0.0011749999999999998
r13945 n8604 n8623 1.8800000000000001
r13946 n8622 n8623 0.0011749999999999998
r13947 n8605 n8624 0.47000000000000003
r13948 n8623 n8624 0.0029375
r13949 n8606 n8625 0.376
r13950 n8624 n8625 0.0052875000000000005
r13951 n8607 n8626 1.8800000000000001
r13952 n8625 n8626 0.0035249999999999999
r13953 n8608 n8627 0.188
r13954 n8626 n8627 0.0064624999999999995
r13955 n8609 n8628 0.62666666666666671
r13956 n8627 n8628 0.0076375000000000002
r13957 n8610 n8629 0.31333333333333335
r13958 n8628 n8629 0.0052875000000000005
r13959 n8611 n8630 0.94000000000000006
r13960 n8629 n8630 0.0046999999999999993
r13961 n8612 n8631 1.8800000000000001
r13962 n8630 n8631 0.0017625
r13963 n8613 n8632 1.8800000000000001
r13964 n8631 n8632 0.0011749999999999998
r13965 n8614 n8633 0.31333333333333335
r13966 n8632 n8633 0.0041124999999999998
r13967 n8615 n8634 0.376
r13968 n8633 n8634 0.0064624999999999995
r13969 n8616 n8635 1.8800000000000001
r13970 n8634 n8635 0.0035249999999999999
r13971 n8617 n8636 0.47000000000000003
r13972 n8635 n8636 0.0029375
r13973 n8618 n8637 0.376
r13974 n8636 n8637 0.0052875000000000005
r13975 n8619 n8638 1.7390000000000001
r13976 n8620 n8639 0.86950000000000005
r13977 n8638 n8639 0.0020735294117647058
r13978 n8621 n8640 1.7390000000000001
r13979 n8639 n8640 0.0020735294117647058
r13980 n8622 n8641 1.7390000000000001
r13981 n8640 n8641 0.0013823529411764704
r13982 n8623 n8642 1.7390000000000001
r13983 n8641 n8642 0.0013823529411764704
r13984 n8624 n8643 0.43475000000000003
r13985 n8642 n8643 0.0034558823529411767
r13986 n8625 n8644 0.3478
r13987 n8643 n8644 0.0062205882352941184
r13988 n8626 n8645 1.7390000000000001
r13989 n8644 n8645 0.0041470588235294117
r13990 n8627 n8646 0.1739
r13991 n8645 n8646 0.0076029411764705884
r13992 n8628 n8647 0.57966666666666666
r13993 n8646 n8647 0.0089852941176470601
r13994 n8629 n8648 0.28983333333333333
r13995 n8647 n8648 0.0062205882352941184
r13996 n8630 n8649 0.86950000000000005
r13997 n8648 n8649 0.0055294117647058817
r13998 n8631 n8650 1.7390000000000001
r13999 n8649 n8650 0.0020735294117647058
r14000 n8632 n8651 1.7390000000000001
r14001 n8650 n8651 0.0013823529411764704
r14002 n8633 n8652 0.28983333333333333
r14003 n8651 n8652 0.0048382352941176475
r14004 n8634 n8653 0.3478
r14005 n8652 n8653 0.0076029411764705884
r14006 n8635 n8654 1.7390000000000001
r14007 n8653 n8654 0.0041470588235294117
r14008 n8636 n8655 0.43475000000000003
r14009 n8654 n8655 0.0034558823529411767
r14010 n8637 n8656 0.3478
r14011 n8655 n8656 0.0062205882352941184
r14012 n8638 n8657 1.8283
r14013 n8639 n8658 0.91415000000000002
r14014 n8657 n8658 0.0016095890410958904
r14015 n8640 n8659 1.8283
r14016 n8658 n8659 0.0016095890410958904
r14017 n8641 n8660 1.8283
r14018 n8659 n8660 0.0010730593607305935
r14019 n8642 n8661 1.8283
r14020 n8660 n8661 0.0010730593607305935
r14021 n8643 n8662 0.45707500000000001
r14022 n8661 n8662 0.0026826484018264841
r14023 n8644 n8663 0.36566000000000004
r14024 n8662 n8663 0.004828767123287672
r14025 n8645 n8664 1.8283
r14026 n8663 n8664 0.0032191780821917808
r14027 n8646 n8665 0.18283000000000002
r14028 n8664 n8665 0.0059018264840182645
r14029 n8647 n8666 0.60943333333333338
r14030 n8665 n8666 0.0069748858447488587
r14031 n8648 n8667 0.30471666666666669
r14032 n8666 n8667 0.004828767123287672
r14033 n8649 n8668 0.91415000000000002
r14034 n8667 n8668 0.0042922374429223741
r14035 n8650 n8669 1.8283
r14036 n8668 n8669 0.0016095890410958904
r14037 n8651 n8670 1.8283
r14038 n8669 n8670 0.0010730593607305935
r14039 n8652 n8671 0.30471666666666669
r14040 n8670 n8671 0.0037557077625570779
r14041 n8653 n8672 0.36566000000000004
r14042 n8671 n8672 0.0059018264840182645
r14043 n8654 n8673 1.8283
r14044 n8672 n8673 0.0032191780821917808
r14045 n8655 n8674 0.45707500000000001
r14046 n8673 n8674 0.0026826484018264841
r14047 n8656 n8675 0.36566000000000004
r14048 n8674 n8675 0.004828767123287672
r14049 n8657 n8676 2.0539000000000001
r14050 n8658 n8677 1.02695
r14051 n8676 n8677 0.0016169724770642201
r14052 n8659 n8678 2.0539000000000001
r14053 n8677 n8678 0.0016169724770642201
r14054 n8660 n8679 2.0539000000000001
r14055 n8678 n8679 0.0010779816513761468
r14056 n8661 n8680 2.0539000000000001
r14057 n8679 n8680 0.0010779816513761468
r14058 n8662 n8681 0.51347500000000001
r14059 n8680 n8681 0.0026949541284403671
r14060 n8663 n8682 0.41078000000000003
r14061 n8681 n8682 0.0048509174311926612
r14062 n8664 n8683 2.0539000000000001
r14063 n8682 n8683 0.0032339449541284402
r14064 n8665 n8684 0.20539000000000002
r14065 n8683 n8684 0.0059288990825688073
r14066 n8666 n8685 0.68463333333333343
r14067 n8684 n8685 0.0070068807339449543
r14068 n8667 n8686 0.34231666666666671
r14069 n8685 n8686 0.0048509174311926612
r14070 n8668 n8687 1.02695
r14071 n8686 n8687 0.0043119266055045872
r14072 n8669 n8688 2.0539000000000001
r14073 n8687 n8688 0.0016169724770642201
r14074 n8670 n8689 2.0539000000000001
r14075 n8688 n8689 0.0010779816513761468
r14076 n8671 n8690 0.34231666666666671
r14077 n8689 n8690 0.0037729357798165137
r14078 n8672 n8691 0.41078000000000003
r14079 n8690 n8691 0.0059288990825688073
r14080 n8673 n8692 2.0539000000000001
r14081 n8691 n8692 0.0032339449541284402
r14082 n8674 n8693 0.51347500000000001
r14083 n8692 n8693 0.0026949541284403671
r14084 n8675 n8694 0.41078000000000003
r14085 n8693 n8694 0.0048509174311926612
r14086 n8676 n8695 2.0539000000000001
r14087 n8677 n8696 1.02695
r14088 n8695 n8696 0.0016095890410958904
r14089 n8678 n8697 2.0539000000000001
r14090 n8696 n8697 0.0016095890410958904
r14091 n8679 n8698 2.0539000000000001
r14092 n8697 n8698 0.0010730593607305935
r14093 n8680 n8699 2.0539000000000001
r14094 n8698 n8699 0.0010730593607305935
r14095 n8681 n8700 0.51347500000000001
r14096 n8699 n8700 0.0026826484018264841
r14097 n8682 n8701 0.41078000000000003
r14098 n8700 n8701 0.004828767123287672
r14099 n8683 n8702 2.0539000000000001
r14100 n8701 n8702 0.0032191780821917808
r14101 n8684 n8703 0.20539000000000002
r14102 n8702 n8703 0.0059018264840182645
r14103 n8685 n8704 0.68463333333333343
r14104 n8703 n8704 0.0069748858447488587
r14105 n8686 n8705 0.34231666666666671
r14106 n8704 n8705 0.004828767123287672
r14107 n8687 n8706 1.02695
r14108 n8705 n8706 0.0042922374429223741
r14109 n8688 n8707 2.0539000000000001
r14110 n8706 n8707 0.0016095890410958904
r14111 n8689 n8708 2.0539000000000001
r14112 n8707 n8708 0.0010730593607305935
r14113 n8690 n8709 0.34231666666666671
r14114 n8708 n8709 0.0037557077625570779
r14115 n8691 n8710 0.41078000000000003
r14116 n8709 n8710 0.0059018264840182645
r14117 n8692 n8711 2.0539000000000001
r14118 n8710 n8711 0.0032191780821917808
r14119 n8693 n8712 0.51347500000000001
r14120 n8711 n8712 0.0026826484018264841
r14121 n8694 n8713 0.41078000000000003
r14122 n8712 n8713 0.004828767123287672
r14123 n8695 n8714 2.0585999999999998
r14124 n8696 n8715 1.0292999999999999
r14125 n8714 n8715 0.0016095890410958904
r14126 n8697 n8716 2.0585999999999998
r14127 n8715 n8716 0.0016095890410958904
r14128 n8698 n8717 2.0585999999999998
r14129 n8716 n8717 0.0010730593607305935
r14130 n8699 n8718 2.0585999999999998
r14131 n8717 n8718 0.0010730593607305935
r14132 n8700 n8719 0.51464999999999994
r14133 n8718 n8719 0.0026826484018264841
r14134 n8701 n8720 0.41171999999999997
r14135 n8719 n8720 0.004828767123287672
r14136 n8702 n8721 2.0585999999999998
r14137 n8720 n8721 0.0032191780821917808
r14138 n8703 n8722 0.20585999999999999
r14139 n8721 n8722 0.0059018264840182645
r14140 n8704 n8723 0.68619999999999992
r14141 n8722 n8723 0.0069748858447488587
r14142 n8705 n8724 0.34309999999999996
r14143 n8723 n8724 0.004828767123287672
r14144 n8706 n8725 1.0292999999999999
r14145 n8724 n8725 0.0042922374429223741
r14146 n8707 n8726 2.0585999999999998
r14147 n8725 n8726 0.0016095890410958904
r14148 n8708 n8727 2.0585999999999998
r14149 n8726 n8727 0.0010730593607305935
r14150 n8709 n8728 0.34309999999999996
r14151 n8727 n8728 0.0037557077625570779
r14152 n8710 n8729 0.41171999999999997
r14153 n8728 n8729 0.0059018264840182645
r14154 n8711 n8730 2.0585999999999998
r14155 n8729 n8730 0.0032191780821917808
r14156 n8712 n8731 0.51464999999999994
r14157 n8730 n8731 0.0026826484018264841
r14158 n8713 n8732 0.41171999999999997
r14159 n8731 n8732 0.004828767123287672
r14160 n8714 out 1.8893999999999997
r14161 n8715 out 0.94469999999999987
r14162 n8716 out 1.8893999999999997
r14163 n8717 out 1.8893999999999997
r14164 n8718 out 1.8893999999999997
r14165 n8719 out 0.47234999999999994
r14166 n8720 out 0.37787999999999999
r14167 n8721 out 1.8893999999999997
r14168 n8722 out 0.18894
r14169 n8723 out 0.62979999999999992
r14170 n8724 out 0.31489999999999996
r14171 n8725 out 0.94469999999999987
r14172 n8726 out 1.8893999999999997
r14173 n8727 out 1.8893999999999997
r14174 n8728 out 0.31489999999999996
r14175 n8729 out 0.37787999999999999
r14176 n8730 out 1.8893999999999997
r14177 n8731 out 0.47234999999999994
r14178 n8732 out 0.37787999999999999
r14179 n12 0 158.10000000000002
r14180 n13 0 10.540000000000001
r14181 n14 0 158.10000000000002
r14182 n300 n2000 2687.7000000000003
r14183 n301 n2001 179.18000000000004
r14184 n302 n2002 2687.7000000000003
r14185 n309 n2014 179.18000000000004
r14186 n310 n2015 11.945333333333334
r14187 n311 n2016 179.18000000000004
r14188 n318 n2028 2687.7000000000003
r14189 n319 n2029 179.18000000000004
r14190 n320 n2030 2687.7000000000003
r14191 n583 n2288 413.49230769230769
r14192 n584 n2289 537.53999999999996
r14193 n585 n2290 1075.0799999999999
r14194 n586 n2291 1075.0799999999999
r14195 n587 n2292 5375.4000000000005
r14196 n620 n2319 51.686538461538461
r14197 n621 n2320 67.192499999999995
r14198 n622 n2321 134.38499999999999
r14199 n623 n2322 134.38499999999999
r14200 n624 n2323 671.92500000000007
r14201 n657 n2350 59.070329670329677
r14202 n658 n2351 76.791428571428582
r14203 n659 n2352 153.58285714285716
r14204 n660 n2353 153.58285714285716
r14205 n661 n2354 767.91428571428582
r14206 n694 n2381 413.49230769230769
r14207 n695 n2382 537.53999999999996
r14208 n696 n2383 1075.0799999999999
r14209 n697 n2384 1075.0799999999999
r14210 n698 n2385 5375.4000000000005
r14211 n851 n2790 413.49230769230769
r14212 n852 n2791 537.53999999999996
r14213 n853 n2792 1075.0799999999999
r14214 n854 n2793 1075.0799999999999
r14215 n855 n2794 5375.4000000000005
r14216 n888 n2821 55.132307692307698
r14217 n889 n2822 71.672000000000011
r14218 n890 n2823 143.34400000000002
r14219 n891 n2824 143.34400000000002
r14220 n892 n2825 716.72000000000014
r14221 n925 n2852 55.132307692307698
r14222 n926 n2853 71.672000000000011
r14223 n927 n2854 143.34400000000002
r14224 n928 n2855 143.34400000000002
r14225 n929 n2856 716.72000000000014
r14226 n962 n2883 413.49230769230769
r14227 n963 n2884 537.53999999999996
r14228 n964 n2885 1075.0799999999999
r14229 n965 n2886 1075.0799999999999
r14230 n966 n2887 5375.4000000000005
r14231 n366 n2111 5375.4000000000005
r14232 n367 n2112 5375.4000000000005
r14233 n368 n2113 5375.4000000000005
r14234 n369 n2114 1343.8500000000001
r14235 n370 n2115 1075.0799999999999
r14236 n371 n2116 5375.4000000000005
r14237 n372 n2117 537.53999999999996
r14238 n373 n2118 1791.8000000000002
r14239 n374 n2119 895.90000000000009
r14240 n375 n2120 2687.7000000000003
r14241 n434 n2133 358.36000000000007
r14242 n435 n2134 358.36000000000007
r14243 n436 n2135 358.36000000000007
r14244 n437 n2136 89.590000000000018
r14245 n438 n2137 71.672000000000011
r14246 n439 n2138 358.36000000000007
r14247 n440 n2139 35.836000000000006
r14248 n441 n2140 119.45333333333335
r14249 n442 n2141 59.726666666666674
r14250 n443 n2142 179.18000000000004
r14251 n502 n2155 5375.4000000000005
r14252 n503 n2156 5375.4000000000005
r14253 n504 n2157 5375.4000000000005
r14254 n505 n2158 1343.8500000000001
r14255 n506 n2159 1075.0799999999999
r14256 n507 n2160 5375.4000000000005
r14257 n508 n2161 537.53999999999996
r14258 n509 n2162 1791.8000000000002
r14259 n510 n2163 895.90000000000009
r14260 n511 n2164 2687.7000000000003
r14261 n598 n2303 5375.4000000000005
r14262 n599 n2304 1343.8500000000001
r14263 n600 n2305 1075.0799999999999
r14264 n601 n2306 5375.4000000000005
r14265 n602 n2307 537.53999999999996
r14266 n603 n2308 1791.8000000000002
r14267 n604 n2309 895.90000000000009
r14268 n605 n2310 2687.7000000000003
r14269 n606 n2311 5375.4000000000005
r14270 n607 n2312 5375.4000000000005
r14271 n635 n2334 671.92500000000007
r14272 n636 n2335 167.98125000000002
r14273 n637 n2336 134.38499999999999
r14274 n638 n2337 671.92500000000007
r14275 n639 n2338 67.192499999999995
r14276 n640 n2339 223.97500000000002
r14277 n641 n2340 111.98750000000001
r14278 n642 n2341 335.96250000000003
r14279 n643 n2342 671.92500000000007
r14280 n644 n2343 671.92500000000007
r14281 n672 n2365 767.91428571428582
r14282 n673 n2366 191.97857142857146
r14283 n674 n2367 153.58285714285716
r14284 n675 n2368 767.91428571428582
r14285 n676 n2369 76.791428571428582
r14286 n677 n2370 255.97142857142859
r14287 n678 n2371 127.98571428571429
r14288 n679 n2372 383.95714285714291
r14289 n680 n2373 767.91428571428582
r14290 n681 n2374 767.91428571428582
r14291 n709 n2396 5375.4000000000005
r14292 n710 n2397 1343.8500000000001
r14293 n711 n2398 1075.0799999999999
r14294 n712 n2399 5375.4000000000005
r14295 n713 n2400 537.53999999999996
r14296 n714 n2401 1791.8000000000002
r14297 n715 n2402 895.90000000000009
r14298 n716 n2403 2687.7000000000003
r14299 n717 n2404 5375.4000000000005
r14300 n718 n2405 5375.4000000000005
r14301 n866 n2805 5375.4000000000005
r14302 n867 n2806 1343.8500000000001
r14303 n868 n2807 1075.0799999999999
r14304 n869 n2808 5375.4000000000005
r14305 n870 n2809 537.53999999999996
r14306 n871 n2810 1791.8000000000002
r14307 n872 n2811 895.90000000000009
r14308 n873 n2812 2687.7000000000003
r14309 n874 n2813 5375.4000000000005
r14310 n875 n2814 5375.4000000000005
r14311 n903 n2836 716.72000000000014
r14312 n904 n2837 179.18000000000004
r14313 n905 n2838 143.34400000000002
r14314 n906 n2839 716.72000000000014
r14315 n907 n2840 71.672000000000011
r14316 n908 n2841 238.90666666666669
r14317 n909 n2842 119.45333333333335
r14318 n910 n2843 358.36000000000007
r14319 n911 n2844 716.72000000000014
r14320 n912 n2845 716.72000000000014
r14321 n940 n2867 716.72000000000014
r14322 n941 n2868 179.18000000000004
r14323 n942 n2869 143.34400000000002
r14324 n943 n2870 716.72000000000014
r14325 n944 n2871 71.672000000000011
r14326 n945 n2872 238.90666666666669
r14327 n946 n2873 119.45333333333335
r14328 n947 n2874 358.36000000000007
r14329 n948 n2875 716.72000000000014
r14330 n949 n2876 716.72000000000014
r14331 n977 n2898 5375.4000000000005
r14332 n978 n2899 1343.8500000000001
r14333 n979 n2900 1075.0799999999999
r14334 n980 n2901 5375.4000000000005
r14335 n981 n2902 537.53999999999996
r14336 n982 n2903 1791.8000000000002
r14337 n983 n2904 895.90000000000009
r14338 n984 n2905 2687.7000000000003
r14339 n985 n2906 5375.4000000000005
r14340 n986 n2907 5375.4000000000005
r14341 n779 n2605 2687.7000000000003
r14342 n780 n2606 316.20000000000005
r14343 n781 n2607 413.49230769230769
r14344 n782 n2608 2687.7000000000003
r14345 n787 n2618 191.97857142857146
r14346 n788 n2619 22.585714285714289
r14347 n789 n2620 29.535164835164839
r14348 n790 n2621 191.97857142857146
r14349 n795 n2631 2687.7000000000003
r14350 n796 n2632 316.20000000000005
r14351 n797 n2633 413.49230769230769
r14352 n798 n2634 2687.7000000000003
r14353 n803 n2644 2687.7000000000003
r14354 n804 n2645 316.20000000000005
r14355 n805 n2646 413.49230769230769
r14356 n806 n2647 2687.7000000000003
r14357 n1186 n3003 2687.7000000000003
r14358 n1187 n3004 179.18000000000004
r14359 n1188 n3005 2687.7000000000003
r14360 n1333 n3008 179.18000000000004
r14361 n1334 n3009 11.945333333333334
r14362 n1335 n3010 179.18000000000004
r14363 n1480 n3013 2687.7000000000003
r14364 n1481 n3014 179.18000000000004
r14365 n1482 n3015 2687.7000000000003
r14366 n2015 n3822 4.5
r14367 n2326 n4802 28.125
r14368 n2327 n4803 25.3125
r14369 n2328 n4804 50.625
r14370 n2329 n4805 50.625
r14371 n2330 n4806 253.125
r14372 n2357 n4863 32.142857142857139
r14373 n2358 n4864 28.928571428571427
r14374 n2359 n4865 57.857142857142854
r14375 n2360 n4866 57.857142857142854
r14376 n2361 n4867 289.28571428571428
r14377 n2828 n5697 30
r14378 n2829 n5698 27
r14379 n2830 n5699 54
r14380 n2831 n5700 54
r14381 n2832 n5701 270
r14382 n2859 n5730 30
r14383 n2860 n5731 27
r14384 n2861 n5732 54
r14385 n2862 n5733 54
r14386 n2863 n5734 270
r14387 n2135 n4258 135
r14388 n2136 n4259 33.75
r14389 n2137 n4260 27
r14390 n2138 n4261 135
r14391 n2139 n4262 13.5
r14392 n2140 n4263 45
r14393 n2141 n4264 22.5
r14394 t_r1_a n7068 135
r14395 t_r1_a n7069 13.5
r14396 t_r1_a n7070 45
r14397 t_r1_a n7071 22.5
r14398 t_r1_a n7072 67.5
r14399 t_r1_a n7073 135
r14400 t_r1_a n7074 135
r14401 t_r1_a n7075 22.5
r14402 n2619 n5340 8.5084033613445378
r14403 n2620 n5341 11.126373626373626
r14404 n2632 n5386 119.11764705882352
r14405 n2633 n5387 155.76923076923077
r14406 n3009 n6437 4.5
r14407 t_r1_b n7084 8.4375
r14408 t_r1_b n7085 9.6428571428571423
r14409 n2021 n3848 135
r14410 n2022 n3849 4.8214285714285712
r14411 n2023 n3850 135
r14412 n5628 n7688 1818.6666666666667
r14413 n5629 n7689 606.22222222222229
r14414 n5630 n7690 1818.6666666666667
r14415 n5631 n7691 202.07407407407408
r14416 n5632 n7692 181.86666666666667
r14417 n5633 n7693 363.73333333333335
r14418 n5634 n7694 363.73333333333335
r14419 n5635 n7695 1818.6666666666667
r14420 n5636 n7696 909.33333333333337
r14421 n5637 n7697 1818.6666666666667
r14422 n5638 n7698 1818.6666666666667
r14423 n5639 n7699 1818.6666666666667
r14424 n5661 n7707 2728
r14425 n5662 n7708 909.33333333333337
r14426 n5663 n7709 2728
r14427 n5664 n7710 303.11111111111114
r14428 n5665 n7711 272.80000000000001
r14429 n5666 n7712 545.60000000000002
r14430 n5667 n7713 545.60000000000002
r14431 n5668 n7714 2728
r14432 n5669 n7715 1364
r14433 n5670 n7716 2728
r14434 n5671 n7717 2728
r14435 n5672 n7718 2728
r14436 n5694 n7726 363.73333333333335
r14437 n5695 n7727 121.24444444444444
r14438 n5696 n7728 363.73333333333335
r14439 n5697 n7729 40.414814814814811
r14440 n5698 n7730 36.373333333333335
r14441 n5699 n7731 72.74666666666667
r14442 n5700 n7732 72.74666666666667
r14443 n5701 n7733 363.73333333333335
r14444 n5702 n7734 181.86666666666667
r14445 n5703 n7735 363.73333333333335
r14446 n5704 n7736 363.73333333333335
r14447 n5705 n7737 363.73333333333335
r14448 n5727 n7745 363.73333333333335
r14449 n5728 n7746 121.24444444444444
r14450 n5729 n7747 363.73333333333335
r14451 n5730 n7748 40.414814814814811
r14452 n5731 n7749 36.373333333333335
r14453 n5732 n7750 72.74666666666667
r14454 n5733 n7751 72.74666666666667
r14455 n5734 n7752 363.73333333333335
r14456 n5735 n7753 181.86666666666667
r14457 n5736 n7754 363.73333333333335
r14458 n5737 n7755 363.73333333333335
r14459 n5738 n7756 363.73333333333335
r14460 n5760 n7764 2728
r14461 n5761 n7765 909.33333333333337
r14462 n5762 n7766 2728
r14463 n5763 n7767 303.11111111111114
r14464 n5764 n7768 272.80000000000001
r14465 n5765 n7769 545.60000000000002
r14466 n5766 n7770 545.60000000000002
r14467 n5767 n7771 2728
r14468 n5768 n7772 1364
r14469 n5769 n7773 2728
r14470 n5770 n7774 2728
r14471 n5771 n7775 2728
r14472 n5793 n7783 1818.6666666666667
r14473 n5794 n7784 606.22222222222229
r14474 n5795 n7785 1818.6666666666667
r14475 n5796 n7786 202.07407407407408
r14476 n5797 n7787 181.86666666666667
r14477 n5798 n7788 363.73333333333335
r14478 n5799 n7789 363.73333333333335
r14479 n5800 n7790 1818.6666666666667
r14480 n5801 n7791 909.33333333333337
r14481 n5802 n7792 1818.6666666666667
r14482 n5803 n7793 1818.6666666666667
r14483 n5804 n7794 1818.6666666666667
r14484 n6953 n8333 363.73333333333335
r14485 n6954 n8334 1818.6666666666667
r14486 n6955 n8335 181.86666666666667
r14487 n6956 n8336 606.22222222222229
r14488 n6957 n8337 303.11111111111114
r14489 n6958 n8338 909.33333333333337
r14490 n6959 n8339 1818.6666666666667
r14491 n6960 n8340 1818.6666666666667
r14492 n6961 n8341 303.11111111111114
r14493 n6962 n8342 363.73333333333335
r14494 n7010 n8363 545.60000000000002
r14495 n7011 n8364 2728
r14496 n7012 n8365 272.80000000000001
r14497 n7013 n8366 909.33333333333337
r14498 n7014 n8367 454.66666666666669
r14499 n7015 n8368 1364
r14500 n7016 n8369 2728
r14501 n7017 n8370 2728
r14502 n7018 n8371 454.66666666666669
r14503 n7019 n8372 545.60000000000002
r14504 n7067 n8393 36.373333333333335
r14505 n7068 n8394 181.86666666666667
r14506 n7069 n8395 18.186666666666667
r14507 n7070 n8396 60.62222222222222
r14508 n7071 n8397 30.31111111111111
r14509 n7072 n8398 90.933333333333337
r14510 n7073 n8399 181.86666666666667
r14511 n7074 n8400 181.86666666666667
r14512 n7075 n8401 30.31111111111111
r14513 n7076 n8402 36.373333333333335
r14514 n7124 n8423 545.60000000000002
r14515 n7125 n8424 2728
r14516 n7126 n8425 272.80000000000001
r14517 n7127 n8426 909.33333333333337
r14518 n7128 n8427 454.66666666666669
r14519 n7129 n8428 1364
r14520 n7130 n8429 2728
r14521 n7131 n8430 2728
r14522 n7132 n8431 454.66666666666669
r14523 n7133 n8432 545.60000000000002
r14524 n7181 n8453 363.73333333333335
r14525 n7182 n8454 1818.6666666666667
r14526 n7183 n8455 181.86666666666667
r14527 n7184 n8456 606.22222222222229
r14528 n7185 n8457 303.11111111111114
r14529 n7186 n8458 909.33333333333337
r14530 n7187 n8459 1818.6666666666667
r14531 n7188 n8460 1818.6666666666667
r14532 n7189 n8461 303.11111111111114
r14533 n7190 n8462 363.73333333333335
r14534 n558 t_m1_b 585
r14535 n652 t_m1_b 1420.7142857142858
r14536 n689 t_m1_b 9945
r14537 n726 t_m1_b 4972.5
r14538 n730 t_m1_b 9945
r14539 n738 t_m1_b 19890
r14540 n746 t_m1_b 4972.5
r14541 n754 t_m1_b 9945
r14542 n762 t_m1_b 3978
r14543 n818 t_m1_b 4972.5
r14544 n826 t_m1_b 2841.4285714285716
r14545 n834 t_m1_b 6630
r14546 n842 t_m1_b 6630
r14547 n846 t_m1_b 9945
r14548 n883 t_m1_b 1326
r14549 n1010 t_m1_b 9945
r14550 n1014 t_m1_b 621.5625
r14551 n346 t_m1_b 10246.363636363636
r14552 n347 t_m1_b 338130
r14553 n414 t_m1_b 683.09090909090912
r14554 n415 t_m1_b 22542
r14555 n482 t_m1_b 10246.363636363636
r14556 n483 t_m1_b 338130
r14557 n1026 t_m1_b 602.72727272727275
r14558 n1027 t_m1_b 19890
r14559 n352 t_m1_b 338130
r14560 n353 t_m1_b 26010
r14561 n354 t_m1_b 33813
r14562 n355 t_m1_b 67626
r14563 n356 t_m1_b 67626
r14564 n420 t_m1_b 22542
r14565 n421 t_m1_b 1734
r14566 n422 t_m1_b 2254.2000000000003
r14567 n423 t_m1_b 4508.4000000000005
r14568 n424 t_m1_b 4508.4000000000005
r14569 n488 t_m1_b 338130
r14570 n489 t_m1_b 26010
r14571 n490 t_m1_b 33813
r14572 n491 t_m1_b 67626
r14573 n492 t_m1_b 67626
r14574 n1032 t_m1_b 19890
r14575 n1033 t_m1_b 1530
r14576 n1034 t_m1_b 1989
r14577 n1035 t_m1_b 3978
r14578 n1036 t_m1_b 3978
r14579 n583 t_m1_s 8225.3846153846152
r14580 n584 t_m1_s 10693
r14581 n585 t_m1_s 21386
r14582 n586 t_m1_s 21386
r14583 n587 t_m1_s 106930
r14584 n620 t_m1_s 1028.1730769230769
r14585 n621 t_m1_s 1336.625
r14586 n622 t_m1_s 2673.25
r14587 n623 t_m1_s 2673.25
r14588 n624 t_m1_s 13366.25
r14589 n657 t_m1_s 1175.0549450549452
r14590 n658 t_m1_s 1527.5714285714287
r14591 n659 t_m1_s 3055.1428571428573
r14592 n660 t_m1_s 3055.1428571428573
r14593 n661 t_m1_s 15275.714285714286
r14594 n694 t_m1_s 8225.3846153846152
r14595 n695 t_m1_s 10693
r14596 n696 t_m1_s 21386
r14597 n697 t_m1_s 21386
r14598 n698 t_m1_s 106930
r14599 n851 t_m1_d 8225.3846153846152
r14600 n852 t_m1_d 10693
r14601 n853 t_m1_d 21386
r14602 n854 t_m1_d 21386
r14603 n855 t_m1_d 106930
r14604 n888 t_m1_d 1096.7179487179487
r14605 n889 t_m1_d 1425.7333333333333
r14606 n890 t_m1_d 2851.4666666666667
r14607 n891 t_m1_d 2851.4666666666667
r14608 n892 t_m1_d 14257.333333333334
r14609 n925 t_m1_d 1096.7179487179487
r14610 n926 t_m1_d 1425.7333333333333
r14611 n927 t_m1_d 2851.4666666666667
r14612 n928 t_m1_d 2851.4666666666667
r14613 n929 t_m1_d 14257.333333333334
r14614 n962 t_m1_d 8225.3846153846152
r14615 n963 t_m1_d 10693
r14616 n964 t_m1_d 21386
r14617 n965 t_m1_d 21386
r14618 n966 t_m1_d 106930
r14619 n367 t_m1_b 338130
r14620 n368 t_m1_b 338130
r14621 n369 t_m1_b 84532.5
r14622 n370 t_m1_b 67626
r14623 n371 t_m1_b 338130
r14624 n372 t_m1_b 33813
r14625 n373 t_m1_b 112710
r14626 n374 t_m1_b 56355
r14627 n375 t_m1_b 169065
r14628 n376 t_m1_b 338130
r14629 n435 t_m1_b 22542
r14630 n436 t_m1_b 22542
r14631 n437 t_m1_b 5635.5
r14632 n438 t_m1_b 4508.4000000000005
r14633 n439 t_m1_b 22542
r14634 n440 t_m1_b 2254.2000000000003
r14635 n441 t_m1_b 7514
r14636 n442 t_m1_b 3757
r14637 n443 t_m1_b 11271
r14638 n444 t_m1_b 22542
r14639 n503 t_m1_b 338130
r14640 n504 t_m1_b 338130
r14641 n505 t_m1_b 84532.5
r14642 n506 t_m1_b 67626
r14643 n507 t_m1_b 338130
r14644 n508 t_m1_b 33813
r14645 n509 t_m1_b 112710
r14646 n510 t_m1_b 56355
r14647 n511 t_m1_b 169065
r14648 n512 t_m1_b 338130
r14649 n1047 t_m1_b 19890
r14650 n1048 t_m1_b 19890
r14651 n1049 t_m1_b 4972.5
r14652 n1050 t_m1_b 3978
r14653 n1051 t_m1_b 19890
r14654 n1052 t_m1_b 1989
r14655 n1053 t_m1_b 6630
r14656 n1054 t_m1_b 3315
r14657 n1055 t_m1_b 9945
r14658 n1056 t_m1_b 19890
r14659 n598 t_m1_s 106930
r14660 n599 t_m1_s 26732.5
r14661 n600 t_m1_s 21386
r14662 n601 t_m1_s 106930
r14663 n602 t_m1_s 10693
r14664 n603 t_m1_s 35643.333333333336
r14665 n604 t_m1_s 17821.666666666668
r14666 n605 t_m1_s 53465
r14667 n606 t_m1_s 106930
r14668 n607 t_m1_s 106930
r14669 n635 t_m1_s 13366.25
r14670 n636 t_m1_s 3341.5625
r14671 n637 t_m1_s 2673.25
r14672 n638 t_m1_s 13366.25
r14673 n639 t_m1_s 1336.625
r14674 n640 t_m1_s 4455.416666666667
r14675 n641 t_m1_s 2227.7083333333335
r14676 n642 t_m1_s 6683.125
r14677 n643 t_m1_s 13366.25
r14678 n644 t_m1_s 13366.25
r14679 n672 t_m1_s 15275.714285714286
r14680 n673 t_m1_s 3818.9285714285716
r14681 n674 t_m1_s 3055.1428571428573
r14682 n675 t_m1_s 15275.714285714286
r14683 n676 t_m1_s 1527.5714285714287
r14684 n677 t_m1_s 5091.9047619047615
r14685 n678 t_m1_s 2545.9523809523807
r14686 n679 t_m1_s 7637.8571428571431
r14687 n680 t_m1_s 15275.714285714286
r14688 n681 t_m1_s 15275.714285714286
r14689 n709 t_m1_s 106930
r14690 n710 t_m1_s 26732.5
r14691 n711 t_m1_s 21386
r14692 n712 t_m1_s 106930
r14693 n713 t_m1_s 10693
r14694 n714 t_m1_s 35643.333333333336
r14695 n715 t_m1_s 17821.666666666668
r14696 n716 t_m1_s 53465
r14697 n717 t_m1_s 106930
r14698 n718 t_m1_s 106930
r14699 n866 t_m1_d 106930
r14700 n867 t_m1_d 26732.5
r14701 n868 t_m1_d 21386
r14702 n869 t_m1_d 106930
r14703 n870 t_m1_d 10693
r14704 n871 t_m1_d 35643.333333333336
r14705 n872 t_m1_d 17821.666666666668
r14706 n873 t_m1_d 53465
r14707 n874 t_m1_d 106930
r14708 n875 t_m1_d 106930
r14709 n903 t_m1_d 14257.333333333334
r14710 n904 t_m1_d 3564.3333333333335
r14711 n905 t_m1_d 2851.4666666666667
r14712 n906 t_m1_d 14257.333333333334
r14713 n907 t_m1_d 1425.7333333333333
r14714 n908 t_m1_d 4752.4444444444443
r14715 n909 t_m1_d 2376.2222222222222
r14716 n910 t_m1_d 7128.666666666667
r14717 n911 t_m1_d 14257.333333333334
r14718 n912 t_m1_d 14257.333333333334
r14719 n940 t_m1_d 14257.333333333334
r14720 n941 t_m1_d 3564.3333333333335
r14721 n942 t_m1_d 2851.4666666666667
r14722 n943 t_m1_d 14257.333333333334
r14723 n944 t_m1_d 1425.7333333333333
r14724 n945 t_m1_d 4752.4444444444443
r14725 n946 t_m1_d 2376.2222222222222
r14726 n947 t_m1_d 7128.666666666667
r14727 n948 t_m1_d 14257.333333333334
r14728 n949 t_m1_d 14257.333333333334
r14729 n977 t_m1_d 106930
r14730 n978 t_m1_d 26732.5
r14731 n979 t_m1_d 21386
r14732 n980 t_m1_d 106930
r14733 n981 t_m1_d 10693
r14734 n982 t_m1_d 35643.333333333336
r14735 n983 t_m1_d 17821.666666666668
r14736 n984 t_m1_d 53465
r14737 n985 t_m1_d 106930
r14738 n986 t_m1_d 106930
r14739 n386 t_m1_b 33813
r14740 n387 t_m1_b 84532.5
r14741 n388 t_m1_b 48304.285714285717
r14742 n389 t_m1_b 37570
r14743 n390 t_m1_b 84532.5
r14744 n454 t_m1_b 2254.2000000000003
r14745 n455 t_m1_b 5635.5
r14746 n456 t_m1_b 3220.2857142857142
r14747 n457 t_m1_b 2504.6666666666665
r14748 n458 t_m1_b 5635.5
r14749 n522 t_m1_b 33813
r14750 n523 t_m1_b 84532.5
r14751 n524 t_m1_b 48304.285714285717
r14752 n525 t_m1_b 37570
r14753 n526 t_m1_b 84532.5
r14754 n1066 t_m1_b 1989
r14755 n1067 t_m1_b 4972.5
r14756 n1068 t_m1_b 2841.4285714285716
r14757 n1069 t_m1_b 2210
r14758 n1070 t_m1_b 4972.5
r14759 n779 t_m1_g 43928
r14760 n780 t_m1_g 5168
r14761 n781 t_m1_g 6758.1538461538457
r14762 n782 t_m1_g 43928
r14763 n787 t_m1_g 3137.7142857142858
r14764 n788 t_m1_g 369.14285714285717
r14765 n789 t_m1_g 482.72527472527474
r14766 n790 t_m1_g 3137.7142857142858
r14767 n795 t_m1_g 43928
r14768 n796 t_m1_g 5168
r14769 n797 t_m1_g 6758.1538461538457
r14770 n798 t_m1_g 43928
r14771 n803 t_m1_g 43928
r14772 n804 t_m1_g 5168
r14773 n805 t_m1_g 6758.1538461538457
r14774 n806 t_m1_g 43928
r14775 n396 t_m1_b 26010
r14776 n397 t_m1_b 169065
r14777 n398 t_m1_b 169065
r14778 n399 t_m1_b 84532.5
r14779 n400 t_m1_b 67626
r14780 n401 t_m1_b 42266.25
r14781 n464 t_m1_b 1734
r14782 n465 t_m1_b 11271
r14783 n466 t_m1_b 11271
r14784 n467 t_m1_b 5635.5
r14785 n468 t_m1_b 4508.4000000000005
r14786 n469 t_m1_b 2817.75
r14787 n532 t_m1_b 26010
r14788 n533 t_m1_b 169065
r14789 n534 t_m1_b 169065
r14790 n535 t_m1_b 84532.5
r14791 n536 t_m1_b 67626
r14792 n537 t_m1_b 42266.25
r14793 n1076 t_m1_b 1530
r14794 n1077 t_m1_b 9945
r14795 n1078 t_m1_b 9945
r14796 n1079 t_m1_b 4972.5
r14797 n1080 t_m1_b 3978
r14798 n1081 t_m1_b 2486.25
r14799 n559 t_m1_b 3978
r14800 n560 t_m1_b 736.66666666666674
r14801 n561 t_m1_b 9945
r14802 n686 t_m1_b 9660.8571428571431
r14803 n687 t_m1_b 1789.047619047619
r14804 n688 t_m1_b 24152.142857142859
r14805 n723 t_m1_b 67626
r14806 n724 t_m1_b 12523.333333333334
r14807 n725 t_m1_b 169065
r14808 n727 t_m1_b 33813
r14809 n728 t_m1_b 6261.666666666667
r14810 n729 t_m1_b 84532.5
r14811 n735 t_m1_b 67626
r14812 n736 t_m1_b 12523.333333333334
r14813 n737 t_m1_b 169065
r14814 n743 t_m1_b 135252
r14815 n744 t_m1_b 25046.666666666668
r14816 n745 t_m1_b 338130
r14817 n751 t_m1_b 33813
r14818 n752 t_m1_b 6261.666666666667
r14819 n753 t_m1_b 84532.5
r14820 n759 t_m1_b 67626
r14821 n760 t_m1_b 12523.333333333334
r14822 n761 t_m1_b 169065
r14823 n767 t_m1_b 27050.400000000001
r14824 n768 t_m1_b 5009.333333333333
r14825 n769 t_m1_b 67626
r14826 n823 t_m1_b 33813
r14827 n824 t_m1_b 6261.666666666667
r14828 n825 t_m1_b 84532.5
r14829 n831 t_m1_b 19321.714285714286
r14830 n832 t_m1_b 3578.0952380952381
r14831 n833 t_m1_b 48304.285714285717
r14832 n839 t_m1_b 45084
r14833 n840 t_m1_b 8348.8888888888887
r14834 n841 t_m1_b 112710
r14835 n843 t_m1_b 45084
r14836 n844 t_m1_b 8348.8888888888887
r14837 n845 t_m1_b 112710
r14838 n880 t_m1_b 67626
r14839 n881 t_m1_b 12523.333333333334
r14840 n882 t_m1_b 169065
r14841 n917 t_m1_b 9016.8000000000011
r14842 n918 t_m1_b 1669.7777777777778
r14843 n919 t_m1_b 22542
r14844 n1011 t_m1_b 67626
r14845 n1012 t_m1_b 12523.333333333334
r14846 n1013 t_m1_b 169065
r14847 n1015 t_m1_b 4226.625
r14848 n1016 t_m1_b 782.70833333333337
r14849 n1017 t_m1_b 10566.5625
r14850 n1543 t_r1_w 1808.181818181818
r14851 n1546 t_r1_w 1989
r14852 n1549 t_r1_w 9945
r14853 n1552 t_r1_w 6630
r14854 n1555 t_r1_w 3978
r14855 n1558 t_r1_w 6630
r14856 n1570 t_r1_w 6630
r14857 n1573 t_r1_w 3978
r14858 n1576 t_r1_w 6630
r14859 n1579 t_r1_w 9945
r14860 n1582 t_r1_w 1989
r14861 n1585 t_r1_w 1808.181818181818
r14862 n1096 t_r1_w 338130
r14863 n1097 t_r1_w 10246.363636363636
r14864 n1243 t_r1_w 22542
r14865 n1244 t_r1_w 683.09090909090912
r14866 n1390 t_r1_w 338130
r14867 n1391 t_r1_w 10246.363636363636
r14868 n1600 t_r1_w 19890
r14869 n1601 t_r1_w 602.72727272727275
r14870 n1102 t_r1_w 67626
r14871 n1103 t_r1_w 338130
r14872 n1104 t_r1_w 26010
r14873 n1105 t_r1_w 33813
r14874 n1106 t_r1_w 67626
r14875 n1249 t_r1_w 4508.4000000000005
r14876 n1250 t_r1_w 22542
r14877 n1251 t_r1_w 1734
r14878 n1252 t_r1_w 2254.2000000000003
r14879 n1253 t_r1_w 4508.4000000000005
r14880 n1396 t_r1_w 67626
r14881 n1397 t_r1_w 338130
r14882 n1398 t_r1_w 26010
r14883 n1399 t_r1_w 33813
r14884 n1400 t_r1_w 67626
r14885 n1606 t_r1_w 3978
r14886 n1607 t_r1_w 19890
r14887 n1608 t_r1_w 1530
r14888 n1609 t_r1_w 1989
r14889 n1610 t_r1_w 3978
r14890 n1114 t_r1_w 67626
r14891 n1115 t_r1_w 338130
r14892 n1116 t_r1_w 169065
r14893 n1117 t_r1_w 338130
r14894 n1118 t_r1_w 338130
r14895 n1119 t_r1_w 338130
r14896 n1120 t_r1_w 84532.5
r14897 n1121 t_r1_w 67626
r14898 n1122 t_r1_w 338130
r14899 n1123 t_r1_w 33813
r14900 n1124 t_r1_w 112710
r14901 n1261 t_r1_w 4508.4000000000005
r14902 n1262 t_r1_w 22542
r14903 n1263 t_r1_w 11271
r14904 n1264 t_r1_w 22542
r14905 n1265 t_r1_w 22542
r14906 n1266 t_r1_w 22542
r14907 n1267 t_r1_w 5635.5
r14908 n1268 t_r1_w 4508.4000000000005
r14909 n1269 t_r1_w 22542
r14910 n1270 t_r1_w 2254.2000000000003
r14911 n1271 t_r1_w 7514
r14912 n1408 t_r1_w 67626
r14913 n1409 t_r1_w 338130
r14914 n1410 t_r1_w 169065
r14915 n1411 t_r1_w 338130
r14916 n1412 t_r1_w 338130
r14917 n1413 t_r1_w 338130
r14918 n1414 t_r1_w 84532.5
r14919 n1415 t_r1_w 67626
r14920 n1416 t_r1_w 338130
r14921 n1417 t_r1_w 33813
r14922 n1418 t_r1_w 112710
r14923 n1618 t_r1_w 3978
r14924 n1619 t_r1_w 19890
r14925 n1620 t_r1_w 9945
r14926 n1621 t_r1_w 19890
r14927 n1622 t_r1_w 19890
r14928 n1623 t_r1_w 19890
r14929 n1624 t_r1_w 4972.5
r14930 n1625 t_r1_w 3978
r14931 n1626 t_r1_w 19890
r14932 n1627 t_r1_w 1989
r14933 n1628 t_r1_w 6630
r14934 n1135 t_r1_w 48304.285714285717
r14935 n1136 t_r1_w 56355
r14936 n1137 t_r1_w 33813
r14937 n1138 t_r1_w 84532.5
r14938 n1139 t_r1_w 48304.285714285717
r14939 n1282 t_r1_w 3220.2857142857142
r14940 n1283 t_r1_w 3757
r14941 n1284 t_r1_w 2254.2000000000003
r14942 n1285 t_r1_w 5635.5
r14943 n1286 t_r1_w 3220.2857142857142
r14944 n1429 t_r1_w 48304.285714285717
r14945 n1430 t_r1_w 56355
r14946 n1431 t_r1_w 33813
r14947 n1432 t_r1_w 84532.5
r14948 n1433 t_r1_w 48304.285714285717
r14949 n1639 t_r1_w 2841.4285714285716
r14950 n1640 t_r1_w 3315
r14951 n1641 t_r1_w 1989
r14952 n1642 t_r1_w 4972.5
r14953 n1643 t_r1_w 2841.4285714285716
r14954 n1146 t_r1_w 19890
r14955 n1147 t_r1_w 26010
r14956 n1148 t_r1_w 169065
r14957 n1149 t_r1_w 169065
r14958 n1293 t_r1_w 1326
r14959 n1294 t_r1_w 1734
r14960 n1295 t_r1_w 11271
r14961 n1296 t_r1_w 11271
r14962 n1440 t_r1_w 19890
r14963 n1441 t_r1_w 26010
r14964 n1442 t_r1_w 169065
r14965 n1443 t_r1_w 169065
r14966 n1650 t_r1_w 1170
r14967 n1651 t_r1_w 1530
r14968 n1652 t_r1_w 9945
r14969 n1653 t_r1_w 9945
r14970 n1155 t_r1_w 48304.285714285717
r14971 n1156 t_r1_w 12523.333333333334
r14972 n1302 t_r1_w 3220.2857142857142
r14973 n1303 t_r1_w 834.88888888888891
r14974 n1449 t_r1_w 48304.285714285717
r14975 n1450 t_r1_w 12523.333333333334
r14976 n1659 t_r1_w 2841.4285714285716
r14977 n1660 t_r1_w 736.66666666666674
r14978 n1160 t_r1_w 169065
r14979 n1161 t_r1_w 10566.5625
r14980 n1307 t_r1_w 11271
r14981 n1308 t_r1_w 704.4375
r14982 n1454 t_r1_w 169065
r14983 n1455 t_r1_w 10566.5625
r14984 n1664 t_r1_w 9945
r14985 n1665 t_r1_w 621.5625
r14986 n1163 t_r1_w 9945
r14987 n1310 t_r1_w 663
r14988 n1457 t_r1_w 9945
r14989 n1667 t_r1_w 585
r14990 n1165 t_r1_w 9945
r14991 n1312 t_r1_w 663
r14992 n1459 t_r1_w 9945
r14993 n1669 t_r1_w 585
r14994 n1167 t_r1_w 9945
r14995 n1314 t_r1_w 663
r14996 n1461 t_r1_w 9945
r14997 n1671 t_r1_w 585
r14998 n1169 t_r1_w 9945
r14999 n1316 t_r1_w 663
r15000 n1463 t_r1_w 9945
r15001 n1673 t_r1_w 585
r15002 n1171 t_r1_w 9945
r15003 n1318 t_r1_w 663
r15004 n1465 t_r1_w 9945
r15005 n1675 t_r1_w 585
r15006 n1173 t_r1_w 9945
r15007 n1320 t_r1_w 663
r15008 n1467 t_r1_w 9945
r15009 n1677 t_r1_w 585
r15010 n1175 t_r1_w 9945
r15011 n1322 t_r1_w 663
r15012 n1469 t_r1_w 9945
r15013 n1679 t_r1_w 585
r15014 n1177 t_r1_w 9945
r15015 n1324 t_r1_w 663
r15016 n1471 t_r1_w 9945
r15017 n1681 t_r1_w 585
r15018 n1179 t_r1_w 9945
r15019 n1326 t_r1_w 663
r15020 n1473 t_r1_w 9945
r15021 n1683 t_r1_w 585
r15022 n1181 t_r1_w 9945
r15023 n1328 t_r1_w 663
r15024 n1475 t_r1_w 9945
r15025 n1685 t_r1_w 585
r15026 n1183 t_r1_w 9945
r15027 n1330 t_r1_w 663
r15028 n1477 t_r1_w 9945
r15029 n1687 t_r1_w 585
r15030 n1186 t_r1_w 169065
r15031 n1187 t_r1_w 11271
r15032 n1188 t_r1_w 169065
r15033 n1333 t_r1_w 11271
r15034 n1334 t_r1_w 751.39999999999998
r15035 n1335 t_r1_w 11271
r15036 n1480 t_r1_w 169065
r15037 n1481 t_r1_w 11271
r15038 n1482 t_r1_w 169065
r15039 n1690 t_r1_w 9945
r15040 n1691 t_r1_w 663
r15041 n1692 t_r1_w 9945
r15042 n1191 t_r1_w 9945
r15043 n1338 t_r1_w 663
r15044 n1485 t_r1_w 9945
r15045 n1695 t_r1_w 585
r15046 n1193 t_r1_w 9945
r15047 n1340 t_r1_w 663
r15048 n1487 t_r1_w 9945
r15049 n1697 t_r1_w 585
r15050 n1195 t_r1_w 9945
r15051 n1342 t_r1_w 663
r15052 n1489 t_r1_w 9945
r15053 n1699 t_r1_w 585
r15054 n1197 t_r1_w 9945
r15055 n1344 t_r1_w 663
r15056 n1491 t_r1_w 9945
r15057 n1701 t_r1_w 585
r15058 n1199 t_r1_w 9945
r15059 n1346 t_r1_w 663
r15060 n1493 t_r1_w 9945
r15061 n1703 t_r1_w 585
r15062 n1201 t_r1_w 9945
r15063 n1348 t_r1_w 663
r15064 n1495 t_r1_w 9945
r15065 n1705 t_r1_w 585
r15066 n1203 t_r1_w 9945
r15067 n1350 t_r1_w 663
r15068 n1497 t_r1_w 9945
r15069 n1707 t_r1_w 585
r15070 n1205 t_r1_w 9945
r15071 n1352 t_r1_w 663
r15072 n1499 t_r1_w 9945
r15073 n1709 t_r1_w 585
r15074 n1207 t_r1_w 9945
r15075 n1354 t_r1_w 663
r15076 n1501 t_r1_w 9945
r15077 n1711 t_r1_w 585
r15078 n1209 t_r1_w 9945
r15079 n1356 t_r1_w 663
r15080 n1503 t_r1_w 9945
r15081 n1713 t_r1_w 585
r15082 n1211 t_r1_w 9945
r15083 n1358 t_r1_w 663
r15084 n1505 t_r1_w 9945
r15085 n1715 t_r1_w 585
r15086 n1213 t_r1_w 9945
r15087 n1360 t_r1_w 663
r15088 n1507 t_r1_w 9945
r15089 n1717 t_r1_w 585
r15090 n1216 t_r1_w 9945
r15091 n1363 t_r1_w 663
r15092 n1510 t_r1_w 9945
r15093 n1720 t_r1_w 585
r15094 n1218 t_r1_w 9945
r15095 n1365 t_r1_w 663
r15096 n1512 t_r1_w 9945
r15097 n1722 t_r1_w 585
r15098 n1220 t_r1_w 12523.333333333334
r15099 n1221 t_r1_w 48304.285714285717
r15100 n1367 t_r1_w 834.88888888888891
r15101 n1368 t_r1_w 3220.2857142857142
r15102 n1514 t_r1_w 12523.333333333334
r15103 n1515 t_r1_w 48304.285714285717
r15104 n1724 t_r1_w 736.66666666666674
r15105 n1725 t_r1_w 2841.4285714285716
r15106 n1224 t_r1_w 24152.142857142859
r15107 n1225 t_r1_w 16906.5
r15108 n1371 t_r1_w 1610.1428571428571
r15109 n1372 t_r1_w 1127.1000000000001
r15110 n1518 t_r1_w 24152.142857142859
r15111 n1519 t_r1_w 16906.5
r15112 n1728 t_r1_w 1420.7142857142858
r15113 n1729 t_r1_w 994.5
r15114 n1228 t_r1_w 9945
r15115 n1375 t_r1_w 663
r15116 n1522 t_r1_w 9945
r15117 n1732 t_r1_w 585
r15118 n1230 t_r1_w 9945
r15119 n1377 t_r1_w 663
r15120 n1524 t_r1_w 9945
r15121 n1734 t_r1_w 585
r15122 n1544 t_r1_w 3616.363636363636
r15123 n1545 t_r1_w 3616.363636363636
r15124 n1547 t_r1_w 3978
r15125 n1548 t_r1_w 3978
r15126 n1550 t_r1_w 19890
r15127 n1551 t_r1_w 19890
r15128 n1553 t_r1_w 13260
r15129 n1554 t_r1_w 13260
r15130 n1556 t_r1_w 7956
r15131 n1557 t_r1_w 7956
r15132 n1559 t_r1_w 13260
r15133 n1560 t_r1_w 13260
r15134 n1571 t_r1_w 13260
r15135 n1572 t_r1_w 13260
r15136 n1574 t_r1_w 7956
r15137 n1575 t_r1_w 7956
r15138 n1577 t_r1_w 13260
r15139 n1578 t_r1_w 13260
r15140 n1580 t_r1_w 19890
r15141 n1581 t_r1_w 19890
r15142 n1583 t_r1_w 3978
r15143 n1584 t_r1_w 3978
r15144 n1586 t_r1_w 3616.363636363636
r15145 n1587 t_r1_w 3616.363636363636
.save v(out) v(in)
.control
set wr_singlescale
set wr_vecnames
ac dec 50 1000 100000000000.0
let h=(v(out)-0)/(v(in)-0)
let hr=real(h)
let hi=imag(h)
wrdata bode.csv hr hi
quit
.endc
.end
