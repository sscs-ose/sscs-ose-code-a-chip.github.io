.subckt CS VDD OUT IN VSS
XR1 OUT VDD VSS sky130_fd_pr__res_high_po_0p35 l=8.67u
XM1 OUT IN VSS VSS sky130_fd_pr__nfet_01v8_lvt l=0.235u w=0.865u
.ends CS
