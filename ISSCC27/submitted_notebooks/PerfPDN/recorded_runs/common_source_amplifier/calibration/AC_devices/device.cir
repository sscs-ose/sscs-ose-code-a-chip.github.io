Device terminal AC matrices at the complete circuit operating point
.lib /home/gokalp/.local/share/perfpdn/pdks/sky130A/libs.tech/ngspice/sky130.lib.spice tt
.option scale=1e-6 reltol=1e-8 abstol=1e-14
.temp 27
XR1 r1_a r1_b r1_w sky130_fd_pr__res_high_po_0p35 L=8.67 mult=1 m=1
XM1 m1_d m1_g m1_s m1_b sky130_fd_pr__nfet_01v8_lvt L=0.235 W=0.865 nf=1 ad='int(( 1 + 1 ) / 2 ) * 0.865 / 1 * 0.29' as='int(( 1 + 2 ) / 2 ) * 0.865 / 1 * 0.29' pd='2 * int(( 1 + 1 ) / 2 ) * ( 0.865 / 1 + 0.29 )' ps='2 * int(( 1 + 2 ) / 2 ) * ( 0.865 / 1 + 0.29 )' nrd='0.29 / 0.865 ' nrs='0.29 / 0.865 ' sa=0 sb=0 sd=0 mult=1 m=1
vc_r1_a r1_a 0 DC 0.68904165855181032 AC 0
vc_r1_b r1_b 0 DC 1.158481613785304 AC 0
vc_r1_w r1_w 0 DC 0.046942378100702682 AC 0
vc_m1_d m1_d 0 DC 0.68383696511071046 AC 0
vc_m1_g m1_g 0 DC 0.95472500000000005 AC 0
vc_m1_s m1_s 0 DC 0.051651895315003242 AC 0
vc_m1_b m1_b 0 DC 0.046934796467946717 AC 0
.save all
.control
set filetype=ascii
op
write clamped.raw all
alter vc_r1_a acmag = 1
ac lin 1 1000 1000
write base_0_0.raw all
ac lin 1 25584151.790354129 25584151.790354129
write base_0_1.raw all
alter vc_r1_a acmag = 0
alter vc_r1_b acmag = 1
ac lin 1 1000 1000
write base_1_0.raw all
ac lin 1 25584151.790354129 25584151.790354129
write base_1_1.raw all
alter vc_r1_b acmag = 0
alter vc_r1_w acmag = 1
ac lin 1 1000 1000
write base_2_0.raw all
ac lin 1 25584151.790354129 25584151.790354129
write base_2_1.raw all
alter vc_r1_w acmag = 0
alter vc_m1_d acmag = 1
ac lin 1 1000 1000
write base_3_0.raw all
ac lin 1 25584151.790354129 25584151.790354129
write base_3_1.raw all
alter vc_m1_d acmag = 0
alter vc_m1_g acmag = 1
ac lin 1 1000 1000
write base_4_0.raw all
ac lin 1 25584151.790354129 25584151.790354129
write base_4_1.raw all
alter vc_m1_g acmag = 0
alter vc_m1_s acmag = 1
ac lin 1 1000 1000
write base_5_0.raw all
ac lin 1 25584151.790354129 25584151.790354129
write base_5_1.raw all
alter vc_m1_s acmag = 0
alter vc_m1_b acmag = 1
ac lin 1 1000 1000
write base_6_0.raw all
ac lin 1 25584151.790354129 25584151.790354129
write base_6_1.raw all
alter vc_m1_b acmag = 0
alter vc_r1_a dc = 0.68914165855181031
alter vc_r1_a acmag = 1
ac lin 1 1000 1000
write plus_0_0_0.raw all
ac lin 1 25584151.790354129 25584151.790354129
write plus_0_0_1.raw all
alter vc_r1_a acmag = 0
alter vc_r1_b acmag = 1
ac lin 1 1000 1000
write plus_0_1_0.raw all
ac lin 1 25584151.790354129 25584151.790354129
write plus_0_1_1.raw all
alter vc_r1_b acmag = 0
alter vc_r1_w acmag = 1
ac lin 1 1000 1000
write plus_0_2_0.raw all
ac lin 1 25584151.790354129 25584151.790354129
write plus_0_2_1.raw all
alter vc_r1_w acmag = 0
alter vc_m1_d acmag = 1
ac lin 1 1000 1000
write plus_0_3_0.raw all
ac lin 1 25584151.790354129 25584151.790354129
write plus_0_3_1.raw all
alter vc_m1_d acmag = 0
alter vc_m1_g acmag = 1
ac lin 1 1000 1000
write plus_0_4_0.raw all
ac lin 1 25584151.790354129 25584151.790354129
write plus_0_4_1.raw all
alter vc_m1_g acmag = 0
alter vc_m1_s acmag = 1
ac lin 1 1000 1000
write plus_0_5_0.raw all
ac lin 1 25584151.790354129 25584151.790354129
write plus_0_5_1.raw all
alter vc_m1_s acmag = 0
alter vc_m1_b acmag = 1
ac lin 1 1000 1000
write plus_0_6_0.raw all
ac lin 1 25584151.790354129 25584151.790354129
write plus_0_6_1.raw all
alter vc_m1_b acmag = 0
alter vc_r1_a dc = 0.68904165855181032
alter vc_r1_a dc = 0.68894165855181033
alter vc_r1_a acmag = 1
ac lin 1 1000 1000
write minus_0_0_0.raw all
ac lin 1 25584151.790354129 25584151.790354129
write minus_0_0_1.raw all
alter vc_r1_a acmag = 0
alter vc_r1_b acmag = 1
ac lin 1 1000 1000
write minus_0_1_0.raw all
ac lin 1 25584151.790354129 25584151.790354129
write minus_0_1_1.raw all
alter vc_r1_b acmag = 0
alter vc_r1_w acmag = 1
ac lin 1 1000 1000
write minus_0_2_0.raw all
ac lin 1 25584151.790354129 25584151.790354129
write minus_0_2_1.raw all
alter vc_r1_w acmag = 0
alter vc_m1_d acmag = 1
ac lin 1 1000 1000
write minus_0_3_0.raw all
ac lin 1 25584151.790354129 25584151.790354129
write minus_0_3_1.raw all
alter vc_m1_d acmag = 0
alter vc_m1_g acmag = 1
ac lin 1 1000 1000
write minus_0_4_0.raw all
ac lin 1 25584151.790354129 25584151.790354129
write minus_0_4_1.raw all
alter vc_m1_g acmag = 0
alter vc_m1_s acmag = 1
ac lin 1 1000 1000
write minus_0_5_0.raw all
ac lin 1 25584151.790354129 25584151.790354129
write minus_0_5_1.raw all
alter vc_m1_s acmag = 0
alter vc_m1_b acmag = 1
ac lin 1 1000 1000
write minus_0_6_0.raw all
ac lin 1 25584151.790354129 25584151.790354129
write minus_0_6_1.raw all
alter vc_m1_b acmag = 0
alter vc_r1_a dc = 0.68904165855181032
alter vc_r1_b dc = 1.158581613785304
alter vc_r1_a acmag = 1
ac lin 1 1000 1000
write plus_1_0_0.raw all
ac lin 1 25584151.790354129 25584151.790354129
write plus_1_0_1.raw all
alter vc_r1_a acmag = 0
alter vc_r1_b acmag = 1
ac lin 1 1000 1000
write plus_1_1_0.raw all
ac lin 1 25584151.790354129 25584151.790354129
write plus_1_1_1.raw all
alter vc_r1_b acmag = 0
alter vc_r1_w acmag = 1
ac lin 1 1000 1000
write plus_1_2_0.raw all
ac lin 1 25584151.790354129 25584151.790354129
write plus_1_2_1.raw all
alter vc_r1_w acmag = 0
alter vc_m1_d acmag = 1
ac lin 1 1000 1000
write plus_1_3_0.raw all
ac lin 1 25584151.790354129 25584151.790354129
write plus_1_3_1.raw all
alter vc_m1_d acmag = 0
alter vc_m1_g acmag = 1
ac lin 1 1000 1000
write plus_1_4_0.raw all
ac lin 1 25584151.790354129 25584151.790354129
write plus_1_4_1.raw all
alter vc_m1_g acmag = 0
alter vc_m1_s acmag = 1
ac lin 1 1000 1000
write plus_1_5_0.raw all
ac lin 1 25584151.790354129 25584151.790354129
write plus_1_5_1.raw all
alter vc_m1_s acmag = 0
alter vc_m1_b acmag = 1
ac lin 1 1000 1000
write plus_1_6_0.raw all
ac lin 1 25584151.790354129 25584151.790354129
write plus_1_6_1.raw all
alter vc_m1_b acmag = 0
alter vc_r1_b dc = 1.158481613785304
alter vc_r1_b dc = 1.158381613785304
alter vc_r1_a acmag = 1
ac lin 1 1000 1000
write minus_1_0_0.raw all
ac lin 1 25584151.790354129 25584151.790354129
write minus_1_0_1.raw all
alter vc_r1_a acmag = 0
alter vc_r1_b acmag = 1
ac lin 1 1000 1000
write minus_1_1_0.raw all
ac lin 1 25584151.790354129 25584151.790354129
write minus_1_1_1.raw all
alter vc_r1_b acmag = 0
alter vc_r1_w acmag = 1
ac lin 1 1000 1000
write minus_1_2_0.raw all
ac lin 1 25584151.790354129 25584151.790354129
write minus_1_2_1.raw all
alter vc_r1_w acmag = 0
alter vc_m1_d acmag = 1
ac lin 1 1000 1000
write minus_1_3_0.raw all
ac lin 1 25584151.790354129 25584151.790354129
write minus_1_3_1.raw all
alter vc_m1_d acmag = 0
alter vc_m1_g acmag = 1
ac lin 1 1000 1000
write minus_1_4_0.raw all
ac lin 1 25584151.790354129 25584151.790354129
write minus_1_4_1.raw all
alter vc_m1_g acmag = 0
alter vc_m1_s acmag = 1
ac lin 1 1000 1000
write minus_1_5_0.raw all
ac lin 1 25584151.790354129 25584151.790354129
write minus_1_5_1.raw all
alter vc_m1_s acmag = 0
alter vc_m1_b acmag = 1
ac lin 1 1000 1000
write minus_1_6_0.raw all
ac lin 1 25584151.790354129 25584151.790354129
write minus_1_6_1.raw all
alter vc_m1_b acmag = 0
alter vc_r1_b dc = 1.158481613785304
alter vc_r1_w dc = 0.047042378100702685
alter vc_r1_a acmag = 1
ac lin 1 1000 1000
write plus_2_0_0.raw all
ac lin 1 25584151.790354129 25584151.790354129
write plus_2_0_1.raw all
alter vc_r1_a acmag = 0
alter vc_r1_b acmag = 1
ac lin 1 1000 1000
write plus_2_1_0.raw all
ac lin 1 25584151.790354129 25584151.790354129
write plus_2_1_1.raw all
alter vc_r1_b acmag = 0
alter vc_r1_w acmag = 1
ac lin 1 1000 1000
write plus_2_2_0.raw all
ac lin 1 25584151.790354129 25584151.790354129
write plus_2_2_1.raw all
alter vc_r1_w acmag = 0
alter vc_m1_d acmag = 1
ac lin 1 1000 1000
write plus_2_3_0.raw all
ac lin 1 25584151.790354129 25584151.790354129
write plus_2_3_1.raw all
alter vc_m1_d acmag = 0
alter vc_m1_g acmag = 1
ac lin 1 1000 1000
write plus_2_4_0.raw all
ac lin 1 25584151.790354129 25584151.790354129
write plus_2_4_1.raw all
alter vc_m1_g acmag = 0
alter vc_m1_s acmag = 1
ac lin 1 1000 1000
write plus_2_5_0.raw all
ac lin 1 25584151.790354129 25584151.790354129
write plus_2_5_1.raw all
alter vc_m1_s acmag = 0
alter vc_m1_b acmag = 1
ac lin 1 1000 1000
write plus_2_6_0.raw all
ac lin 1 25584151.790354129 25584151.790354129
write plus_2_6_1.raw all
alter vc_m1_b acmag = 0
alter vc_r1_w dc = 0.046942378100702682
alter vc_r1_w dc = 0.046842378100702679
alter vc_r1_a acmag = 1
ac lin 1 1000 1000
write minus_2_0_0.raw all
ac lin 1 25584151.790354129 25584151.790354129
write minus_2_0_1.raw all
alter vc_r1_a acmag = 0
alter vc_r1_b acmag = 1
ac lin 1 1000 1000
write minus_2_1_0.raw all
ac lin 1 25584151.790354129 25584151.790354129
write minus_2_1_1.raw all
alter vc_r1_b acmag = 0
alter vc_r1_w acmag = 1
ac lin 1 1000 1000
write minus_2_2_0.raw all
ac lin 1 25584151.790354129 25584151.790354129
write minus_2_2_1.raw all
alter vc_r1_w acmag = 0
alter vc_m1_d acmag = 1
ac lin 1 1000 1000
write minus_2_3_0.raw all
ac lin 1 25584151.790354129 25584151.790354129
write minus_2_3_1.raw all
alter vc_m1_d acmag = 0
alter vc_m1_g acmag = 1
ac lin 1 1000 1000
write minus_2_4_0.raw all
ac lin 1 25584151.790354129 25584151.790354129
write minus_2_4_1.raw all
alter vc_m1_g acmag = 0
alter vc_m1_s acmag = 1
ac lin 1 1000 1000
write minus_2_5_0.raw all
ac lin 1 25584151.790354129 25584151.790354129
write minus_2_5_1.raw all
alter vc_m1_s acmag = 0
alter vc_m1_b acmag = 1
ac lin 1 1000 1000
write minus_2_6_0.raw all
ac lin 1 25584151.790354129 25584151.790354129
write minus_2_6_1.raw all
alter vc_m1_b acmag = 0
alter vc_r1_w dc = 0.046942378100702682
alter vc_m1_d dc = 0.68393696511071045
alter vc_r1_a acmag = 1
ac lin 1 1000 1000
write plus_3_0_0.raw all
ac lin 1 25584151.790354129 25584151.790354129
write plus_3_0_1.raw all
alter vc_r1_a acmag = 0
alter vc_r1_b acmag = 1
ac lin 1 1000 1000
write plus_3_1_0.raw all
ac lin 1 25584151.790354129 25584151.790354129
write plus_3_1_1.raw all
alter vc_r1_b acmag = 0
alter vc_r1_w acmag = 1
ac lin 1 1000 1000
write plus_3_2_0.raw all
ac lin 1 25584151.790354129 25584151.790354129
write plus_3_2_1.raw all
alter vc_r1_w acmag = 0
alter vc_m1_d acmag = 1
ac lin 1 1000 1000
write plus_3_3_0.raw all
ac lin 1 25584151.790354129 25584151.790354129
write plus_3_3_1.raw all
alter vc_m1_d acmag = 0
alter vc_m1_g acmag = 1
ac lin 1 1000 1000
write plus_3_4_0.raw all
ac lin 1 25584151.790354129 25584151.790354129
write plus_3_4_1.raw all
alter vc_m1_g acmag = 0
alter vc_m1_s acmag = 1
ac lin 1 1000 1000
write plus_3_5_0.raw all
ac lin 1 25584151.790354129 25584151.790354129
write plus_3_5_1.raw all
alter vc_m1_s acmag = 0
alter vc_m1_b acmag = 1
ac lin 1 1000 1000
write plus_3_6_0.raw all
ac lin 1 25584151.790354129 25584151.790354129
write plus_3_6_1.raw all
alter vc_m1_b acmag = 0
alter vc_m1_d dc = 0.68383696511071046
alter vc_m1_d dc = 0.68373696511071047
alter vc_r1_a acmag = 1
ac lin 1 1000 1000
write minus_3_0_0.raw all
ac lin 1 25584151.790354129 25584151.790354129
write minus_3_0_1.raw all
alter vc_r1_a acmag = 0
alter vc_r1_b acmag = 1
ac lin 1 1000 1000
write minus_3_1_0.raw all
ac lin 1 25584151.790354129 25584151.790354129
write minus_3_1_1.raw all
alter vc_r1_b acmag = 0
alter vc_r1_w acmag = 1
ac lin 1 1000 1000
write minus_3_2_0.raw all
ac lin 1 25584151.790354129 25584151.790354129
write minus_3_2_1.raw all
alter vc_r1_w acmag = 0
alter vc_m1_d acmag = 1
ac lin 1 1000 1000
write minus_3_3_0.raw all
ac lin 1 25584151.790354129 25584151.790354129
write minus_3_3_1.raw all
alter vc_m1_d acmag = 0
alter vc_m1_g acmag = 1
ac lin 1 1000 1000
write minus_3_4_0.raw all
ac lin 1 25584151.790354129 25584151.790354129
write minus_3_4_1.raw all
alter vc_m1_g acmag = 0
alter vc_m1_s acmag = 1
ac lin 1 1000 1000
write minus_3_5_0.raw all
ac lin 1 25584151.790354129 25584151.790354129
write minus_3_5_1.raw all
alter vc_m1_s acmag = 0
alter vc_m1_b acmag = 1
ac lin 1 1000 1000
write minus_3_6_0.raw all
ac lin 1 25584151.790354129 25584151.790354129
write minus_3_6_1.raw all
alter vc_m1_b acmag = 0
alter vc_m1_d dc = 0.68383696511071046
alter vc_m1_g dc = 0.95482500000000003
alter vc_r1_a acmag = 1
ac lin 1 1000 1000
write plus_4_0_0.raw all
ac lin 1 25584151.790354129 25584151.790354129
write plus_4_0_1.raw all
alter vc_r1_a acmag = 0
alter vc_r1_b acmag = 1
ac lin 1 1000 1000
write plus_4_1_0.raw all
ac lin 1 25584151.790354129 25584151.790354129
write plus_4_1_1.raw all
alter vc_r1_b acmag = 0
alter vc_r1_w acmag = 1
ac lin 1 1000 1000
write plus_4_2_0.raw all
ac lin 1 25584151.790354129 25584151.790354129
write plus_4_2_1.raw all
alter vc_r1_w acmag = 0
alter vc_m1_d acmag = 1
ac lin 1 1000 1000
write plus_4_3_0.raw all
ac lin 1 25584151.790354129 25584151.790354129
write plus_4_3_1.raw all
alter vc_m1_d acmag = 0
alter vc_m1_g acmag = 1
ac lin 1 1000 1000
write plus_4_4_0.raw all
ac lin 1 25584151.790354129 25584151.790354129
write plus_4_4_1.raw all
alter vc_m1_g acmag = 0
alter vc_m1_s acmag = 1
ac lin 1 1000 1000
write plus_4_5_0.raw all
ac lin 1 25584151.790354129 25584151.790354129
write plus_4_5_1.raw all
alter vc_m1_s acmag = 0
alter vc_m1_b acmag = 1
ac lin 1 1000 1000
write plus_4_6_0.raw all
ac lin 1 25584151.790354129 25584151.790354129
write plus_4_6_1.raw all
alter vc_m1_b acmag = 0
alter vc_m1_g dc = 0.95472500000000005
alter vc_m1_g dc = 0.95462500000000006
alter vc_r1_a acmag = 1
ac lin 1 1000 1000
write minus_4_0_0.raw all
ac lin 1 25584151.790354129 25584151.790354129
write minus_4_0_1.raw all
alter vc_r1_a acmag = 0
alter vc_r1_b acmag = 1
ac lin 1 1000 1000
write minus_4_1_0.raw all
ac lin 1 25584151.790354129 25584151.790354129
write minus_4_1_1.raw all
alter vc_r1_b acmag = 0
alter vc_r1_w acmag = 1
ac lin 1 1000 1000
write minus_4_2_0.raw all
ac lin 1 25584151.790354129 25584151.790354129
write minus_4_2_1.raw all
alter vc_r1_w acmag = 0
alter vc_m1_d acmag = 1
ac lin 1 1000 1000
write minus_4_3_0.raw all
ac lin 1 25584151.790354129 25584151.790354129
write minus_4_3_1.raw all
alter vc_m1_d acmag = 0
alter vc_m1_g acmag = 1
ac lin 1 1000 1000
write minus_4_4_0.raw all
ac lin 1 25584151.790354129 25584151.790354129
write minus_4_4_1.raw all
alter vc_m1_g acmag = 0
alter vc_m1_s acmag = 1
ac lin 1 1000 1000
write minus_4_5_0.raw all
ac lin 1 25584151.790354129 25584151.790354129
write minus_4_5_1.raw all
alter vc_m1_s acmag = 0
alter vc_m1_b acmag = 1
ac lin 1 1000 1000
write minus_4_6_0.raw all
ac lin 1 25584151.790354129 25584151.790354129
write minus_4_6_1.raw all
alter vc_m1_b acmag = 0
alter vc_m1_g dc = 0.95472500000000005
alter vc_m1_s dc = 0.051751895315003245
alter vc_r1_a acmag = 1
ac lin 1 1000 1000
write plus_5_0_0.raw all
ac lin 1 25584151.790354129 25584151.790354129
write plus_5_0_1.raw all
alter vc_r1_a acmag = 0
alter vc_r1_b acmag = 1
ac lin 1 1000 1000
write plus_5_1_0.raw all
ac lin 1 25584151.790354129 25584151.790354129
write plus_5_1_1.raw all
alter vc_r1_b acmag = 0
alter vc_r1_w acmag = 1
ac lin 1 1000 1000
write plus_5_2_0.raw all
ac lin 1 25584151.790354129 25584151.790354129
write plus_5_2_1.raw all
alter vc_r1_w acmag = 0
alter vc_m1_d acmag = 1
ac lin 1 1000 1000
write plus_5_3_0.raw all
ac lin 1 25584151.790354129 25584151.790354129
write plus_5_3_1.raw all
alter vc_m1_d acmag = 0
alter vc_m1_g acmag = 1
ac lin 1 1000 1000
write plus_5_4_0.raw all
ac lin 1 25584151.790354129 25584151.790354129
write plus_5_4_1.raw all
alter vc_m1_g acmag = 0
alter vc_m1_s acmag = 1
ac lin 1 1000 1000
write plus_5_5_0.raw all
ac lin 1 25584151.790354129 25584151.790354129
write plus_5_5_1.raw all
alter vc_m1_s acmag = 0
alter vc_m1_b acmag = 1
ac lin 1 1000 1000
write plus_5_6_0.raw all
ac lin 1 25584151.790354129 25584151.790354129
write plus_5_6_1.raw all
alter vc_m1_b acmag = 0
alter vc_m1_s dc = 0.051651895315003242
alter vc_m1_s dc = 0.051551895315003239
alter vc_r1_a acmag = 1
ac lin 1 1000 1000
write minus_5_0_0.raw all
ac lin 1 25584151.790354129 25584151.790354129
write minus_5_0_1.raw all
alter vc_r1_a acmag = 0
alter vc_r1_b acmag = 1
ac lin 1 1000 1000
write minus_5_1_0.raw all
ac lin 1 25584151.790354129 25584151.790354129
write minus_5_1_1.raw all
alter vc_r1_b acmag = 0
alter vc_r1_w acmag = 1
ac lin 1 1000 1000
write minus_5_2_0.raw all
ac lin 1 25584151.790354129 25584151.790354129
write minus_5_2_1.raw all
alter vc_r1_w acmag = 0
alter vc_m1_d acmag = 1
ac lin 1 1000 1000
write minus_5_3_0.raw all
ac lin 1 25584151.790354129 25584151.790354129
write minus_5_3_1.raw all
alter vc_m1_d acmag = 0
alter vc_m1_g acmag = 1
ac lin 1 1000 1000
write minus_5_4_0.raw all
ac lin 1 25584151.790354129 25584151.790354129
write minus_5_4_1.raw all
alter vc_m1_g acmag = 0
alter vc_m1_s acmag = 1
ac lin 1 1000 1000
write minus_5_5_0.raw all
ac lin 1 25584151.790354129 25584151.790354129
write minus_5_5_1.raw all
alter vc_m1_s acmag = 0
alter vc_m1_b acmag = 1
ac lin 1 1000 1000
write minus_5_6_0.raw all
ac lin 1 25584151.790354129 25584151.790354129
write minus_5_6_1.raw all
alter vc_m1_b acmag = 0
alter vc_m1_s dc = 0.051651895315003242
alter vc_m1_b dc = 0.04703479646794672
alter vc_r1_a acmag = 1
ac lin 1 1000 1000
write plus_6_0_0.raw all
ac lin 1 25584151.790354129 25584151.790354129
write plus_6_0_1.raw all
alter vc_r1_a acmag = 0
alter vc_r1_b acmag = 1
ac lin 1 1000 1000
write plus_6_1_0.raw all
ac lin 1 25584151.790354129 25584151.790354129
write plus_6_1_1.raw all
alter vc_r1_b acmag = 0
alter vc_r1_w acmag = 1
ac lin 1 1000 1000
write plus_6_2_0.raw all
ac lin 1 25584151.790354129 25584151.790354129
write plus_6_2_1.raw all
alter vc_r1_w acmag = 0
alter vc_m1_d acmag = 1
ac lin 1 1000 1000
write plus_6_3_0.raw all
ac lin 1 25584151.790354129 25584151.790354129
write plus_6_3_1.raw all
alter vc_m1_d acmag = 0
alter vc_m1_g acmag = 1
ac lin 1 1000 1000
write plus_6_4_0.raw all
ac lin 1 25584151.790354129 25584151.790354129
write plus_6_4_1.raw all
alter vc_m1_g acmag = 0
alter vc_m1_s acmag = 1
ac lin 1 1000 1000
write plus_6_5_0.raw all
ac lin 1 25584151.790354129 25584151.790354129
write plus_6_5_1.raw all
alter vc_m1_s acmag = 0
alter vc_m1_b acmag = 1
ac lin 1 1000 1000
write plus_6_6_0.raw all
ac lin 1 25584151.790354129 25584151.790354129
write plus_6_6_1.raw all
alter vc_m1_b acmag = 0
alter vc_m1_b dc = 0.046934796467946717
alter vc_m1_b dc = 0.046834796467946714
alter vc_r1_a acmag = 1
ac lin 1 1000 1000
write minus_6_0_0.raw all
ac lin 1 25584151.790354129 25584151.790354129
write minus_6_0_1.raw all
alter vc_r1_a acmag = 0
alter vc_r1_b acmag = 1
ac lin 1 1000 1000
write minus_6_1_0.raw all
ac lin 1 25584151.790354129 25584151.790354129
write minus_6_1_1.raw all
alter vc_r1_b acmag = 0
alter vc_r1_w acmag = 1
ac lin 1 1000 1000
write minus_6_2_0.raw all
ac lin 1 25584151.790354129 25584151.790354129
write minus_6_2_1.raw all
alter vc_r1_w acmag = 0
alter vc_m1_d acmag = 1
ac lin 1 1000 1000
write minus_6_3_0.raw all
ac lin 1 25584151.790354129 25584151.790354129
write minus_6_3_1.raw all
alter vc_m1_d acmag = 0
alter vc_m1_g acmag = 1
ac lin 1 1000 1000
write minus_6_4_0.raw all
ac lin 1 25584151.790354129 25584151.790354129
write minus_6_4_1.raw all
alter vc_m1_g acmag = 0
alter vc_m1_s acmag = 1
ac lin 1 1000 1000
write minus_6_5_0.raw all
ac lin 1 25584151.790354129 25584151.790354129
write minus_6_5_1.raw all
alter vc_m1_s acmag = 0
alter vc_m1_b acmag = 1
ac lin 1 1000 1000
write minus_6_6_0.raw all
ac lin 1 25584151.790354129 25584151.790354129
write minus_6_6_1.raw all
alter vc_m1_b acmag = 0
alter vc_m1_b dc = 0.046934796467946717
quit
.endc
.end
