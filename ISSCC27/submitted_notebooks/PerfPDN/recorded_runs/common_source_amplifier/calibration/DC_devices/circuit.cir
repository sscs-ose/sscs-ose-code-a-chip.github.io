MOS terminal derivatives at the complete circuit's solved operating point
.lib /home/gokalp/.local/share/perfpdn/pdks/sky130A/libs.tech/ngspice/sky130.lib.spice tt
.option scale=1e-6 reltol=1e-8 abstol=1e-14
.temp 27
XR1 r1_a r1_b r1_w sky130_fd_pr__res_high_po_0p35 L=8.67 mult=1 m=1
XM1 m1_d m1_g m1_s m1_b sky130_fd_pr__nfet_01v8_lvt L=0.235 W=0.865 nf=1 ad='int(( 1 + 1 ) / 2 ) * 0.865 / 1 * 0.29' as='int(( 1 + 2 ) / 2 ) * 0.865 / 1 * 0.29' pd='2 * int(( 1 + 1 ) / 2 ) * ( 0.865 / 1 + 0.29 )' ps='2 * int(( 1 + 2 ) / 2 ) * ( 0.865 / 1 + 0.29 )' nrd='0.29 / 0.865 ' nrs='0.29 / 0.865 ' sa=0 sb=0 sd=0 mult=1 m=1
vc_r1_a r1_a 0 0.68904165855181032
vc_r1_b r1_b 0 1.158481613785304
vc_r1_w r1_w 0 0.046942378100702682
vc_m1_d m1_d 0 0.68383696511071046
vc_m1_g m1_g 0 0.95472500000000005
vc_m1_s m1_s 0 0.051651895315003242
vc_m1_b m1_b 0 0.046934796467946717
.control
set filetype=ascii
op
write clamped.raw all
tf i(vc_r1_a) vc_r1_a
write tf_0_0.raw all
tf i(vc_r1_a) vc_r1_b
write tf_0_1.raw all
tf i(vc_r1_a) vc_r1_w
write tf_0_2.raw all
tf i(vc_r1_a) vc_m1_d
write tf_0_3.raw all
tf i(vc_r1_a) vc_m1_g
write tf_0_4.raw all
tf i(vc_r1_a) vc_m1_s
write tf_0_5.raw all
tf i(vc_r1_a) vc_m1_b
write tf_0_6.raw all
tf i(vc_r1_b) vc_r1_a
write tf_1_0.raw all
tf i(vc_r1_b) vc_r1_b
write tf_1_1.raw all
tf i(vc_r1_b) vc_r1_w
write tf_1_2.raw all
tf i(vc_r1_b) vc_m1_d
write tf_1_3.raw all
tf i(vc_r1_b) vc_m1_g
write tf_1_4.raw all
tf i(vc_r1_b) vc_m1_s
write tf_1_5.raw all
tf i(vc_r1_b) vc_m1_b
write tf_1_6.raw all
tf i(vc_r1_w) vc_r1_a
write tf_2_0.raw all
tf i(vc_r1_w) vc_r1_b
write tf_2_1.raw all
tf i(vc_r1_w) vc_r1_w
write tf_2_2.raw all
tf i(vc_r1_w) vc_m1_d
write tf_2_3.raw all
tf i(vc_r1_w) vc_m1_g
write tf_2_4.raw all
tf i(vc_r1_w) vc_m1_s
write tf_2_5.raw all
tf i(vc_r1_w) vc_m1_b
write tf_2_6.raw all
tf i(vc_m1_d) vc_r1_a
write tf_3_0.raw all
tf i(vc_m1_d) vc_r1_b
write tf_3_1.raw all
tf i(vc_m1_d) vc_r1_w
write tf_3_2.raw all
tf i(vc_m1_d) vc_m1_d
write tf_3_3.raw all
tf i(vc_m1_d) vc_m1_g
write tf_3_4.raw all
tf i(vc_m1_d) vc_m1_s
write tf_3_5.raw all
tf i(vc_m1_d) vc_m1_b
write tf_3_6.raw all
tf i(vc_m1_g) vc_r1_a
write tf_4_0.raw all
tf i(vc_m1_g) vc_r1_b
write tf_4_1.raw all
tf i(vc_m1_g) vc_r1_w
write tf_4_2.raw all
tf i(vc_m1_g) vc_m1_d
write tf_4_3.raw all
tf i(vc_m1_g) vc_m1_g
write tf_4_4.raw all
tf i(vc_m1_g) vc_m1_s
write tf_4_5.raw all
tf i(vc_m1_g) vc_m1_b
write tf_4_6.raw all
tf i(vc_m1_s) vc_r1_a
write tf_5_0.raw all
tf i(vc_m1_s) vc_r1_b
write tf_5_1.raw all
tf i(vc_m1_s) vc_r1_w
write tf_5_2.raw all
tf i(vc_m1_s) vc_m1_d
write tf_5_3.raw all
tf i(vc_m1_s) vc_m1_g
write tf_5_4.raw all
tf i(vc_m1_s) vc_m1_s
write tf_5_5.raw all
tf i(vc_m1_s) vc_m1_b
write tf_5_6.raw all
tf i(vc_m1_b) vc_r1_a
write tf_6_0.raw all
tf i(vc_m1_b) vc_r1_b
write tf_6_1.raw all
tf i(vc_m1_b) vc_r1_w
write tf_6_2.raw all
tf i(vc_m1_b) vc_m1_d
write tf_6_3.raw all
tf i(vc_m1_b) vc_m1_g
write tf_6_4.raw all
tf i(vc_m1_b) vc_m1_s
write tf_6_5.raw all
tf i(vc_m1_b) vc_m1_b
write tf_6_6.raw all
.endc
.end
