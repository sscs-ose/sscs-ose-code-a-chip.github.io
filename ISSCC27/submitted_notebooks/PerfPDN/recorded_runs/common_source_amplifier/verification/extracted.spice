* Extracted by KLayout with SKY130 LVS runset on : 29/10/2026 22:58

.SUBCKT CS IN OUT VDD VSS
XM$1 VSS IN OUT VSS sky130_fd_pr__nfet_01v8_lvt L=0.235 W=0.865 AS=0.2595
+ AD=0.2595 PS=2.33 PD=2.33
XR$2 OUT VDD VSS sky130_fd_pr__res_high_po_0p35 R=7921.90285714 L=8.67 W=0.35
+ A=3.0345 P=18.04
.ENDS CS
