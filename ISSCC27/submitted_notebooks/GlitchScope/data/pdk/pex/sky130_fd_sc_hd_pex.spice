* SKY130 HD standard cells, parasitic-extracted with Magic from the SKY130 PDK cell layouts
* (Apache-2.0, SkyWater/Google).  Generated by scripts/extract_cells_pex.sh; units: um (.option scale=1e-6).
.subckt sky130_fd_sc_hd__a21oi_1 VPWR VGND VPB VNB A2 A1 B1 Y
X0 a_199_47# A1 Y VNB sky130_fd_pr__nfet_01v8 ad=0.09588 pd=0.945 as=0.091 ps=0.93 w=0.65 l=0.15
X1 a_113_297# A2 VPWR VPB sky130_fd_pr__pfet_01v8_hvt ad=0.265 pd=2.53 as=0.1475 ps=1.295 w=1 l=0.15
X2 Y B1 VGND VNB sky130_fd_pr__nfet_01v8 ad=0.091 pd=0.93 as=0.17225 ps=1.83 w=0.65 l=0.15
X3 VPWR A1 a_113_297# VPB sky130_fd_pr__pfet_01v8_hvt ad=0.1475 pd=1.295 as=0.14 ps=1.28 w=1 l=0.15
X4 a_113_297# B1 Y VPB sky130_fd_pr__pfet_01v8_hvt ad=0.14 pd=1.28 as=0.265 ps=2.53 w=1 l=0.15
X5 VGND A2 a_199_47# VNB sky130_fd_pr__nfet_01v8 ad=0.17225 pd=1.83 as=0.09588 ps=0.945 w=0.65 l=0.15
C0 VPWR A2 0.0147f
C1 a_199_47# A1 0.00917f
C2 a_113_297# Y 0.04873f
C3 VPB Y 0.01464f
C4 a_113_297# A2 0.03656f
C5 Y VGND 0.04248f
C6 VPB A2 0.03728f
C7 VPWR A1 0.01539f
C8 VGND A2 0.03772f
C9 B1 A1 0.02592f
C10 VPWR a_199_47# 0
C11 a_113_297# A1 0.03445f
C12 VPB A1 0.02639f
C13 a_113_297# a_199_47# 0
C14 VGND A1 0.05137f
C15 B1 VPWR 0.01343f
C16 VGND a_199_47# 0.00498f
C17 a_113_297# VPWR 0.11629f
C18 Y A2 0.00122f
C19 B1 a_113_297# 0.00758f
C20 VPB VPWR 0.04551f
C21 VPB B1 0.03887f
C22 VPWR VGND 0.0198f
C23 B1 VGND 0.0349f
C24 VPB a_113_297# 0.0108f
C25 Y A1 0.04643f
C26 a_113_297# VGND 0.0072f
C27 VPB VGND 0.00548f
C28 Y a_199_47# 0.00151f
C29 A2 A1 0.05114f
C30 VPWR Y 0.03186f
C31 B1 Y 0.076f
C32 VGND VNB 0.34947f
C33 VPWR VNB 0.26281f
C34 Y VNB 0.15131f
C35 VPB VNB 0.42757f
C36 a_199_47# VNB 0.03246f
C37 a_113_297# VNB 0.08934f
.ends

.subckt sky130_fd_sc_hd__a22oi_1 VPWR VGND VPB VNB B2 B1 Y A1 A2
X0 Y B1 a_109_47# VNB sky130_fd_pr__nfet_01v8 ad=0.169 pd=1.82 as=0.07475 ps=0.88 w=0.65 l=0.15
X1 Y B1 a_109_297# VPB sky130_fd_pr__pfet_01v8_hvt ad=0.26 pd=2.52 as=0.135 ps=1.27 w=1 l=0.15
X2 VPWR A2 a_109_297# VPB sky130_fd_pr__pfet_01v8_hvt ad=0.3 pd=2.6 as=0.135 ps=1.27 w=1 l=0.15
X3 a_109_297# A1 VPWR VPB sky130_fd_pr__pfet_01v8_hvt ad=0.135 pd=1.27 as=0.26 ps=2.52 w=1 l=0.15
X4 a_381_47# A1 Y VNB sky130_fd_pr__nfet_01v8 ad=0.06825 pd=0.86 as=0.169 ps=1.82 w=0.65 l=0.15
X5 a_109_297# B2 Y VPB sky130_fd_pr__pfet_01v8_hvt ad=0.135 pd=1.27 as=0.26 ps=2.52 w=1 l=0.15
X6 a_109_47# B2 VGND VNB sky130_fd_pr__nfet_01v8 ad=0.07475 pd=0.88 as=0.169 ps=1.82 w=0.65 l=0.15
X7 VGND A2 a_381_47# VNB sky130_fd_pr__nfet_01v8 ad=0.234 pd=2.02 as=0.06825 ps=0.86 w=0.65 l=0.15
C0 VPB A2 0.03015f
C1 a_109_297# B2 0.00239f
C2 VGND a_381_47# 0
C3 VGND Y 0.15436f
C4 Y VPB 0.0308f
C5 VGND VPWR 0.0297f
C6 VPWR VPB 0.07428f
C7 A1 B1 0.03243f
C8 a_109_297# A2 0.00311f
C9 Y a_109_47# 0.00414f
C10 B2 B1 0.04654f
C11 VPWR a_109_47# 0.00101f
C12 Y a_109_297# 0.12837f
C13 VPWR a_109_297# 0.07013f
C14 VGND VPB 0.00747f
C15 A2 B1 0
C16 VGND a_109_47# 0.00869f
C17 A2 A1 0.04516f
C18 A1 a_381_47# 0
C19 Y B1 0.06084f
C20 VGND a_109_297# 0.00421f
C21 a_109_297# VPB 0.00911f
C22 B2 A2 0
C23 VPWR B1 0.00963f
C24 Y A1 0.06209f
C25 VPWR A1 0.01743f
C26 Y B2 0.04361f
C27 VPWR B2 0.00871f
C28 VGND B1 0.01704f
C29 A2 a_381_47# 0
C30 VPB B1 0.03202f
C31 VGND A1 0.01324f
C32 VPB A1 0.03629f
C33 Y A2 0.06988f
C34 B1 a_109_47# 0.00139f
C35 VPWR A2 0.02244f
C36 Y a_381_47# 0.00786f
C37 VGND B2 0.03954f
C38 B2 VPB 0.0296f
C39 VPWR a_381_47# 0
C40 a_109_297# B1 0.00847f
C41 Y VPWR 0.12979f
C42 B2 a_109_47# 0.00138f
C43 a_109_297# A1 0.00997f
C44 VGND A2 0.01648f
C45 VGND VNB 0.37159f
C46 VPWR VNB 0.38292f
C47 Y VNB 0.2003f
C48 VPB VNB 0.60476f
C49 a_109_47# VNB 0.03639f
C50 a_109_297# VNB 0.13472f
.ends

.subckt sky130_fd_sc_hd__and2_1 VPWR VGND X B A VPB VNB
X0 VPWR B a_59_75# VPB sky130_fd_pr__pfet_01v8_hvt ad=0.16655 pd=1.39 as=0.0567 ps=0.69 w=0.42 l=0.15
X1 X a_59_75# VPWR VPB sky130_fd_pr__pfet_01v8_hvt ad=0.475 pd=2.95 as=0.16655 ps=1.39 w=1 l=0.15
X2 VGND B a_145_75# VNB sky130_fd_pr__nfet_01v8 ad=0.1118 pd=1.04 as=0.0567 ps=0.69 w=0.42 l=0.15
X3 a_59_75# A VPWR VPB sky130_fd_pr__pfet_01v8_hvt ad=0.0567 pd=0.69 as=0.1176 ps=1.4 w=0.42 l=0.15
X4 X a_59_75# VGND VNB sky130_fd_pr__nfet_01v8 ad=0.182 pd=1.86 as=0.1118 ps=1.04 w=0.65 l=0.15
X5 a_145_75# A a_59_75# VNB sky130_fd_pr__nfet_01v8 ad=0.0567 pd=0.69 as=0.1176 ps=1.4 w=0.42 l=0.15
C0 a_59_75# VPB 0.05631f
C1 a_145_75# VGND 0.00511f
C2 X A 0
C3 VPWR A 0.02995f
C4 B a_59_75# 0.08982f
C5 X VGND 0.06437f
C6 VPWR VGND 0.02488f
C7 a_59_75# A 0.05418f
C8 X a_145_75# 0
C9 VPWR a_145_75# 0
C10 a_59_75# VGND 0.08361f
C11 B VPB 0.06287f
C12 X VPWR 0.07136f
C13 a_145_75# a_59_75# 0.00658f
C14 A VPB 0.08057f
C15 B A 0.04912f
C16 X a_59_75# 0.067f
C17 VGND VPB 0.008f
C18 VPWR a_59_75# 0.10046f
C19 B VGND 0.01299f
C20 VGND A 0.01478f
C21 X VPB 0.01408f
C22 VPWR VPB 0.08544f
C23 X B 0.00276f
C24 VPWR B 0.01339f
C25 VGND VNB 0.34205f
C26 X VNB 0.22502f
C27 VPWR VNB 0.46129f
C28 VPB VNB 0.51617f
.ends

.subckt sky130_fd_sc_hd__buf_1 VGND VPWR X A VPB VNB
X0 VPWR A a_27_47# VPB sky130_fd_pr__pfet_01v8_hvt ad=0.11455 pd=1.08 as=0.2054 ps=2.1 w=0.79 l=0.15
X1 X a_27_47# VGND VNB sky130_fd_pr__nfet_01v8 ad=0.1352 pd=1.56 as=0.0754 ps=0.81 w=0.52 l=0.15
X2 X a_27_47# VPWR VPB sky130_fd_pr__pfet_01v8_hvt ad=0.2054 pd=2.1 as=0.11455 ps=1.08 w=0.79 l=0.15
X3 VGND A a_27_47# VNB sky130_fd_pr__nfet_01v8 ad=0.0754 pd=0.81 as=0.1352 ps=1.56 w=0.52 l=0.15
C0 VGND a_27_47# 0.07282f
C1 VPB a_27_47# 0.06036f
C2 A a_27_47# 0.1146f
C3 VPWR a_27_47# 0.08841f
C4 VPB VGND 0.00505f
C5 A VGND 0.01757f
C6 VPB A 0.05239f
C7 VPWR VGND 0.0155f
C8 VPB VPWR 0.0385f
C9 A VPWR 0.02101f
C10 X a_27_47# 0.06542f
C11 VGND X 0.03677f
C12 VPB X 0.01276f
C13 A X 0.00151f
C14 VPWR X 0.05441f
C15 VGND VNB 0.3251f
C16 X VNB 0.21093f
C17 VPWR VNB 0.23774f
C18 VPB VNB 0.33898f
.ends

.subckt sky130_fd_sc_hd__inv_1 VPB VNB VGND VPWR A Y
X0 Y A VGND VNB sky130_fd_pr__nfet_01v8 ad=0.169 pd=1.82 as=0.169 ps=1.82 w=0.65 l=0.15
X1 Y A VPWR VPB sky130_fd_pr__pfet_01v8_hvt ad=0.26 pd=2.52 as=0.26 ps=2.52 w=1 l=0.15
C0 VPWR VPB 0.06649f
C1 VPWR Y 0.07413f
C2 VGND A 0.03709f
C3 VPB A 0.04506f
C4 Y A 0.03773f
C5 VGND VPB 0.01319f
C6 VGND Y 0.05975f
C7 VPB Y 0.01774f
C8 VPWR A 0.03629f
C9 VPWR VGND 0.01841f
C10 VGND VNB 0.31071f
C11 Y VNB 0.1626f
C12 VPWR VNB 0.20582f
C13 VPB VNB 0.33898f
.ends

.subckt sky130_fd_sc_hd__nand2_1 VPB VNB VGND VPWR A Y B
X0 VPWR A Y VPB sky130_fd_pr__pfet_01v8_hvt ad=0.26 pd=2.52 as=0.135 ps=1.27 w=1 l=0.15
X1 Y A a_113_47# VNB sky130_fd_pr__nfet_01v8 ad=0.169 pd=1.82 as=0.08775 ps=0.92 w=0.65 l=0.15
X2 a_113_47# B VGND VNB sky130_fd_pr__nfet_01v8 ad=0.08775 pd=0.92 as=0.169 ps=1.82 w=0.65 l=0.15
X3 Y B VPWR VPB sky130_fd_pr__pfet_01v8_hvt ad=0.135 pd=1.27 as=0.26 ps=2.52 w=1 l=0.15
C0 Y a_113_47# 0.00937f
C1 VPB B 0.03907f
C2 VGND a_113_47# 0.00201f
C3 VPB A 0.03788f
C4 B A 0.02548f
C5 VPWR a_113_47# 0
C6 VPB Y 0.00618f
C7 B Y 0.03697f
C8 A Y 0.06225f
C9 VPB VGND 0.0044f
C10 VGND B 0.04166f
C11 VPB VPWR 0.05574f
C12 B VPWR 0.0398f
C13 VGND A 0.00949f
C14 VGND Y 0.0866f
C15 A VPWR 0.03737f
C16 VPWR Y 0.1173f
C17 VGND VPWR 0.01852f
C18 VGND VNB 0.28787f
C19 Y VNB 0.11064f
C20 VPWR VNB 0.29519f
C21 VPB VNB 0.33898f
C22 a_113_47# VNB 0.05633f
.ends

.subckt sky130_fd_sc_hd__nand3_1 VPB VNB VGND VPWR A B Y C
X0 VPWR B Y VPB sky130_fd_pr__pfet_01v8_hvt ad=0.165 pd=1.33 as=0.135 ps=1.27 w=1 l=0.15
X1 Y A VPWR VPB sky130_fd_pr__pfet_01v8_hvt ad=0.26 pd=2.52 as=0.165 ps=1.33 w=1 l=0.15
X2 a_193_47# B a_109_47# VNB sky130_fd_pr__nfet_01v8 ad=0.10725 pd=0.98 as=0.08775 ps=0.92 w=0.65 l=0.15
X3 Y A a_193_47# VNB sky130_fd_pr__nfet_01v8 ad=0.169 pd=1.82 as=0.10725 ps=0.98 w=0.65 l=0.15
X4 Y C VPWR VPB sky130_fd_pr__pfet_01v8_hvt ad=0.135 pd=1.27 as=0.26 ps=2.52 w=1 l=0.15
X5 a_109_47# C VGND VNB sky130_fd_pr__nfet_01v8 ad=0.08775 pd=0.92 as=0.169 ps=1.82 w=0.65 l=0.15
C0 a_109_47# Y 0.01083f
C1 VPWR Y 0.18487f
C2 A VPB 0.03683f
C3 C VPB 0.03732f
C4 VPWR a_193_47# 0
C5 B VGND 0.01159f
C6 VPWR VPB 0.05586f
C7 Y VGND 0.11693f
C8 VPWR A 0.0185f
C9 VGND a_193_47# 0.00152f
C10 VPWR C 0.03597f
C11 VGND VPB 0.00519f
C12 VPWR a_109_47# 0
C13 B Y 0.09271f
C14 A VGND 0.0099f
C15 C VGND 0.03364f
C16 B a_193_47# 0.00347f
C17 Y a_193_47# 0.01172f
C18 a_109_47# VGND 0.00101f
C19 VPWR VGND 0.0233f
C20 B VPB 0.02678f
C21 Y VPB 0.01658f
C22 A B 0.04466f
C23 A Y 0.06625f
C24 B C 0.02548f
C25 C Y 0.04963f
C26 a_109_47# B 0
C27 VPWR B 0.01942f
C28 VGND VNB 0.26245f
C29 Y VNB 0.2301f
C30 VPWR VNB 0.38997f
C31 VPB VNB 0.42757f
.ends

.subckt sky130_fd_sc_hd__nor2_1 VPB VNB VGND VPWR A B Y
X0 VPWR A a_109_297# VPB sky130_fd_pr__pfet_01v8_hvt ad=0.26 pd=2.52 as=0.105 ps=1.21 w=1 l=0.15
X1 VGND A Y VNB sky130_fd_pr__nfet_01v8 ad=0.169 pd=1.82 as=0.08775 ps=0.92 w=0.65 l=0.15
X2 a_109_297# B Y VPB sky130_fd_pr__pfet_01v8_hvt ad=0.105 pd=1.21 as=0.26 ps=2.52 w=1 l=0.15
X3 Y B VGND VNB sky130_fd_pr__nfet_01v8 ad=0.08775 pd=0.92 as=0.169 ps=1.82 w=0.65 l=0.15
C0 VGND VPWR 0.01797f
C1 Y B 0.06339f
C2 a_109_297# VPWR 0.01162f
C3 Y VPWR 0.06054f
C4 VGND VPB 0.00456f
C5 Y VPB 0.01392f
C6 VGND a_109_297# 0.00128f
C7 Y VGND 0.08768f
C8 Y a_109_297# 0.01129f
C9 B A 0.02921f
C10 VPWR A 0.04414f
C11 A VPB 0.04146f
C12 B VPWR 0.01651f
C13 B VPB 0.0367f
C14 VGND A 0.03932f
C15 VPWR VPB 0.0536f
C16 Y A 0.03679f
C17 VGND B 0.03688f
C18 VGND VNB 0.26093f
C19 VPWR VNB 0.26273f
C20 Y VNB 0.1153f
C21 VPB VNB 0.33898f
C22 a_109_297# VNB 0.11272f
.ends

.subckt sky130_fd_sc_hd__o21ai_0 VNB VPB VGND VPWR B1 A1 Y A2
X0 a_120_369# A1 VPWR VPB sky130_fd_pr__pfet_01v8_hvt ad=0.0768 pd=0.88 as=0.1696 ps=1.81 w=0.64 l=0.15
X1 VGND A1 a_32_47# VNB sky130_fd_pr__nfet_01v8 ad=0.0588 pd=0.7 as=0.1113 ps=1.37 w=0.42 l=0.15
X2 Y A2 a_120_369# VPB sky130_fd_pr__pfet_01v8_hvt ad=0.0896 pd=0.92 as=0.0768 ps=0.88 w=0.64 l=0.15
X3 a_32_47# A2 VGND VNB sky130_fd_pr__nfet_01v8 ad=0.0588 pd=0.7 as=0.0588 ps=0.7 w=0.42 l=0.15
X4 VPWR B1 Y VPB sky130_fd_pr__pfet_01v8_hvt ad=0.1824 pd=1.85 as=0.0896 ps=0.92 w=0.64 l=0.15
X5 Y B1 a_32_47# VNB sky130_fd_pr__nfet_01v8 ad=0.1113 pd=1.37 as=0.0588 ps=0.7 w=0.42 l=0.15
C0 A2 A1 0.06205f
C1 a_32_47# Y 0.02803f
C2 VPWR Y 0.07539f
C3 Y A1 0.00752f
C4 a_120_369# VGND 0.00106f
C5 A2 VPB 0.05352f
C6 VPB Y 0.01182f
C7 A2 B1 0.04146f
C8 Y B1 0.06851f
C9 a_32_47# VGND 0.08552f
C10 VPWR VGND 0.01967f
C11 VGND A1 0.01873f
C12 a_32_47# a_120_369# 0
C13 VPWR a_120_369# 0.01097f
C14 VGND VPB 0.00603f
C15 VPWR a_32_47# 0.00348f
C16 a_32_47# A1 0.03304f
C17 VGND B1 0.01394f
C18 VPWR A1 0.04075f
C19 A2 Y 0.03875f
C20 a_32_47# VPB 0.00145f
C21 VPWR VPB 0.06242f
C22 VPB A1 0.07714f
C23 a_32_47# B1 0.00567f
C24 VPWR B1 0.03263f
C25 A2 VGND 0.01617f
C26 VGND Y 0.03116f
C27 a_120_369# A2 0.00326f
C28 a_120_369# Y 0.0043f
C29 VPB B1 0.0725f
C30 a_32_47# A2 0.02613f
C31 VPWR A2 0.02187f
C32 VGND VNB 0.25322f
C33 Y VNB 0.17593f
C34 VPWR VNB 0.41028f
C35 VPB VNB 0.42757f
C36 a_32_47# VNB 0.03132f
C37 a_120_369# VNB 0.12578f
.ends

.subckt sky130_fd_sc_hd__or2_1 VPB VNB VGND VPWR X A B
X0 VGND A a_68_297# VNB sky130_fd_pr__nfet_01v8 ad=0.10025 pd=0.985 as=0.0567 ps=0.69 w=0.42 l=0.15
X1 a_68_297# B VGND VNB sky130_fd_pr__nfet_01v8 ad=0.0567 pd=0.69 as=0.1092 ps=1.36 w=0.42 l=0.15
X2 X a_68_297# VGND VNB sky130_fd_pr__nfet_01v8 ad=0.169 pd=1.82 as=0.10025 ps=0.985 w=0.65 l=0.15
X3 VPWR A a_150_297# VPB sky130_fd_pr__pfet_01v8_hvt ad=0.14575 pd=1.335 as=0.0441 ps=0.63 w=0.42 l=0.15
X4 X a_68_297# VPWR VPB sky130_fd_pr__pfet_01v8_hvt ad=0.34 pd=2.68 as=0.14575 ps=1.335 w=1 l=0.15
X5 a_150_297# B a_68_297# VPB sky130_fd_pr__pfet_01v8_hvt ad=0.0441 pd=0.63 as=0.1092 ps=1.36 w=0.42 l=0.15
C0 B X 0
C1 VPWR a_150_297# 0.00203f
C2 a_68_297# a_150_297# 0.00477f
C3 VPWR VPB 0.09245f
C4 a_68_297# VPWR 0.06485f
C5 VPWR A 0.0088f
C6 a_68_297# VPB 0.06114f
C7 A VPB 0.03097f
C8 B VPWR 0.00836f
C9 a_68_297# A 0.09131f
C10 B VPB 0.0462f
C11 a_68_297# B 0.06593f
C12 B A 0.03754f
C13 X VGND 0.07473f
C14 VGND a_150_297# 0
C15 VPWR VGND 0.02487f
C16 VPB VGND 0.01133f
C17 X a_150_297# 0
C18 a_68_297# VGND 0.07904f
C19 A VGND 0.02939f
C20 VPWR X 0.08178f
C21 B VGND 0.03601f
C22 VPB X 0.0209f
C23 a_68_297# X 0.06633f
C24 A X 0.0083f
C25 VGND VNB 0.54651f
C26 X VNB 0.21764f
C27 VPWR VNB 0.25598f
C28 VPB VNB 0.51617f
.ends

.subckt sky130_fd_sc_hd__xnor2_1 VGND VPWR B Y A VPB VNB
X0 a_377_297# A VPWR VPB sky130_fd_pr__pfet_01v8_hvt ad=0.105 pd=1.21 as=0.365 ps=1.73 w=1 l=0.15
X1 a_47_47# B VPWR VPB sky130_fd_pr__pfet_01v8_hvt ad=0.135 pd=1.27 as=0.3 ps=2.6 w=1 l=0.15
X2 a_129_47# B a_47_47# VNB sky130_fd_pr__nfet_01v8 ad=0.06825 pd=0.86 as=0.169 ps=1.82 w=0.65 l=0.15
X3 a_285_47# B VGND VNB sky130_fd_pr__nfet_01v8 ad=0.08775 pd=0.92 as=0.169 ps=1.82 w=0.65 l=0.15
X4 Y a_47_47# a_285_47# VNB sky130_fd_pr__nfet_01v8 ad=0.195 pd=1.9 as=0.08775 ps=0.92 w=0.65 l=0.15
X5 VGND A a_129_47# VNB sky130_fd_pr__nfet_01v8 ad=0.08775 pd=0.92 as=0.06825 ps=0.86 w=0.65 l=0.15
X6 VPWR A a_47_47# VPB sky130_fd_pr__pfet_01v8_hvt ad=0.365 pd=1.73 as=0.135 ps=1.27 w=1 l=0.15
X7 VPWR a_47_47# Y VPB sky130_fd_pr__pfet_01v8_hvt ad=0.36 pd=2.72 as=0.165 ps=1.33 w=1 l=0.15
X8 Y B a_377_297# VPB sky130_fd_pr__pfet_01v8_hvt ad=0.165 pd=1.33 as=0.105 ps=1.21 w=1 l=0.15
X9 a_285_47# A VGND VNB sky130_fd_pr__nfet_01v8 ad=0.169 pd=1.82 as=0.08775 ps=0.92 w=0.65 l=0.15
C0 A a_47_47# 0.0307f
C1 VGND a_285_47# 0.12623f
C2 A Y 0.00181f
C3 VPWR A 0.03776f
C4 a_129_47# VGND 0.00952f
C5 VGND B 0.03773f
C6 VGND a_47_47# 0.07226f
C7 Y VGND 0.02832f
C8 VPWR VGND 0.03726f
C9 a_285_47# B 0.04134f
C10 A VPB 0.0822f
C11 a_47_47# a_285_47# 0.01271f
C12 a_129_47# B 0.00236f
C13 Y a_285_47# 0.02285f
C14 VPWR a_285_47# 0.00255f
C15 a_129_47# a_47_47# 0.00369f
C16 VPWR a_129_47# 0
C17 a_47_47# B 0.20369f
C18 VGND VPB 0.00583f
C19 Y B 0.00334f
C20 VPWR B 0.04493f
C21 Y a_47_47# 0.08783f
C22 VPWR a_47_47# 0.18092f
C23 VPWR Y 0.07481f
C24 VPB a_285_47# 0
C25 VGND a_377_297# 0.00125f
C26 VPB B 0.06468f
C27 VPB a_47_47# 0.04439f
C28 Y VPB 0.01105f
C29 VPWR VPB 0.0832f
C30 A VGND 0.0594f
C31 a_377_297# B 0.00254f
C32 a_377_297# a_47_47# 0.00899f
C33 Y a_377_297# 0.00188f
C34 A a_285_47# 0.02586f
C35 VPWR a_377_297# 0.00836f
C36 A B 0.13628f
C37 VGND VNB 0.39193f
C38 Y VNB 0.19517f
C39 VPWR VNB 0.48649f
C40 VPB VNB 0.69336f
C41 a_285_47# VNB 0.13511f
C42 a_377_297# VNB 0.07427f
.ends

.subckt sky130_fd_sc_hd__xor2_1 VNB VPB VPWR VGND A X B
X0 X a_35_297# a_285_297# VPB sky130_fd_pr__pfet_01v8_hvt ad=0.3 pd=2.6 as=0.26 ps=2.52 w=1 l=0.15
X1 X B a_285_47# VNB sky130_fd_pr__nfet_01v8 ad=0.25025 pd=1.42 as=0.08775 ps=0.92 w=0.65 l=0.15
X2 a_35_297# B VGND VNB sky130_fd_pr__nfet_01v8 ad=0.08775 pd=0.92 as=0.169 ps=1.82 w=0.65 l=0.15
X3 a_117_297# B a_35_297# VPB sky130_fd_pr__pfet_01v8_hvt ad=0.135 pd=1.27 as=0.26 ps=2.52 w=1 l=0.15
X4 VPWR B a_285_297# VPB sky130_fd_pr__pfet_01v8_hvt ad=0.26 pd=2.52 as=0.135 ps=1.27 w=1 l=0.15
X5 VGND A a_35_297# VNB sky130_fd_pr__nfet_01v8 ad=0.08775 pd=0.92 as=0.08775 ps=0.92 w=0.65 l=0.15
X6 VGND a_35_297# X VNB sky130_fd_pr__nfet_01v8 ad=0.208 pd=1.94 as=0.25025 ps=1.42 w=0.65 l=0.15
X7 a_285_297# A VPWR VPB sky130_fd_pr__pfet_01v8_hvt ad=0.135 pd=1.27 as=0.135 ps=1.27 w=1 l=0.15
X8 VPWR A a_117_297# VPB sky130_fd_pr__pfet_01v8_hvt ad=0.135 pd=1.27 as=0.135 ps=1.27 w=1 l=0.15
X9 a_285_47# A VGND VNB sky130_fd_pr__nfet_01v8 ad=0.08775 pd=0.92 as=0.08775 ps=0.92 w=0.65 l=0.15
C0 a_285_297# VPWR 0.14827f
C1 B VPWR 0.05753f
C2 a_35_297# X 0.11257f
C3 a_285_47# a_35_297# 0.00778f
C4 VGND a_35_297# 0.12298f
C5 VPB A 0.05101f
C6 B a_117_297# 0.00777f
C7 a_35_297# VPWR 0.06862f
C8 VPB a_285_297# 0.01327f
C9 B VPB 0.07078f
C10 a_285_47# X 0.00206f
C11 A a_285_297# 0.00749f
C12 B A 0.12571f
C13 VGND X 0.10675f
C14 a_285_47# VGND 0.00743f
C15 B a_285_297# 0.03769f
C16 VPWR X 0.03875f
C17 a_285_47# VPWR 0
C18 a_117_297# a_35_297# 0.00641f
C19 VPB a_35_297# 0.06993f
C20 VGND VPWR 0.03501f
C21 A a_35_297# 0.04725f
C22 a_285_297# a_35_297# 0.01818f
C23 a_117_297# X 0
C24 B a_35_297# 0.12181f
C25 VPB X 0.01604f
C26 VGND a_117_297# 0.00177f
C27 VPB VGND 0.00696f
C28 A X 0.00166f
C29 a_117_297# VPWR 0.01429f
C30 VPB VPWR 0.08344f
C31 a_285_297# X 0.03879f
C32 B X 0.01114f
C33 B a_285_47# 0
C34 A VGND 0.03284f
C35 a_285_297# VGND 0.00394f
C36 A VPWR 0.04026f
C37 B VGND 0.03045f
C38 VGND VNB 0.5053f
C39 X VNB 0.26782f
C40 VPWR VNB 0.31748f
C41 VPB VNB 0.69336f
C42 a_285_47# VNB 0.07244f
C43 a_285_297# VNB 0.1099f
.ends

.subckt sky130_fd_sc_hd__dfxtp_1 Q CLK D VPB VNB VPWR VGND
X0 Q a_1059_315# VGND VNB sky130_fd_pr__nfet_01v8 ad=0.169 pd=1.82 as=0.08775 ps=0.92 w=0.65 l=0.15
X1 a_891_413# a_193_47# a_634_159# VNB sky130_fd_pr__special_nfet_01v8 ad=0.0684 pd=0.74 as=0.0989 ps=0.995 w=0.36 l=0.15
X2 a_561_413# a_27_47# a_466_413# VPB sky130_fd_pr__pfet_01v8_hvt ad=0.07665 pd=0.785 as=0.06825 ps=0.745 w=0.42 l=0.15
X3 VPWR CLK a_27_47# VPB sky130_fd_pr__pfet_01v8_hvt ad=0.0864 pd=0.91 as=0.1664 ps=1.8 w=0.64 l=0.15
X4 Q a_1059_315# VPWR VPB sky130_fd_pr__pfet_01v8_hvt ad=0.26 pd=2.52 as=0.135 ps=1.27 w=1 l=0.15
X5 a_381_47# D VPWR VPB sky130_fd_pr__pfet_01v8_hvt ad=0.05775 pd=0.695 as=0.1092 ps=1.36 w=0.42 l=0.15
X6 VGND a_634_159# a_592_47# VNB sky130_fd_pr__nfet_01v8 ad=0.12095 pd=1.085 as=0.0696 ps=0.765 w=0.42 l=0.15
X7 VPWR a_891_413# a_1059_315# VPB sky130_fd_pr__pfet_01v8_hvt ad=0.135 pd=1.27 as=0.27 ps=2.54 w=1 l=0.15
X8 a_466_413# a_193_47# a_381_47# VPB sky130_fd_pr__pfet_01v8_hvt ad=0.06825 pd=0.745 as=0.05775 ps=0.695 w=0.42 l=0.15
X9 VPWR a_634_159# a_561_413# VPB sky130_fd_pr__pfet_01v8_hvt ad=0.17887 pd=1.26 as=0.07665 ps=0.785 w=0.42 l=0.15
X10 a_634_159# a_466_413# VGND VNB sky130_fd_pr__nfet_01v8 ad=0.0989 pd=0.995 as=0.12095 ps=1.085 w=0.64 l=0.15
X11 a_634_159# a_466_413# VPWR VPB sky130_fd_pr__pfet_01v8_hvt ad=0.1095 pd=1.075 as=0.17887 ps=1.26 w=0.75 l=0.15
X12 a_975_413# a_193_47# a_891_413# VPB sky130_fd_pr__pfet_01v8_hvt ad=0.0882 pd=0.84 as=0.0567 ps=0.69 w=0.42 l=0.15
X13 VGND a_1059_315# a_1017_47# VNB sky130_fd_pr__nfet_01v8 ad=0.1092 pd=1.36 as=0.066 ps=0.745 w=0.42 l=0.15
X14 a_193_47# a_27_47# VGND VNB sky130_fd_pr__nfet_01v8 ad=0.1092 pd=1.36 as=0.0567 ps=0.69 w=0.42 l=0.15
X15 a_891_413# a_27_47# a_634_159# VPB sky130_fd_pr__pfet_01v8_hvt ad=0.0567 pd=0.69 as=0.1095 ps=1.075 w=0.42 l=0.15
X16 a_592_47# a_193_47# a_466_413# VNB sky130_fd_pr__special_nfet_01v8 ad=0.0696 pd=0.765 as=0.0621 ps=0.705 w=0.36 l=0.15
X17 VPWR a_1059_315# a_975_413# VPB sky130_fd_pr__pfet_01v8_hvt ad=0.1113 pd=1.37 as=0.0882 ps=0.84 w=0.42 l=0.15
X18 a_1017_47# a_27_47# a_891_413# VNB sky130_fd_pr__special_nfet_01v8 ad=0.066 pd=0.745 as=0.0684 ps=0.74 w=0.36 l=0.15
X19 a_193_47# a_27_47# VPWR VPB sky130_fd_pr__pfet_01v8_hvt ad=0.1664 pd=1.8 as=0.0864 ps=0.91 w=0.64 l=0.15
X20 a_466_413# a_27_47# a_381_47# VNB sky130_fd_pr__special_nfet_01v8 ad=0.0621 pd=0.705 as=0.0813 ps=0.83 w=0.36 l=0.15
X21 VGND a_891_413# a_1059_315# VNB sky130_fd_pr__nfet_01v8 ad=0.08775 pd=0.92 as=0.169 ps=1.82 w=0.65 l=0.15
X22 a_381_47# D VGND VNB sky130_fd_pr__nfet_01v8 ad=0.0813 pd=0.83 as=0.1092 ps=1.36 w=0.42 l=0.15
X23 VGND CLK a_27_47# VNB sky130_fd_pr__nfet_01v8 ad=0.0567 pd=0.69 as=0.1092 ps=1.36 w=0.42 l=0.15
C0 a_1059_315# VPWR 0.15531f
C1 a_891_413# a_975_413# 0.00851f
C2 VPWR VGND 0.03429f
C3 a_381_47# a_561_413# 0.00138f
C4 a_27_47# a_466_413# 0.16041f
C5 VPWR D 0.02136f
C6 a_592_47# a_466_413# 0.00553f
C7 a_634_159# a_1017_47# 0
C8 a_634_159# a_381_47# 0
C9 a_634_159# a_193_47# 0.08347f
C10 a_891_413# VPB 0.07294f
C11 a_466_413# VPWR 0.1177f
C12 a_193_47# CLK 0.0036f
C13 a_27_47# a_561_413# 0.0027f
C14 a_1059_315# a_891_413# 0.20625f
C15 a_975_413# VGND 0
C16 a_891_413# VGND 0.09168f
C17 a_634_159# a_27_47# 0.09081f
C18 a_634_159# a_592_47# 0
C19 a_561_413# VPWR 0.00405f
C20 a_27_47# CLK 0.12923f
C21 a_1059_315# VPB 0.15529f
C22 VGND VPB 0.01254f
C23 a_634_159# VPWR 0.0637f
C24 D VPB 0.09689f
C25 a_193_47# Q 0
C26 a_1059_315# VGND 0.11035f
C27 VPWR CLK 0.01847f
C28 a_193_47# a_381_47# 0.06685f
C29 D VGND 0.03089f
C30 a_466_413# VPB 0.07827f
C31 a_27_47# Q 0
C32 a_634_159# a_975_413# 0.00131f
C33 a_634_159# a_891_413# 0.0205f
C34 a_466_413# VGND 0.06439f
C35 a_381_47# a_27_47# 0.04548f
C36 a_193_47# a_27_47# 0.56916f
C37 a_193_47# a_592_47# 0.00135f
C38 VPWR Q 0.066f
C39 a_1017_47# VPWR 0
C40 a_381_47# VPWR 0.03764f
C41 a_634_159# VPB 0.07963f
C42 a_193_47# VPWR 0.07893f
C43 CLK VPB 0.07006f
C44 a_634_159# a_1059_315# 0
C45 a_634_159# VGND 0.08746f
C46 CLK VGND 0.01841f
C47 a_27_47# VPWR 0.23561f
C48 a_891_413# Q 0.00215f
C49 a_561_413# a_466_413# 0.00772f
C50 a_1017_47# a_891_413# 0.00617f
C51 a_193_47# a_975_413# 0
C52 a_193_47# a_891_413# 0.1112f
C53 a_634_159# a_466_413# 0.16113f
C54 VPB Q 0.01383f
C55 a_381_47# VPB 0.01589f
C56 a_193_47# VPB 0.17849f
C57 a_1059_315# Q 0.05378f
C58 a_891_413# a_27_47# 0.03079f
C59 VGND Q 0.04838f
C60 a_1059_315# a_1017_47# 0
C61 a_1017_47# VGND 0.0056f
C62 a_381_47# VGND 0.03617f
C63 a_193_47# a_1059_315# 0.01914f
C64 a_193_47# VGND 0.12656f
C65 a_381_47# D 0.07311f
C66 a_193_47# D 0.10493f
C67 a_975_413# VPWR 0.00521f
C68 a_891_413# VPWR 0.08369f
C69 a_27_47# VPB 0.25419f
C70 a_1059_315# a_27_47# 0.02545f
C71 a_381_47# a_466_413# 0.02068f
C72 a_27_47# VGND 0.10295f
C73 a_193_47# a_466_413# 0.07623f
C74 a_592_47# VGND 0.00814f
C75 VPWR VPB 0.19712f
C76 a_27_47# D 0.03838f
C77 Q VNB 0.17906f
C78 VGND VNB 1.25914f
C79 VPWR VNB 0.90023f
C80 VPB VNB 1.49072f
C81 a_1017_47# VNB 0.05752f
C82 a_592_47# VNB 0.12575f
C83 a_561_413# VNB 0.16996f
C84 a_381_47# VNB 0.06738f
C85 a_466_413# VNB 0.02035f
C86 a_634_159# VNB 0.13266f
.ends

* added for post-layout SPICE: cells OpenROAD inserts in the routed multiplier layouts
.subckt sky130_fd_sc_hd__buf_4 VPWR VGND X A VPB VNB
X0 VPWR a_27_47# X VPB sky130_fd_pr__pfet_01v8_hvt ad=0.26 pd=2.52 as=0.135 ps=1.27 w=1 l=0.15
X1 X a_27_47# VPWR VPB sky130_fd_pr__pfet_01v8_hvt ad=0.135 pd=1.27 as=0.135 ps=1.27 w=1 l=0.15
X2 VPWR a_27_47# X VPB sky130_fd_pr__pfet_01v8_hvt ad=0.135 pd=1.27 as=0.135 ps=1.27 w=1 l=0.15
X3 X a_27_47# VPWR VPB sky130_fd_pr__pfet_01v8_hvt ad=0.135 pd=1.27 as=0.135 ps=1.27 w=1 l=0.15
X4 X a_27_47# VGND VNB sky130_fd_pr__nfet_01v8 ad=0.08775 pd=0.92 as=0.08775 ps=0.92 w=0.65 l=0.15
X5 X a_27_47# VGND VNB sky130_fd_pr__nfet_01v8 ad=0.08775 pd=0.92 as=0.08775 ps=0.92 w=0.65 l=0.15
X6 VGND a_27_47# X VNB sky130_fd_pr__nfet_01v8 ad=0.08775 pd=0.92 as=0.08775 ps=0.92 w=0.65 l=0.15
X7 VGND a_27_47# X VNB sky130_fd_pr__nfet_01v8 ad=0.169 pd=1.82 as=0.08775 ps=0.92 w=0.65 l=0.15
X8 VPWR A a_27_47# VPB sky130_fd_pr__pfet_01v8_hvt ad=0.135 pd=1.27 as=0.26 ps=2.52 w=1 l=0.15
X9 VGND A a_27_47# VNB sky130_fd_pr__nfet_01v8 ad=0.08775 pd=0.92 as=0.169 ps=1.82 w=0.65 l=0.15
C0 X VPWR 0.19182f
C1 VPWR A 0.01839f
C2 VPB a_27_47# 0.13472f
C3 X A 0.00145f
C4 VGND VPWR 0.03971f
C5 VGND X 0.13928f
C6 VGND A 0.01844f
C7 VPB VPWR 0.08072f
C8 VPWR a_27_47# 0.17035f
C9 VPB X 0.01753f
C10 X a_27_47# 0.18738f
C11 VPB A 0.03609f
C12 A a_27_47# 0.10851f
C13 VGND VPB 0.00995f
C14 VGND a_27_47# 0.13425f
C15 VGND VNB 0.37171f
C16 X VNB 0.1875f
C17 VPWR VNB 0.52844f
C18 VPB VNB 0.60476f
C19 a_27_47# VNB 0.05331f
.ends

.subckt sky130_fd_sc_hd__bufinv_16 VNB VPB VGND VPWR A Y
X0 a_361_47# a_27_47# VGND VNB sky130_fd_pr__nfet_01v8 ad=0.08775 pd=0.92 as=0.08775 ps=0.92 w=0.65 l=0.15
X1 VPWR a_361_47# Y VPB sky130_fd_pr__pfet_01v8_hvt ad=0.135 pd=1.27 as=0.135 ps=1.27 w=1 l=0.15
X2 a_361_47# a_27_47# VGND VNB sky130_fd_pr__nfet_01v8 ad=0.08775 pd=0.92 as=0.08775 ps=0.92 w=0.65 l=0.15
X3 Y a_361_47# VGND VNB sky130_fd_pr__nfet_01v8 ad=0.08775 pd=0.92 as=0.08775 ps=0.92 w=0.65 l=0.15
X4 VPWR a_361_47# Y VPB sky130_fd_pr__pfet_01v8_hvt ad=0.135 pd=1.27 as=0.135 ps=1.27 w=1 l=0.15
X5 Y a_361_47# VGND VNB sky130_fd_pr__nfet_01v8 ad=0.08775 pd=0.92 as=0.08775 ps=0.92 w=0.65 l=0.15
X6 Y a_361_47# VPWR VPB sky130_fd_pr__pfet_01v8_hvt ad=0.135 pd=1.27 as=0.135 ps=1.27 w=1 l=0.15
X7 VPWR a_27_47# a_361_47# VPB sky130_fd_pr__pfet_01v8_hvt ad=0.135 pd=1.27 as=0.135 ps=1.27 w=1 l=0.15
X8 VPWR a_361_47# Y VPB sky130_fd_pr__pfet_01v8_hvt ad=0.26 pd=2.52 as=0.135 ps=1.27 w=1 l=0.15
X9 VPWR a_361_47# Y VPB sky130_fd_pr__pfet_01v8_hvt ad=0.135 pd=1.27 as=0.135 ps=1.27 w=1 l=0.15
X10 VGND a_361_47# Y VNB sky130_fd_pr__nfet_01v8 ad=0.169 pd=1.82 as=0.08775 ps=0.92 w=0.65 l=0.15
X11 a_361_47# a_27_47# VPWR VPB sky130_fd_pr__pfet_01v8_hvt ad=0.135 pd=1.27 as=0.135 ps=1.27 w=1 l=0.15
X12 VGND a_361_47# Y VNB sky130_fd_pr__nfet_01v8 ad=0.08775 pd=0.92 as=0.08775 ps=0.92 w=0.65 l=0.15
X13 VGND a_361_47# Y VNB sky130_fd_pr__nfet_01v8 ad=0.08775 pd=0.92 as=0.08775 ps=0.92 w=0.65 l=0.15
X14 VGND a_361_47# Y VNB sky130_fd_pr__nfet_01v8 ad=0.08775 pd=0.92 as=0.08775 ps=0.92 w=0.65 l=0.15
X15 VGND a_361_47# Y VNB sky130_fd_pr__nfet_01v8 ad=0.08775 pd=0.92 as=0.08775 ps=0.92 w=0.65 l=0.15
X16 VPWR A a_27_47# VPB sky130_fd_pr__pfet_01v8_hvt ad=0.135 pd=1.27 as=0.135 ps=1.27 w=1 l=0.15
X17 Y a_361_47# VPWR VPB sky130_fd_pr__pfet_01v8_hvt ad=0.135 pd=1.27 as=0.135 ps=1.27 w=1 l=0.15
X18 VGND a_361_47# Y VNB sky130_fd_pr__nfet_01v8 ad=0.08775 pd=0.92 as=0.08775 ps=0.92 w=0.65 l=0.15
X19 VPWR a_361_47# Y VPB sky130_fd_pr__pfet_01v8_hvt ad=0.135 pd=1.27 as=0.135 ps=1.27 w=1 l=0.15
X20 a_27_47# A VPWR VPB sky130_fd_pr__pfet_01v8_hvt ad=0.135 pd=1.27 as=0.135 ps=1.27 w=1 l=0.15
X21 Y a_361_47# VPWR VPB sky130_fd_pr__pfet_01v8_hvt ad=0.135 pd=1.27 as=0.135 ps=1.27 w=1 l=0.15
X22 a_27_47# A VGND VNB sky130_fd_pr__nfet_01v8 ad=0.08775 pd=0.92 as=0.08775 ps=0.92 w=0.65 l=0.15
X23 a_361_47# a_27_47# VGND VNB sky130_fd_pr__nfet_01v8 ad=0.08775 pd=0.92 as=0.08775 ps=0.92 w=0.65 l=0.15
X24 Y a_361_47# VPWR VPB sky130_fd_pr__pfet_01v8_hvt ad=0.135 pd=1.27 as=0.135 ps=1.27 w=1 l=0.15
X25 Y a_361_47# VGND VNB sky130_fd_pr__nfet_01v8 ad=0.08775 pd=0.92 as=0.08775 ps=0.92 w=0.65 l=0.15
X26 VPWR a_27_47# a_361_47# VPB sky130_fd_pr__pfet_01v8_hvt ad=0.135 pd=1.27 as=0.135 ps=1.27 w=1 l=0.15
X27 Y a_361_47# VGND VNB sky130_fd_pr__nfet_01v8 ad=0.08775 pd=0.92 as=0.08775 ps=0.92 w=0.65 l=0.15
X28 Y a_361_47# VPWR VPB sky130_fd_pr__pfet_01v8_hvt ad=0.135 pd=1.27 as=0.135 ps=1.27 w=1 l=0.15
X29 Y a_361_47# VGND VNB sky130_fd_pr__nfet_01v8 ad=0.08775 pd=0.92 as=0.08775 ps=0.92 w=0.65 l=0.15
X30 a_361_47# a_27_47# VPWR VPB sky130_fd_pr__pfet_01v8_hvt ad=0.135 pd=1.27 as=0.135 ps=1.27 w=1 l=0.15
X31 VPWR a_361_47# Y VPB sky130_fd_pr__pfet_01v8_hvt ad=0.135 pd=1.27 as=0.135 ps=1.27 w=1 l=0.15
X32 Y a_361_47# VGND VNB sky130_fd_pr__nfet_01v8 ad=0.08775 pd=0.92 as=0.08775 ps=0.92 w=0.65 l=0.15
X33 VGND A a_27_47# VNB sky130_fd_pr__nfet_01v8 ad=0.08775 pd=0.92 as=0.08775 ps=0.92 w=0.65 l=0.15
X34 VGND a_27_47# a_361_47# VNB sky130_fd_pr__nfet_01v8 ad=0.08775 pd=0.92 as=0.08775 ps=0.92 w=0.65 l=0.15
X35 VPWR a_27_47# a_361_47# VPB sky130_fd_pr__pfet_01v8_hvt ad=0.135 pd=1.27 as=0.135 ps=1.27 w=1 l=0.15
X36 Y a_361_47# VPWR VPB sky130_fd_pr__pfet_01v8_hvt ad=0.135 pd=1.27 as=0.135 ps=1.27 w=1 l=0.15
X37 VGND a_27_47# a_361_47# VNB sky130_fd_pr__nfet_01v8 ad=0.08775 pd=0.92 as=0.08775 ps=0.92 w=0.65 l=0.15
X38 VGND a_27_47# a_361_47# VNB sky130_fd_pr__nfet_01v8 ad=0.08775 pd=0.92 as=0.08775 ps=0.92 w=0.65 l=0.15
X39 a_361_47# a_27_47# VPWR VPB sky130_fd_pr__pfet_01v8_hvt ad=0.135 pd=1.27 as=0.135 ps=1.27 w=1 l=0.15
X40 VPWR a_361_47# Y VPB sky130_fd_pr__pfet_01v8_hvt ad=0.135 pd=1.27 as=0.135 ps=1.27 w=1 l=0.15
X41 VPWR a_361_47# Y VPB sky130_fd_pr__pfet_01v8_hvt ad=0.135 pd=1.27 as=0.135 ps=1.27 w=1 l=0.15
X42 VGND a_361_47# Y VNB sky130_fd_pr__nfet_01v8 ad=0.08775 pd=0.92 as=0.08775 ps=0.92 w=0.65 l=0.15
X43 VGND a_361_47# Y VNB sky130_fd_pr__nfet_01v8 ad=0.08775 pd=0.92 as=0.08775 ps=0.92 w=0.65 l=0.15
X44 VPWR A a_27_47# VPB sky130_fd_pr__pfet_01v8_hvt ad=0.135 pd=1.27 as=0.26 ps=2.52 w=1 l=0.15
X45 Y a_361_47# VPWR VPB sky130_fd_pr__pfet_01v8_hvt ad=0.135 pd=1.27 as=0.135 ps=1.27 w=1 l=0.15
X46 Y a_361_47# VGND VNB sky130_fd_pr__nfet_01v8 ad=0.08775 pd=0.92 as=0.08775 ps=0.92 w=0.65 l=0.15
X47 Y a_361_47# VPWR VPB sky130_fd_pr__pfet_01v8_hvt ad=0.135 pd=1.27 as=0.135 ps=1.27 w=1 l=0.15
X48 VGND A a_27_47# VNB sky130_fd_pr__nfet_01v8 ad=0.08775 pd=0.92 as=0.169 ps=1.82 w=0.65 l=0.15
X49 Y a_361_47# VGND VNB sky130_fd_pr__nfet_01v8 ad=0.08775 pd=0.92 as=0.08775 ps=0.92 w=0.65 l=0.15
C0 A VPB 0.08817f
C1 a_27_47# VPWR 0.30389f
C2 a_361_47# Y 1.14819f
C3 a_27_47# VGND 0.24446f
C4 VPB a_361_47# 0.51914f
C5 A VPWR 0.05703f
C6 A VGND 0.04821f
C7 VPWR a_361_47# 0.62517f
C8 VGND a_361_47# 0.50648f
C9 VPB Y 0.03485f
C10 VPWR Y 0.85004f
C11 a_27_47# A 0.25055f
C12 VPWR VPB 0.27738f
C13 VGND Y 0.64578f
C14 VGND VPB 0.01272f
C15 a_27_47# a_361_47# 0.44383f
C16 A a_361_47# 0.00148f
C17 VPWR VGND 0.12753f
C18 a_27_47# Y 0.0017f
C19 a_27_47# VPB 0.1979f
C20 VGND VNB 1.42096f
C21 Y VNB 0.69277f
C22 VPWR VNB 1.65898f
C23 VPB VNB 2.19949f
.ends

.subckt sky130_fd_sc_hd__clkbuf_1 VGND VPWR X A VPB VNB
X0 VPWR a_75_212# X VPB sky130_fd_pr__pfet_01v8_hvt ad=0.11455 pd=1.08 as=0.2054 ps=2.1 w=0.79 l=0.15
X1 a_75_212# A VGND VNB sky130_fd_pr__nfet_01v8 ad=0.1352 pd=1.56 as=0.0754 ps=0.81 w=0.52 l=0.15
X2 a_75_212# A VPWR VPB sky130_fd_pr__pfet_01v8_hvt ad=0.2054 pd=2.1 as=0.11455 ps=1.08 w=0.79 l=0.15
X3 VGND a_75_212# X VNB sky130_fd_pr__nfet_01v8 ad=0.0754 pd=0.81 as=0.1352 ps=1.56 w=0.52 l=0.15
C0 VGND VPWR 0.01544f
C1 VPWR X 0.05434f
C2 VPB VPWR 0.03869f
C3 a_75_212# VPWR 0.08784f
C4 VGND X 0.03663f
C5 VGND VPB 0.00507f
C6 a_75_212# VGND 0.07292f
C7 VPB X 0.01279f
C8 a_75_212# X 0.06483f
C9 a_75_212# VPB 0.06061f
C10 A VPWR 0.02111f
C11 A VGND 0.01757f
C12 A X 0.00151f
C13 A VPB 0.05249f
C14 a_75_212# A 0.11316f
C15 VGND VNB 0.30467f
C16 VPWR VNB 0.25831f
C17 X VNB 0.21109f
C18 VPB VNB 0.33898f
.ends

.subckt sky130_fd_sc_hd__clkbuf_8 X A VPB VNB VGND VPWR
X0 VPWR A a_110_47# VPB sky130_fd_pr__pfet_01v8_hvt ad=0.14 pd=1.28 as=0.14 ps=1.28 w=1 l=0.15
X1 VPWR a_110_47# X VPB sky130_fd_pr__pfet_01v8_hvt ad=0.14 pd=1.28 as=0.14 ps=1.28 w=1 l=0.15
X2 X a_110_47# VPWR VPB sky130_fd_pr__pfet_01v8_hvt ad=0.14 pd=1.28 as=0.14 ps=1.28 w=1 l=0.15
X3 a_110_47# A VPWR VPB sky130_fd_pr__pfet_01v8_hvt ad=0.14 pd=1.28 as=0.265 ps=2.53 w=1 l=0.15
X4 X a_110_47# VGND VNB sky130_fd_pr__nfet_01v8 ad=0.0588 pd=0.7 as=0.0588 ps=0.7 w=0.42 l=0.15
X5 X a_110_47# VPWR VPB sky130_fd_pr__pfet_01v8_hvt ad=0.14 pd=1.28 as=0.14 ps=1.28 w=1 l=0.15
X6 VGND a_110_47# X VNB sky130_fd_pr__nfet_01v8 ad=0.0588 pd=0.7 as=0.0588 ps=0.7 w=0.42 l=0.15
X7 VPWR a_110_47# X VPB sky130_fd_pr__pfet_01v8_hvt ad=0.14 pd=1.28 as=0.14 ps=1.28 w=1 l=0.15
X8 VGND A a_110_47# VNB sky130_fd_pr__nfet_01v8 ad=0.0588 pd=0.7 as=0.0588 ps=0.7 w=0.42 l=0.15
X9 VGND a_110_47# X VNB sky130_fd_pr__nfet_01v8 ad=0.1134 pd=1.38 as=0.0588 ps=0.7 w=0.42 l=0.15
X10 a_110_47# A VGND VNB sky130_fd_pr__nfet_01v8 ad=0.0588 pd=0.7 as=0.1113 ps=1.37 w=0.42 l=0.15
X11 VPWR a_110_47# X VPB sky130_fd_pr__pfet_01v8_hvt ad=0.14 pd=1.28 as=0.14 ps=1.28 w=1 l=0.15
X12 X a_110_47# VPWR VPB sky130_fd_pr__pfet_01v8_hvt ad=0.14 pd=1.28 as=0.14 ps=1.28 w=1 l=0.15
X13 VGND a_110_47# X VNB sky130_fd_pr__nfet_01v8 ad=0.0588 pd=0.7 as=0.0588 ps=0.7 w=0.42 l=0.15
X14 VGND a_110_47# X VNB sky130_fd_pr__nfet_01v8 ad=0.0588 pd=0.7 as=0.0588 ps=0.7 w=0.42 l=0.15
X15 X a_110_47# VPWR VPB sky130_fd_pr__pfet_01v8_hvt ad=0.14 pd=1.28 as=0.14 ps=1.28 w=1 l=0.15
X16 X a_110_47# VGND VNB sky130_fd_pr__nfet_01v8 ad=0.0588 pd=0.7 as=0.0588 ps=0.7 w=0.42 l=0.15
X17 VPWR a_110_47# X VPB sky130_fd_pr__pfet_01v8_hvt ad=0.265 pd=2.53 as=0.14 ps=1.28 w=1 l=0.15
X18 X a_110_47# VGND VNB sky130_fd_pr__nfet_01v8 ad=0.0588 pd=0.7 as=0.0588 ps=0.7 w=0.42 l=0.15
X19 X a_110_47# VGND VNB sky130_fd_pr__nfet_01v8 ad=0.0588 pd=0.7 as=0.0588 ps=0.7 w=0.42 l=0.15
C0 A a_110_47# 0.13685f
C1 VPWR X 0.41321f
C2 VPWR VPB 0.13555f
C3 VPB X 0.02232f
C4 VGND VPWR 0.05883f
C5 VGND X 0.29404f
C6 VPWR a_110_47# 0.29075f
C7 a_110_47# X 0.54666f
C8 VGND VPB 0.01098f
C9 VPB a_110_47# 0.26091f
C10 VPWR A 0.06988f
C11 A X 0.00168f
C12 VGND a_110_47# 0.21582f
C13 A VPB 0.07074f
C14 VGND A 0.05824f
C15 VGND VNB 0.59864f
C16 X VNB 0.44184f
C17 VPWR VNB 0.97731f
C18 VPB VNB 1.04774f
.ends

.subckt sky130_fd_sc_hd__clkbuf_16 VNB VPB VGND VPWR A X
X0 VPWR A a_110_47# VPB sky130_fd_pr__pfet_01v8_hvt ad=0.14 pd=1.28 as=0.14 ps=1.28 w=1 l=0.15
X1 VPWR a_110_47# X VPB sky130_fd_pr__pfet_01v8_hvt ad=0.14 pd=1.28 as=0.14 ps=1.28 w=1 l=0.15
X2 X a_110_47# VPWR VPB sky130_fd_pr__pfet_01v8_hvt ad=0.14 pd=1.28 as=0.14 ps=1.28 w=1 l=0.15
X3 X a_110_47# VPWR VPB sky130_fd_pr__pfet_01v8_hvt ad=0.14 pd=1.28 as=0.14 ps=1.28 w=1 l=0.15
X4 VPWR a_110_47# X VPB sky130_fd_pr__pfet_01v8_hvt ad=0.14 pd=1.28 as=0.14 ps=1.28 w=1 l=0.15
X5 VPWR a_110_47# X VPB sky130_fd_pr__pfet_01v8_hvt ad=0.265 pd=2.53 as=0.14 ps=1.28 w=1 l=0.15
X6 a_110_47# A VPWR VPB sky130_fd_pr__pfet_01v8_hvt ad=0.14 pd=1.28 as=0.265 ps=2.53 w=1 l=0.15
X7 a_110_47# A VGND VNB sky130_fd_pr__nfet_01v8 ad=0.0588 pd=0.7 as=0.0588 ps=0.7 w=0.42 l=0.15
X8 VGND a_110_47# X VNB sky130_fd_pr__nfet_01v8 ad=0.0588 pd=0.7 as=0.0588 ps=0.7 w=0.42 l=0.15
X9 X a_110_47# VGND VNB sky130_fd_pr__nfet_01v8 ad=0.0588 pd=0.7 as=0.0588 ps=0.7 w=0.42 l=0.15
X10 VGND a_110_47# X VNB sky130_fd_pr__nfet_01v8 ad=0.0588 pd=0.7 as=0.0588 ps=0.7 w=0.42 l=0.15
X11 a_110_47# A VPWR VPB sky130_fd_pr__pfet_01v8_hvt ad=0.14 pd=1.28 as=0.14 ps=1.28 w=1 l=0.15
X12 VGND A a_110_47# VNB sky130_fd_pr__nfet_01v8 ad=0.0588 pd=0.7 as=0.0588 ps=0.7 w=0.42 l=0.15
X13 VGND a_110_47# X VNB sky130_fd_pr__nfet_01v8 ad=0.05775 pd=0.695 as=0.0588 ps=0.7 w=0.42 l=0.15
X14 VPWR a_110_47# X VPB sky130_fd_pr__pfet_01v8_hvt ad=0.14 pd=1.28 as=0.14 ps=1.28 w=1 l=0.15
X15 X a_110_47# VPWR VPB sky130_fd_pr__pfet_01v8_hvt ad=0.14 pd=1.28 as=0.14 ps=1.28 w=1 l=0.15
X16 VGND A a_110_47# VNB sky130_fd_pr__nfet_01v8 ad=0.0588 pd=0.7 as=0.0588 ps=0.7 w=0.42 l=0.15
X17 VGND a_110_47# X VNB sky130_fd_pr__nfet_01v8 ad=0.1113 pd=1.37 as=0.0588 ps=0.7 w=0.42 l=0.15
X18 VPWR a_110_47# X VPB sky130_fd_pr__pfet_01v8_hvt ad=0.1375 pd=1.275 as=0.14 ps=1.28 w=1 l=0.15
X19 VGND a_110_47# X VNB sky130_fd_pr__nfet_01v8 ad=0.0588 pd=0.7 as=0.0588 ps=0.7 w=0.42 l=0.15
X20 X a_110_47# VPWR VPB sky130_fd_pr__pfet_01v8_hvt ad=0.14 pd=1.28 as=0.1375 ps=1.275 w=1 l=0.15
X21 a_110_47# A VGND VNB sky130_fd_pr__nfet_01v8 ad=0.0588 pd=0.7 as=0.1113 ps=1.37 w=0.42 l=0.15
X22 VPWR A a_110_47# VPB sky130_fd_pr__pfet_01v8_hvt ad=0.14 pd=1.28 as=0.14 ps=1.28 w=1 l=0.15
X23 VPWR a_110_47# X VPB sky130_fd_pr__pfet_01v8_hvt ad=0.14 pd=1.28 as=0.14 ps=1.28 w=1 l=0.15
X24 VPWR a_110_47# X VPB sky130_fd_pr__pfet_01v8_hvt ad=0.14 pd=1.28 as=0.14 ps=1.28 w=1 l=0.15
X25 VGND a_110_47# X VNB sky130_fd_pr__nfet_01v8 ad=0.0588 pd=0.7 as=0.0588 ps=0.7 w=0.42 l=0.15
X26 X a_110_47# VPWR VPB sky130_fd_pr__pfet_01v8_hvt ad=0.14 pd=1.28 as=0.14 ps=1.28 w=1 l=0.15
X27 VGND a_110_47# X VNB sky130_fd_pr__nfet_01v8 ad=0.0588 pd=0.7 as=0.0588 ps=0.7 w=0.42 l=0.15
X28 VGND a_110_47# X VNB sky130_fd_pr__nfet_01v8 ad=0.0588 pd=0.7 as=0.0588 ps=0.7 w=0.42 l=0.15
X29 X a_110_47# VGND VNB sky130_fd_pr__nfet_01v8 ad=0.0588 pd=0.7 as=0.0588 ps=0.7 w=0.42 l=0.15
X30 X a_110_47# VPWR VPB sky130_fd_pr__pfet_01v8_hvt ad=0.14 pd=1.28 as=0.14 ps=1.28 w=1 l=0.15
X31 X a_110_47# VPWR VPB sky130_fd_pr__pfet_01v8_hvt ad=0.14 pd=1.28 as=0.14 ps=1.28 w=1 l=0.15
X32 X a_110_47# VGND VNB sky130_fd_pr__nfet_01v8 ad=0.0588 pd=0.7 as=0.0588 ps=0.7 w=0.42 l=0.15
X33 VPWR a_110_47# X VPB sky130_fd_pr__pfet_01v8_hvt ad=0.14 pd=1.28 as=0.14 ps=1.28 w=1 l=0.15
X34 X a_110_47# VPWR VPB sky130_fd_pr__pfet_01v8_hvt ad=0.14 pd=1.28 as=0.14 ps=1.28 w=1 l=0.15
X35 X a_110_47# VGND VNB sky130_fd_pr__nfet_01v8 ad=0.0588 pd=0.7 as=0.0588 ps=0.7 w=0.42 l=0.15
X36 X a_110_47# VGND VNB sky130_fd_pr__nfet_01v8 ad=0.0588 pd=0.7 as=0.0588 ps=0.7 w=0.42 l=0.15
X37 X a_110_47# VGND VNB sky130_fd_pr__nfet_01v8 ad=0.0588 pd=0.7 as=0.0588 ps=0.7 w=0.42 l=0.15
X38 X a_110_47# VGND VNB sky130_fd_pr__nfet_01v8 ad=0.0588 pd=0.7 as=0.0588 ps=0.7 w=0.42 l=0.15
X39 X a_110_47# VGND VNB sky130_fd_pr__nfet_01v8 ad=0.0588 pd=0.7 as=0.05775 ps=0.695 w=0.42 l=0.15
C0 VPB VGND 0.01166f
C1 a_110_47# VPWR 0.53192f
C2 a_110_47# A 0.2524f
C3 X a_110_47# 1.15602f
C4 a_110_47# VGND 0.44143f
C5 A VPWR 0.10579f
C6 X VPWR 0.79762f
C7 a_110_47# VPB 0.52756f
C8 VGND VPWR 0.10405f
C9 X A 0.00292f
C10 VPB VPWR 0.1935f
C11 VGND A 0.10285f
C12 X VGND 0.5821f
C13 VPB A 0.1334f
C14 X VPB 0.03148f
C15 VGND VNB 1.00249f
C16 X VNB 0.79867f
C17 VPWR VNB 1.69407f
C18 VPB VNB 1.84511f
.ends

.subckt sky130_fd_sc_hd__clkdlybuf4s50_1 VNB VPB VGND VPWR A X
X0 a_283_47# a_27_47# VPWR VPB sky130_fd_pr__pfet_01v8_hvt ad=0.2173 pd=2.17 as=0.1701 ps=1.36 w=0.82 l=0.5
X1 VPWR A a_27_47# VPB sky130_fd_pr__pfet_01v8_hvt ad=0.1701 pd=1.36 as=0.27 ps=2.54 w=1 l=0.15
X2 VPWR a_283_47# a_390_47# VPB sky130_fd_pr__pfet_01v8_hvt ad=0.15575 pd=1.325 as=0.2173 ps=2.17 w=0.82 l=0.5
X3 VGND a_283_47# a_390_47# VNB sky130_fd_pr__nfet_01v8 ad=0.097 pd=0.975 as=0.17225 ps=1.83 w=0.65 l=0.5
X4 X a_390_47# VPWR VPB sky130_fd_pr__pfet_01v8_hvt ad=0.355 pd=2.71 as=0.15575 ps=1.325 w=1 l=0.15
X5 VGND A a_27_47# VNB sky130_fd_pr__nfet_01v8 ad=0.10435 pd=1.01 as=0.1134 ps=1.38 w=0.42 l=0.15
X6 a_283_47# a_27_47# VGND VNB sky130_fd_pr__nfet_01v8 ad=0.169 pd=1.82 as=0.10435 ps=1.01 w=0.65 l=0.5
X7 X a_390_47# VGND VNB sky130_fd_pr__nfet_01v8 ad=0.1491 pd=1.55 as=0.097 ps=0.975 w=0.42 l=0.15
C0 a_390_47# VGND 0.07934f
C1 VGND a_27_47# 0.12853f
C2 VGND A 0.01718f
C3 a_390_47# VPWR 0.08324f
C4 VPWR A 0.01919f
C5 VPWR a_27_47# 0.15139f
C6 a_283_47# a_390_47# 0.23648f
C7 a_283_47# A 0.00128f
C8 a_283_47# a_27_47# 0.10373f
C9 X VGND 0.0543f
C10 X VPWR 0.06864f
C11 X a_283_47# 0.0053f
C12 VPWR VGND 0.04042f
C13 a_283_47# VGND 0.09586f
C14 VPB a_390_47# 0.04246f
C15 VPB A 0.03487f
C16 VPB a_27_47# 0.08754f
C17 a_283_47# VPWR 0.11265f
C18 a_390_47# a_27_47# 0
C19 a_390_47# A 0.00104f
C20 A a_27_47# 0.11427f
C21 X VPB 0.01322f
C22 VPB VGND 0.00817f
C23 X a_390_47# 0.04857f
C24 VPB VPWR 0.09136f
C25 VPB a_283_47# 0.09946f
C26 VGND VNB 0.46462f
C27 X VNB 0.22066f
C28 VPWR VNB 0.76551f
C29 VPB VNB 0.78196f
C30 a_283_47# VNB 0.03229f
.ends

.subckt sky130_fd_sc_hd__clkinv_2 VNB VPB VPWR VGND A Y
X0 Y A VGND VNB sky130_fd_pr__nfet_01v8 ad=0.0588 pd=0.7 as=0.1113 ps=1.37 w=0.42 l=0.15
X1 Y A VPWR VPB sky130_fd_pr__pfet_01v8_hvt ad=0.14 pd=1.28 as=0.14 ps=1.28 w=1 l=0.15
X2 VPWR A Y VPB sky130_fd_pr__pfet_01v8_hvt ad=0.14 pd=1.28 as=0.265 ps=2.53 w=1 l=0.15
X3 VGND A Y VNB sky130_fd_pr__nfet_01v8 ad=0.1092 pd=1.36 as=0.0588 ps=0.7 w=0.42 l=0.15
X4 VPWR A Y VPB sky130_fd_pr__pfet_01v8_hvt ad=0.265 pd=2.53 as=0.14 ps=1.28 w=1 l=0.15
C0 VPWR A 0.0677f
C1 A Y 0.17124f
C2 VPWR Y 0.17231f
C3 VGND VPB 0.00544f
C4 VPB A 0.10832f
C5 VPB VPWR 0.05252f
C6 VPB Y 0.01974f
C7 VGND A 0.06132f
C8 VGND VPWR 0.02081f
C9 VGND Y 0.07449f
C10 VGND VNB 0.43783f
C11 VPWR VNB 0.23289f
C12 Y VNB 0.25487f
C13 VPB VNB 0.42757f
.ends

.subckt sky130_fd_sc_hd__clkinv_4 VNB VPB VPWR VGND A Y
X0 Y A VPWR VPB sky130_fd_pr__pfet_01v8_hvt ad=0.14 pd=1.28 as=0.14 ps=1.28 w=1 l=0.15
X1 VGND A Y VNB sky130_fd_pr__nfet_01v8 ad=0.1659 pd=1.63 as=0.0588 ps=0.7 w=0.42 l=0.15
X2 VGND A Y VNB sky130_fd_pr__nfet_01v8 ad=0.0588 pd=0.7 as=0.0588 ps=0.7 w=0.42 l=0.15
X3 VPWR A Y VPB sky130_fd_pr__pfet_01v8_hvt ad=0.14 pd=1.28 as=0.14 ps=1.28 w=1 l=0.15
X4 VPWR A Y VPB sky130_fd_pr__pfet_01v8_hvt ad=0.345 pd=2.69 as=0.14 ps=1.28 w=1 l=0.15
X5 Y A VGND VNB sky130_fd_pr__nfet_01v8 ad=0.0588 pd=0.7 as=0.0588 ps=0.7 w=0.42 l=0.15
X6 Y A VPWR VPB sky130_fd_pr__pfet_01v8_hvt ad=0.14 pd=1.28 as=0.305 ps=2.61 w=1 l=0.15
X7 Y A VGND VNB sky130_fd_pr__nfet_01v8 ad=0.0588 pd=0.7 as=0.1386 ps=1.5 w=0.42 l=0.15
X8 Y A VPWR VPB sky130_fd_pr__pfet_01v8_hvt ad=0.14 pd=1.28 as=0.14 ps=1.28 w=1 l=0.15
X9 VPWR A Y VPB sky130_fd_pr__pfet_01v8_hvt ad=0.14 pd=1.28 as=0.14 ps=1.28 w=1 l=0.15
C0 VPWR A 0.13381f
C1 Y VGND 0.19168f
C2 VPWR VPB 0.08026f
C3 A VGND 0.08504f
C4 VPB VGND 0.00593f
C5 VPWR VGND 0.03751f
C6 A Y 0.4194f
C7 VPB Y 0.02448f
C8 VPWR Y 0.33176f
C9 A VPB 0.19288f
C10 VGND VNB 0.42579f
C11 Y VNB 0.36301f
C12 VPWR VNB 0.58284f
C13 VPB VNB 0.69336f
.ends

.subckt sky130_fd_sc_hd__clkinvlp_4 VNB VPB VPWR VGND A Y
X0 Y A VPWR VPB sky130_fd_pr__pfet_01v8_hvt ad=0.14 pd=1.28 as=0.265 ps=2.53 w=1 l=0.25
X1 VGND A a_268_47# VNB sky130_fd_pr__nfet_01v8 ad=0.14575 pd=1.63 as=0.05775 ps=0.76 w=0.55 l=0.15
X2 Y A VPWR VPB sky130_fd_pr__pfet_01v8_hvt ad=0.14 pd=1.28 as=0.14 ps=1.28 w=1 l=0.25
X3 Y A a_110_47# VNB sky130_fd_pr__nfet_01v8 ad=0.077 pd=0.83 as=0.05775 ps=0.76 w=0.55 l=0.15
X4 VPWR A Y VPB sky130_fd_pr__pfet_01v8_hvt ad=0.14 pd=1.28 as=0.14 ps=1.28 w=1 l=0.25
X5 a_110_47# A VGND VNB sky130_fd_pr__nfet_01v8 ad=0.05775 pd=0.76 as=0.14575 ps=1.63 w=0.55 l=0.15
X6 a_268_47# A Y VNB sky130_fd_pr__nfet_01v8 ad=0.05775 pd=0.76 as=0.077 ps=0.83 w=0.55 l=0.15
X7 VPWR A Y VPB sky130_fd_pr__pfet_01v8_hvt ad=0.265 pd=2.53 as=0.14 ps=1.28 w=1 l=0.25
C0 VGND a_268_47# 0.00835f
C1 Y VPB 0.01065f
C2 VPWR VPB 0.08915f
C3 VPWR Y 0.2408f
C4 A VPB 0.15965f
C5 Y A 0.22155f
C6 Y a_110_47# 0.00568f
C7 VPWR A 0.16749f
C8 VGND VPB 0.00867f
C9 VPWR a_110_47# 0
C10 Y VGND 0.10704f
C11 A a_110_47# 0
C12 VPWR VGND 0.03797f
C13 Y a_268_47# 0.00587f
C14 VPWR a_268_47# 0
C15 VGND A 0.09431f
C16 VGND a_110_47# 0.00186f
C17 VGND VNB 0.39461f
C18 Y VNB 0.24084f
C19 VPWR VNB 0.55393f
C20 VPB VNB 0.60476f
.ends

.subckt sky130_fd_sc_hd__inv_6 VPB VNB VPWR VGND Y A
X0 VPWR A Y VPB sky130_fd_pr__pfet_01v8_hvt ad=0.27 pd=2.54 as=0.135 ps=1.27 w=1 l=0.15
X1 Y A VPWR VPB sky130_fd_pr__pfet_01v8_hvt ad=0.135 pd=1.27 as=0.135 ps=1.27 w=1 l=0.15
X2 Y A VGND VNB sky130_fd_pr__nfet_01v8 ad=0.08775 pd=0.92 as=0.08775 ps=0.92 w=0.65 l=0.15
X3 VPWR A Y VPB sky130_fd_pr__pfet_01v8_hvt ad=0.135 pd=1.27 as=0.135 ps=1.27 w=1 l=0.15
X4 Y A VPWR VPB sky130_fd_pr__pfet_01v8_hvt ad=0.135 pd=1.27 as=0.135 ps=1.27 w=1 l=0.15
X5 VPWR A Y VPB sky130_fd_pr__pfet_01v8_hvt ad=0.135 pd=1.27 as=0.135 ps=1.27 w=1 l=0.15
X6 Y A VGND VNB sky130_fd_pr__nfet_01v8 ad=0.08775 pd=0.92 as=0.247 ps=2.06 w=0.65 l=0.15
X7 Y A VGND VNB sky130_fd_pr__nfet_01v8 ad=0.08775 pd=0.92 as=0.08775 ps=0.92 w=0.65 l=0.15
X8 Y A VPWR VPB sky130_fd_pr__pfet_01v8_hvt ad=0.135 pd=1.27 as=0.43 ps=2.86 w=1 l=0.15
X9 VGND A Y VNB sky130_fd_pr__nfet_01v8 ad=0.08775 pd=0.92 as=0.08775 ps=0.92 w=0.65 l=0.15
X10 VGND A Y VNB sky130_fd_pr__nfet_01v8 ad=0.08775 pd=0.92 as=0.08775 ps=0.92 w=0.65 l=0.15
X11 VGND A Y VNB sky130_fd_pr__nfet_01v8 ad=0.1755 pd=1.84 as=0.08775 ps=0.92 w=0.65 l=0.15
C0 VPB VGND 0.00676f
C1 A VGND 0.12744f
C2 VPB VPWR 0.09306f
C3 Y VGND 0.20779f
C4 A VPWR 0.13831f
C5 Y VPWR 0.31494f
C6 VPB A 0.21261f
C7 Y VPB 0.01838f
C8 Y A 0.38649f
C9 VPWR VGND 0.04018f
C10 VGND VNB 0.41174f
C11 Y VNB 0.30767f
C12 VPWR VNB 0.57992f
C13 VPB VNB 0.69336f
.ends

.subckt sky130_fd_sc_hd__inv_8 VNB VPB VGND VPWR Y A
X0 VPWR A Y VPB sky130_fd_pr__pfet_01v8_hvt ad=0.135 pd=1.27 as=0.135 ps=1.27 w=1 l=0.15
X1 Y A VPWR VPB sky130_fd_pr__pfet_01v8_hvt ad=0.135 pd=1.27 as=0.135 ps=1.27 w=1 l=0.15
X2 Y A VGND VNB sky130_fd_pr__nfet_01v8 ad=0.08775 pd=0.92 as=0.08775 ps=0.92 w=0.65 l=0.15
X3 Y A VGND VNB sky130_fd_pr__nfet_01v8 ad=0.08775 pd=0.92 as=0.08775 ps=0.92 w=0.65 l=0.15
X4 VPWR A Y VPB sky130_fd_pr__pfet_01v8_hvt ad=0.135 pd=1.27 as=0.135 ps=1.27 w=1 l=0.15
X5 Y A VPWR VPB sky130_fd_pr__pfet_01v8_hvt ad=0.135 pd=1.27 as=0.26 ps=2.52 w=1 l=0.15
X6 Y A VGND VNB sky130_fd_pr__nfet_01v8 ad=0.08775 pd=0.92 as=0.169 ps=1.82 w=0.65 l=0.15
X7 VPWR A Y VPB sky130_fd_pr__pfet_01v8_hvt ad=0.26 pd=2.52 as=0.135 ps=1.27 w=1 l=0.15
X8 Y A VGND VNB sky130_fd_pr__nfet_01v8 ad=0.08775 pd=0.92 as=0.08775 ps=0.92 w=0.65 l=0.15
X9 Y A VPWR VPB sky130_fd_pr__pfet_01v8_hvt ad=0.135 pd=1.27 as=0.135 ps=1.27 w=1 l=0.15
X10 VPWR A Y VPB sky130_fd_pr__pfet_01v8_hvt ad=0.135 pd=1.27 as=0.135 ps=1.27 w=1 l=0.15
X11 VGND A Y VNB sky130_fd_pr__nfet_01v8 ad=0.08775 pd=0.92 as=0.08775 ps=0.92 w=0.65 l=0.15
X12 VGND A Y VNB sky130_fd_pr__nfet_01v8 ad=0.08775 pd=0.92 as=0.08775 ps=0.92 w=0.65 l=0.15
X13 VGND A Y VNB sky130_fd_pr__nfet_01v8 ad=0.08775 pd=0.92 as=0.08775 ps=0.92 w=0.65 l=0.15
X14 Y A VPWR VPB sky130_fd_pr__pfet_01v8_hvt ad=0.135 pd=1.27 as=0.135 ps=1.27 w=1 l=0.15
X15 VGND A Y VNB sky130_fd_pr__nfet_01v8 ad=0.169 pd=1.82 as=0.08775 ps=0.92 w=0.65 l=0.15
C0 VPWR Y 0.45667f
C1 VPB Y 0.03479f
C2 VGND VPWR 0.04805f
C3 VGND VPB 0.00793f
C4 VPB VPWR 0.12025f
C5 A Y 0.57692f
C6 A VGND 0.1313f
C7 A VPWR 0.15267f
C8 A VPB 0.25409f
C9 VGND Y 0.35493f
C10 VGND VNB 0.50296f
C11 Y VNB 0.37881f
C12 VPWR VNB 0.68081f
C13 VPB VNB 0.87055f
.ends
