* STATUS (R3 exploration A, final bounded refinement under amendments A6-A8, 2026-10-31): driver candidate.
* drv_Q1 = drv_z7 with three existing values changed: Cc 3.8 -> 5 pF, CO 3 -> 4 pF (noise), NMOS mirror cascodes
* XM15/XM16 m 7 -> 12 and their bias diode XM22 L 2.8 -> 2.5 um (XM16 saturation at ss/1.60/-40).
* Supplies 1.60/1.80/1.95 V, 45 conditions. Supply 782 uA at tt (617-977 uA over PVT).
* Sampled noise (repository noise.py, 45 x {0.6, 1.2} V): worst 138.7 uV rms (ff/1.95/125, 1.2 V).
* R_S <= 0.062 mV; stability.py PM >= 66.1 deg, GM >= 14.4 dB; primary screens (tight numerics):
* charge-free 1 kOhm <= 0.149 LSB, boot() W 5 um <= 0.133 LSB. Saturation >= 50 mV except the native input pair at
* sf/1.60/125, 1.2 V input (XM2 31 mV, XM1 33 mV): explained exception, see report Section 11.
* STRESS timing (diagnostic, A6): 1.9-7.3 LSB with boot() at tt and hot low-VDD points.
* Ideal elements (poly-R / MIM in layout): Rz 0.3 kOhm, Cc 5 pF, CO 4 pF (output to vss), RF1-RF5 100 kOhm,
* CF1-CF5 2 pF (bias-line RC filters). Report: the design-study record.
.subckt drv_Q1 vcmd fb out ibias vdd vss
* reference (Iref = 10 uA sunk into ibias) and NMOS bias sinks, 10 uA each
XM8  ibias ibias vss vss sky130_fd_pr__nfet_01v8 W=4 L=1 m=1
XM18 vbp   ibias vss vss sky130_fd_pr__nfet_01v8 W=4 L=1 m=1
XM21 vbpc  ibias vss vss sky130_fd_pr__nfet_01v8 W=4 L=1 m=1
* PMOS bias: vbp diode; PMOS copies feeding the vbnc diode and the output-sink diode; vbpc diode
XM17 vbp   vbp   vdd vdd sky130_fd_pr__pfet_01v8_lvt W=20 L=0.5 m=1
XM20 vbnc  vbp   vdd vdd sky130_fd_pr__pfet_01v8_lvt W=20 L=0.5 m=1
XM22 vbnc  vbnc  vss vss sky130_fd_pr__nfet_01v8 W=1 L=2.5 m=1
XM19 vbpc  vbpc  vdd vdd sky130_fd_pr__pfet_01v8_lvt W=1.65 L=1 m=1
XM23 ib2   vbp   vdd vdd sky130_fd_pr__pfet_01v8_lvt W=20 L=0.5 m=1
XM24 ib2   ib2   vss vss sky130_fd_pr__nfet_01v8 W=2.5 L=4 m=1
* tail and native-threshold input pair
XM5  tail  ibt   vss vss sky130_fd_pr__nfet_01v8 W=4 L=1 m=17
XM1  f1    fb    tail vss sky130_fd_pr__nfet_03v3_nvt W=4 L=0.5 m=8
XM2  f2    vcmd  tail vss sky130_fd_pr__nfet_03v3_nvt W=4 L=0.5 m=8
* PMOS folding sources and cascodes
XM9  f1    vbpf   vdd vdd sky130_fd_pr__pfet_01v8_lvt W=20 L=0.5 m=17
XM10 f2    vbpf   vdd vdd sky130_fd_pr__pfet_01v8_lvt W=20 L=0.5 m=17
XM11 y1    vbpcf  f1  vdd sky130_fd_pr__pfet_01v8_lvt W=5 L=1 m=13
XM12 x     vbpcf  f2  vdd sky130_fd_pr__pfet_01v8_lvt W=5 L=1 m=13
* NMOS low-voltage cascode mirror (diode side y1)
XM15 y1    vbncf  s1  vss sky130_fd_pr__nfet_01v8 W=5 L=1 m=12
XM16 x     vbncf  s2  vss sky130_fd_pr__nfet_01v8 W=5 L=1 m=12
XM13 s1    y1    vss vss sky130_fd_pr__nfet_01v8 W=3 L=2 m=5
XM14 s2    y1    vss vss sky130_fd_pr__nfet_01v8 W=3 L=2 m=5
* second stage
XM6  out   x     vdd vdd sky130_fd_pr__pfet_01v8 W=5 L=0.5 m=110
XM7  out   ib2f   vss vss sky130_fd_pr__nfet_01v8 W=2.5 L=4 m=34
RZ   x     xc    0.3k
CC   xc    out   5p
RF3  vbpc  vbpcf 100k
CF3  vbpcf vdd   2p
RF4  vbnc  vbncf 100k
CF4  vbncf vss   2p
* bias-noise filters
RF1  vbp   vbpf  100k
CF1  vbpf  vdd   2p
RF2  ib2   ib2f  100k
CF2  ib2f  vss   2p
CO   out   vss   4p
RF5  ibias ibt   100k
CF5  ibt   vss   2p
.ends drv_Q1
