* Small-step port comparison (SMALL_STEP_PORT_COMPARISON.md): output-port disturbance, switch as R_if.
* Input held at @VTARGET@ V. Cs is precharged to @VPREV@ V (ideal fixture, opens at 20 ns) and
* connected through an ideal switch (closing at mid-edge, 25.1 ns) in series with R_if.
.lib "@PDK_LIB@" @CORNER@
.temp @TEMP@
.include "@OUTDIR@/@SRCFILE@"
.option reltol=@RELTOL@ vntol=1e-7 abstol=1e-13
VDD vdd 0 1.8
IREF vdd ibias @IREF@
XSRC vcmd out out ibias vdd 0 src2
VCMD vcmd 0 @VTARGET@
VPRE pre 0 @VPREV@
SPRE samp pre ctlp 0 swideal
VCTLP ctlp 0 PWL(0 1 20n 1 20.1n 0)
.model swideal sw vt=0.5 vh=0.1 ron=1 roff=1e13
VPHI phi 0 PWL(0 0 25n 0 25.2n 1)
SIF out mid phi 0 swideal
RIF mid samp @RIF@
CS samp 0 @CS@
.control
save v(out) v(samp) v(xsrc.x) v(vcmd) @m.xsrc.xm6.msky130_fd_pr__pfet_01v8_lvt[id] @m.xsrc.xm7.msky130_fd_pr__nfet_01v8[id] @m.xsrc.xm1.msky130_fd_pr__nfet_01v8_lvt[id] @m.xsrc.xm2.msky130_fd_pr__nfet_01v8_lvt[id]
tran 10p 225n 0 @TMAX@
let i_m6 = @m.xsrc.xm6.msky130_fd_pr__pfet_01v8_lvt[id]
let i_m7 = @m.xsrc.xm7.msky130_fd_pr__nfet_01v8[id]
let i_m1 = @m.xsrc.xm1.msky130_fd_pr__nfet_01v8_lvt[id]
let i_m2 = @m.xsrc.xm2.msky130_fd_pr__nfet_01v8_lvt[id]
linearize v(out) v(samp) v(xsrc.x) v(vcmd) i_m6 i_m7 i_m1 i_m2
wrdata @OUTDIR@/tran.dat v(out) v(samp) v(xsrc.x) v(vcmd) i_m6 i_m7 i_m1 i_m2
.endc
.end
