* Test (a): input-step settling of the source
* Cchar = Cs is connected directly at the source output for the whole test.
* The input Vcmd steps from @VCMD0@ V to @VTARGET@ V at t_event = 25 ns (0.1 ns ramp).
.lib "@PDK_LIB@" @CORNER@
.temp @TEMP@
.include "@OUTDIR@/@SRCFILE@"
.option reltol=@RELTOL@ vntol=1e-7 abstol=1e-13
VDD vdd 0 1.8
IREF vdd ibias @IREF@
XSRC vcmd out out ibias vdd 0 src2
VCMD vcmd 0 PWL(0 @VCMD0@ 25n @VCMD0@ 25.1n @VTARGET@)
* samp is the same node as out here (0 V ammeter), so both are recorded
VCHAR out samp 0
CCHAR samp 0 @CS@
.control
save v(out) v(samp) v(xsrc.x) v(vcmd) @m.xsrc.xm6.msky130_fd_pr__pfet_01v8_lvt[id] @m.xsrc.xm7.msky130_fd_pr__nfet_01v8[id]
tran 10p 425n 0 @TMAX@
let i_m6 = @m.xsrc.xm6.msky130_fd_pr__pfet_01v8_lvt[id]
let i_m7 = @m.xsrc.xm7.msky130_fd_pr__nfet_01v8[id]
linearize v(out) v(samp) v(xsrc.x) v(vcmd) i_m6 i_m7
wrdata @OUTDIR@/tran.dat v(out) v(samp) v(xsrc.x) v(vcmd) i_m6 i_m7
.endc
.end
