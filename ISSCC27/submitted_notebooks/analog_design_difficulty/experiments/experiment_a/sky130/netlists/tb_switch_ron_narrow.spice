* Transmission-gate on-resistance versus level for the narrow gates of the width bridge
* (HOLD_ERROR_DESIGN_RESPONSE.md, added after the bridge result): one eighth and one quarter
* of the chosen width. Same method as tb_switch_ron.spice: gates fully on, both terminals
* at V (swept 0.5 V to 1.3 V), Ron(V) = 1 mV / I.
.lib "@PDK_LIB@" @CORNER@
.temp @TEMP@
.option reltol=1e-6 abstol=1e-15
VDD vdd 0 1.8
VGN gn 0 1.8
VGP gp 0 0
VS s 0 0.9
VD1 d1 s 1m
VD2 d2 s 1m
* one eighth: Wn 1.875 um, Wp 3.75 um
XN1 d1 gn s 0 sky130_fd_pr__nfet_01v8 W=0.625 L=0.15 m=3
XP1 d1 gp s vdd sky130_fd_pr__pfet_01v8 W=0.625 L=0.15 m=6
* one quarter: Wn 3.75 um, Wp 7.5 um
XN2 d2 gn s 0 sky130_fd_pr__nfet_01v8 W=1.25 L=0.15 m=3
XP2 d2 gp s vdd sky130_fd_pr__pfet_01v8 W=1.25 L=0.15 m=6
.control
dc VS 0.5 1.3 0.01
let ron_eighth = 1m/(-i(VD1))
let ron_quarter = 1m/(-i(VD2))
wrdata @OUTDIR@/ron.dat ron_eighth ron_quarter
.endc
.end
