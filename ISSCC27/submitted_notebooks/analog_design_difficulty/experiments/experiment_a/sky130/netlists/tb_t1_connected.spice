* Test (c): connected sampler, stored-charge disturbance at the source output
* Input Vcmd = Vtarget throughout. Cs holds Vprev (ideal precharge fixture, opens at 20 ns).
* The transmission gate closes at t_event = 25 ns: phi 0 -> 1.8 V and phib 1.8 -> 0 V
* in 0.2 ns (DESIGN_BRIEF.md). Gate size: n = @MN@ and p = @MP@
* fingers of W = @WF@ um (5 um for the chosen gate; SWITCH_WIDTH_STUDY.md).
.lib "@PDK_LIB@" @CORNER@
.temp @TEMP@
.include "@OUTDIR@/@SRCFILE@"
.option reltol=@RELTOL@ vntol=1e-7 abstol=1e-13
VDD vdd 0 1.8
IREF vdd ibias @IREF@
XSRC vcmd out out ibias vdd 0 src2
VCMD vcmd 0 @VTARGET@
* test fixture: previous sample left on Cs
VPRE pre 0 @VPREV@
SPRE samp pre ctlp 0 swideal
VCTLP ctlp 0 PWL(0 1 20n 1 20.1n 0)
.model swideal sw vt=0.5 vh=0.1 ron=1 roff=1e13
VPHI phi 0 PWL(0 0 25n 0 25.2n 1.8)
VPHIB phib 0 PWL(0 1.8 25n 1.8 25.2n 0)
* sampler: CMOS transmission gate (NMOS bulk 0 V, PMOS bulk 1.8 V) and sampling capacitor
XSWN out phi samp 0 sky130_fd_pr__nfet_01v8 W=@WF@ L=0.15 m=@MN@
XSWP out phib samp vdd sky130_fd_pr__pfet_01v8 W=@WF@ L=0.15 m=@MP@
CS samp 0 @CS@
.control
save v(out) v(samp) v(xsrc.x) v(vcmd) @m.xsrc.xm6.msky130_fd_pr__pfet_01v8_lvt[id] @m.xsrc.xm7.msky130_fd_pr__nfet_01v8[id]
tran 10p 425n 0 @TMAX@
let i_m6 = @m.xsrc.xm6.msky130_fd_pr__pfet_01v8_lvt[id]
let i_m7 = @m.xsrc.xm7.msky130_fd_pr__nfet_01v8[id]
linearize v(out) v(samp) v(xsrc.x) v(vcmd) i_m6 i_m7
wrdata @OUTDIR@/tran.dat v(out) v(samp) v(xsrc.x) v(vcmd) i_m6 i_m7
.endc
.end
