* Test (m): matched control for test (c)
* Same switch and Cs as T1, but the switch is closed from t = 0 and Cs has settled
* with the source at Vcmd = @VCMD0@ V. At t_event = 25 ns Vcmd steps to @VTARGET@ V.
* Initial sampling-capacitor error therefore equals the T1 value (Vcmd0 = Vprev).
.lib "@PDK_LIB@" @CORNER@
.temp @TEMP@
.include "@OUTDIR@/@SRCFILE@"
.option reltol=@RELTOL@ vntol=1e-7 abstol=1e-13
VDD vdd 0 1.8
IREF vdd ibias @IREF@
XSRC vcmd out out ibias vdd 0 src2
VCMD vcmd 0 PWL(0 @VCMD0@ 25n @VCMD0@ 25.1n @VTARGET@)
VPHI phi 0 1.8
VPHIB phib 0 0
* sampler: CMOS transmission gate (NMOS bulk 0 V, PMOS bulk 1.8 V) and sampling capacitor
XSWN out phi samp 0 sky130_fd_pr__nfet_01v8 W=5 L=0.15 m=@MN@
XSWP out phib samp vdd sky130_fd_pr__pfet_01v8 W=5 L=0.15 m=@MP@
CS samp 0 @CS@
.control
save v(out) v(samp) v(xsrc.x) v(vcmd) @m.xsrc.xm6.msky130_fd_pr__pfet_01v8_lvt[id] @m.xsrc.xm7.msky130_fd_pr__nfet_01v8[id]
tran 10p 425n 0 @TMAX@
let i_m6 = @m.xsrc.xm6.msky130_fd_pr__pfet_01v8_lvt[id]
let i_m7 = @m.xsrc.xm7.msky130_fd_pr__nfet_01v8[id]
linearize v(out) v(samp) v(xsrc.x) v(vcmd) i_m6 i_m7
wrdata @OUTDIR@/tran.dat v(out) v(samp) v(xsrc.x) v(vcmd) i_m6 i_m7
.endc
.end
