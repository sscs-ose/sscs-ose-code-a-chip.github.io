* Test (b): output-port block test of the source with the sampler's interface model.
* Cs holds Vprev (same ideal precharge fixture as test (c)) and is connected to the
* source output through an ideal switch (closing at mid-edge, 25.1 ns) in series with
* a linear resistor RIF = maximum DC on-resistance of the transmission gate over the
* signal range. Vcmd = Vtarget throughout. Only the sampler model differs from (c).
.lib "@PDK_LIB@" @CORNER@
.temp @TEMP@
.include "@OUTDIR@/@SRCFILE@"
.option reltol=@RELTOL@ vntol=1e-7 abstol=1e-13
VDD vdd 0 1.8
IREF vdd ibias @IREF@
XSRC vcmd out out ibias vdd 0 src2
VCMD vcmd 0 @VTARGET@
* test fixture: previous sample left on Cs
VPRE pre 0 @VPREV@
SPRE samp pre ctlp 0 swideal
VCTLP ctlp 0 PWL(0 1 20n 1 20.1n 0)
.model swideal sw vt=0.5 vh=0.1 ron=1 roff=1e13
* receiver interface model: ideal switch + linear on-resistance + Cs
VPHI phi 0 PWL(0 0 25n 0 25.2n 1)
SIF out mid phi 0 swideal
RIF mid samp @RIF@
CS samp 0 @CS@
.control
save v(out) v(samp) v(xsrc.x) v(vcmd) @m.xsrc.xm6.msky130_fd_pr__pfet_01v8_lvt[id] @m.xsrc.xm7.msky130_fd_pr__nfet_01v8[id]
tran 10p 425n 0 @TMAX@
let i_m6 = @m.xsrc.xm6.msky130_fd_pr__pfet_01v8_lvt[id]
let i_m7 = @m.xsrc.xm7.msky130_fd_pr__nfet_01v8[id]
linearize v(out) v(samp) v(xsrc.x) v(vcmd) i_m6 i_m7
wrdata @OUTDIR@/tran.dat v(out) v(samp) v(xsrc.x) v(vcmd) i_m6 i_m7
.endc
.end
