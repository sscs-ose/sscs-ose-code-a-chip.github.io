* Hold step when the transmission gate opens (DESIGN_BRIEF.md, HOLD_ERROR_DESIGN_RESPONSE.md)
* As test (c) with Vprev = Vtarget: the gate closes at 25 ns and opens at the end
* of Tacq, 65 ns (phi 1.8 -> 0 V, phib 0 -> 1.8 V, 0.2 ns). Channel-charge injection
* and clock feedthrough at turn-off change the voltage held on Cs; they are not
* separated here. Gate width scale: n = @MN@ and p = @MP@ fingers of W = @WF@ um.
.lib "@PDK_LIB@" @CORNER@
.temp @TEMP@
.include "@OUTDIR@/@SRCFILE@"
.option reltol=@RELTOL@ vntol=1e-7 abstol=1e-13
VDD vdd 0 1.8
IREF vdd ibias @IREF@
XSRC vcmd out out ibias vdd 0 src2
VCMD vcmd 0 @VTARGET@
VPRE pre 0 @VPREV@
SPRE samp pre ctlp 0 swideal
VCTLP ctlp 0 PWL(0 1 20n 1 20.1n 0)
.model swideal sw vt=0.5 vh=0.1 ron=1 roff=1e13
VPHI phi 0 PWL(0 0 25n 0 25.2n 1.8 65n 1.8 65.2n 0)
VPHIB phib 0 PWL(0 1.8 25n 1.8 25.2n 0 65n 0 65.2n 1.8)
XSWN out phi samp 0 sky130_fd_pr__nfet_01v8 W=@WF@ L=0.15 m=@MN@
XSWP out phib samp vdd sky130_fd_pr__pfet_01v8 W=@WF@ L=0.15 m=@MP@
CS samp 0 @CS@
.control
save v(out) v(samp) v(xsrc.x) v(vcmd) @m.xsrc.xm6.msky130_fd_pr__pfet_01v8_lvt[id] @m.xsrc.xm7.msky130_fd_pr__nfet_01v8[id]
tran 10p 125n 0 @TMAX@
let i_m6 = @m.xsrc.xm6.msky130_fd_pr__pfet_01v8_lvt[id]
let i_m7 = @m.xsrc.xm7.msky130_fd_pr__nfet_01v8[id]
linearize v(out) v(samp) v(xsrc.x) v(vcmd) i_m6 i_m7
wrdata @OUTDIR@/tran.dat v(out) v(samp) v(xsrc.x) v(vcmd) i_m6 i_m7
.endc
.end
