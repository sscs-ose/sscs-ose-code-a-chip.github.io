* run_Tline_coll_out_le - lumped-element equivalent (Ngspice / SPICE3)
* generated by snp2le
* EQUIVALENT CIRCUIT FOR VECTOR FITTED S-MATRIX
* Created using scikit-rf vectorFitting.py
*
*
.SUBCKT run_Tline_coll_out_le p1 p2
V1 p1 s1 0
R1 s1 0 50 noisy=0
Gd1_1 0 s1 p1 0 -0.001703762913
Fd1_1 0 s1 V1 -0.08518814563
Gr1_re_1_1 0 s1 x1_re_a1 0 466449.7792
Gr1_im_1_1 0 s1 x1_im_a1 0 354357.9228
Gr2_re_1_1 0 s1 x2_re_a1 0 -160365.0883
Gr2_im_1_1 0 s1 x2_im_a1 0 -17974.76958
Gr3_1_1 0 s1 x3_a1 0 -0.2999202508
Gd1_2 0 s1 p2 0 -0.002337600903
Fd1_2 0 s1 V2 -0.1168800452
Gr1_re_1_2 0 s1 x1_re_a2 0 -196475.2807
Gr1_im_1_2 0 s1 x1_im_a2 0 -1154240.147
Gr2_re_1_2 0 s1 x2_re_a2 0 -17391.75395
Gr2_im_1_2 0 s1 x2_im_a2 0 -113753.2599
Gr3_1_2 0 s1 x3_a2 0 0.3668525893
Cx1_re_a1 x1_re_a1 0 3.196335523e-13
Gx1_re_a1 0 x1_re_a1 p1 0 4.077416893e-08
Fx1_re_a1 0 x1_re_a1 V1 2.038708447e-06
Rp1_re_re_a1 0 x1_re_a1 1 noisy=0
Gp1_re_im_a1 0 x1_re_a1 x1_im_a1 0 0.8339611005
Cx1_im_a1 x1_im_a1 0 3.196335523e-13
Gp1_im_re_a1 0 x1_im_a1 x1_re_a1 0 -0.8339611005
Rp1_im_im_a1 0 x1_im_a1 1 noisy=0
Cx2_re_a1 x2_re_a1 0 2.232677374e-11
Gx2_re_a1 0 x2_re_a1 p1 0 8.52894744e-09
Fx2_re_a1 0 x2_re_a1 V1 4.26447372e-07
Rp2_re_re_a1 0 x2_re_a1 1 noisy=0
Gp2_re_im_a1 0 x2_re_a1 x2_im_a1 0 51.34061601
Cx2_im_a1 x2_im_a1 0 2.232677374e-11
Gp2_im_re_a1 0 x2_im_a1 x2_re_a1 0 -51.34061601
Rp2_im_im_a1 0 x2_im_a1 1 noisy=0
Cx3_a1 x3_a1 0 7.584460577e-13
Gx3_a1 0 x3_a1 p1 0 0.007369406002
Fx3_a1 0 x3_a1 V1 0.3684703001
Rp3_a1 0 x3_a1 1 noisy=0
V2 p2 s2 0
R2 s2 0 50 noisy=0
Gd2_1 0 s2 p1 0 -0.002352854554
Fd2_1 0 s2 V1 -0.1176427277
Gr1_re_2_1 0 s2 x1_re_a1 0 -205192.0009
Gr1_im_2_1 0 s2 x1_im_a1 0 -1213171.538
Gr2_re_2_1 0 s2 x2_re_a1 0 -17036.28231
Gr2_im_2_1 0 s2 x2_im_a1 0 -119928.1848
Gr3_2_1 0 s2 x3_a1 0 0.3684703001
Gd2_2 0 s2 p2 0 -0.004065151884
Fd2_2 0 s2 V2 -0.2032575942
Gr1_re_2_2 0 s2 x1_re_a2 0 543834.1391
Gr1_im_2_2 0 s2 x1_im_a2 0 336090.2968
Gr2_re_2_2 0 s2 x2_re_a2 0 -186053.9537
Gr2_im_2_2 0 s2 x2_im_a2 0 -7795.919711
Gr3_2_2 0 s2 x3_a2 0 -0.3295024069
Cx1_re_a2 x1_re_a2 0 3.196335523e-13
Gx1_re_a2 0 x1_re_a2 p2 0 4.294403883e-08
Fx1_re_a2 0 x1_re_a2 V2 2.147201942e-06
Rp1_re_re_a2 0 x1_re_a2 1 noisy=0
Gp1_re_im_a2 0 x1_re_a2 x1_im_a2 0 0.8339611005
Cx1_im_a2 x1_im_a2 0 3.196335523e-13
Gp1_im_re_a2 0 x1_im_a2 x1_re_a2 0 -0.8339611005
Rp1_im_im_a2 0 x1_im_a2 1 noisy=0
Cx2_re_a2 x2_re_a2 0 2.232677374e-11
Gx2_re_a2 0 x2_re_a2 p2 0 8.947078984e-09
Fx2_re_a2 0 x2_re_a2 V2 4.473539492e-07
Rp2_re_re_a2 0 x2_re_a2 1 noisy=0
Gp2_re_im_a2 0 x2_re_a2 x2_im_a2 0 51.34061601
Cx2_im_a2 x2_im_a2 0 2.232677374e-11
Gp2_im_re_a2 0 x2_im_a2 x2_re_a2 0 -51.34061601
Rp2_im_im_a2 0 x2_im_a2 1 noisy=0
Cx3_a2 x3_a2 0 7.584460577e-13
Gx3_a2 0 x3_a2 p2 0 0.007337051785
Fx3_a2 0 x3_a2 V2 0.3668525893
Rp3_a2 0 x3_a2 1 noisy=0
.ENDS run_Tline_coll_out_le
