* Qucs 25.2.0  /home/ihp-pdk/QucsWorkspace/ISSCS_60GHz_MPA_prj/isscs_lvs_demo.sch
.SUBCKT isscs_lvs_demo P1 P2
*.GLOBAL 0:G
*.PININFO P1:I P2:I
R1 P2 P1 sub! rhigh w=5u l=4.3u b=0 m=1
.ENDS
.END
