* Extracted by KLayout with SG13G2 LVS runset on : 29/10/2026 17:26

.SUBCKT isscs_lvs_demo P1 P2
R$1 P1 P2 \$1 rhigh w=5u l=4.3u ps=0u b=0 m=1
.ENDS isscs_lvs_demo
