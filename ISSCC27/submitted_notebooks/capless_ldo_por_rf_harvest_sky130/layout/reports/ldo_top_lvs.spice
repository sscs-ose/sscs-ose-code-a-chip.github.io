* NGSPICE file created from ldo_top.ext - technology: sky130A

.subckt sky130_fd_pr__pfet_g5v0d10v5_UFECYT B D0 S0 G0 D1 S1 G1 D2 S2 G2 D3 S3 G3
X0 S2 G2 D2 B sky130_fd_pr__pfet_g5v0d10v5 ad=5.8 pd=40.58 as=5.8 ps=40.58 w=20 l=16
X1 S0 G0 D0 B sky130_fd_pr__pfet_g5v0d10v5 ad=5.8 pd=40.58 as=5.8 ps=40.58 w=20 l=16
X2 S3 G3 D3 B sky130_fd_pr__pfet_g5v0d10v5 ad=5.8 pd=40.58 as=5.8 ps=40.58 w=20 l=16
X3 S1 G1 D1 B sky130_fd_pr__pfet_g5v0d10v5 ad=5.8 pd=40.58 as=5.8 ps=40.58 w=20 l=16
.ends

.subckt sky130_fd_pr__nfet_g5v0d10v5_3LMSA7 B D S G
X0 S G D B sky130_fd_pr__nfet_g5v0d10v5 ad=1.45 pd=10.58 as=1.45 ps=10.58 w=5 l=0.5
.ends

.subckt sky130_fd_pr__pfet_g5v0d10v5_TGGT4A B D0_0 G0_0 D0_1 G0_1 D0_2 G0_2 D0_3 G0_3
+ S1_0 G1_0 S1_1 G1_1 S1_2 G1_2 S1_3 G1_3 D2_0 G2_0 D2_1 G2_1 D2_2 G2_2 D2_3 G2_3
+ S3_0 G3_0 S3_1 G3_1 S3_2 G3_2 S3_3 G3_3 a_887_n4118# a_887_n8283# a_887_47# a_887_4212#
X0 S3_2 G2_2 D2_2 B sky130_fd_pr__pfet_g5v0d10v5 ad=2.9 pd=20.29 as=2.9 ps=20.29 w=20 l=2
X1 a_887_4212# G3_3 S3_3 B sky130_fd_pr__pfet_g5v0d10v5 ad=5.8 pd=40.58 as=2.9 ps=20.29 w=20 l=2
X2 S1_3 G0_3 D0_3 B sky130_fd_pr__pfet_g5v0d10v5 ad=2.9 pd=20.29 as=5.8 ps=40.58 w=20 l=2
X3 S3_1 G2_1 D2_1 B sky130_fd_pr__pfet_g5v0d10v5 ad=2.9 pd=20.29 as=2.9 ps=20.29 w=20 l=2
X4 S1_0 G0_0 D0_0 B sky130_fd_pr__pfet_g5v0d10v5 ad=2.9 pd=20.29 as=5.8 ps=40.58 w=20 l=2
X5 D2_2 G1_2 S1_2 B sky130_fd_pr__pfet_g5v0d10v5 ad=2.9 pd=20.29 as=2.9 ps=20.29 w=20 l=2
X6 a_887_n8283# G3_0 S3_0 B sky130_fd_pr__pfet_g5v0d10v5 ad=5.8 pd=40.58 as=2.9 ps=20.29 w=20 l=2
X7 S1_2 G0_2 D0_2 B sky130_fd_pr__pfet_g5v0d10v5 ad=2.9 pd=20.29 as=5.8 ps=40.58 w=20 l=2
X8 D2_3 G1_3 S1_3 B sky130_fd_pr__pfet_g5v0d10v5 ad=2.9 pd=20.29 as=2.9 ps=20.29 w=20 l=2
X9 D2_0 G1_0 S1_0 B sky130_fd_pr__pfet_g5v0d10v5 ad=2.9 pd=20.29 as=2.9 ps=20.29 w=20 l=2
X10 S1_1 G0_1 D0_1 B sky130_fd_pr__pfet_g5v0d10v5 ad=2.9 pd=20.29 as=5.8 ps=40.58 w=20 l=2
X11 a_887_n4118# G3_1 S3_1 B sky130_fd_pr__pfet_g5v0d10v5 ad=5.8 pd=40.58 as=2.9 ps=20.29 w=20 l=2
X12 D2_1 G1_1 S1_1 B sky130_fd_pr__pfet_g5v0d10v5 ad=2.9 pd=20.29 as=2.9 ps=20.29 w=20 l=2
X13 a_887_47# G3_2 S3_2 B sky130_fd_pr__pfet_g5v0d10v5 ad=5.8 pd=40.58 as=2.9 ps=20.29 w=20 l=2
X14 S3_0 G2_0 D2_0 B sky130_fd_pr__pfet_g5v0d10v5 ad=2.9 pd=20.29 as=2.9 ps=20.29 w=20 l=2
X15 S3_3 G2_3 D2_3 B sky130_fd_pr__pfet_g5v0d10v5 ad=2.9 pd=20.29 as=2.9 ps=20.29 w=20 l=2
.ends

.subckt sky130_fd_pr__nfet_g5v0d10v5_C8EBTW B D S G
X0 S G D B sky130_fd_pr__nfet_g5v0d10v5 ad=0.203 pd=1.98 as=0.203 ps=1.98 w=0.7 l=20
.ends

.subckt sky130_fd_pr__nfet_g5v0d10v5_62W55W B D S G
X0 S G D B sky130_fd_pr__nfet_g5v0d10v5 ad=0.29 pd=2.58 as=0.29 ps=2.58 w=1 l=1
.ends

.subckt sky130_fd_pr__cap_mim_m3_1_BTY6QK C2 C1
X0 C1 C2 sky130_fd_pr__cap_mim_m3_1 l=25 w=25
.ends

.subckt sky130_fd_pr__cap_mim_m3_1_V8HUNN C2 C1
X0 C1 C2 sky130_fd_pr__cap_mim_m3_1 l=16 w=16
.ends

.subckt sky130_fd_pr__nfet_g5v0d10v5_NUFNY9 B D S G
X0 S G D B sky130_fd_pr__nfet_g5v0d10v5 ad=0.29 pd=2.58 as=0.29 ps=2.58 w=1 l=4
.ends

.subckt sky130_fd_pr__nfet_05v0_nvt_F4CC77 B D S G
X0 S G D B sky130_fd_pr__nfet_05v0_nvt ad=0.29 pd=2.58 as=0.29 ps=2.58 w=1 l=25
.ends

.subckt sky130_fd_pr__nfet_05v0_nvt_ASWYB8 B D0 G0 S1 G1 D2 G2 S3 G3 D4 G4 S5 G5 a_15145_n131#
X0 S3 G2 D2 B sky130_fd_pr__nfet_05v0_nvt ad=0.145 pd=1.29 as=0.145 ps=1.29 w=1 l=25
X1 S1 G0 D0 B sky130_fd_pr__nfet_05v0_nvt ad=0.145 pd=1.29 as=0.29 ps=2.58 w=1 l=25
X2 D2 G1 S1 B sky130_fd_pr__nfet_05v0_nvt ad=0.145 pd=1.29 as=0.145 ps=1.29 w=1 l=25
X3 D4 G3 S3 B sky130_fd_pr__nfet_05v0_nvt ad=0.145 pd=1.29 as=0.145 ps=1.29 w=1 l=25
X4 a_15145_n131# G5 S5 B sky130_fd_pr__nfet_05v0_nvt ad=0.29 pd=2.58 as=0.145 ps=1.29 w=1 l=25
X5 S5 G4 D4 B sky130_fd_pr__nfet_05v0_nvt ad=0.145 pd=1.29 as=0.145 ps=1.29 w=1 l=25
.ends

.subckt sky130_fd_pr__nfet_g5v0d10v5_BE4NYT B D S G
X0 S G D B sky130_fd_pr__nfet_g5v0d10v5 ad=0.58 pd=4.58 as=0.58 ps=4.58 w=2 l=4
.ends

.subckt sky130_fd_pr__res_xhigh_po_0p35_5J6MKL B R1 R2
X0 R2 R1 B sky130_fd_pr__res_xhigh_po_0p35 l=94.73
.ends

.subckt sky130_fd_pr__nfet_g5v0d10v5_A8HTHF B D S G
X0 S G D B sky130_fd_pr__nfet_g5v0d10v5 ad=0.29 pd=2.58 as=0.29 ps=2.58 w=1 l=0.5
.ends

.subckt sky130_fd_pr__nfet_g5v0d10v5_YQMGE2 B D0 G0 S1 G1 D2 G2 S3 G3 D4 G4 S5 G5
+ D6 G6 S7 G7 D8 G8 S9 G9 D10 G10 S11 G11 D12 G12 S13 G13 D14 G14 S15 G15 D16 G16
+ S17 G17 D18 G18 S19 G19 a_8551_n231#
X0 S7 G6 D6 B sky130_fd_pr__nfet_g5v0d10v5 ad=0.29 pd=2.29 as=0.29 ps=2.29 w=2 l=4
X1 D12 G11 S11 B sky130_fd_pr__nfet_g5v0d10v5 ad=0.29 pd=2.29 as=0.29 ps=2.29 w=2 l=4
X2 D18 G17 S17 B sky130_fd_pr__nfet_g5v0d10v5 ad=0.29 pd=2.29 as=0.29 ps=2.29 w=2 l=4
X3 D16 G15 S15 B sky130_fd_pr__nfet_g5v0d10v5 ad=0.29 pd=2.29 as=0.29 ps=2.29 w=2 l=4
X4 D6 G5 S5 B sky130_fd_pr__nfet_g5v0d10v5 ad=0.29 pd=2.29 as=0.29 ps=2.29 w=2 l=4
X5 D8 G7 S7 B sky130_fd_pr__nfet_g5v0d10v5 ad=0.29 pd=2.29 as=0.29 ps=2.29 w=2 l=4
X6 S17 G16 D16 B sky130_fd_pr__nfet_g5v0d10v5 ad=0.29 pd=2.29 as=0.29 ps=2.29 w=2 l=4
X7 S9 G8 D8 B sky130_fd_pr__nfet_g5v0d10v5 ad=0.29 pd=2.29 as=0.29 ps=2.29 w=2 l=4
X8 S1 G0 D0 B sky130_fd_pr__nfet_g5v0d10v5 ad=0.29 pd=2.29 as=0.58 ps=4.58 w=2 l=4
X9 S3 G2 D2 B sky130_fd_pr__nfet_g5v0d10v5 ad=0.29 pd=2.29 as=0.29 ps=2.29 w=2 l=4
X10 D14 G13 S13 B sky130_fd_pr__nfet_g5v0d10v5 ad=0.29 pd=2.29 as=0.29 ps=2.29 w=2 l=4
X11 D2 G1 S1 B sky130_fd_pr__nfet_g5v0d10v5 ad=0.29 pd=2.29 as=0.29 ps=2.29 w=2 l=4
X12 D10 G9 S9 B sky130_fd_pr__nfet_g5v0d10v5 ad=0.29 pd=2.29 as=0.29 ps=2.29 w=2 l=4
X13 D4 G3 S3 B sky130_fd_pr__nfet_g5v0d10v5 ad=0.29 pd=2.29 as=0.29 ps=2.29 w=2 l=4
X14 S15 G14 D14 B sky130_fd_pr__nfet_g5v0d10v5 ad=0.29 pd=2.29 as=0.29 ps=2.29 w=2 l=4
X15 S13 G12 D12 B sky130_fd_pr__nfet_g5v0d10v5 ad=0.29 pd=2.29 as=0.29 ps=2.29 w=2 l=4
X16 a_8551_n231# G19 S19 B sky130_fd_pr__nfet_g5v0d10v5 ad=0.58 pd=4.58 as=0.29 ps=2.29 w=2 l=4
X17 S5 G4 D4 B sky130_fd_pr__nfet_g5v0d10v5 ad=0.29 pd=2.29 as=0.29 ps=2.29 w=2 l=4
X18 S19 G18 D18 B sky130_fd_pr__nfet_g5v0d10v5 ad=0.29 pd=2.29 as=0.29 ps=2.29 w=2 l=4
X19 S11 G10 D10 B sky130_fd_pr__nfet_g5v0d10v5 ad=0.29 pd=2.29 as=0.29 ps=2.29 w=2 l=4
.ends

.subckt sky130_fd_pr__res_xhigh_po_0p35_PL9RNS B R1 R2
X0 R2 R1 B sky130_fd_pr__res_xhigh_po_0p35 l=991.66
.ends

.subckt sky130_fd_pr__rf_pnp_05v5_W3p40L3p40 Emitter Collector Base m=1
X0 Collector Base Emitter sky130_fd_pr__pnp_05v5_W3p40L3p40
**devattr s=462400,2720
.ends

.subckt sky130_fd_pr__res_xhigh_po_0p35_R4U9XH B R1 R2
X0 R1 R2 B sky130_fd_pr__res_xhigh_po_0p35 l=3.74
.ends

.subckt sky130_fd_pr__res_xhigh_po_0p35_XV4KRP B R1 R2
X0 R1 R2 B sky130_fd_pr__res_xhigh_po_0p35 l=7.4
.ends

.subckt sky130_fd_pr__cap_mim_m3_1_84Z4WG C2 C1
X0 C1 C2 sky130_fd_pr__cap_mim_m3_1 l=22 w=22
.ends

.subckt sky130_fd_pr__res_xhigh_po_0p35_4E3LTY B R1 R2
X0 R1 R2 B sky130_fd_pr__res_xhigh_po_0p35 l=14.76
.ends

.subckt sky130_fd_pr__pfet_g5v0d10v5_32MMT9 B D S G
X0 S G D B sky130_fd_pr__pfet_g5v0d10v5 ad=0.1218 pd=1.42 as=0.1218 ps=1.42 w=0.42 l=50
.ends

.subckt sky130_fd_pr__pfet_g5v0d10v5_MN82PF B D S G
X0 S G D B sky130_fd_pr__pfet_g5v0d10v5 ad=1.16 pd=8.58 as=1.16 ps=8.58 w=4 l=4
.ends

.subckt sky130_fd_pr__res_xhigh_po_0p35_VEZ8JB B R1 R2
X0 R1 R2 B sky130_fd_pr__res_xhigh_po_0p35 l=29.46
.ends

.subckt sky130_fd_pr__res_xhigh_po_0p35_HGUK4G B R1 R2
X0 R1 R2 B sky130_fd_pr__res_xhigh_po_0p35 l=58.86
.ends

.subckt sky130_fd_pr__res_xhigh_po_0p35_YNY9WN B R1 R2
X0 R2 R1 B sky130_fd_pr__res_xhigh_po_0p35 l=278.22
.ends

.subckt sky130_fd_pr__res_xhigh_po_0p35_8Z5M7R B R1 R2
X0 R2 R1 B sky130_fd_pr__res_xhigh_po_0p35 l=467.55
.ends

.subckt sky130_fd_pr__res_xhigh_po_0p35_KAXJA5 B R1 R2
X0 R2 R1 B sky130_fd_pr__res_xhigh_po_0p35 l=187.59
.ends

.subckt sky130_fd_pr__res_xhigh_po_0p35_NT9K52 B R1 R2
X0 R2 R1 B sky130_fd_pr__res_xhigh_po_0p35 l=583.97
.ends

.subckt sky130_fd_pr__res_xhigh_po_0p35_J82YCH B R1 R2
X0 R2 R1 B sky130_fd_pr__res_xhigh_po_0p35 l=205.27
.ends

.subckt sky130_fd_pr__pfet_g5v0d10v5_PSYF8E B D0 G0 S1 G1 D2 G2 S3 G3 D4 G4 S5 G5
+ D6 G6 S7 G7 D8 G8 S9 G9 D10 G10 S11 G11 D12 G12 S13 G13 D14 G14 S15 G15 D16 G16
+ S17 G17 D18 G18 S19 G19 D20 G20 S21 G21 D22 G22 S23 G23 D24 G24 S25 G25 D26 G26
+ S27 G27 D28 G28 S29 G29 D30 G30 S31 G31 D32 G32 S33 G33 D34 G34 S35 G35 D36 G36
+ S37 G37 D38 G38 S39 G39 a_3131_n1036#
X0 S17 G16 D16 B sky130_fd_pr__pfet_g5v0d10v5 ad=1.45 pd=10.29 as=1.45 ps=10.29 w=10 l=0.5
X1 S3 G2 D2 B sky130_fd_pr__pfet_g5v0d10v5 ad=1.45 pd=10.29 as=1.45 ps=10.29 w=10 l=0.5
X2 D22 G21 S21 B sky130_fd_pr__pfet_g5v0d10v5 ad=1.45 pd=10.29 as=1.45 ps=10.29 w=10 l=0.5
X3 D2 G1 S1 B sky130_fd_pr__pfet_g5v0d10v5 ad=1.45 pd=10.29 as=1.45 ps=10.29 w=10 l=0.5
X4 D16 G15 S15 B sky130_fd_pr__pfet_g5v0d10v5 ad=1.45 pd=10.29 as=1.45 ps=10.29 w=10 l=0.5
X5 S13 G12 D12 B sky130_fd_pr__pfet_g5v0d10v5 ad=1.45 pd=10.29 as=1.45 ps=10.29 w=10 l=0.5
X6 D12 G11 S11 B sky130_fd_pr__pfet_g5v0d10v5 ad=1.45 pd=10.29 as=1.45 ps=10.29 w=10 l=0.5
X7 D10 G9 S9 B sky130_fd_pr__pfet_g5v0d10v5 ad=1.45 pd=10.29 as=1.45 ps=10.29 w=10 l=0.5
X8 D20 G19 S19 B sky130_fd_pr__pfet_g5v0d10v5 ad=1.45 pd=10.29 as=1.45 ps=10.29 w=10 l=0.5
X9 D30 G29 S29 B sky130_fd_pr__pfet_g5v0d10v5 ad=1.45 pd=10.29 as=1.45 ps=10.29 w=10 l=0.5
X10 D34 G33 S33 B sky130_fd_pr__pfet_g5v0d10v5 ad=1.45 pd=10.29 as=1.45 ps=10.29 w=10 l=0.5
X11 S9 G8 D8 B sky130_fd_pr__pfet_g5v0d10v5 ad=1.45 pd=10.29 as=1.45 ps=10.29 w=10 l=0.5
X12 S19 G18 D18 B sky130_fd_pr__pfet_g5v0d10v5 ad=1.45 pd=10.29 as=1.45 ps=10.29 w=10 l=0.5
X13 S5 G4 D4 B sky130_fd_pr__pfet_g5v0d10v5 ad=1.45 pd=10.29 as=1.45 ps=10.29 w=10 l=0.5
X14 S33 G32 D32 B sky130_fd_pr__pfet_g5v0d10v5 ad=1.45 pd=10.29 as=1.45 ps=10.29 w=10 l=0.5
X15 S37 G36 D36 B sky130_fd_pr__pfet_g5v0d10v5 ad=1.45 pd=10.29 as=1.45 ps=10.29 w=10 l=0.5
X16 S1 G0 D0 B sky130_fd_pr__pfet_g5v0d10v5 ad=1.45 pd=10.29 as=2.9 ps=20.58 w=10 l=0.5
X17 S21 G20 D20 B sky130_fd_pr__pfet_g5v0d10v5 ad=1.45 pd=10.29 as=1.45 ps=10.29 w=10 l=0.5
X18 S23 G22 D22 B sky130_fd_pr__pfet_g5v0d10v5 ad=1.45 pd=10.29 as=1.45 ps=10.29 w=10 l=0.5
X19 D8 G7 S7 B sky130_fd_pr__pfet_g5v0d10v5 ad=1.45 pd=10.29 as=1.45 ps=10.29 w=10 l=0.5
X20 D26 G25 S25 B sky130_fd_pr__pfet_g5v0d10v5 ad=1.45 pd=10.29 as=1.45 ps=10.29 w=10 l=0.5
X21 S11 G10 D10 B sky130_fd_pr__pfet_g5v0d10v5 ad=1.45 pd=10.29 as=1.45 ps=10.29 w=10 l=0.5
X22 S27 G26 D26 B sky130_fd_pr__pfet_g5v0d10v5 ad=1.45 pd=10.29 as=1.45 ps=10.29 w=10 l=0.5
X23 S7 G6 D6 B sky130_fd_pr__pfet_g5v0d10v5 ad=1.45 pd=10.29 as=1.45 ps=10.29 w=10 l=0.5
X24 S35 G34 D34 B sky130_fd_pr__pfet_g5v0d10v5 ad=1.45 pd=10.29 as=1.45 ps=10.29 w=10 l=0.5
X25 D4 G3 S3 B sky130_fd_pr__pfet_g5v0d10v5 ad=1.45 pd=10.29 as=1.45 ps=10.29 w=10 l=0.5
X26 D18 G17 S17 B sky130_fd_pr__pfet_g5v0d10v5 ad=1.45 pd=10.29 as=1.45 ps=10.29 w=10 l=0.5
X27 D38 G37 S37 B sky130_fd_pr__pfet_g5v0d10v5 ad=1.45 pd=10.29 as=1.45 ps=10.29 w=10 l=0.5
X28 S15 G14 D14 B sky130_fd_pr__pfet_g5v0d10v5 ad=1.45 pd=10.29 as=1.45 ps=10.29 w=10 l=0.5
X29 D14 G13 S13 B sky130_fd_pr__pfet_g5v0d10v5 ad=1.45 pd=10.29 as=1.45 ps=10.29 w=10 l=0.5
X30 S39 G38 D38 B sky130_fd_pr__pfet_g5v0d10v5 ad=1.45 pd=10.29 as=1.45 ps=10.29 w=10 l=0.5
X31 D28 G27 S27 B sky130_fd_pr__pfet_g5v0d10v5 ad=1.45 pd=10.29 as=1.45 ps=10.29 w=10 l=0.5
X32 S29 G28 D28 B sky130_fd_pr__pfet_g5v0d10v5 ad=1.45 pd=10.29 as=1.45 ps=10.29 w=10 l=0.5
X33 D24 G23 S23 B sky130_fd_pr__pfet_g5v0d10v5 ad=1.45 pd=10.29 as=1.45 ps=10.29 w=10 l=0.5
X34 S31 G30 D30 B sky130_fd_pr__pfet_g5v0d10v5 ad=1.45 pd=10.29 as=1.45 ps=10.29 w=10 l=0.5
X35 S25 G24 D24 B sky130_fd_pr__pfet_g5v0d10v5 ad=1.45 pd=10.29 as=1.45 ps=10.29 w=10 l=0.5
X36 D32 G31 S31 B sky130_fd_pr__pfet_g5v0d10v5 ad=1.45 pd=10.29 as=1.45 ps=10.29 w=10 l=0.5
X37 D36 G35 S35 B sky130_fd_pr__pfet_g5v0d10v5 ad=1.45 pd=10.29 as=1.45 ps=10.29 w=10 l=0.5
X38 D6 G5 S5 B sky130_fd_pr__pfet_g5v0d10v5 ad=1.45 pd=10.29 as=1.45 ps=10.29 w=10 l=0.5
X39 a_3131_n1036# G39 S39 B sky130_fd_pr__pfet_g5v0d10v5 ad=2.9 pd=20.58 as=1.45 ps=10.29 w=10 l=0.5
.ends

.subckt sky130_fd_pr__pfet_g5v0d10v5_7B62CL B D S G
X0 S G D B sky130_fd_pr__pfet_g5v0d10v5 ad=0.2436 pd=2.26 as=0.2436 ps=2.26 w=0.84 l=0.5
.ends

.subckt sky130_fd_pr__pfet_g5v0d10v5_PN8J4Z B D0 S0 G0 D1 S1 G1 D2 S2 G2
X0 S2 G2 D2 B sky130_fd_pr__pfet_g5v0d10v5 ad=1.16 pd=8.58 as=1.16 ps=8.58 w=4 l=4
X1 S1 G1 D1 B sky130_fd_pr__pfet_g5v0d10v5 ad=1.16 pd=8.58 as=1.16 ps=8.58 w=4 l=4
X2 S0 G0 D0 B sky130_fd_pr__pfet_g5v0d10v5 ad=1.16 pd=8.58 as=1.16 ps=8.58 w=4 l=4
.ends

.subckt sky130_fd_pr__nfet_g5v0d10v5_3UQFYT B D0 S0 G0 D1 S1 G1 D2 S2 G2
X0 S0 G0 D0 B sky130_fd_pr__nfet_g5v0d10v5 ad=0.58 pd=4.58 as=0.58 ps=4.58 w=2 l=4
X1 S1 G1 D1 B sky130_fd_pr__nfet_g5v0d10v5 ad=0.58 pd=4.58 as=0.58 ps=4.58 w=2 l=4
X2 S2 G2 D2 B sky130_fd_pr__nfet_g5v0d10v5 ad=0.58 pd=4.58 as=0.58 ps=4.58 w=2 l=4
.ends

.subckt sky130_fd_pr__res_xhigh_po_0p35_ADWJQG B R1 R2
X0 R2 R1 B sky130_fd_pr__res_xhigh_po_0p35 l=292.92
.ends

.subckt sky130_fd_pr__cap_mim_m3_1_Y3HN7X C2 C1
X0 C1 C2 sky130_fd_pr__cap_mim_m3_1 l=27.5 w=27.5
.ends

.subckt sky130_fd_pr__nfet_g5v0d10v5_WMYWGM B D S G
X0 S G D B sky130_fd_pr__nfet_g5v0d10v5 ad=2.32 pd=16.58 as=2.32 ps=16.58 w=8 l=2
.ends

.subckt sky130_fd_pr__pfet_g5v0d10v5_DNGK98 B D S G
X0 S G D B sky130_fd_pr__pfet_g5v0d10v5 ad=4.64 pd=32.58 as=4.64 ps=32.58 w=16 l=4
.ends

.subckt sky130_fd_pr__nfet_g5v0d10v5_DDWFWJ B D0 G0 S1 G1 D2 S2 G2
X0 D2 G1 S1 B sky130_fd_pr__nfet_g5v0d10v5 ad=0.58 pd=4.29 as=0.58 ps=4.29 w=4 l=1
X1 S1 G0 D0 B sky130_fd_pr__nfet_g5v0d10v5 ad=0.58 pd=4.29 as=1.16 ps=8.58 w=4 l=1
X2 S2 G2 D2 B sky130_fd_pr__nfet_g5v0d10v5 ad=1.16 pd=8.58 as=0.58 ps=4.29 w=4 l=1
.ends

.subckt sky130_fd_pr__nfet_g5v0d10v5_FZ2B7C B D S G
X0 S G D B sky130_fd_pr__nfet_g5v0d10v5 ad=0.1218 pd=1.42 as=0.1218 ps=1.42 w=0.42 l=0.5
.ends

.subckt sky130_fd_pr__cap_mim_m3_1_PP9XRG C2 C1
X0 C1 C2 sky130_fd_pr__cap_mim_m3_1 l=30 w=30
.ends

.subckt sky130_fd_pr__nfet_g5v0d10v5_HA9V6X B D0 S0 G0 D1 S1 G1 D2 S2 G2 D3 S3 G3
X0 S1 G1 D1 B sky130_fd_pr__nfet_g5v0d10v5 ad=0.58 pd=4.58 as=0.58 ps=4.58 w=2 l=4
X1 S3 G3 D3 B sky130_fd_pr__nfet_g5v0d10v5 ad=0.58 pd=4.58 as=0.58 ps=4.58 w=2 l=4
X2 S2 G2 D2 B sky130_fd_pr__nfet_g5v0d10v5 ad=0.58 pd=4.58 as=0.58 ps=4.58 w=2 l=4
X3 S0 G0 D0 B sky130_fd_pr__nfet_g5v0d10v5 ad=0.58 pd=4.58 as=0.58 ps=4.58 w=2 l=4
.ends

.subckt sky130_fd_pr__pfet_g5v0d10v5_KMGDV8 B D0_0 G0_0 D0_1 G0_1 D0_2 G0_2 D0_3 G0_3
+ S1_0 G1_0 S1_1 G1_1 S1_2 G1_2 S1_3 G1_3 D2_0 G2_0 D2_1 G2_1 D2_2 G2_2 D2_3 G2_3
+ S3_0 G3_0 S3_1 G3_1 S3_2 G3_2 S3_3 G3_3 D4_0 G4_0 D4_1 G4_1 D4_2 G4_2 D4_3 G4_3
+ S5_0 G5_0 S5_1 G5_1 S5_2 G5_2 S5_3 G5_3 D6_0 G6_0 D6_1 G6_1 D6_2 G6_2 D6_3 G6_3
+ S7_0 G7_0 S7_1 G7_1 S7_2 G7_2 S7_3 G7_3 a_1803_n8283# a_1803_4212# a_1803_n4118#
+ a_1803_47#
X0 a_1803_4212# G7_3 S7_3 B sky130_fd_pr__pfet_g5v0d10v5 ad=5.8 pd=40.58 as=2.9 ps=20.29 w=20 l=2
X1 S5_2 G4_2 D4_2 B sky130_fd_pr__pfet_g5v0d10v5 ad=2.9 pd=20.29 as=2.9 ps=20.29 w=20 l=2
X2 D6_3 G5_3 S5_3 B sky130_fd_pr__pfet_g5v0d10v5 ad=2.9 pd=20.29 as=2.9 ps=20.29 w=20 l=2
X3 S3_3 G2_3 D2_3 B sky130_fd_pr__pfet_g5v0d10v5 ad=2.9 pd=20.29 as=2.9 ps=20.29 w=20 l=2
X4 S5_1 G4_1 D4_1 B sky130_fd_pr__pfet_g5v0d10v5 ad=2.9 pd=20.29 as=2.9 ps=20.29 w=20 l=2
X5 S3_0 G2_0 D2_0 B sky130_fd_pr__pfet_g5v0d10v5 ad=2.9 pd=20.29 as=2.9 ps=20.29 w=20 l=2
X6 S1_3 G0_3 D0_3 B sky130_fd_pr__pfet_g5v0d10v5 ad=2.9 pd=20.29 as=5.8 ps=40.58 w=20 l=2
X7 D4_2 G3_2 S3_2 B sky130_fd_pr__pfet_g5v0d10v5 ad=2.9 pd=20.29 as=2.9 ps=20.29 w=20 l=2
X8 D2_0 G1_0 S1_0 B sky130_fd_pr__pfet_g5v0d10v5 ad=2.9 pd=20.29 as=2.9 ps=20.29 w=20 l=2
X9 D6_0 G5_0 S5_0 B sky130_fd_pr__pfet_g5v0d10v5 ad=2.9 pd=20.29 as=2.9 ps=20.29 w=20 l=2
X10 a_1803_n8283# G7_0 S7_0 B sky130_fd_pr__pfet_g5v0d10v5 ad=5.8 pd=40.58 as=2.9 ps=20.29 w=20 l=2
X11 S3_2 G2_2 D2_2 B sky130_fd_pr__pfet_g5v0d10v5 ad=2.9 pd=20.29 as=2.9 ps=20.29 w=20 l=2
X12 S7_0 G6_0 D6_0 B sky130_fd_pr__pfet_g5v0d10v5 ad=2.9 pd=20.29 as=2.9 ps=20.29 w=20 l=2
X13 D4_3 G3_3 S3_3 B sky130_fd_pr__pfet_g5v0d10v5 ad=2.9 pd=20.29 as=2.9 ps=20.29 w=20 l=2
X14 S1_0 G0_0 D0_0 B sky130_fd_pr__pfet_g5v0d10v5 ad=2.9 pd=20.29 as=5.8 ps=40.58 w=20 l=2
X15 D4_0 G3_0 S3_0 B sky130_fd_pr__pfet_g5v0d10v5 ad=2.9 pd=20.29 as=2.9 ps=20.29 w=20 l=2
X16 S7_3 G6_3 D6_3 B sky130_fd_pr__pfet_g5v0d10v5 ad=2.9 pd=20.29 as=2.9 ps=20.29 w=20 l=2
X17 S3_1 G2_1 D2_1 B sky130_fd_pr__pfet_g5v0d10v5 ad=2.9 pd=20.29 as=2.9 ps=20.29 w=20 l=2
X18 D6_1 G5_1 S5_1 B sky130_fd_pr__pfet_g5v0d10v5 ad=2.9 pd=20.29 as=2.9 ps=20.29 w=20 l=2
X19 D2_1 G1_1 S1_1 B sky130_fd_pr__pfet_g5v0d10v5 ad=2.9 pd=20.29 as=2.9 ps=20.29 w=20 l=2
X20 a_1803_n4118# G7_1 S7_1 B sky130_fd_pr__pfet_g5v0d10v5 ad=5.8 pd=40.58 as=2.9 ps=20.29 w=20 l=2
X21 S1_1 G0_1 D0_1 B sky130_fd_pr__pfet_g5v0d10v5 ad=2.9 pd=20.29 as=5.8 ps=40.58 w=20 l=2
X22 S7_1 G6_1 D6_1 B sky130_fd_pr__pfet_g5v0d10v5 ad=2.9 pd=20.29 as=2.9 ps=20.29 w=20 l=2
X23 D2_3 G1_3 S1_3 B sky130_fd_pr__pfet_g5v0d10v5 ad=2.9 pd=20.29 as=2.9 ps=20.29 w=20 l=2
X24 D4_1 G3_1 S3_1 B sky130_fd_pr__pfet_g5v0d10v5 ad=2.9 pd=20.29 as=2.9 ps=20.29 w=20 l=2
X25 D6_2 G5_2 S5_2 B sky130_fd_pr__pfet_g5v0d10v5 ad=2.9 pd=20.29 as=2.9 ps=20.29 w=20 l=2
X26 D2_2 G1_2 S1_2 B sky130_fd_pr__pfet_g5v0d10v5 ad=2.9 pd=20.29 as=2.9 ps=20.29 w=20 l=2
X27 a_1803_47# G7_2 S7_2 B sky130_fd_pr__pfet_g5v0d10v5 ad=5.8 pd=40.58 as=2.9 ps=20.29 w=20 l=2
X28 S5_0 G4_0 D4_0 B sky130_fd_pr__pfet_g5v0d10v5 ad=2.9 pd=20.29 as=2.9 ps=20.29 w=20 l=2
X29 S7_2 G6_2 D6_2 B sky130_fd_pr__pfet_g5v0d10v5 ad=2.9 pd=20.29 as=2.9 ps=20.29 w=20 l=2
X30 S5_3 G4_3 D4_3 B sky130_fd_pr__pfet_g5v0d10v5 ad=2.9 pd=20.29 as=2.9 ps=20.29 w=20 l=2
X31 S1_2 G0_2 D0_2 B sky130_fd_pr__pfet_g5v0d10v5 ad=2.9 pd=20.29 as=5.8 ps=40.58 w=20 l=2
.ends

.subckt sky130_fd_pr__pfet_g5v0d10v5_UFWJXT B D0_0 G0_0 D0_1 G0_1 D0_2 G0_2 D0_3 G0_3
+ S1_0 G1_0 S1_1 G1_1 S1_2 G1_2 S1_3 G1_3 a_3229_n8283# a_3229_4212# a_3229_47# a_3229_n4118#
X0 a_3229_47# G1_2 S1_2 B sky130_fd_pr__pfet_g5v0d10v5 ad=5.8 pd=40.58 as=2.9 ps=20.29 w=20 l=16
X1 S1_2 G0_2 D0_2 B sky130_fd_pr__pfet_g5v0d10v5 ad=2.9 pd=20.29 as=5.8 ps=40.58 w=20 l=16
X2 a_3229_n4118# G1_1 S1_1 B sky130_fd_pr__pfet_g5v0d10v5 ad=5.8 pd=40.58 as=2.9 ps=20.29 w=20 l=16
X3 S1_3 G0_3 D0_3 B sky130_fd_pr__pfet_g5v0d10v5 ad=2.9 pd=20.29 as=5.8 ps=40.58 w=20 l=16
X4 S1_0 G0_0 D0_0 B sky130_fd_pr__pfet_g5v0d10v5 ad=2.9 pd=20.29 as=5.8 ps=40.58 w=20 l=16
X5 a_3229_n8283# G1_0 S1_0 B sky130_fd_pr__pfet_g5v0d10v5 ad=5.8 pd=40.58 as=2.9 ps=20.29 w=20 l=16
X6 a_3229_4212# G1_3 S1_3 B sky130_fd_pr__pfet_g5v0d10v5 ad=5.8 pd=40.58 as=2.9 ps=20.29 w=20 l=16
X7 S1_1 G0_1 D0_1 B sky130_fd_pr__pfet_g5v0d10v5 ad=2.9 pd=20.29 as=5.8 ps=40.58 w=20 l=16
.ends

.subckt sky130_fd_pr__nfet_g5v0d10v5_F3NX3J B D S G
X0 S G D B sky130_fd_pr__nfet_g5v0d10v5 ad=0.1218 pd=1.42 as=0.1218 ps=1.42 w=0.42 l=4
.ends

.subckt sky130_fd_pr__nfet_05v0_nvt_6T4HWX B D0 S0 G0 D1 S1 G1
X0 S1 G1 D1 B sky130_fd_pr__nfet_05v0_nvt ad=0.29 pd=2.58 as=0.29 ps=2.58 w=1 l=25
X1 S0 G0 D0 B sky130_fd_pr__nfet_05v0_nvt ad=0.29 pd=2.58 as=0.29 ps=2.58 w=1 l=25
.ends

.subckt sky130_fd_pr__pfet_g5v0d10v5_5EJAKB B D S G
X0 S G D B sky130_fd_pr__pfet_g5v0d10v5 ad=0.2436 pd=2.26 as=0.2436 ps=2.26 w=0.84 l=4
.ends

.subckt ldo_top vin vout rstn gnd
Xbgr_MPO vin bgr_MPO/D3 vin bgr_MS2/D bgr_MPO/D3 vin bgr_MS2/D bgr_MPO/D3 vin bgr_MS2/D
+ bgr_MPO/D3 vin bgr_MS2/D sky130_fd_pr__pfet_g5v0d10v5_UFECYT
Xbgr_MT0 gnd bgr_R2/R1 bgr_MT1/D gnd sky130_fd_pr__nfet_g5v0d10v5_3LMSA7
Xbgr_MPCC vin bgr_MNCD/G bgr_MS2/D bgr_MNCD/G bgr_MS2/D bgr_MNCD/G bgr_MS2/D bgr_MNCD/G
+ bgr_MS2/D bgr_MPC/D3 bgr_MS2/D bgr_MPC/D3 bgr_MS2/D bgr_MPC/D3 bgr_MS2/D bgr_MPC/D3
+ bgr_MS2/D bgr_MNCD/G bgr_MS2/D bgr_MNCD/G bgr_MS2/D bgr_MNCD/G bgr_MS2/D bgr_MNCD/G
+ bgr_MS2/D bgr_MPC/D3 bgr_MS2/D bgr_MPC/D3 bgr_MS2/D bgr_MPC/D3 bgr_MS2/D bgr_MPC/D3
+ bgr_MS2/D bgr_MNCD/G bgr_MNCD/G bgr_MNCD/G bgr_MNCD/G sky130_fd_pr__pfet_g5v0d10v5_TGGT4A
Xbgr_MT1 gnd bgr_MT1/D bgr_MT2/D gnd sky130_fd_pr__nfet_g5v0d10v5_3LMSA7
Xbgr_MPBC vin bgr_MNB/G5 bgr_MS2/D bgr_MNB/G5 bgr_MS2/D bgr_MNB/G5 bgr_MS2/D bgr_MNB/G5
+ bgr_MS2/D bgr_MPB/D3 bgr_MS2/D bgr_MPB/D3 bgr_MS2/D bgr_MPB/D3 bgr_MS2/D bgr_MPB/D3
+ bgr_MS2/D bgr_MNB/G5 bgr_MS2/D bgr_MNB/G5 bgr_MS2/D bgr_MNB/G5 bgr_MS2/D bgr_MNB/G5
+ bgr_MS2/D bgr_MPB/D3 bgr_MS2/D bgr_MPB/D3 bgr_MS2/D bgr_MPB/D3 bgr_MS2/D bgr_MPB/D3
+ bgr_MS2/D bgr_MNB/G5 bgr_MNB/G5 bgr_MNB/G5 bgr_MNB/G5 sky130_fd_pr__pfet_g5v0d10v5_TGGT4A
Xpor_MD gnd por_MD/D gnd por_MD/G sky130_fd_pr__nfet_g5v0d10v5_C8EBTW
Xbgr_MT2 gnd bgr_MT2/D bgr_MT3/D gnd sky130_fd_pr__nfet_g5v0d10v5_3LMSA7
Xbgr_MPAC vin bgr_MNF/G5 bgr_MS2/D bgr_MNF/G5 bgr_MS2/D bgr_MNF/G5 bgr_MS2/D bgr_MNF/G5
+ bgr_MS2/D bgr_MPA/D3 bgr_MS2/D bgr_MPA/D3 bgr_MS2/D bgr_MPA/D3 bgr_MS2/D bgr_MPA/D3
+ bgr_MS2/D bgr_MNF/G5 bgr_MS2/D bgr_MNF/G5 bgr_MS2/D bgr_MNF/G5 bgr_MS2/D bgr_MNF/G5
+ bgr_MS2/D bgr_MPA/D3 bgr_MS2/D bgr_MPA/D3 bgr_MS2/D bgr_MPA/D3 bgr_MS2/D bgr_MPA/D3
+ bgr_MS2/D bgr_MNF/G5 bgr_MNF/G5 bgr_MNF/G5 bgr_MNF/G5 sky130_fd_pr__pfet_g5v0d10v5_TGGT4A
Xbgr_MT3 gnd bgr_MT3/D bgr_MT4/D gnd sky130_fd_pr__nfet_g5v0d10v5_3LMSA7
Xbgr_MS2 gnd bgr_MS2/D gnd bgr_MSN/D sky130_fd_pr__nfet_g5v0d10v5_62W55W
Xbgr_Cvr0 gnd ldo_MN2/G sky130_fd_pr__cap_mim_m3_1_BTY6QK
Xldo_Cff_0 ldo_MNX/S2 vin sky130_fd_pr__cap_mim_m3_1_V8HUNN
Xldo_MNA gnd ldo_MPS/D gnd ldo_MPS/D sky130_fd_pr__nfet_g5v0d10v5_NUFNY9
Xbgr_MT4 gnd bgr_MT4/D bgr_MT4/S vin sky130_fd_pr__nfet_g5v0d10v5_3LMSA7
Xbgr_MNCD gnd bgr_MNCD/G bgr_MNCD/S bgr_MNCD/G sky130_fd_pr__nfet_05v0_nvt_F4CC77
Xbgr_MNBC gnd bgr_MNF/G5 bgr_MNCD/G bgr_MNB/D4 bgr_MNCD/G bgr_MNF/G5 bgr_MNCD/G bgr_MNB/D4
+ bgr_MNCD/G bgr_MNF/G5 bgr_MNCD/G bgr_MNB/D4 bgr_MNCD/G bgr_MNF/G5 sky130_fd_pr__nfet_05v0_nvt_ASWYB8
Xbgr_Cvr1 gnd ldo_MN2/G sky130_fd_pr__cap_mim_m3_1_BTY6QK
Xldo_Cff_1 ldo_MNX/S2 vin sky130_fd_pr__cap_mim_m3_1_V8HUNN
Xldo_MNB gnd ldo_MNB/G gnd ldo_MNB/G sky130_fd_pr__nfet_g5v0d10v5_BE4NYT
Xbgr_R1 gnd bgr_R1/R1 bgr_R1/R2 sky130_fd_pr__res_xhigh_po_0p35_5J6MKL
Xpor_MH gnd por_MH/D gnd por_MH/G sky130_fd_pr__nfet_g5v0d10v5_A8HTHF
Xbgr_Cvr2 gnd ldo_MN2/G sky130_fd_pr__cap_mim_m3_1_BTY6QK
Xldo_Cff_2 ldo_MNX/S2 vin sky130_fd_pr__cap_mim_m3_1_V8HUNN
Xldo_MNBL gnd vout ldo_MNB/G gnd ldo_MNB/G vout ldo_MNB/G gnd ldo_MNB/G vout ldo_MNB/G
+ gnd ldo_MNB/G vout ldo_MNB/G gnd ldo_MNB/G vout ldo_MNB/G gnd ldo_MNB/G vout ldo_MNB/G
+ gnd ldo_MNB/G vout ldo_MNB/G gnd ldo_MNB/G vout ldo_MNB/G gnd ldo_MNB/G vout ldo_MNB/G
+ gnd ldo_MNB/G vout ldo_MNB/G gnd ldo_MNB/G vout sky130_fd_pr__nfet_g5v0d10v5_YQMGE2
Xbgr_R2 gnd bgr_R2/R1 bgr_Rf/R2 sky130_fd_pr__res_xhigh_po_0p35_PL9RNS
Xbgr_Q1 bgr_MNA/S5 gnd gnd sky130_fd_pr__rf_pnp_05v5_W3p40L3p40 m=1
Xbgr_Cvr3 gnd ldo_MN2/G sky130_fd_pr__cap_mim_m3_1_BTY6QK
Xldo_Cff_3 ldo_MNX/S2 vin sky130_fd_pr__cap_mim_m3_1_V8HUNN
Xbgr_Q3 bgr_MT4/S gnd gnd sky130_fd_pr__rf_pnp_05v5_W3p40L3p40 m=1
Xbgr_RT0 gnd bgr_MT1/D bgr_R2/R1 sky130_fd_pr__res_xhigh_po_0p35_R4U9XH
Xbgr_Q5 bgr_MNCD/S gnd gnd sky130_fd_pr__rf_pnp_05v5_W3p40L3p40 m=1
Xbgr_RT1 gnd bgr_MT2/D bgr_MT1/D sky130_fd_pr__res_xhigh_po_0p35_XV4KRP
Xldo_Cbp gnd ldo_Rsh/R1 sky130_fd_pr__cap_mim_m3_1_84Z4WG
Xbgr_RT2 gnd bgr_MT3/D bgr_MT2/D sky130_fd_pr__res_xhigh_po_0p35_4E3LTY
Xbgr_Q7 bgr_MSN/S gnd gnd sky130_fd_pr__rf_pnp_05v5_W3p40L3p40 m=1
Xbgr_MSU0 vin bgr_MSU1/S vin bgr_MSU1/S sky130_fd_pr__pfet_g5v0d10v5_32MMT9
Xldo_MPB2 vin ldo_Rsh/R2 vin ldo_Rsh/R2 sky130_fd_pr__pfet_g5v0d10v5_MN82PF
Xbgr_RT3 gnd bgr_MT4/D bgr_MT3/D sky130_fd_pr__res_xhigh_po_0p35_VEZ8JB
Xbgr_RT4 gnd bgr_MT4/S bgr_MT4/D sky130_fd_pr__res_xhigh_po_0p35_HGUK4G
Xbgr_Q2_0 bgr_R1/R1 gnd gnd sky130_fd_pr__rf_pnp_05v5_W3p40L3p40 m=1
Xbgr_Q8 bgr_MNSK/S1 gnd gnd sky130_fd_pr__rf_pnp_05v5_W3p40L3p40 m=1
Xpor_R1 gnd por_MD/G vin sky130_fd_pr__res_xhigh_po_0p35_YNY9WN
Xbgr_MSU1 vin bgr_MSU2/S bgr_MSU1/S bgr_MSU2/S sky130_fd_pr__pfet_g5v0d10v5_32MMT9
Xbgr_Q2_1 bgr_R1/R1 gnd gnd sky130_fd_pr__rf_pnp_05v5_W3p40L3p40 m=1
Xpor_R2 gnd por_MH/D por_MD/G sky130_fd_pr__res_xhigh_po_0p35_8Z5M7R
Xbgr_MSU3 vin bgr_MSN/D bgr_MSU3/S bgr_MSN/D sky130_fd_pr__pfet_g5v0d10v5_32MMT9
Xbgr_MSU2 vin bgr_MSU3/S bgr_MSU2/S bgr_MSU3/S sky130_fd_pr__pfet_g5v0d10v5_32MMT9
Xbgr_Q2_2 bgr_R1/R1 gnd gnd sky130_fd_pr__rf_pnp_05v5_W3p40L3p40 m=1
Xpor_R3 gnd gnd por_MH/D sky130_fd_pr__res_xhigh_po_0p35_KAXJA5
Xpor_Rpu gnd por_MD/D vin sky130_fd_pr__res_xhigh_po_0p35_NT9K52
Xldo_MNA2 gnd ldo_MN2/S gnd ldo_MPS/D sky130_fd_pr__nfet_g5v0d10v5_NUFNY9
Xldo_MNB3 gnd ldo_Rsh/R1 gnd ldo_MNB/G sky130_fd_pr__nfet_g5v0d10v5_BE4NYT
Xldo_Rsh gnd ldo_Rsh/R1 ldo_Rsh/R2 sky130_fd_pr__res_xhigh_po_0p35_J82YCH
Xbgr_Q2_3 bgr_R1/R1 gnd gnd sky130_fd_pr__rf_pnp_05v5_W3p40L3p40 m=1
Xldo_MPP vin vout ldo_MPS/G vin ldo_MPS/G vout ldo_MPS/G vin ldo_MPS/G vout ldo_MPS/G
+ vin ldo_MPS/G vout ldo_MPS/G vin ldo_MPS/G vout ldo_MPS/G vin ldo_MPS/G vout ldo_MPS/G
+ vin ldo_MPS/G vout ldo_MPS/G vin ldo_MPS/G vout ldo_MPS/G vin ldo_MPS/G vout ldo_MPS/G
+ vin ldo_MPS/G vout ldo_MPS/G vin ldo_MPS/G vout ldo_MPS/G vin ldo_MPS/G vout ldo_MPS/G
+ vin ldo_MPS/G vout ldo_MPS/G vin ldo_MPS/G vout ldo_MPS/G vin ldo_MPS/G vout ldo_MPS/G
+ vin ldo_MPS/G vout ldo_MPS/G vin ldo_MPS/G vout ldo_MPS/G vin ldo_MPS/G vout ldo_MPS/G
+ vin ldo_MPS/G vout ldo_MPS/G vin ldo_MPS/G vout ldo_MPS/G vin ldo_MPS/G vout sky130_fd_pr__pfet_g5v0d10v5_PSYF8E
Xbgr_Q2_5 bgr_R1/R1 gnd gnd sky130_fd_pr__rf_pnp_05v5_W3p40L3p40 m=1
Xbgr_Q2_4 bgr_R1/R1 gnd gnd sky130_fd_pr__rf_pnp_05v5_W3p40L3p40 m=1
Xbgr_Q2_6 bgr_R1/R1 gnd gnd sky130_fd_pr__rf_pnp_05v5_W3p40L3p40 m=1
Xldo_MPS vin ldo_MPS/D vin ldo_MPS/G sky130_fd_pr__pfet_g5v0d10v5_7B62CL
Xbgr_Q2_7 bgr_R1/R1 gnd gnd sky130_fd_pr__rf_pnp_05v5_W3p40L3p40 m=1
Xldo_MPT vin ldo_MPX/S2 vin ldo_Rsh/R2 ldo_MPX/S2 vin ldo_Rsh/R2 ldo_MPX/S2 vin ldo_Rsh/R2
+ sky130_fd_pr__pfet_g5v0d10v5_PN8J4Z
Xbgr_MPA vin bgr_MPA/D3 vin bgr_MS2/D bgr_MPA/D3 vin bgr_MS2/D bgr_MPA/D3 vin bgr_MS2/D
+ bgr_MPA/D3 vin bgr_MS2/D sky130_fd_pr__pfet_g5v0d10v5_UFECYT
Xldo_MNS gnd ldo_MNX/S2 gnd ldo_MNB/G ldo_MNX/S2 gnd ldo_MNB/G ldo_MNX/S2 gnd ldo_MNB/G
+ sky130_fd_pr__nfet_g5v0d10v5_3UQFYT
Xbgr_Rf gnd ldo_MN2/G bgr_Rf/R2 sky130_fd_pr__res_xhigh_po_0p35_ADWJQG
Xbgr_MPC vin bgr_MPC/D3 vin bgr_MS2/D bgr_MPC/D3 vin bgr_MS2/D bgr_MPC/D3 vin bgr_MS2/D
+ bgr_MPC/D3 vin bgr_MS2/D sky130_fd_pr__pfet_g5v0d10v5_UFECYT
Xbgr_MPB vin bgr_MPB/D3 vin bgr_MS2/D bgr_MPB/D3 vin bgr_MS2/D bgr_MPB/D3 vin bgr_MS2/D
+ bgr_MPB/D3 vin bgr_MS2/D sky130_fd_pr__pfet_g5v0d10v5_UFECYT
Xbgr_MNA gnd bgr_MNB/G5 bgr_MNB/G5 bgr_MNA/S5 bgr_MNB/G5 bgr_MNB/G5 bgr_MNB/G5 bgr_MNA/S5
+ bgr_MNB/G5 bgr_MNB/G5 bgr_MNB/G5 bgr_MNA/S5 bgr_MNB/G5 bgr_MNB/G5 sky130_fd_pr__nfet_05v0_nvt_ASWYB8
Xbgr_MPOC vin bgr_Rf/R2 bgr_MS2/D bgr_Rf/R2 bgr_MS2/D bgr_Rf/R2 bgr_MS2/D bgr_Rf/R2
+ bgr_MS2/D bgr_MPO/D3 bgr_MS2/D bgr_MPO/D3 bgr_MS2/D bgr_MPO/D3 bgr_MS2/D bgr_MPO/D3
+ bgr_MS2/D bgr_Rf/R2 bgr_MS2/D bgr_Rf/R2 bgr_MS2/D bgr_Rf/R2 bgr_MS2/D bgr_Rf/R2
+ bgr_MS2/D bgr_MPO/D3 bgr_MS2/D bgr_MPO/D3 bgr_MS2/D bgr_MPO/D3 bgr_MS2/D bgr_MPO/D3
+ bgr_MS2/D bgr_Rf/R2 bgr_Rf/R2 bgr_Rf/R2 bgr_Rf/R2 sky130_fd_pr__pfet_g5v0d10v5_TGGT4A
Xbgr_MNB gnd bgr_MNB/D4 bgr_MNB/G5 bgr_R1/R2 bgr_MNB/G5 bgr_MNB/D4 bgr_MNB/G5 bgr_R1/R2
+ bgr_MNB/G5 bgr_MNB/D4 bgr_MNB/G5 bgr_R1/R2 bgr_MNB/G5 bgr_MNB/D4 sky130_fd_pr__nfet_05v0_nvt_ASWYB8
Xldo_Cfp_0 ldo_MPX/S2 vout sky130_fd_pr__cap_mim_m3_1_Y3HN7X
Xldo_MN1 gnd ldo_MP4/G ldo_MN2/S vout sky130_fd_pr__nfet_g5v0d10v5_WMYWGM
Xldo_MP3 vin ldo_MP4/G vin ldo_MP4/G sky130_fd_pr__pfet_g5v0d10v5_DNGK98
Xldo_Cfp_1 ldo_MPX/S2 vout sky130_fd_pr__cap_mim_m3_1_Y3HN7X
Xldo_MN2 gnd ldo_MPS/G ldo_MN2/S ldo_MN2/G sky130_fd_pr__nfet_g5v0d10v5_WMYWGM
Xldo_MPX vin ldo_MPS/G ldo_MPX/S2 ldo_Rsh/R1 ldo_MPS/G ldo_MPX/S2 ldo_Rsh/R1 ldo_MPS/G
+ ldo_MPX/S2 ldo_Rsh/R1 sky130_fd_pr__pfet_g5v0d10v5_PN8J4Z
Xldo_MP4 vin ldo_MPS/G vin ldo_MP4/G sky130_fd_pr__pfet_g5v0d10v5_DNGK98
Xldo_Cfp_2 ldo_MPX/S2 vout sky130_fd_pr__cap_mim_m3_1_Y3HN7X
Xldo_MNX gnd ldo_MPS/G ldo_MN2/G ldo_MNX/S2 ldo_MN2/G ldo_MPS/G ldo_MNX/S2 ldo_MN2/G
+ sky130_fd_pr__nfet_g5v0d10v5_DDWFWJ
Xpor_MI3N gnd rstn gnd por_MH/G sky130_fd_pr__nfet_g5v0d10v5_FZ2B7C
Xldo_Cfn_0 ldo_MNX/S2 vout sky130_fd_pr__cap_mim_m3_1_Y3HN7X
Xldo_Cfp_3 ldo_MPX/S2 vout sky130_fd_pr__cap_mim_m3_1_Y3HN7X
Xldo_Cc vout ldo_MPS/G sky130_fd_pr__cap_mim_m3_1_PP9XRG
Xldo_MN5 gnd ldo_MN2/S gnd ldo_MNB/G ldo_MN2/S gnd ldo_MNB/G ldo_MN2/S gnd ldo_MNB/G
+ ldo_MN2/S gnd ldo_MNB/G sky130_fd_pr__nfet_g5v0d10v5_HA9V6X
Xbgr_MNF gnd vin bgr_MNF/G5 bgr_MS2/D bgr_MNF/G5 vin bgr_MNF/G5 bgr_MS2/D bgr_MNF/G5
+ vin bgr_MNF/G5 bgr_MS2/D bgr_MNF/G5 vin sky130_fd_pr__nfet_05v0_nvt_ASWYB8
Xpor_MI2N gnd por_MH/G gnd por_MI2P/G sky130_fd_pr__nfet_g5v0d10v5_FZ2B7C
Xldo_Cfn_1 ldo_MNX/S2 vout sky130_fd_pr__cap_mim_m3_1_Y3HN7X
Xbgr_MPIC vin ldo_MNB/G bgr_MS2/D ldo_MNB/G bgr_MS2/D ldo_MNB/G bgr_MS2/D ldo_MNB/G
+ bgr_MS2/D bgr_MPI/D0_3 bgr_MS2/D bgr_MPI/D0_3 bgr_MS2/D bgr_MPI/D0_3 bgr_MS2/D bgr_MPI/D0_3
+ bgr_MS2/D ldo_MNB/G bgr_MS2/D ldo_MNB/G bgr_MS2/D ldo_MNB/G bgr_MS2/D ldo_MNB/G
+ bgr_MS2/D bgr_MPI/D0_3 bgr_MS2/D bgr_MPI/D0_3 bgr_MS2/D bgr_MPI/D0_3 bgr_MS2/D bgr_MPI/D0_3
+ bgr_MS2/D ldo_MNB/G bgr_MS2/D ldo_MNB/G bgr_MS2/D ldo_MNB/G bgr_MS2/D ldo_MNB/G
+ bgr_MS2/D bgr_MPI/D0_3 bgr_MS2/D bgr_MPI/D0_3 bgr_MS2/D bgr_MPI/D0_3 bgr_MS2/D bgr_MPI/D0_3
+ bgr_MS2/D ldo_MNB/G bgr_MS2/D ldo_MNB/G bgr_MS2/D ldo_MNB/G bgr_MS2/D ldo_MNB/G
+ bgr_MS2/D bgr_MPI/D0_3 bgr_MS2/D bgr_MPI/D0_3 bgr_MS2/D bgr_MPI/D0_3 bgr_MS2/D bgr_MPI/D0_3
+ bgr_MS2/D ldo_MNB/G ldo_MNB/G ldo_MNB/G ldo_MNB/G sky130_fd_pr__pfet_g5v0d10v5_KMGDV8
Xbgr_MPI vin bgr_MPI/D0_3 bgr_MS2/D bgr_MPI/D0_3 bgr_MS2/D bgr_MPI/D0_3 bgr_MS2/D
+ bgr_MPI/D0_3 bgr_MS2/D vin bgr_MS2/D vin bgr_MS2/D vin bgr_MS2/D vin bgr_MS2/D bgr_MPI/D0_3
+ bgr_MPI/D0_3 bgr_MPI/D0_3 bgr_MPI/D0_3 sky130_fd_pr__pfet_g5v0d10v5_UFWJXT
Xpor_MI1N gnd por_MI2P/G gnd por_MD/D sky130_fd_pr__nfet_g5v0d10v5_F3NX3J
Xpor_MI3P vout rstn vout por_MH/G sky130_fd_pr__pfet_g5v0d10v5_7B62CL
Xldo_Cfn_2 ldo_MNX/S2 vout sky130_fd_pr__cap_mim_m3_1_Y3HN7X
Xpor_MI2P vin por_MH/G vin por_MI2P/G sky130_fd_pr__pfet_g5v0d10v5_7B62CL
Xldo_Cfn_3 ldo_MNX/S2 vout sky130_fd_pr__cap_mim_m3_1_Y3HN7X
Xbgr_MNSK gnd bgr_MS2/D bgr_MNSK/S1 bgr_MNB/G5 bgr_MS2/D bgr_MNSK/S1 bgr_MNB/G5 sky130_fd_pr__nfet_05v0_nvt_6T4HWX
Xbgr_MSN gnd bgr_MSN/D bgr_MSN/S bgr_Rf/R2 sky130_fd_pr__nfet_g5v0d10v5_NUFNY9
Xpor_MI1P vin por_MI2P/G vin por_MD/D sky130_fd_pr__pfet_g5v0d10v5_5EJAKB
.ends
