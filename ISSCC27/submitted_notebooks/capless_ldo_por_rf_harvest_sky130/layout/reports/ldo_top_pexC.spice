* NGSPICE file created from ldo_top.ext - technology: sky130A

.subckt sky130_fd_pr__pfet_g5v0d10v5_UFECYT B D0 S0 G0 D1 S1 G1 D2 S2 G2 D3 S3 G3
+ VSUBS
X0 S2 G2 D2 B sky130_fd_pr__pfet_g5v0d10v5 ad=5.8 pd=40.58 as=5.8 ps=40.58 w=20 l=16
X1 S0 G0 D0 B sky130_fd_pr__pfet_g5v0d10v5 ad=5.8 pd=40.58 as=5.8 ps=40.58 w=20 l=16
X2 S3 G3 D3 B sky130_fd_pr__pfet_g5v0d10v5 ad=5.8 pd=40.58 as=5.8 ps=40.58 w=20 l=16
X3 S1 G1 D1 B sky130_fd_pr__pfet_g5v0d10v5 ad=5.8 pd=40.58 as=5.8 ps=40.58 w=20 l=16
C0 G2 D2 0.843488f
C1 S0 S1 0.014232f
C2 D3 D2 0.014232f
C3 S0 B 1.14186f
C4 S0 G0 0.843488f
C5 S1 S2 0.014232f
C6 D1 G1 0.843488f
C7 G2 G3 1.79553f
C8 S3 G3 0.843488f
C9 G2 B 1.63817f
C10 S3 B 1.14084f
C11 D3 G3 0.843488f
C12 D3 B 1.14084f
C13 B S2 1.13466f
C14 S1 G1 0.843488f
C15 D1 D2 0.014232f
C16 B G1 1.63817f
C17 G0 G1 1.79553f
C18 B D2 1.13466f
C19 B D1 1.13466f
C20 B S1 1.13466f
C21 D0 D1 0.014232f
C22 B G3 2.90949f
C23 B G0 2.08018f
C24 G2 S2 0.843488f
C25 S3 S2 0.014232f
C26 G2 G1 1.79553f
C27 D0 B 1.14186f
C28 D0 G0 0.843488f
C29 S0 VSUBS 1.63025f
C30 D0 VSUBS 1.63025f
C31 G0 VSUBS 3.53008f
C32 S1 VSUBS 1.62405f
C33 D1 VSUBS 1.62405f
C34 G1 VSUBS 3.28219f
C35 S2 VSUBS 1.62405f
C36 D2 VSUBS 1.62405f
C37 G2 VSUBS 3.28219f
C38 S3 VSUBS 1.6295f
C39 D3 VSUBS 1.6295f
C40 G3 VSUBS 3.33883f
C41 B VSUBS 0.200533p
.ends

.subckt sky130_fd_pr__nfet_g5v0d10v5_3LMSA7 B D S G
X0 S G D B sky130_fd_pr__nfet_g5v0d10v5 ad=1.45 pd=10.58 as=1.45 ps=10.58 w=5 l=0.5
C0 D G 0.06583f
C1 S G 0.06583f
C2 D S 0.446027f
C3 S B 0.524972f
C4 D B 0.524972f
C5 G B 0.301693f
.ends

.subckt sky130_fd_pr__pfet_g5v0d10v5_TGGT4A B D0_0 G0_0 D0_1 G0_1 D0_2 G0_2 D0_3 G0_3
+ S1_0 G1_0 S1_1 G1_1 S1_2 G1_2 S1_3 G1_3 D2_0 G2_0 D2_1 G2_1 D2_2 G2_2 D2_3 G2_3
+ S3_0 G3_0 S3_1 G3_1 S3_2 G3_2 S3_3 G3_3 a_887_n4118# a_887_n8283# a_887_47# a_887_4212#
+ VSUBS
X0 S3_2 G2_2 D2_2 B sky130_fd_pr__pfet_g5v0d10v5 ad=2.9 pd=20.29 as=2.9 ps=20.29 w=20 l=2
X1 a_887_4212# G3_3 S3_3 B sky130_fd_pr__pfet_g5v0d10v5 ad=5.8 pd=40.58 as=2.9 ps=20.29 w=20 l=2
X2 S1_3 G0_3 D0_3 B sky130_fd_pr__pfet_g5v0d10v5 ad=2.9 pd=20.29 as=5.8 ps=40.58 w=20 l=2
X3 S3_1 G2_1 D2_1 B sky130_fd_pr__pfet_g5v0d10v5 ad=2.9 pd=20.29 as=2.9 ps=20.29 w=20 l=2
X4 S1_0 G0_0 D0_0 B sky130_fd_pr__pfet_g5v0d10v5 ad=2.9 pd=20.29 as=5.8 ps=40.58 w=20 l=2
X5 D2_2 G1_2 S1_2 B sky130_fd_pr__pfet_g5v0d10v5 ad=2.9 pd=20.29 as=2.9 ps=20.29 w=20 l=2
X6 a_887_n8283# G3_0 S3_0 B sky130_fd_pr__pfet_g5v0d10v5 ad=5.8 pd=40.58 as=2.9 ps=20.29 w=20 l=2
X7 S1_2 G0_2 D0_2 B sky130_fd_pr__pfet_g5v0d10v5 ad=2.9 pd=20.29 as=5.8 ps=40.58 w=20 l=2
X8 D2_3 G1_3 S1_3 B sky130_fd_pr__pfet_g5v0d10v5 ad=2.9 pd=20.29 as=2.9 ps=20.29 w=20 l=2
X9 D2_0 G1_0 S1_0 B sky130_fd_pr__pfet_g5v0d10v5 ad=2.9 pd=20.29 as=2.9 ps=20.29 w=20 l=2
X10 S1_1 G0_1 D0_1 B sky130_fd_pr__pfet_g5v0d10v5 ad=2.9 pd=20.29 as=5.8 ps=40.58 w=20 l=2
X11 a_887_n4118# G3_1 S3_1 B sky130_fd_pr__pfet_g5v0d10v5 ad=5.8 pd=40.58 as=2.9 ps=20.29 w=20 l=2
X12 D2_1 G1_1 S1_1 B sky130_fd_pr__pfet_g5v0d10v5 ad=2.9 pd=20.29 as=2.9 ps=20.29 w=20 l=2
X13 a_887_47# G3_2 S3_2 B sky130_fd_pr__pfet_g5v0d10v5 ad=5.8 pd=40.58 as=2.9 ps=20.29 w=20 l=2
X14 S3_0 G2_0 D2_0 B sky130_fd_pr__pfet_g5v0d10v5 ad=2.9 pd=20.29 as=2.9 ps=20.29 w=20 l=2
X15 S3_3 G2_3 D2_3 B sky130_fd_pr__pfet_g5v0d10v5 ad=2.9 pd=20.29 as=2.9 ps=20.29 w=20 l=2
C0 G2_2 B 0.223127f
C1 G1_1 G1_2 0.227831f
C2 S3_2 B 0.009616f
C3 B D2_1 0.009616f
C4 G2_0 D2_0 0.625982f
C5 G1_1 S1_1 0.625982f
C6 B G2_3 0.382207f
C7 G3_1 S3_1 0.625982f
C8 G1_1 G1_0 0.227831f
C9 S3_3 G3_3 0.625982f
C10 G0_1 B 0.247781f
C11 S1_3 D0_3 0.614813f
C12 G3_1 a_887_n4118# 0.625982f
C13 S1_3 D2_3 0.614813f
C14 G2_0 S3_0 0.625982f
C15 G1_1 D2_1 0.625982f
C16 S1_3 S1_2 0.014232f
C17 D0_2 D0_3 0.014232f
C18 G3_2 a_887_47# 0.625982f
C19 G1_0 G2_0 0.061903f
C20 D0_2 S1_2 0.614813f
C21 S1_3 G1_3 0.625982f
C22 G1_1 B 0.223127f
C23 G2_1 G2_2 0.227831f
C24 G0_2 D0_2 0.625982f
C25 S3_3 a_887_4212# 0.614813f
C26 a_887_47# a_887_4212# 0.014232f
C27 G1_1 G0_1 0.061903f
C28 D0_0 D0_1 0.014232f
C29 G2_1 D2_1 0.625982f
C30 D0_2 D0_1 0.014232f
C31 D0_0 S1_0 0.614813f
C32 D2_3 G1_3 0.625982f
C33 B G2_0 0.278378f
C34 G2_1 B 0.223127f
C35 B G0_3 0.40686f
C36 G0_2 S1_2 0.625982f
C37 D2_3 S3_3 0.614813f
C38 G3_0 a_887_n8283# 0.625982f
C39 G3_0 S3_0 0.625982f
C40 G0_0 D0_0 0.625982f
C41 G3_1 B 0.247781f
C42 G1_1 G2_1 0.061903f
C43 D2_2 D2_3 0.014232f
C44 D2_2 S1_2 0.614813f
C45 G2_2 G3_2 0.061903f
C46 G2_3 G3_3 0.061903f
C47 S3_2 G3_2 0.625982f
C48 B G3_3 0.40686f
C49 G2_1 G2_0 0.227831f
C50 B G3_0 0.303032f
C51 B G3_2 0.247781f
C52 G1_2 S1_2 0.625982f
C53 a_887_47# a_887_n4118# 0.014232f
C54 G1_2 G1_3 0.227831f
C55 S1_0 D2_0 0.614813f
C56 S1_2 S1_1 0.014232f
C57 G0_2 G1_2 0.061903f
C58 B a_887_4212# 1.14085f
C59 S3_1 a_887_n4118# 0.614813f
C60 G0_0 S1_0 0.625982f
C61 B S1_3 0.015791f
C62 G2_1 G3_1 0.061903f
C63 B D0_0 1.14187f
C64 B D0_2 1.13467f
C65 D0_1 S1_1 0.614813f
C66 S1_0 S1_1 0.014232f
C67 G2_3 D2_3 0.625982f
C68 S3_1 S3_0 0.014232f
C69 G1_0 S1_0 0.625982f
C70 D2_2 G1_2 0.625982f
C71 B D0_3 1.14085f
C72 B D2_3 0.015791f
C73 G2_3 G1_3 0.061903f
C74 B S1_2 0.009616f
C75 G2_0 G3_0 0.061903f
C76 S3_2 S3_3 0.014232f
C77 S3_2 a_887_47# 0.614813f
C78 B G1_3 0.382207f
C79 a_887_n4118# a_887_n8283# 0.014232f
C80 D2_0 S3_0 0.614813f
C81 G0_2 B 0.247781f
C82 G2_3 S3_3 0.625982f
C83 S3_2 S3_1 0.014232f
C84 S3_1 D2_1 0.614813f
C85 G1_0 D2_0 0.625982f
C86 B D0_1 1.13467f
C87 D2_2 G2_2 0.625982f
C88 G0_1 G0_2 0.227831f
C89 B S3_3 0.015791f
C90 B a_887_47# 1.13467f
C91 B S1_0 0.016816f
C92 D2_2 S3_2 0.614813f
C93 G0_1 D0_1 0.625982f
C94 D2_2 D2_1 0.014232f
C95 G0_3 S1_3 0.625982f
C96 G3_1 G3_0 0.227831f
C97 G0_0 G1_0 0.061903f
C98 G3_1 G3_2 0.227831f
C99 B S3_1 0.009616f
C100 S3_0 a_887_n8283# 0.614813f
C101 D2_0 D2_1 0.014232f
C102 D2_2 B 0.009616f
C103 G1_2 G2_2 0.061903f
C104 B a_887_n4118# 1.13467f
C105 B D2_0 0.016816f
C106 G3_2 G3_3 0.227831f
C107 G0_3 D0_3 0.625982f
C108 B G0_0 0.303032f
C109 S1_1 D2_1 0.614813f
C110 G0_3 G1_3 0.061903f
C111 G3_3 a_887_4212# 0.625982f
C112 G0_1 G0_0 0.227831f
C113 G1_2 B 0.223127f
C114 G0_2 G0_3 0.227831f
C115 B a_887_n8283# 1.14187f
C116 B S1_1 0.009616f
C117 B S3_0 0.016816f
C118 S3_2 G2_2 0.625982f
C119 G0_1 S1_1 0.625982f
C120 G2_2 G2_3 0.227831f
C121 B G1_0 0.278378f
C122 G2_1 S3_1 0.625982f
C123 S3_0 VSUBS 0.863504f
C124 D2_0 VSUBS 0.863504f
C125 S1_0 VSUBS 0.863504f
C126 D0_0 VSUBS 1.12621f
C127 G3_0 VSUBS 0.440605f
C128 G2_0 VSUBS 0.427224f
C129 G1_0 VSUBS 0.427224f
C130 G0_0 VSUBS 0.440605f
C131 S3_1 VSUBS 0.857307f
C132 D2_1 VSUBS 0.857307f
C133 S1_1 VSUBS 0.857307f
C134 D0_1 VSUBS 1.12001f
C135 G3_1 VSUBS 0.409619f
C136 G2_1 VSUBS 0.396239f
C137 G1_1 VSUBS 0.396239f
C138 G0_1 VSUBS 0.409619f
C139 S3_2 VSUBS 0.857307f
C140 D2_2 VSUBS 0.857307f
C141 S1_2 VSUBS 0.857307f
C142 D0_2 VSUBS 1.12001f
C143 G3_2 VSUBS 0.409619f
C144 G2_2 VSUBS 0.396239f
C145 G1_2 VSUBS 0.396239f
C146 G0_2 VSUBS 0.409619f
C147 S3_3 VSUBS 0.862757f
C148 D2_3 VSUBS 0.862757f
C149 S1_3 VSUBS 0.862757f
C150 D0_3 VSUBS 1.12546f
C151 G3_3 VSUBS 0.420067f
C152 G2_3 VSUBS 0.406686f
C153 G1_3 VSUBS 0.406686f
C154 G0_3 VSUBS 0.420067f
C155 B VSUBS 0.12679p
C156 a_887_n8283# VSUBS 1.12621f
C157 a_887_n4118# VSUBS 1.12001f
C158 a_887_47# VSUBS 1.12001f
C159 a_887_4212# VSUBS 1.12546f
.ends

.subckt sky130_fd_pr__nfet_g5v0d10v5_C8EBTW B D S G
X0 S G D B sky130_fd_pr__nfet_g5v0d10v5 ad=0.203 pd=1.98 as=0.203 ps=1.98 w=0.7 l=20
C0 G D 0.036799f
C1 G S 0.036799f
C2 S B 0.128043f
C3 D B 0.128043f
C4 G B 8.82479f
.ends

.subckt sky130_fd_pr__nfet_g5v0d10v5_62W55W B D S G
X0 S G D B sky130_fd_pr__nfet_g5v0d10v5 ad=0.29 pd=2.58 as=0.29 ps=2.58 w=1 l=1
C0 G D 0.026809f
C1 G S 0.026809f
C2 D S 0.055609f
C3 S B 0.138407f
C4 D B 0.138407f
C5 G B 0.526365f
.ends

.subckt sky130_fd_pr__cap_mim_m3_1_BTY6QK C2 C1 VSUBS
X0 C1 C2 sky130_fd_pr__cap_mim_m3_1 l=25 w=25
C0 C2 C1 55.2292f
C1 C1 VSUBS 2.59358f
C2 C2 VSUBS 13.8127f
.ends

.subckt sky130_fd_pr__cap_mim_m3_1_V8HUNN C2 C1 VSUBS
X0 C1 C2 sky130_fd_pr__cap_mim_m3_1 l=16 w=16
C0 C2 C1 23.226198f
C1 C1 VSUBS 1.64509f
C2 C2 VSUBS 7.15816f
.ends

.subckt sky130_fd_pr__nfet_g5v0d10v5_NUFNY9 B D S G
X0 S G D B sky130_fd_pr__nfet_g5v0d10v5 ad=0.29 pd=2.58 as=0.29 ps=2.58 w=1 l=4
C0 G D 0.04509f
C1 G S 0.04509f
C2 D S 0.016591f
C3 S B 0.152182f
C4 D B 0.152182f
C5 G B 1.8263f
.ends

.subckt sky130_fd_pr__nfet_05v0_nvt_F4CC77 B D S G
X0 S G D B sky130_fd_pr__nfet_05v0_nvt ad=0.29 pd=2.58 as=0.29 ps=2.58 w=1 l=25
C0 G D 0.049339f
C1 G S 0.049339f
C2 S B 0.169637f
C3 D B 0.169637f
C4 G B 10.926f
.ends

.subckt sky130_fd_pr__nfet_05v0_nvt_ASWYB8 B D0 G0 S1 G1 D2 G2 S3 G3 D4 G4 S5 G5 a_15145_n131#
X0 S3 G2 D2 B sky130_fd_pr__nfet_05v0_nvt ad=0.145 pd=1.29 as=0.145 ps=1.29 w=1 l=25
X1 S1 G0 D0 B sky130_fd_pr__nfet_05v0_nvt ad=0.145 pd=1.29 as=0.29 ps=2.58 w=1 l=25
X2 D2 G1 S1 B sky130_fd_pr__nfet_05v0_nvt ad=0.145 pd=1.29 as=0.145 ps=1.29 w=1 l=25
X3 D4 G3 S3 B sky130_fd_pr__nfet_05v0_nvt ad=0.145 pd=1.29 as=0.145 ps=1.29 w=1 l=25
X4 a_15145_n131# G5 S5 B sky130_fd_pr__nfet_05v0_nvt ad=0.29 pd=2.58 as=0.145 ps=1.29 w=1 l=25
X5 S5 G4 D4 B sky130_fd_pr__nfet_05v0_nvt ad=0.145 pd=1.29 as=0.145 ps=1.29 w=1 l=25
C0 G1 D2 0.049339f
C1 G0 S1 0.049339f
C2 G1 S1 0.049339f
C3 G5 S5 0.049339f
C4 G2 D2 0.049339f
C5 G1 G2 0.05942f
C6 G2 S3 0.049339f
C7 G0 D0 0.049339f
C8 G4 S5 0.049339f
C9 G3 S3 0.049339f
C10 G2 G3 0.05942f
C11 G5 G4 0.05942f
C12 G5 a_15145_n131# 0.049339f
C13 D4 G3 0.049339f
C14 G3 G4 0.05942f
C15 D4 G4 0.049339f
C16 G0 G1 0.05942f
C17 S5 B 0.119853f
C18 D4 B 0.119853f
C19 S3 B 0.119853f
C20 D2 B 0.119853f
C21 S1 B 0.119853f
C22 D0 B 0.169637f
C23 G5 B 10.8897f
C24 G4 B 10.853401f
C25 G3 B 10.853401f
C26 G2 B 10.853401f
C27 G1 B 10.853401f
C28 G0 B 10.8897f
C29 a_15145_n131# B 0.169637f
.ends

.subckt sky130_fd_pr__nfet_g5v0d10v5_BE4NYT B D S G
X0 S G D B sky130_fd_pr__nfet_g5v0d10v5 ad=0.58 pd=4.58 as=0.58 ps=4.58 w=2 l=4
C0 D S 0.032918f
C1 D G 0.082975f
C2 S G 0.082975f
C3 S B 0.271253f
C4 D B 0.271253f
C5 G B 1.80067f
.ends

.subckt sky130_fd_pr__res_xhigh_po_0p35_5J6MKL B R1 R2
X0 R2 R1 B sky130_fd_pr__res_xhigh_po_0p35 l=94.73
C0 R1 R2 0.296258f
C1 R2 B 0.387223f
C2 R1 B 0.387223f
.ends

.subckt sky130_fd_pr__nfet_g5v0d10v5_A8HTHF B D S G
X0 S G D B sky130_fd_pr__nfet_g5v0d10v5 ad=0.29 pd=2.58 as=0.29 ps=2.58 w=1 l=0.5
C0 D S 0.090631f
C1 D G 0.016273f
C2 S G 0.016273f
C3 S B 0.133548f
C4 D B 0.133548f
C5 G B 0.309709f
.ends

.subckt sky130_fd_pr__nfet_g5v0d10v5_YQMGE2 B D0 G0 S1 G1 D2 G2 S3 G3 D4 G4 S5 G5
+ D6 G6 S7 G7 D8 G8 S9 G9 D10 G10 S11 G11 D12 G12 S13 G13 D14 G14 S15 G15 D16 G16
+ S17 G17 D18 G18 S19 G19 a_8551_n231#
X0 S7 G6 D6 B sky130_fd_pr__nfet_g5v0d10v5 ad=0.29 pd=2.29 as=0.29 ps=2.29 w=2 l=4
X1 D12 G11 S11 B sky130_fd_pr__nfet_g5v0d10v5 ad=0.29 pd=2.29 as=0.29 ps=2.29 w=2 l=4
X2 D18 G17 S17 B sky130_fd_pr__nfet_g5v0d10v5 ad=0.29 pd=2.29 as=0.29 ps=2.29 w=2 l=4
X3 D16 G15 S15 B sky130_fd_pr__nfet_g5v0d10v5 ad=0.29 pd=2.29 as=0.29 ps=2.29 w=2 l=4
X4 D6 G5 S5 B sky130_fd_pr__nfet_g5v0d10v5 ad=0.29 pd=2.29 as=0.29 ps=2.29 w=2 l=4
X5 D8 G7 S7 B sky130_fd_pr__nfet_g5v0d10v5 ad=0.29 pd=2.29 as=0.29 ps=2.29 w=2 l=4
X6 S17 G16 D16 B sky130_fd_pr__nfet_g5v0d10v5 ad=0.29 pd=2.29 as=0.29 ps=2.29 w=2 l=4
X7 S9 G8 D8 B sky130_fd_pr__nfet_g5v0d10v5 ad=0.29 pd=2.29 as=0.29 ps=2.29 w=2 l=4
X8 S1 G0 D0 B sky130_fd_pr__nfet_g5v0d10v5 ad=0.29 pd=2.29 as=0.58 ps=4.58 w=2 l=4
X9 S3 G2 D2 B sky130_fd_pr__nfet_g5v0d10v5 ad=0.29 pd=2.29 as=0.29 ps=2.29 w=2 l=4
X10 D14 G13 S13 B sky130_fd_pr__nfet_g5v0d10v5 ad=0.29 pd=2.29 as=0.29 ps=2.29 w=2 l=4
X11 D2 G1 S1 B sky130_fd_pr__nfet_g5v0d10v5 ad=0.29 pd=2.29 as=0.29 ps=2.29 w=2 l=4
X12 D10 G9 S9 B sky130_fd_pr__nfet_g5v0d10v5 ad=0.29 pd=2.29 as=0.29 ps=2.29 w=2 l=4
X13 D4 G3 S3 B sky130_fd_pr__nfet_g5v0d10v5 ad=0.29 pd=2.29 as=0.29 ps=2.29 w=2 l=4
X14 S15 G14 D14 B sky130_fd_pr__nfet_g5v0d10v5 ad=0.29 pd=2.29 as=0.29 ps=2.29 w=2 l=4
X15 S13 G12 D12 B sky130_fd_pr__nfet_g5v0d10v5 ad=0.29 pd=2.29 as=0.29 ps=2.29 w=2 l=4
X16 a_8551_n231# G19 S19 B sky130_fd_pr__nfet_g5v0d10v5 ad=0.58 pd=4.58 as=0.29 ps=2.29 w=2 l=4
X17 S5 G4 D4 B sky130_fd_pr__nfet_g5v0d10v5 ad=0.29 pd=2.29 as=0.29 ps=2.29 w=2 l=4
X18 S19 G18 D18 B sky130_fd_pr__nfet_g5v0d10v5 ad=0.29 pd=2.29 as=0.29 ps=2.29 w=2 l=4
X19 S11 G10 D10 B sky130_fd_pr__nfet_g5v0d10v5 ad=0.29 pd=2.29 as=0.29 ps=2.29 w=2 l=4
C0 S5 G5 0.082975f
C1 G10 G9 0.05942f
C2 G17 G16 0.05942f
C3 G17 D18 0.082975f
C4 G14 S15 0.082975f
C5 D4 S5 0.032918f
C6 S13 G12 0.082975f
C7 D16 G16 0.082975f
C8 G11 S11 0.082975f
C9 D12 S13 0.032918f
C10 D6 S5 0.032918f
C11 D8 S9 0.032918f
C12 S1 G0 0.082975f
C13 G7 D8 0.082975f
C14 G0 G1 0.05942f
C15 G19 G18 0.05942f
C16 G11 G12 0.05942f
C17 G8 D8 0.082975f
C18 G11 D12 0.082975f
C19 D4 G3 0.082975f
C20 G11 G10 0.05942f
C21 G9 S9 0.082975f
C22 D0 G0 0.082975f
C23 S1 G1 0.082975f
C24 S15 D16 0.032918f
C25 G8 G9 0.05942f
C26 S1 D0 0.032918f
C27 S3 G3 0.082975f
C28 G2 G3 0.05942f
C29 D14 G13 0.082975f
C30 S19 a_8551_n231# 0.032918f
C31 G8 S9 0.082975f
C32 S7 D8 0.032918f
C33 G4 S5 0.082975f
C34 G12 G13 0.05942f
C35 G8 G7 0.05942f
C36 G14 G13 0.05942f
C37 G2 G1 0.05942f
C38 D6 G5 0.082975f
C39 G18 D18 0.082975f
C40 G19 S19 0.082975f
C41 S13 G13 0.082975f
C42 G4 G3 0.05942f
C43 D2 S1 0.032918f
C44 S3 D4 0.032918f
C45 D2 G1 0.082975f
C46 G18 S19 0.082975f
C47 D10 S11 0.032918f
C48 G6 G5 0.05942f
C49 G6 G7 0.05942f
C50 D6 G6 0.082975f
C51 S3 G2 0.082975f
C52 G15 G16 0.05942f
C53 G18 G17 0.05942f
C54 D10 G9 0.082975f
C55 S17 G16 0.082975f
C56 S17 D18 0.032918f
C57 D10 G10 0.082975f
C58 S7 G7 0.082975f
C59 G14 G15 0.05942f
C60 D6 S7 0.032918f
C61 G14 D14 0.082975f
C62 G4 G5 0.05942f
C63 S3 D2 0.032918f
C64 G2 D2 0.082975f
C65 S15 G15 0.082975f
C66 G4 D4 0.082975f
C67 S11 D12 0.032918f
C68 G19 a_8551_n231# 0.082975f
C69 D18 S19 0.032918f
C70 S11 G10 0.082975f
C71 D10 S9 0.032918f
C72 D14 S15 0.032918f
C73 G17 S17 0.082975f
C74 D14 S13 0.032918f
C75 D12 G12 0.082975f
C76 S7 G6 0.082975f
C77 D16 G15 0.082975f
C78 S17 D16 0.032918f
C79 S19 B 0.144855f
C80 D18 B 0.144855f
C81 S17 B 0.144855f
C82 D16 B 0.144855f
C83 S15 B 0.144855f
C84 D14 B 0.144855f
C85 S13 B 0.144855f
C86 D12 B 0.144855f
C87 S11 B 0.144855f
C88 D10 B 0.144855f
C89 S9 B 0.144855f
C90 D8 B 0.144855f
C91 S7 B 0.144855f
C92 D6 B 0.144855f
C93 S5 B 0.144855f
C94 D4 B 0.144855f
C95 S3 B 0.144855f
C96 D2 B 0.144855f
C97 S1 B 0.144855f
C98 D0 B 0.271253f
C99 G19 B 1.76447f
C100 G18 B 1.72826f
C101 G17 B 1.72826f
C102 G16 B 1.72826f
C103 G15 B 1.72826f
C104 G14 B 1.72826f
C105 G13 B 1.72826f
C106 G12 B 1.72826f
C107 G11 B 1.72826f
C108 G10 B 1.72826f
C109 G9 B 1.72826f
C110 G8 B 1.72826f
C111 G7 B 1.72826f
C112 G6 B 1.72826f
C113 G5 B 1.72826f
C114 G4 B 1.72826f
C115 G3 B 1.72826f
C116 G2 B 1.72826f
C117 G1 B 1.72826f
C118 G0 B 1.76447f
C119 a_8551_n231# B 0.271253f
.ends

.subckt sky130_fd_pr__res_xhigh_po_0p35_PL9RNS B R1 R2
X0 R2 R1 B sky130_fd_pr__res_xhigh_po_0p35 l=991.66
C0 R1 B 0.595753f
C1 R2 B 0.595753f
.ends

.subckt sky130_fd_pr__rf_pnp_05v5_W3p40L3p40 Emitter Collector Base m=1
X0 Collector Base Emitter sky130_fd_pr__pnp_05v5_W3p40L3p40
**devattr s=462400,2720
C0 Base Emitter 0.896583f
C1 Base Collector 1.10722f
.ends

.subckt sky130_fd_pr__res_xhigh_po_0p35_R4U9XH B R1 R2
X0 R1 R2 B sky130_fd_pr__res_xhigh_po_0p35 l=3.74
C0 R1 R2 0.00525f
C1 R2 B 0.591075f
C2 R1 B 0.591075f
.ends

.subckt sky130_fd_pr__res_xhigh_po_0p35_XV4KRP B R1 R2
X0 R1 R2 B sky130_fd_pr__res_xhigh_po_0p35 l=7.4
C0 R1 R2 0.002672f
C1 R2 B 0.594177f
C2 R1 B 0.594177f
.ends

.subckt sky130_fd_pr__cap_mim_m3_1_84Z4WG C2 C1 VSUBS
X0 C1 C2 sky130_fd_pr__cap_mim_m3_1 l=22 w=22
C0 C2 C1 43.049f
C1 C1 VSUBS 2.27742f
C2 C2 VSUBS 11.371901f
.ends

.subckt sky130_fd_pr__res_xhigh_po_0p35_4E3LTY B R1 R2
X0 R1 R2 B sky130_fd_pr__res_xhigh_po_0p35 l=14.76
C0 R2 B 0.597536f
C1 R1 B 0.597536f
.ends

.subckt sky130_fd_pr__pfet_g5v0d10v5_32MMT9 B D S G VSUBS
X0 S G D B sky130_fd_pr__pfet_g5v0d10v5 ad=0.1218 pd=1.42 as=0.1218 ps=1.42 w=0.42 l=50
C0 B D 0.049475f
C1 G D 0.025096f
C2 S B 0.049475f
C3 S G 0.025096f
C4 B G 11.7075f
C5 S VSUBS 0.04086f
C6 D VSUBS 0.04086f
C7 G VSUBS 10.6399f
C8 B VSUBS 25.0718f
.ends

.subckt sky130_fd_pr__pfet_g5v0d10v5_MN82PF B D S G VSUBS
X0 S G D B sky130_fd_pr__pfet_g5v0d10v5 ad=1.16 pd=8.58 as=1.16 ps=8.58 w=4 l=4
C0 B D 0.250339f
C1 G D 0.158746f
C2 S B 0.250339f
C3 S G 0.158746f
C4 B G 0.922222f
C5 S D 0.065571f
C6 S VSUBS 0.263093f
C7 D VSUBS 0.263093f
C8 G VSUBS 0.882827f
C9 B VSUBS 6.46382f
.ends

.subckt sky130_fd_pr__res_xhigh_po_0p35_VEZ8JB B R1 R2
X0 R1 R2 B sky130_fd_pr__res_xhigh_po_0p35 l=29.46
C0 R2 B 0.597536f
C1 R1 B 0.597536f
.ends

.subckt sky130_fd_pr__res_xhigh_po_0p35_HGUK4G B R1 R2
X0 R1 R2 B sky130_fd_pr__res_xhigh_po_0p35 l=58.86
C0 R2 B 0.597536f
C1 R1 B 0.597536f
.ends

.subckt sky130_fd_pr__res_xhigh_po_0p35_YNY9WN B R1 R2
X0 R2 R1 B sky130_fd_pr__res_xhigh_po_0p35 l=278.22
C0 R1 B 0.577911f
C1 R2 B 0.577911f
.ends

.subckt sky130_fd_pr__res_xhigh_po_0p35_8Z5M7R B R1 R2
X0 R2 R1 B sky130_fd_pr__res_xhigh_po_0p35 l=467.55
C0 R1 R2 0.035726f
C1 R2 B 0.550181f
C2 R1 B 0.550181f
.ends

.subckt sky130_fd_pr__res_xhigh_po_0p35_KAXJA5 B R1 R2
X0 R2 R1 B sky130_fd_pr__res_xhigh_po_0p35 l=187.59
C0 R1 R2 0.086197f
C1 R2 B 0.493283f
C2 R1 B 0.493283f
.ends

.subckt sky130_fd_pr__res_xhigh_po_0p35_NT9K52 B R1 R2
X0 R2 R1 B sky130_fd_pr__res_xhigh_po_0p35 l=583.97
C0 R1 R2 0.02764f
C1 R2 B 0.560383f
C2 R1 B 0.560383f
.ends

.subckt sky130_fd_pr__res_xhigh_po_0p35_J82YCH B R1 R2
X0 R2 R1 B sky130_fd_pr__res_xhigh_po_0p35 l=205.27
C0 R1 R2 0.086197f
C1 R2 B 0.493283f
C2 R1 B 0.493283f
.ends

.subckt sky130_fd_pr__pfet_g5v0d10v5_PSYF8E B D0 G0 S1 G1 D2 G2 S3 G3 D4 G4 S5 G5
+ D6 G6 S7 G7 D8 G8 S9 G9 D10 G10 S11 G11 D12 G12 S13 G13 D14 G14 S15 G15 D16 G16
+ S17 G17 D18 G18 S19 G19 D20 G20 S21 G21 D22 G22 S23 G23 D24 G24 S25 G25 D26 G26
+ S27 G27 D28 G28 S29 G29 D30 G30 S31 G31 D32 G32 S33 G33 D34 G34 S35 G35 D36 G36
+ S37 G37 D38 G38 S39 G39 a_3131_n1036# VSUBS
X0 S17 G16 D16 B sky130_fd_pr__pfet_g5v0d10v5 ad=1.45 pd=10.29 as=1.45 ps=10.29 w=10 l=0.5
X1 S3 G2 D2 B sky130_fd_pr__pfet_g5v0d10v5 ad=1.45 pd=10.29 as=1.45 ps=10.29 w=10 l=0.5
X2 D22 G21 S21 B sky130_fd_pr__pfet_g5v0d10v5 ad=1.45 pd=10.29 as=1.45 ps=10.29 w=10 l=0.5
X3 D2 G1 S1 B sky130_fd_pr__pfet_g5v0d10v5 ad=1.45 pd=10.29 as=1.45 ps=10.29 w=10 l=0.5
X4 D16 G15 S15 B sky130_fd_pr__pfet_g5v0d10v5 ad=1.45 pd=10.29 as=1.45 ps=10.29 w=10 l=0.5
X5 S13 G12 D12 B sky130_fd_pr__pfet_g5v0d10v5 ad=1.45 pd=10.29 as=1.45 ps=10.29 w=10 l=0.5
X6 D12 G11 S11 B sky130_fd_pr__pfet_g5v0d10v5 ad=1.45 pd=10.29 as=1.45 ps=10.29 w=10 l=0.5
X7 D10 G9 S9 B sky130_fd_pr__pfet_g5v0d10v5 ad=1.45 pd=10.29 as=1.45 ps=10.29 w=10 l=0.5
X8 D20 G19 S19 B sky130_fd_pr__pfet_g5v0d10v5 ad=1.45 pd=10.29 as=1.45 ps=10.29 w=10 l=0.5
X9 D30 G29 S29 B sky130_fd_pr__pfet_g5v0d10v5 ad=1.45 pd=10.29 as=1.45 ps=10.29 w=10 l=0.5
X10 D34 G33 S33 B sky130_fd_pr__pfet_g5v0d10v5 ad=1.45 pd=10.29 as=1.45 ps=10.29 w=10 l=0.5
X11 S9 G8 D8 B sky130_fd_pr__pfet_g5v0d10v5 ad=1.45 pd=10.29 as=1.45 ps=10.29 w=10 l=0.5
X12 S19 G18 D18 B sky130_fd_pr__pfet_g5v0d10v5 ad=1.45 pd=10.29 as=1.45 ps=10.29 w=10 l=0.5
X13 S5 G4 D4 B sky130_fd_pr__pfet_g5v0d10v5 ad=1.45 pd=10.29 as=1.45 ps=10.29 w=10 l=0.5
X14 S33 G32 D32 B sky130_fd_pr__pfet_g5v0d10v5 ad=1.45 pd=10.29 as=1.45 ps=10.29 w=10 l=0.5
X15 S37 G36 D36 B sky130_fd_pr__pfet_g5v0d10v5 ad=1.45 pd=10.29 as=1.45 ps=10.29 w=10 l=0.5
X16 S1 G0 D0 B sky130_fd_pr__pfet_g5v0d10v5 ad=1.45 pd=10.29 as=2.9 ps=20.58 w=10 l=0.5
X17 S21 G20 D20 B sky130_fd_pr__pfet_g5v0d10v5 ad=1.45 pd=10.29 as=1.45 ps=10.29 w=10 l=0.5
X18 S23 G22 D22 B sky130_fd_pr__pfet_g5v0d10v5 ad=1.45 pd=10.29 as=1.45 ps=10.29 w=10 l=0.5
X19 D8 G7 S7 B sky130_fd_pr__pfet_g5v0d10v5 ad=1.45 pd=10.29 as=1.45 ps=10.29 w=10 l=0.5
X20 D26 G25 S25 B sky130_fd_pr__pfet_g5v0d10v5 ad=1.45 pd=10.29 as=1.45 ps=10.29 w=10 l=0.5
X21 S11 G10 D10 B sky130_fd_pr__pfet_g5v0d10v5 ad=1.45 pd=10.29 as=1.45 ps=10.29 w=10 l=0.5
X22 S27 G26 D26 B sky130_fd_pr__pfet_g5v0d10v5 ad=1.45 pd=10.29 as=1.45 ps=10.29 w=10 l=0.5
X23 S7 G6 D6 B sky130_fd_pr__pfet_g5v0d10v5 ad=1.45 pd=10.29 as=1.45 ps=10.29 w=10 l=0.5
X24 S35 G34 D34 B sky130_fd_pr__pfet_g5v0d10v5 ad=1.45 pd=10.29 as=1.45 ps=10.29 w=10 l=0.5
X25 D4 G3 S3 B sky130_fd_pr__pfet_g5v0d10v5 ad=1.45 pd=10.29 as=1.45 ps=10.29 w=10 l=0.5
X26 D18 G17 S17 B sky130_fd_pr__pfet_g5v0d10v5 ad=1.45 pd=10.29 as=1.45 ps=10.29 w=10 l=0.5
X27 D38 G37 S37 B sky130_fd_pr__pfet_g5v0d10v5 ad=1.45 pd=10.29 as=1.45 ps=10.29 w=10 l=0.5
X28 S15 G14 D14 B sky130_fd_pr__pfet_g5v0d10v5 ad=1.45 pd=10.29 as=1.45 ps=10.29 w=10 l=0.5
X29 D14 G13 S13 B sky130_fd_pr__pfet_g5v0d10v5 ad=1.45 pd=10.29 as=1.45 ps=10.29 w=10 l=0.5
X30 S39 G38 D38 B sky130_fd_pr__pfet_g5v0d10v5 ad=1.45 pd=10.29 as=1.45 ps=10.29 w=10 l=0.5
X31 D28 G27 S27 B sky130_fd_pr__pfet_g5v0d10v5 ad=1.45 pd=10.29 as=1.45 ps=10.29 w=10 l=0.5
X32 S29 G28 D28 B sky130_fd_pr__pfet_g5v0d10v5 ad=1.45 pd=10.29 as=1.45 ps=10.29 w=10 l=0.5
X33 D24 G23 S23 B sky130_fd_pr__pfet_g5v0d10v5 ad=1.45 pd=10.29 as=1.45 ps=10.29 w=10 l=0.5
X34 S31 G30 D30 B sky130_fd_pr__pfet_g5v0d10v5 ad=1.45 pd=10.29 as=1.45 ps=10.29 w=10 l=0.5
X35 S25 G24 D24 B sky130_fd_pr__pfet_g5v0d10v5 ad=1.45 pd=10.29 as=1.45 ps=10.29 w=10 l=0.5
X36 D32 G31 S31 B sky130_fd_pr__pfet_g5v0d10v5 ad=1.45 pd=10.29 as=1.45 ps=10.29 w=10 l=0.5
X37 D36 G35 S35 B sky130_fd_pr__pfet_g5v0d10v5 ad=1.45 pd=10.29 as=1.45 ps=10.29 w=10 l=0.5
X38 D6 G5 S5 B sky130_fd_pr__pfet_g5v0d10v5 ad=1.45 pd=10.29 as=1.45 ps=10.29 w=10 l=0.5
X39 a_3131_n1036# G39 S39 B sky130_fd_pr__pfet_g5v0d10v5 ad=2.9 pd=20.58 as=1.45 ps=10.29 w=10 l=0.5
C0 D18 B 0.023038f
C1 D8 B 0.023038f
C2 G7 S7 0.127776f
C3 D38 S39 0.890272f
C4 B G28 0.130407f
C5 G26 S27 0.127776f
C6 G39 a_3131_n1036# 0.127776f
C7 D18 G18 0.127776f
C8 S17 G17 0.127776f
C9 B G32 0.130407f
C10 B D38 0.023038f
C11 G14 G13 0.061903f
C12 D10 S9 0.890272f
C13 D24 B 0.023038f
C14 B G34 0.130407f
C15 G33 D34 0.127776f
C16 G27 B 0.130407f
C17 G5 G6 0.061903f
C18 D20 B 0.023038f
C19 D20 S21 0.890272f
C20 B G25 0.130407f
C21 G3 B 0.130407f
C22 D30 G30 0.127776f
C23 D10 B 0.023038f
C24 G34 S35 0.127776f
C25 G7 G6 0.061903f
C26 S23 G22 0.127776f
C27 G12 G11 0.061903f
C28 G31 B 0.130407f
C29 D30 S31 0.890272f
C30 B D34 0.023038f
C31 B G33 0.130407f
C32 G23 S23 0.127776f
C33 S9 B 0.023038f
C34 D4 S3 0.890272f
C35 G9 G10 0.061903f
C36 D0 B 0.58701f
C37 D18 G17 0.127776f
C38 D10 S11 0.890272f
C39 B S39 0.023038f
C40 G16 G15 0.061903f
C41 D34 S35 0.890272f
C42 S15 D16 0.890272f
C43 S21 B 0.023038f
C44 G5 G4 0.061903f
C45 G26 G27 0.061903f
C46 G18 B 0.130407f
C47 S13 B 0.023038f
C48 G26 G25 0.061903f
C49 G36 B 0.130407f
C50 G31 G30 0.061903f
C51 S11 B 0.023038f
C52 G31 S31 0.127776f
C53 B S35 0.023038f
C54 G23 D24 0.127776f
C55 G14 B 0.130407f
C56 G39 S39 0.127776f
C57 D0 G0 0.127776f
C58 D10 G10 0.127776f
C59 D14 G13 0.127776f
C60 G7 D8 0.127776f
C61 G24 D24 0.127776f
C62 B G30 0.130407f
C63 G39 B 0.15506f
C64 D4 G4 0.127776f
C65 B S31 0.023038f
C66 D6 S7 0.890272f
C67 B G0 0.15506f
C68 S29 G29 0.127776f
C69 G26 B 0.130407f
C70 S1 G1 0.127776f
C71 G24 G25 0.061903f
C72 G17 B 0.130407f
C73 G12 G13 0.061903f
C74 B G10 0.130407f
C75 D12 B 0.023038f
C76 S3 D2 0.890272f
C77 G18 G17 0.061903f
C78 D16 G16 0.127776f
C79 B D36 0.023038f
C80 B G22 0.130407f
C81 G23 B 0.130407f
C82 S13 D12 0.890272f
C83 S19 G19 0.127776f
C84 S11 G10 0.127776f
C85 S11 D12 0.890272f
C86 G36 D36 0.127776f
C87 G30 S31 0.127776f
C88 S25 D26 0.890272f
C89 D6 G6 0.127776f
C90 G1 D2 0.127776f
C91 S5 G4 0.127776f
C92 G5 B 0.130407f
C93 G24 B 0.130407f
C94 D32 G32 0.127776f
C95 S35 D36 0.890272f
C96 D30 G29 0.127776f
C97 G19 G20 0.061903f
C98 D4 G3 0.127776f
C99 G28 G29 0.061903f
C100 G7 B 0.130407f
C101 S17 G16 0.127776f
C102 D16 G15 0.127776f
C103 G37 S37 0.127776f
C104 D14 B 0.023038f
C105 G31 D32 0.127776f
C106 S13 D14 0.890272f
C107 G37 G38 0.061903f
C108 D4 B 0.023038f
C109 G2 D2 0.127776f
C110 S33 G32 0.127776f
C111 D14 G14 0.127776f
C112 G12 B 0.130407f
C113 G23 G22 0.061903f
C114 G21 D22 0.127776f
C115 B D32 0.023038f
C116 S13 G12 0.127776f
C117 G8 G9 0.061903f
C118 D0 S1 0.890272f
C119 S15 B 0.023038f
C120 G24 G23 0.061903f
C121 B G29 0.130407f
C122 G21 G20 0.061903f
C123 G8 D8 0.127776f
C124 D34 S33 0.890272f
C125 G33 S33 0.127776f
C126 S5 B 0.023038f
C127 S1 B 0.023038f
C128 D20 G19 0.127776f
C129 S15 G14 0.127776f
C130 D24 S25 0.890272f
C131 S31 D32 0.890272f
C132 B S33 0.023038f
C133 G29 G30 0.061903f
C134 S7 G6 0.127776f
C135 D12 G12 0.127776f
C136 G25 S25 0.127776f
C137 B D2 0.023038f
C138 G37 D38 0.127776f
C139 G8 S9 0.127776f
C140 D6 B 0.023038f
C141 S1 G0 0.127776f
C142 G19 B 0.130407f
C143 D28 S29 0.890272f
C144 D16 S17 0.890272f
C145 G16 B 0.130407f
C146 G19 G18 0.061903f
C147 D28 S27 0.890272f
C148 D26 S27 0.890272f
C149 G8 B 0.130407f
C150 B S25 0.023038f
C151 S5 G5 0.127776f
C152 S7 D8 0.890272f
C153 D22 S23 0.890272f
C154 G37 B 0.130407f
C155 D14 S15 0.890272f
C156 G15 B 0.130407f
C157 D28 G28 0.127776f
C158 G2 S3 0.127776f
C159 G16 G17 0.061903f
C160 G36 G37 0.061903f
C161 S37 D38 0.890272f
C162 S19 D18 0.890272f
C163 G21 B 0.130407f
C164 S21 G21 0.127776f
C165 D4 S5 0.890272f
C166 G15 G14 0.061903f
C167 G27 D28 0.127776f
C168 G38 D38 0.127776f
C169 G1 G2 0.061903f
C170 D6 G5 0.127776f
C171 G35 G34 0.061903f
C172 G25 D26 0.127776f
C173 S29 D30 0.890272f
C174 S17 D18 0.890272f
C175 S19 D20 0.890272f
C176 S29 G28 0.127776f
C177 G3 S3 0.127776f
C178 G24 S25 0.127776f
C179 S7 B 0.023038f
C180 G11 B 0.130407f
C181 D20 G20 0.127776f
C182 D28 B 0.023038f
C183 D16 B 0.023038f
C184 D32 S33 0.890272f
C185 G7 G8 0.061903f
C186 B S37 0.023038f
C187 B D26 0.023038f
C188 G38 S39 0.127776f
C189 G27 S27 0.127776f
C190 S11 G11 0.127776f
C191 B S3 0.023038f
C192 S23 D24 0.890272f
C193 G35 B 0.130407f
C194 B G38 0.130407f
C195 G36 S37 0.127776f
C196 S19 B 0.023038f
C197 G21 G22 0.061903f
C198 D22 B 0.023038f
C199 S21 D22 0.890272f
C200 S19 G18 0.127776f
C201 G36 G35 0.061903f
C202 G6 B 0.130407f
C203 B G20 0.130407f
C204 G35 S35 0.127776f
C205 G1 B 0.130407f
C206 S21 G20 0.127776f
C207 S1 D2 0.890272f
C208 S29 B 0.023038f
C209 S5 D6 0.890272f
C210 S17 B 0.023038f
C211 G3 G4 0.061903f
C212 a_3131_n1036# S39 0.890272f
C213 B S27 0.023038f
C214 D10 G9 0.127776f
C215 G26 D26 0.127776f
C216 G11 G10 0.061903f
C217 G2 G3 0.061903f
C218 D12 G11 0.127776f
C219 G27 G28 0.061903f
C220 G39 G38 0.061903f
C221 S9 G9 0.127776f
C222 a_3131_n1036# B 0.58701f
C223 S23 B 0.023038f
C224 D8 S9 0.890272f
C225 S37 D36 0.890272f
C226 G31 G32 0.061903f
C227 B G4 0.130407f
C228 G33 G32 0.061903f
C229 B G9 0.130407f
C230 B G13 0.130407f
C231 G35 D36 0.127776f
C232 G1 G0 0.061903f
C233 G2 B 0.130407f
C234 G34 D34 0.127776f
C235 G34 G33 0.061903f
C236 D22 G22 0.127776f
C237 S15 G15 0.127776f
C238 S13 G13 0.127776f
C239 D30 B 0.023038f
C240 S39 VSUBS 0.172108f
C241 D38 VSUBS 0.172108f
C242 S37 VSUBS 0.172108f
C243 D36 VSUBS 0.172108f
C244 S35 VSUBS 0.172108f
C245 D34 VSUBS 0.172108f
C246 S33 VSUBS 0.172108f
C247 D32 VSUBS 0.172108f
C248 S31 VSUBS 0.172108f
C249 D30 VSUBS 0.172108f
C250 S29 VSUBS 0.172108f
C251 D28 VSUBS 0.172108f
C252 S27 VSUBS 0.172108f
C253 D26 VSUBS 0.172108f
C254 S25 VSUBS 0.172108f
C255 D24 VSUBS 0.172108f
C256 S23 VSUBS 0.172108f
C257 D22 VSUBS 0.172108f
C258 S21 VSUBS 0.172108f
C259 D20 VSUBS 0.172108f
C260 S19 VSUBS 0.172108f
C261 D18 VSUBS 0.172108f
C262 S17 VSUBS 0.172108f
C263 D16 VSUBS 0.172108f
C264 S15 VSUBS 0.172108f
C265 D14 VSUBS 0.172108f
C266 S13 VSUBS 0.172108f
C267 D12 VSUBS 0.172108f
C268 S11 VSUBS 0.172108f
C269 D10 VSUBS 0.172108f
C270 S9 VSUBS 0.172108f
C271 D8 VSUBS 0.172108f
C272 S7 VSUBS 0.172108f
C273 D6 VSUBS 0.172108f
C274 S5 VSUBS 0.172108f
C275 D4 VSUBS 0.172108f
C276 S3 VSUBS 0.172108f
C277 D2 VSUBS 0.172108f
C278 S1 VSUBS 0.172108f
C279 D0 VSUBS 0.437153f
C280 G39 VSUBS 0.116486f
C281 G38 VSUBS 0.103106f
C282 G37 VSUBS 0.103106f
C283 G36 VSUBS 0.103106f
C284 G35 VSUBS 0.103106f
C285 G34 VSUBS 0.103106f
C286 G33 VSUBS 0.103106f
C287 G32 VSUBS 0.103106f
C288 G31 VSUBS 0.103106f
C289 G30 VSUBS 0.103106f
C290 G29 VSUBS 0.103106f
C291 G28 VSUBS 0.103106f
C292 G27 VSUBS 0.103106f
C293 G26 VSUBS 0.103106f
C294 G25 VSUBS 0.103106f
C295 G24 VSUBS 0.103106f
C296 G23 VSUBS 0.103106f
C297 G22 VSUBS 0.103106f
C298 G21 VSUBS 0.103106f
C299 G20 VSUBS 0.103106f
C300 G19 VSUBS 0.103106f
C301 G18 VSUBS 0.103106f
C302 G17 VSUBS 0.103106f
C303 G16 VSUBS 0.103106f
C304 G15 VSUBS 0.103106f
C305 G14 VSUBS 0.103106f
C306 G13 VSUBS 0.103106f
C307 G12 VSUBS 0.103106f
C308 G11 VSUBS 0.103106f
C309 G10 VSUBS 0.103106f
C310 G9 VSUBS 0.103106f
C311 G8 VSUBS 0.103106f
C312 G7 VSUBS 0.103106f
C313 G6 VSUBS 0.103106f
C314 G5 VSUBS 0.103106f
C315 G4 VSUBS 0.103106f
C316 G3 VSUBS 0.103106f
C317 G2 VSUBS 0.103106f
C318 G1 VSUBS 0.103106f
C319 G0 VSUBS 0.116486f
C320 B VSUBS 56.7882f
C321 a_3131_n1036# VSUBS 0.437153f
.ends

.subckt sky130_fd_pr__pfet_g5v0d10v5_7B62CL B D S G VSUBS
X0 S G D B sky130_fd_pr__pfet_g5v0d10v5 ad=0.2436 pd=2.26 as=0.2436 ps=2.26 w=0.84 l=0.5
C0 B G 0.190892f
C1 B D 0.073078f
C2 G D 0.01429f
C3 S B 0.073078f
C4 S G 0.01429f
C5 S D 0.076415f
C6 S VSUBS 0.045757f
C7 D VSUBS 0.045757f
C8 G VSUBS 0.127382f
C9 B VSUBS 1.74241f
.ends

.subckt sky130_fd_pr__pfet_g5v0d10v5_PN8J4Z B D0 S0 G0 D1 S1 G1 D2 S2 G2 VSUBS
X0 S2 G2 D2 B sky130_fd_pr__pfet_g5v0d10v5 ad=1.16 pd=8.58 as=1.16 ps=8.58 w=4 l=4
X1 S1 G1 D1 B sky130_fd_pr__pfet_g5v0d10v5 ad=1.16 pd=8.58 as=1.16 ps=8.58 w=4 l=4
X2 S0 G0 D0 B sky130_fd_pr__pfet_g5v0d10v5 ad=1.16 pd=8.58 as=1.16 ps=8.58 w=4 l=4
C0 G1 D1 0.158746f
C1 D0 B 0.244168f
C2 D0 D1 0.014232f
C3 G1 G2 0.497349f
C4 D1 B 0.236968f
C5 S2 S1 0.014232f
C6 B G2 0.786334f
C7 D0 S0 0.065571f
C8 S0 B 0.244168f
C9 B D2 0.243139f
C10 D1 D2 0.014232f
C11 G0 G1 0.497349f
C12 G2 D2 0.158746f
C13 G1 S1 0.158746f
C14 D0 G0 0.158746f
C15 G0 B 0.605257f
C16 B S1 0.236968f
C17 D1 S1 0.065571f
C18 S0 G0 0.158746f
C19 S0 S1 0.014232f
C20 S2 B 0.243139f
C21 S2 G2 0.158746f
C22 S2 D2 0.065571f
C23 G1 B 0.469368f
C24 S0 VSUBS 0.257653f
C25 D0 VSUBS 0.257653f
C26 G0 VSUBS 0.801835f
C27 S1 VSUBS 0.251456f
C28 D1 VSUBS 0.251456f
C29 G1 VSUBS 0.703093f
C30 S2 VSUBS 0.256896f
C31 D2 VSUBS 0.256896f
C32 G2 VSUBS 0.784084f
C33 B VSUBS 15.1219f
.ends

.subckt sky130_fd_pr__nfet_g5v0d10v5_3UQFYT B D0 S0 G0 D1 S1 G1 D2 S2 G2
X0 S0 G0 D0 B sky130_fd_pr__nfet_g5v0d10v5 ad=0.58 pd=4.58 as=0.58 ps=4.58 w=2 l=4
X1 S1 G1 D1 B sky130_fd_pr__nfet_g5v0d10v5 ad=0.58 pd=4.58 as=0.58 ps=4.58 w=2 l=4
X2 S2 G2 D2 B sky130_fd_pr__nfet_g5v0d10v5 ad=0.58 pd=4.58 as=0.58 ps=4.58 w=2 l=4
C0 D2 D1 0.014895f
C1 G0 D0 0.082975f
C2 G2 D2 0.082975f
C3 D1 D0 0.014895f
C4 S2 S1 0.014895f
C5 S1 G1 0.082975f
C6 D0 S0 0.032918f
C7 G1 G0 0.519044f
C8 S1 D1 0.032918f
C9 G1 D1 0.082975f
C10 G2 S2 0.082975f
C11 G2 G1 0.519044f
C12 S1 S0 0.014895f
C13 G0 S0 0.082975f
C14 D2 S2 0.032918f
C15 S0 B 0.259336f
C16 D0 B 0.259336f
C17 G0 B 1.37874f
C18 S1 B 0.245838f
C19 D1 B 0.245838f
C20 G1 B 1.10221f
C21 S2 B 0.257756f
C22 D2 B 0.257756f
C23 G2 B 1.52414f
.ends

.subckt sky130_fd_pr__res_xhigh_po_0p35_ADWJQG B R1 R2
X0 R2 R1 B sky130_fd_pr__res_xhigh_po_0p35 l=292.92
C0 R1 B 0.577911f
C1 R2 B 0.577911f
.ends

.subckt sky130_fd_pr__cap_mim_m3_1_Y3HN7X C2 C1 VSUBS
X0 C1 C2 sky130_fd_pr__cap_mim_m3_1 l=27.5 w=27.5
C0 C1 C2 66.5348f
C1 C1 VSUBS 2.85705f
C2 C2 VSUBS 16.0169f
.ends

.subckt sky130_fd_pr__nfet_g5v0d10v5_WMYWGM B D S G
X0 S G D B sky130_fd_pr__nfet_g5v0d10v5 ad=2.32 pd=16.58 as=2.32 ps=16.58 w=8 l=2
C0 S G 0.254328f
C1 D G 0.254328f
C2 D S 0.246248f
C3 S B 0.92443f
C4 D B 0.92443f
C5 G B 0.935471f
.ends

.subckt sky130_fd_pr__pfet_g5v0d10v5_DNGK98 B D S G VSUBS
X0 S G D B sky130_fd_pr__pfet_g5v0d10v5 ad=4.64 pd=32.58 as=4.64 ps=32.58 w=16 l=4
C0 S D 0.26149f
C1 S G 0.613371f
C2 D B 0.923613f
C3 G B 0.895007f
C4 S B 0.923613f
C5 G D 0.613371f
C6 S VSUBS 1.03041f
C7 D VSUBS 1.03041f
C8 G VSUBS 0.910237f
C9 B VSUBS 17.1758f
.ends

.subckt sky130_fd_pr__nfet_g5v0d10v5_DDWFWJ B D0 G0 S1 G1 D2 S2 G2
X0 D2 G1 S1 B sky130_fd_pr__nfet_g5v0d10v5 ad=0.58 pd=4.29 as=0.58 ps=4.29 w=4 l=1
X1 S1 G0 D0 B sky130_fd_pr__nfet_g5v0d10v5 ad=0.58 pd=4.29 as=1.16 ps=8.58 w=4 l=1
X2 S2 G2 D2 B sky130_fd_pr__nfet_g5v0d10v5 ad=1.16 pd=8.58 as=0.58 ps=4.29 w=4 l=1
C0 D2 G2 0.090922f
C1 D2 G1 0.090922f
C2 G1 G0 0.05942f
C3 D0 G0 0.090922f
C4 G1 S1 0.090922f
C5 D2 S1 0.219309f
C6 D0 S1 0.219309f
C7 S2 G2 0.090922f
C8 S1 G0 0.090922f
C9 D2 S2 0.219309f
C10 G1 G2 0.05942f
C11 S2 B 0.448578f
C12 D2 B 0.140565f
C13 S1 B 0.140565f
C14 D0 B 0.448578f
C15 G2 B 0.477445f
C16 G1 B 0.441242f
C17 G0 B 0.477445f
.ends

.subckt sky130_fd_pr__nfet_g5v0d10v5_FZ2B7C B D S G
X0 S G D B sky130_fd_pr__nfet_g5v0d10v5 ad=0.1218 pd=1.42 as=0.1218 ps=1.42 w=0.42 l=0.5
C0 D G 0.009087f
C1 S G 0.009087f
C2 S D 0.039098f
C3 S B 0.076791f
C4 D B 0.076791f
C5 G B 0.314309f
.ends

.subckt sky130_fd_pr__cap_mim_m3_1_PP9XRG C2 C1 VSUBS
X0 C1 C2 sky130_fd_pr__cap_mim_m3_1 l=30 w=30
C0 C1 C2 78.8907f
C1 C1 VSUBS 3.12051f
C2 C2 VSUBS 18.375599f
.ends

.subckt sky130_fd_pr__nfet_g5v0d10v5_HA9V6X B D0 S0 G0 D1 S1 G1 D2 S2 G2 D3 S3 G3
X0 S1 G1 D1 B sky130_fd_pr__nfet_g5v0d10v5 ad=0.58 pd=4.58 as=0.58 ps=4.58 w=2 l=4
X1 S3 G3 D3 B sky130_fd_pr__nfet_g5v0d10v5 ad=0.58 pd=4.58 as=0.58 ps=4.58 w=2 l=4
X2 S2 G2 D2 B sky130_fd_pr__nfet_g5v0d10v5 ad=0.58 pd=4.58 as=0.58 ps=4.58 w=2 l=4
X3 S0 G0 D0 B sky130_fd_pr__nfet_g5v0d10v5 ad=0.58 pd=4.58 as=0.58 ps=4.58 w=2 l=4
C0 S1 D1 0.032918f
C1 D2 D1 0.014895f
C2 S1 S2 0.014895f
C3 D0 G0 0.082975f
C4 D2 S2 0.032918f
C5 D2 G2 0.082975f
C6 G3 G2 0.519044f
C7 S3 S2 0.014895f
C8 S1 S0 0.014895f
C9 D2 D3 0.014895f
C10 D3 G3 0.082975f
C11 G0 G1 0.519044f
C12 D0 D1 0.014895f
C13 S3 G3 0.082975f
C14 S3 D3 0.032918f
C15 D0 S0 0.032918f
C16 G1 D1 0.082975f
C17 G0 S0 0.082975f
C18 G1 G2 0.519044f
C19 S1 G1 0.082975f
C20 S2 G2 0.082975f
C21 S0 B 0.259336f
C22 D0 B 0.259336f
C23 G0 B 1.37874f
C24 S1 B 0.245838f
C25 D1 B 0.245838f
C26 G1 B 1.10221f
C27 S2 B 0.245838f
C28 D2 B 0.245838f
C29 G2 B 1.10221f
C30 S3 B 0.257756f
C31 D3 B 0.257756f
C32 G3 B 1.52414f
.ends

.subckt sky130_fd_pr__pfet_g5v0d10v5_KMGDV8 B D0_0 G0_0 D0_1 G0_1 D0_2 G0_2 D0_3 G0_3
+ S1_0 G1_0 S1_1 G1_1 S1_2 G1_2 S1_3 G1_3 D2_0 G2_0 D2_1 G2_1 D2_2 G2_2 D2_3 G2_3
+ S3_0 G3_0 S3_1 G3_1 S3_2 G3_2 S3_3 G3_3 D4_0 G4_0 D4_1 G4_1 D4_2 G4_2 D4_3 G4_3
+ S5_0 G5_0 S5_1 G5_1 S5_2 G5_2 S5_3 G5_3 D6_0 G6_0 D6_1 G6_1 D6_2 G6_2 D6_3 G6_3
+ S7_0 G7_0 S7_1 G7_1 S7_2 G7_2 S7_3 G7_3 a_1803_n8283# a_1803_4212# a_1803_n4118#
+ a_1803_47# VSUBS
X0 a_1803_4212# G7_3 S7_3 B sky130_fd_pr__pfet_g5v0d10v5 ad=5.8 pd=40.58 as=2.9 ps=20.29 w=20 l=2
X1 S5_2 G4_2 D4_2 B sky130_fd_pr__pfet_g5v0d10v5 ad=2.9 pd=20.29 as=2.9 ps=20.29 w=20 l=2
X2 D6_3 G5_3 S5_3 B sky130_fd_pr__pfet_g5v0d10v5 ad=2.9 pd=20.29 as=2.9 ps=20.29 w=20 l=2
X3 S3_3 G2_3 D2_3 B sky130_fd_pr__pfet_g5v0d10v5 ad=2.9 pd=20.29 as=2.9 ps=20.29 w=20 l=2
X4 S5_1 G4_1 D4_1 B sky130_fd_pr__pfet_g5v0d10v5 ad=2.9 pd=20.29 as=2.9 ps=20.29 w=20 l=2
X5 S3_0 G2_0 D2_0 B sky130_fd_pr__pfet_g5v0d10v5 ad=2.9 pd=20.29 as=2.9 ps=20.29 w=20 l=2
X6 S1_3 G0_3 D0_3 B sky130_fd_pr__pfet_g5v0d10v5 ad=2.9 pd=20.29 as=5.8 ps=40.58 w=20 l=2
X7 D4_2 G3_2 S3_2 B sky130_fd_pr__pfet_g5v0d10v5 ad=2.9 pd=20.29 as=2.9 ps=20.29 w=20 l=2
X8 D2_0 G1_0 S1_0 B sky130_fd_pr__pfet_g5v0d10v5 ad=2.9 pd=20.29 as=2.9 ps=20.29 w=20 l=2
X9 D6_0 G5_0 S5_0 B sky130_fd_pr__pfet_g5v0d10v5 ad=2.9 pd=20.29 as=2.9 ps=20.29 w=20 l=2
X10 a_1803_n8283# G7_0 S7_0 B sky130_fd_pr__pfet_g5v0d10v5 ad=5.8 pd=40.58 as=2.9 ps=20.29 w=20 l=2
X11 S3_2 G2_2 D2_2 B sky130_fd_pr__pfet_g5v0d10v5 ad=2.9 pd=20.29 as=2.9 ps=20.29 w=20 l=2
X12 S7_0 G6_0 D6_0 B sky130_fd_pr__pfet_g5v0d10v5 ad=2.9 pd=20.29 as=2.9 ps=20.29 w=20 l=2
X13 D4_3 G3_3 S3_3 B sky130_fd_pr__pfet_g5v0d10v5 ad=2.9 pd=20.29 as=2.9 ps=20.29 w=20 l=2
X14 S1_0 G0_0 D0_0 B sky130_fd_pr__pfet_g5v0d10v5 ad=2.9 pd=20.29 as=5.8 ps=40.58 w=20 l=2
X15 D4_0 G3_0 S3_0 B sky130_fd_pr__pfet_g5v0d10v5 ad=2.9 pd=20.29 as=2.9 ps=20.29 w=20 l=2
X16 S7_3 G6_3 D6_3 B sky130_fd_pr__pfet_g5v0d10v5 ad=2.9 pd=20.29 as=2.9 ps=20.29 w=20 l=2
X17 S3_1 G2_1 D2_1 B sky130_fd_pr__pfet_g5v0d10v5 ad=2.9 pd=20.29 as=2.9 ps=20.29 w=20 l=2
X18 D6_1 G5_1 S5_1 B sky130_fd_pr__pfet_g5v0d10v5 ad=2.9 pd=20.29 as=2.9 ps=20.29 w=20 l=2
X19 D2_1 G1_1 S1_1 B sky130_fd_pr__pfet_g5v0d10v5 ad=2.9 pd=20.29 as=2.9 ps=20.29 w=20 l=2
X20 a_1803_n4118# G7_1 S7_1 B sky130_fd_pr__pfet_g5v0d10v5 ad=5.8 pd=40.58 as=2.9 ps=20.29 w=20 l=2
X21 S1_1 G0_1 D0_1 B sky130_fd_pr__pfet_g5v0d10v5 ad=2.9 pd=20.29 as=5.8 ps=40.58 w=20 l=2
X22 S7_1 G6_1 D6_1 B sky130_fd_pr__pfet_g5v0d10v5 ad=2.9 pd=20.29 as=2.9 ps=20.29 w=20 l=2
X23 D2_3 G1_3 S1_3 B sky130_fd_pr__pfet_g5v0d10v5 ad=2.9 pd=20.29 as=2.9 ps=20.29 w=20 l=2
X24 D4_1 G3_1 S3_1 B sky130_fd_pr__pfet_g5v0d10v5 ad=2.9 pd=20.29 as=2.9 ps=20.29 w=20 l=2
X25 D6_2 G5_2 S5_2 B sky130_fd_pr__pfet_g5v0d10v5 ad=2.9 pd=20.29 as=2.9 ps=20.29 w=20 l=2
X26 D2_2 G1_2 S1_2 B sky130_fd_pr__pfet_g5v0d10v5 ad=2.9 pd=20.29 as=2.9 ps=20.29 w=20 l=2
X27 a_1803_47# G7_2 S7_2 B sky130_fd_pr__pfet_g5v0d10v5 ad=5.8 pd=40.58 as=2.9 ps=20.29 w=20 l=2
X28 S5_0 G4_0 D4_0 B sky130_fd_pr__pfet_g5v0d10v5 ad=2.9 pd=20.29 as=2.9 ps=20.29 w=20 l=2
X29 S7_2 G6_2 D6_2 B sky130_fd_pr__pfet_g5v0d10v5 ad=2.9 pd=20.29 as=2.9 ps=20.29 w=20 l=2
X30 S5_3 G4_3 D4_3 B sky130_fd_pr__pfet_g5v0d10v5 ad=2.9 pd=20.29 as=2.9 ps=20.29 w=20 l=2
X31 S1_2 G0_2 D0_2 B sky130_fd_pr__pfet_g5v0d10v5 ad=2.9 pd=20.29 as=5.8 ps=40.58 w=20 l=2
C0 D0_2 G0_2 0.625982f
C1 G5_0 D6_0 0.625982f
C2 D0_1 S1_1 0.614813f
C3 G4_3 D4_3 0.625982f
C4 G4_2 D4_2 0.625982f
C5 G1_1 D2_1 0.625982f
C6 G2_3 D2_3 0.625982f
C7 B G5_2 0.223127f
C8 S3_2 S3_3 0.014232f
C9 G4_3 S5_3 0.625982f
C10 G2_3 G3_3 0.061903f
C11 B S1_2 0.009616f
C12 D6_0 S7_0 0.614813f
C13 B D4_2 0.009616f
C14 B D2_0 0.016816f
C15 G4_0 G5_0 0.061903f
C16 G4_3 G3_3 0.061903f
C17 B D2_2 0.009616f
C18 G7_2 B 0.247781f
C19 G4_0 G4_1 0.227831f
C20 G2_2 D2_2 0.625982f
C21 G6_3 G7_3 0.061903f
C22 G1_2 G1_3 0.227831f
C23 G5_2 G5_1 0.227831f
C24 B G0_1 0.247781f
C25 B G6_1 0.223127f
C26 B D6_3 0.015791f
C27 G2_3 S3_3 0.625982f
C28 G4_2 B 0.223127f
C29 a_1803_n4118# a_1803_47# 0.014232f
C30 G1_3 D2_3 0.625982f
C31 S3_2 D4_2 0.614813f
C32 D0_0 G0_0 0.625982f
C33 S3_0 D2_0 0.614813f
C34 G7_2 S7_2 0.625982f
C35 G7_2 G7_1 0.227831f
C36 D0_2 S1_2 0.614813f
C37 S3_1 B 0.009616f
C38 S3_2 D2_2 0.614813f
C39 G7_1 G6_1 0.061903f
C40 D0_0 S1_0 0.614813f
C41 G6_1 G5_1 0.061903f
C42 D6_1 D6_2 0.014232f
C43 G2_2 B 0.223127f
C44 G7_2 G7_3 0.227831f
C45 a_1803_4212# B 1.14085f
C46 S5_2 D6_2 0.614813f
C47 a_1803_n4118# S7_1 0.614813f
C48 G6_2 G6_3 0.227831f
C49 B S7_2 0.009616f
C50 G7_1 B 0.247781f
C51 G0_3 D0_3 0.625982f
C52 S3_1 S3_2 0.014232f
C53 S3_1 S3_0 0.014232f
C54 B G5_1 0.223127f
C55 B S5_1 0.009616f
C56 G4_2 G4_1 0.227831f
C57 S3_2 B 0.009616f
C58 S3_0 B 0.016816f
C59 G1_3 S1_3 0.625982f
C60 G6_2 G5_2 0.061903f
C61 S3_2 G2_2 0.625982f
C62 G1_1 G0_1 0.061903f
C63 B a_1803_n8283# 1.14187f
C64 G2_0 G2_1 0.227831f
C65 G6_3 S7_3 0.625982f
C66 G5_0 B 0.278378f
C67 B G7_3 0.40686f
C68 D0_2 B 1.13467f
C69 S3_1 G3_1 0.625982f
C70 D4_0 D4_1 0.014232f
C71 B G3_1 0.223127f
C72 G4_1 B 0.223127f
C73 a_1803_4212# G7_3 0.625982f
C74 G4_3 G4_2 0.227831f
C75 G5_3 S5_3 0.625982f
C76 S5_1 G5_1 0.625982f
C77 B S7_0 0.016816f
C78 G7_2 G6_2 0.061903f
C79 G2_3 B 0.382207f
C80 G2_0 G1_0 0.061903f
C81 G0_3 G0_2 0.227831f
C82 G6_0 G7_0 0.061903f
C83 G1_1 B 0.223127f
C84 G5_2 D6_2 0.625982f
C85 G6_2 G6_1 0.227831f
C86 G2_3 G2_2 0.227831f
C87 G5_0 G5_1 0.227831f
C88 G4_3 B 0.382207f
C89 D0_0 B 1.14187f
C90 G2_0 G3_0 0.061903f
C91 G4_1 G5_1 0.061903f
C92 G4_1 S5_1 0.625982f
C93 D6_3 S7_3 0.614813f
C94 S1_1 D2_1 0.614813f
C95 G6_2 B 0.223127f
C96 G0_3 S1_3 0.625982f
C97 D6_2 D6_3 0.014232f
C98 a_1803_n8283# S7_0 0.614813f
C99 G4_1 G3_1 0.061903f
C100 G2_1 D2_1 0.625982f
C101 D0_1 G0_1 0.625982f
C102 D4_0 S5_0 0.614813f
C103 G1_3 B 0.382207f
C104 G5_3 G6_3 0.061903f
C105 B S7_3 0.015791f
C106 D6_0 S5_0 0.614813f
C107 G6_2 S7_2 0.625982f
C108 D4_2 D4_1 0.014232f
C109 B D6_2 0.009616f
C110 a_1803_4212# S7_3 0.614813f
C111 G5_3 G5_2 0.227831f
C112 S7_1 D6_1 0.614813f
C113 S1_1 S1_0 0.014232f
C114 D0_1 B 1.13467f
C115 S7_2 S7_3 0.014232f
C116 G4_0 S5_0 0.625982f
C117 D4_3 S5_3 0.614813f
C118 D6_2 S7_2 0.614813f
C119 G6_0 D6_0 0.625982f
C120 S7_3 G7_3 0.625982f
C121 D4_0 G3_0 0.625982f
C122 G3_3 D4_3 0.625982f
C123 G5_3 D6_3 0.625982f
C124 S3_1 D4_1 0.614813f
C125 G1_2 G0_2 0.061903f
C126 B D4_1 0.009616f
C127 S1_1 S1_2 0.014232f
C128 G1_0 G0_0 0.061903f
C129 G3_3 G3_2 0.227831f
C130 G0_3 B 0.40686f
C131 S5_3 S5_2 0.014232f
C132 G1_3 G2_3 0.061903f
C133 G1_0 S1_0 0.625982f
C134 a_1803_n4118# B 1.13467f
C135 G2_0 D2_0 0.625982f
C136 D0_2 D0_1 0.014232f
C137 D6_1 D6_0 0.014232f
C138 G7_2 a_1803_47# 0.625982f
C139 D4_3 S3_3 0.614813f
C140 S1_1 G0_1 0.625982f
C141 G5_3 B 0.382207f
C142 G4_0 G3_0 0.061903f
C143 D0_3 S1_3 0.614813f
C144 S5_1 D4_1 0.614813f
C145 D2_3 S3_3 0.614813f
C146 a_1803_n4118# G7_1 0.625982f
C147 G3_3 S3_3 0.625982f
C148 G4_0 D4_0 0.625982f
C149 D2_3 S1_3 0.614813f
C150 S1_1 B 0.009616f
C151 G1_0 D2_0 0.625982f
C152 D0_0 D0_1 0.014232f
C153 G3_1 D4_1 0.625982f
C154 a_1803_47# B 1.13467f
C155 a_1803_n4118# a_1803_n8283# 0.014232f
C156 G4_1 D4_1 0.625982f
C157 B G7_0 0.303032f
C158 G2_0 B 0.278378f
C159 G6_2 D6_2 0.625982f
C160 B S5_0 0.016816f
C161 G1_2 S1_2 0.625982f
C162 S7_1 G6_1 0.625982f
C163 S3_1 G2_1 0.625982f
C164 a_1803_47# a_1803_4212# 0.014232f
C165 D4_2 D4_3 0.014232f
C166 G2_1 B 0.223127f
C167 G6_0 G6_1 0.227831f
C168 G2_1 G2_2 0.227831f
C169 G1_2 D2_2 0.625982f
C170 a_1803_47# S7_2 0.614813f
C171 G5_2 S5_2 0.625982f
C172 D4_2 G3_2 0.625982f
C173 G0_0 S1_0 0.625982f
C174 D2_1 D2_0 0.014232f
C175 G7_1 G7_0 0.227831f
C176 D2_1 D2_2 0.014232f
C177 B S7_1 0.009616f
C178 D2_3 D2_2 0.014232f
C179 S3_0 G2_0 0.625982f
C180 S5_1 S5_0 0.014232f
C181 G0_2 S1_2 0.625982f
C182 B G1_0 0.278378f
C183 S5_3 D6_3 0.614813f
C184 a_1803_n8283# G7_0 0.625982f
C185 G6_0 B 0.278378f
C186 D4_2 S5_2 0.614813f
C187 D6_1 G6_1 0.625982f
C188 G4_3 G5_3 0.061903f
C189 G5_0 S5_0 0.625982f
C190 G4_2 G3_2 0.061903f
C191 D0_3 B 1.14085f
C192 B D4_3 0.015791f
C193 G1_2 B 0.223127f
C194 B G3_0 0.278378f
C195 G0_1 G0_2 0.227831f
C196 G1_2 G2_2 0.061903f
C197 S7_1 S7_2 0.014232f
C198 G7_1 S7_1 0.625982f
C199 G1_1 S1_1 0.625982f
C200 G2_1 G3_1 0.061903f
C201 G7_0 S7_0 0.625982f
C202 G4_2 S5_2 0.625982f
C203 S3_1 D2_1 0.614813f
C204 G1_3 G0_3 0.061903f
C205 B S5_3 0.015791f
C206 B G3_2 0.223127f
C207 B D2_1 0.009616f
C208 B D2_3 0.015791f
C209 S1_3 S1_2 0.014232f
C210 B D6_1 0.009616f
C211 G2_2 G3_2 0.061903f
C212 S1_0 D2_0 0.614813f
C213 G0_1 G0_0 0.227831f
C214 G2_1 G1_1 0.061903f
C215 D4_0 B 0.016816f
C216 G3_3 B 0.382207f
C217 G5_0 G6_0 0.061903f
C218 B S5_2 0.009616f
C219 B G0_2 0.247781f
C220 B D6_0 0.016816f
C221 S3_0 G3_0 0.625982f
C222 D0_2 D0_3 0.014232f
C223 G6_3 D6_3 0.625982f
C224 S7_1 S7_0 0.014232f
C225 S3_2 G3_2 0.625982f
C226 D6_1 G5_1 0.625982f
C227 G6_0 S7_0 0.625982f
C228 D6_1 S5_1 0.614813f
C229 B G0_0 0.303032f
C230 G1_1 G1_0 0.227831f
C231 G3_0 G3_1 0.227831f
C232 B S3_3 0.015791f
C233 S1_2 D2_2 0.614813f
C234 G4_0 B 0.278378f
C235 S3_0 D4_0 0.614813f
C236 S5_1 S5_2 0.014232f
C237 B S1_0 0.016816f
C238 G4_2 G5_2 0.061903f
C239 G3_2 G3_1 0.227831f
C240 B S1_3 0.015791f
C241 G1_2 G1_1 0.227831f
C242 B G6_3 0.382207f
C243 S7_0 VSUBS 0.863504f
C244 D6_0 VSUBS 0.863504f
C245 S5_0 VSUBS 0.863504f
C246 D4_0 VSUBS 0.863504f
C247 S3_0 VSUBS 0.863504f
C248 D2_0 VSUBS 0.863504f
C249 S1_0 VSUBS 0.863504f
C250 D0_0 VSUBS 1.12621f
C251 G7_0 VSUBS 0.440605f
C252 G6_0 VSUBS 0.427224f
C253 G5_0 VSUBS 0.427224f
C254 G4_0 VSUBS 0.427224f
C255 G3_0 VSUBS 0.427224f
C256 G2_0 VSUBS 0.427224f
C257 G1_0 VSUBS 0.427224f
C258 G0_0 VSUBS 0.440605f
C259 S7_1 VSUBS 0.857307f
C260 D6_1 VSUBS 0.857307f
C261 S5_1 VSUBS 0.857307f
C262 D4_1 VSUBS 0.857307f
C263 S3_1 VSUBS 0.857307f
C264 D2_1 VSUBS 0.857307f
C265 S1_1 VSUBS 0.857307f
C266 D0_1 VSUBS 1.12001f
C267 G7_1 VSUBS 0.409619f
C268 G6_1 VSUBS 0.396239f
C269 G5_1 VSUBS 0.396239f
C270 G4_1 VSUBS 0.396239f
C271 G3_1 VSUBS 0.396239f
C272 G2_1 VSUBS 0.396239f
C273 G1_1 VSUBS 0.396239f
C274 G0_1 VSUBS 0.409619f
C275 S7_2 VSUBS 0.857307f
C276 D6_2 VSUBS 0.857307f
C277 S5_2 VSUBS 0.857307f
C278 D4_2 VSUBS 0.857307f
C279 S3_2 VSUBS 0.857307f
C280 D2_2 VSUBS 0.857307f
C281 S1_2 VSUBS 0.857307f
C282 D0_2 VSUBS 1.12001f
C283 G7_2 VSUBS 0.409619f
C284 G6_2 VSUBS 0.396239f
C285 G5_2 VSUBS 0.396239f
C286 G4_2 VSUBS 0.396239f
C287 G3_2 VSUBS 0.396239f
C288 G2_2 VSUBS 0.396239f
C289 G1_2 VSUBS 0.396239f
C290 G0_2 VSUBS 0.409619f
C291 S7_3 VSUBS 0.862757f
C292 D6_3 VSUBS 0.862757f
C293 S5_3 VSUBS 0.862757f
C294 D4_3 VSUBS 0.862757f
C295 S3_3 VSUBS 0.862757f
C296 D2_3 VSUBS 0.862757f
C297 S1_3 VSUBS 0.862757f
C298 D0_3 VSUBS 1.12546f
C299 G7_3 VSUBS 0.420067f
C300 G6_3 VSUBS 0.406686f
C301 G5_3 VSUBS 0.406686f
C302 G4_3 VSUBS 0.406686f
C303 G3_3 VSUBS 0.406686f
C304 G2_3 VSUBS 0.406686f
C305 G1_3 VSUBS 0.406686f
C306 G0_3 VSUBS 0.420067f
C307 B VSUBS 0.221525p
C308 a_1803_n8283# VSUBS 1.12621f
C309 a_1803_n4118# VSUBS 1.12001f
C310 a_1803_47# VSUBS 1.12001f
C311 a_1803_4212# VSUBS 1.12546f
.ends

.subckt sky130_fd_pr__pfet_g5v0d10v5_UFWJXT B D0_0 G0_0 D0_1 G0_1 D0_2 G0_2 D0_3 G0_3
+ S1_0 G1_0 S1_1 G1_1 S1_2 G1_2 S1_3 G1_3 a_3229_n8283# a_3229_4212# a_3229_47# a_3229_n4118#
+ VSUBS
X0 a_3229_47# G1_2 S1_2 B sky130_fd_pr__pfet_g5v0d10v5 ad=5.8 pd=40.58 as=2.9 ps=20.29 w=20 l=16
X1 S1_2 G0_2 D0_2 B sky130_fd_pr__pfet_g5v0d10v5 ad=2.9 pd=20.29 as=5.8 ps=40.58 w=20 l=16
X2 a_3229_n4118# G1_1 S1_1 B sky130_fd_pr__pfet_g5v0d10v5 ad=5.8 pd=40.58 as=2.9 ps=20.29 w=20 l=16
X3 S1_3 G0_3 D0_3 B sky130_fd_pr__pfet_g5v0d10v5 ad=2.9 pd=20.29 as=5.8 ps=40.58 w=20 l=16
X4 S1_0 G0_0 D0_0 B sky130_fd_pr__pfet_g5v0d10v5 ad=2.9 pd=20.29 as=5.8 ps=40.58 w=20 l=16
X5 a_3229_n8283# G1_0 S1_0 B sky130_fd_pr__pfet_g5v0d10v5 ad=5.8 pd=40.58 as=2.9 ps=20.29 w=20 l=16
X6 a_3229_4212# G1_3 S1_3 B sky130_fd_pr__pfet_g5v0d10v5 ad=5.8 pd=40.58 as=2.9 ps=20.29 w=20 l=16
X7 S1_1 G0_1 D0_1 B sky130_fd_pr__pfet_g5v0d10v5 ad=2.9 pd=20.29 as=5.8 ps=40.58 w=20 l=16
C0 D0_2 B 1.13466f
C1 S1_1 B 0.009589f
C2 G0_0 B 2.05553f
C3 a_3229_47# G1_2 0.843488f
C4 D0_1 D0_0 0.014232f
C5 B G0_3 2.88484f
C6 G1_1 S1_1 0.843488f
C7 G1_3 B 2.88484f
C8 a_3229_47# a_3229_4212# 0.014232f
C9 G1_2 G1_3 1.79553f
C10 G0_0 G1_0 0.061903f
C11 D0_0 B 1.14186f
C12 D0_1 G0_1 0.843488f
C13 G1_3 a_3229_4212# 0.843488f
C14 S1_3 S1_2 0.014232f
C15 G0_1 G0_2 1.79553f
C16 a_3229_n4118# a_3229_n8283# 0.014232f
C17 G0_1 B 1.61352f
C18 S1_3 B 0.015764f
C19 B a_3229_n8283# 1.14186f
C20 S1_2 G0_2 0.843488f
C21 D0_1 B 1.13466f
C22 G0_1 G1_1 0.061903f
C23 G1_3 G0_3 0.061903f
C24 D0_3 B 1.14084f
C25 S1_2 B 0.009589f
C26 G0_2 B 1.61352f
C27 G1_2 S1_2 0.843488f
C28 S1_0 B 0.016789f
C29 D0_0 G0_0 0.843488f
C30 G1_2 G0_2 0.061903f
C31 a_3229_n4118# B 1.13466f
C32 G1_0 a_3229_n8283# 0.843488f
C33 a_3229_n4118# G1_1 0.843488f
C34 G1_1 B 1.61352f
C35 G1_2 B 1.61352f
C36 G1_2 G1_1 1.79553f
C37 S1_0 G1_0 0.843488f
C38 B a_3229_4212# 1.14084f
C39 G0_1 S1_1 0.843488f
C40 G0_0 G0_1 1.79553f
C41 D0_2 D0_1 0.014232f
C42 G1_0 B 2.05553f
C43 S1_3 G0_3 0.843488f
C44 G1_1 G1_0 1.79553f
C45 D0_2 D0_3 0.014232f
C46 G1_3 S1_3 0.843488f
C47 S1_2 S1_1 0.014232f
C48 D0_2 G0_2 0.843488f
C49 D0_3 G0_3 0.843488f
C50 a_3229_47# a_3229_n4118# 0.014232f
C51 G0_2 G0_3 1.79553f
C52 S1_0 S1_1 0.014232f
C53 G0_0 S1_0 0.843488f
C54 a_3229_47# B 1.13466f
C55 S1_0 VSUBS 1.87158f
C56 D0_0 VSUBS 1.63025f
C57 G1_0 VSUBS 3.5167f
C58 G0_0 VSUBS 3.5167f
C59 S1_1 VSUBS 1.86538f
C60 D0_1 VSUBS 1.62405f
C61 G1_1 VSUBS 3.26881f
C62 G0_1 VSUBS 3.26881f
C63 S1_2 VSUBS 1.86538f
C64 D0_2 VSUBS 1.62405f
C65 G1_2 VSUBS 3.26881f
C66 G0_2 VSUBS 3.26881f
C67 S1_3 VSUBS 1.87083f
C68 D0_3 VSUBS 1.6295f
C69 G1_3 VSUBS 3.32544f
C70 G0_3 VSUBS 3.32544f
C71 B VSUBS 0.369011p
C72 a_3229_n8283# VSUBS 1.63025f
C73 a_3229_n4118# VSUBS 1.62405f
C74 a_3229_47# VSUBS 1.62405f
C75 a_3229_4212# VSUBS 1.6295f
.ends

.subckt sky130_fd_pr__nfet_g5v0d10v5_F3NX3J B D S G
X0 S G D B sky130_fd_pr__nfet_g5v0d10v5 ad=0.1218 pd=1.42 as=0.1218 ps=1.42 w=0.42 l=4
C0 G S 0.023116f
C1 D S 0.007122f
C2 D G 0.023116f
C3 S B 0.083121f
C4 D B 0.083121f
C5 G B 1.85725f
.ends

.subckt sky130_fd_pr__nfet_05v0_nvt_6T4HWX B D0 S0 G0 D1 S1 G1
X0 S1 G1 D1 B sky130_fd_pr__nfet_05v0_nvt ad=0.29 pd=2.58 as=0.29 ps=2.58 w=1 l=25
X1 S0 G0 D0 B sky130_fd_pr__nfet_05v0_nvt ad=0.29 pd=2.58 as=0.29 ps=2.58 w=1 l=25
C0 G0 S0 0.049339f
C1 G0 D0 0.049339f
C2 G1 S1 0.049339f
C3 D1 G1 0.049339f
C4 G0 G1 3.42782f
C5 S0 S1 0.014895f
C6 D1 D0 0.014895f
C7 S0 B 0.157719f
C8 D0 B 0.157719f
C9 G0 B 8.145109f
C10 S1 B 0.156139f
C11 D1 B 0.156139f
C12 G1 B 8.90423f
.ends

.subckt sky130_fd_pr__pfet_g5v0d10v5_5EJAKB B D S G VSUBS
X0 S G D B sky130_fd_pr__pfet_g5v0d10v5 ad=0.2436 pd=2.26 as=0.2436 ps=2.26 w=0.84 l=4
C0 B D 0.073044f
C1 G D 0.039028f
C2 G B 0.982043f
C3 S D 0.013979f
C4 S B 0.073044f
C5 S G 0.039028f
C6 S VSUBS 0.061032f
C7 D VSUBS 0.061032f
C8 G VSUBS 0.873669f
C9 B VSUBS 3.60478f
.ends

.subckt ldo_top vin vout rstn gnd
Xbgr_MPO vin bgr_MPO/D3 vin bgr_MS2/D bgr_MPO/D3 vin bgr_MS2/D bgr_MPO/D3 vin bgr_MS2/D
+ bgr_MPO/D3 vin bgr_MS2/D gnd sky130_fd_pr__pfet_g5v0d10v5_UFECYT
Xbgr_MT0 gnd bgr_R2/R1 bgr_MT1/D gnd sky130_fd_pr__nfet_g5v0d10v5_3LMSA7
Xbgr_MPCC vin bgr_MNCD/G bgr_MS2/D bgr_MNCD/G bgr_MS2/D bgr_MNCD/G bgr_MS2/D bgr_MNCD/G
+ bgr_MS2/D bgr_MPC/D3 bgr_MS2/D bgr_MPC/D3 bgr_MS2/D bgr_MPC/D3 bgr_MS2/D bgr_MPC/D3
+ bgr_MS2/D bgr_MNCD/G bgr_MS2/D bgr_MNCD/G bgr_MS2/D bgr_MNCD/G bgr_MS2/D bgr_MNCD/G
+ bgr_MS2/D bgr_MPC/D3 bgr_MS2/D bgr_MPC/D3 bgr_MS2/D bgr_MPC/D3 bgr_MS2/D bgr_MPC/D3
+ bgr_MS2/D bgr_MNCD/G bgr_MNCD/G bgr_MNCD/G bgr_MNCD/G gnd sky130_fd_pr__pfet_g5v0d10v5_TGGT4A
Xbgr_MT1 gnd bgr_MT1/D bgr_MT2/D gnd sky130_fd_pr__nfet_g5v0d10v5_3LMSA7
Xbgr_MPBC vin bgr_MNB/G5 bgr_MS2/D bgr_MNB/G5 bgr_MS2/D bgr_MNB/G5 bgr_MS2/D bgr_MNB/G5
+ bgr_MS2/D bgr_MPB/D3 bgr_MS2/D bgr_MPB/D3 bgr_MS2/D bgr_MPB/D3 bgr_MS2/D bgr_MPB/D3
+ bgr_MS2/D bgr_MNB/G5 bgr_MS2/D bgr_MNB/G5 bgr_MS2/D bgr_MNB/G5 bgr_MS2/D bgr_MNB/G5
+ bgr_MS2/D bgr_MPB/D3 bgr_MS2/D bgr_MPB/D3 bgr_MS2/D bgr_MPB/D3 bgr_MS2/D bgr_MPB/D3
+ bgr_MS2/D bgr_MNB/G5 bgr_MNB/G5 bgr_MNB/G5 bgr_MNB/G5 gnd sky130_fd_pr__pfet_g5v0d10v5_TGGT4A
Xpor_MD gnd por_MD/D gnd por_MD/G sky130_fd_pr__nfet_g5v0d10v5_C8EBTW
Xbgr_MT2 gnd bgr_MT2/D bgr_MT3/D gnd sky130_fd_pr__nfet_g5v0d10v5_3LMSA7
Xbgr_MPAC vin bgr_MNF/G5 bgr_MS2/D bgr_MNF/G5 bgr_MS2/D bgr_MNF/G5 bgr_MS2/D bgr_MNF/G5
+ bgr_MS2/D bgr_MPA/D3 bgr_MS2/D bgr_MPA/D3 bgr_MS2/D bgr_MPA/D3 bgr_MS2/D bgr_MPA/D3
+ bgr_MS2/D bgr_MNF/G5 bgr_MS2/D bgr_MNF/G5 bgr_MS2/D bgr_MNF/G5 bgr_MS2/D bgr_MNF/G5
+ bgr_MS2/D bgr_MPA/D3 bgr_MS2/D bgr_MPA/D3 bgr_MS2/D bgr_MPA/D3 bgr_MS2/D bgr_MPA/D3
+ bgr_MS2/D bgr_MNF/G5 bgr_MNF/G5 bgr_MNF/G5 bgr_MNF/G5 gnd sky130_fd_pr__pfet_g5v0d10v5_TGGT4A
Xbgr_MT3 gnd bgr_MT3/D bgr_MT4/D gnd sky130_fd_pr__nfet_g5v0d10v5_3LMSA7
Xbgr_MS2 gnd bgr_MS2/D gnd bgr_MSN/D sky130_fd_pr__nfet_g5v0d10v5_62W55W
Xbgr_Cvr0 gnd ldo_MN2/G gnd sky130_fd_pr__cap_mim_m3_1_BTY6QK
Xldo_Cff_0 ldo_MNX/S2 vin gnd sky130_fd_pr__cap_mim_m3_1_V8HUNN
Xldo_MNA gnd ldo_MPS/D gnd ldo_MPS/D sky130_fd_pr__nfet_g5v0d10v5_NUFNY9
Xbgr_MT4 gnd bgr_MT4/D bgr_MT4/S vin sky130_fd_pr__nfet_g5v0d10v5_3LMSA7
Xbgr_MNCD gnd bgr_MNCD/G bgr_MNCD/S bgr_MNCD/G sky130_fd_pr__nfet_05v0_nvt_F4CC77
Xbgr_MNBC gnd bgr_MNF/G5 bgr_MNCD/G bgr_MNB/D4 bgr_MNCD/G bgr_MNF/G5 bgr_MNCD/G bgr_MNB/D4
+ bgr_MNCD/G bgr_MNF/G5 bgr_MNCD/G bgr_MNB/D4 bgr_MNCD/G bgr_MNF/G5 sky130_fd_pr__nfet_05v0_nvt_ASWYB8
Xbgr_Cvr1 gnd ldo_MN2/G gnd sky130_fd_pr__cap_mim_m3_1_BTY6QK
Xldo_Cff_1 ldo_MNX/S2 vin gnd sky130_fd_pr__cap_mim_m3_1_V8HUNN
Xldo_MNB gnd ldo_MNB/G gnd ldo_MNB/G sky130_fd_pr__nfet_g5v0d10v5_BE4NYT
Xbgr_R1 gnd bgr_R1/R1 bgr_R1/R2 sky130_fd_pr__res_xhigh_po_0p35_5J6MKL
Xpor_MH gnd por_MH/D gnd por_MH/G sky130_fd_pr__nfet_g5v0d10v5_A8HTHF
Xbgr_Cvr2 gnd ldo_MN2/G gnd sky130_fd_pr__cap_mim_m3_1_BTY6QK
Xldo_Cff_2 ldo_MNX/S2 vin gnd sky130_fd_pr__cap_mim_m3_1_V8HUNN
Xldo_MNBL gnd vout ldo_MNB/G gnd ldo_MNB/G vout ldo_MNB/G gnd ldo_MNB/G vout ldo_MNB/G
+ gnd ldo_MNB/G vout ldo_MNB/G gnd ldo_MNB/G vout ldo_MNB/G gnd ldo_MNB/G vout ldo_MNB/G
+ gnd ldo_MNB/G vout ldo_MNB/G gnd ldo_MNB/G vout ldo_MNB/G gnd ldo_MNB/G vout ldo_MNB/G
+ gnd ldo_MNB/G vout ldo_MNB/G gnd ldo_MNB/G vout sky130_fd_pr__nfet_g5v0d10v5_YQMGE2
Xbgr_R2 gnd bgr_R2/R1 bgr_Rf/R2 sky130_fd_pr__res_xhigh_po_0p35_PL9RNS
Xbgr_Q1 bgr_MNA/S5 gnd gnd sky130_fd_pr__rf_pnp_05v5_W3p40L3p40 m=1
Xbgr_Cvr3 gnd ldo_MN2/G gnd sky130_fd_pr__cap_mim_m3_1_BTY6QK
Xldo_Cff_3 ldo_MNX/S2 vin gnd sky130_fd_pr__cap_mim_m3_1_V8HUNN
Xbgr_Q3 bgr_MT4/S gnd gnd sky130_fd_pr__rf_pnp_05v5_W3p40L3p40 m=1
Xbgr_RT0 gnd bgr_MT1/D bgr_R2/R1 sky130_fd_pr__res_xhigh_po_0p35_R4U9XH
Xbgr_Q5 bgr_MNCD/S gnd gnd sky130_fd_pr__rf_pnp_05v5_W3p40L3p40 m=1
Xbgr_RT1 gnd bgr_MT2/D bgr_MT1/D sky130_fd_pr__res_xhigh_po_0p35_XV4KRP
Xldo_Cbp gnd ldo_Rsh/R1 gnd sky130_fd_pr__cap_mim_m3_1_84Z4WG
Xbgr_RT2 gnd bgr_MT3/D bgr_MT2/D sky130_fd_pr__res_xhigh_po_0p35_4E3LTY
Xbgr_Q7 bgr_MSN/S gnd gnd sky130_fd_pr__rf_pnp_05v5_W3p40L3p40 m=1
Xbgr_MSU0 vin bgr_MSU1/S vin bgr_MSU1/S gnd sky130_fd_pr__pfet_g5v0d10v5_32MMT9
Xldo_MPB2 vin ldo_Rsh/R2 vin ldo_Rsh/R2 gnd sky130_fd_pr__pfet_g5v0d10v5_MN82PF
Xbgr_RT3 gnd bgr_MT4/D bgr_MT3/D sky130_fd_pr__res_xhigh_po_0p35_VEZ8JB
Xbgr_RT4 gnd bgr_MT4/S bgr_MT4/D sky130_fd_pr__res_xhigh_po_0p35_HGUK4G
Xbgr_Q2_0 bgr_R1/R1 gnd gnd sky130_fd_pr__rf_pnp_05v5_W3p40L3p40 m=1
Xbgr_Q8 bgr_MNSK/S1 gnd gnd sky130_fd_pr__rf_pnp_05v5_W3p40L3p40 m=1
Xpor_R1 gnd por_MD/G vin sky130_fd_pr__res_xhigh_po_0p35_YNY9WN
Xbgr_MSU1 vin bgr_MSU2/S bgr_MSU1/S bgr_MSU2/S gnd sky130_fd_pr__pfet_g5v0d10v5_32MMT9
Xbgr_Q2_1 bgr_R1/R1 gnd gnd sky130_fd_pr__rf_pnp_05v5_W3p40L3p40 m=1
Xpor_R2 gnd por_MH/D por_MD/G sky130_fd_pr__res_xhigh_po_0p35_8Z5M7R
Xbgr_MSU3 vin bgr_MSN/D bgr_MSU3/S bgr_MSN/D gnd sky130_fd_pr__pfet_g5v0d10v5_32MMT9
Xbgr_MSU2 vin bgr_MSU3/S bgr_MSU2/S bgr_MSU3/S gnd sky130_fd_pr__pfet_g5v0d10v5_32MMT9
Xbgr_Q2_2 bgr_R1/R1 gnd gnd sky130_fd_pr__rf_pnp_05v5_W3p40L3p40 m=1
Xpor_R3 gnd gnd por_MH/D sky130_fd_pr__res_xhigh_po_0p35_KAXJA5
Xpor_Rpu gnd por_MD/D vin sky130_fd_pr__res_xhigh_po_0p35_NT9K52
Xldo_MNA2 gnd ldo_MN2/S gnd ldo_MPS/D sky130_fd_pr__nfet_g5v0d10v5_NUFNY9
Xldo_MNB3 gnd ldo_Rsh/R1 gnd ldo_MNB/G sky130_fd_pr__nfet_g5v0d10v5_BE4NYT
Xldo_Rsh gnd ldo_Rsh/R1 ldo_Rsh/R2 sky130_fd_pr__res_xhigh_po_0p35_J82YCH
Xbgr_Q2_3 bgr_R1/R1 gnd gnd sky130_fd_pr__rf_pnp_05v5_W3p40L3p40 m=1
Xldo_MPP vin vout ldo_MPS/G vin ldo_MPS/G vout ldo_MPS/G vin ldo_MPS/G vout ldo_MPS/G
+ vin ldo_MPS/G vout ldo_MPS/G vin ldo_MPS/G vout ldo_MPS/G vin ldo_MPS/G vout ldo_MPS/G
+ vin ldo_MPS/G vout ldo_MPS/G vin ldo_MPS/G vout ldo_MPS/G vin ldo_MPS/G vout ldo_MPS/G
+ vin ldo_MPS/G vout ldo_MPS/G vin ldo_MPS/G vout ldo_MPS/G vin ldo_MPS/G vout ldo_MPS/G
+ vin ldo_MPS/G vout ldo_MPS/G vin ldo_MPS/G vout ldo_MPS/G vin ldo_MPS/G vout ldo_MPS/G
+ vin ldo_MPS/G vout ldo_MPS/G vin ldo_MPS/G vout ldo_MPS/G vin ldo_MPS/G vout ldo_MPS/G
+ vin ldo_MPS/G vout ldo_MPS/G vin ldo_MPS/G vout ldo_MPS/G vin ldo_MPS/G vout gnd
+ sky130_fd_pr__pfet_g5v0d10v5_PSYF8E
Xbgr_Q2_5 bgr_R1/R1 gnd gnd sky130_fd_pr__rf_pnp_05v5_W3p40L3p40 m=1
Xbgr_Q2_4 bgr_R1/R1 gnd gnd sky130_fd_pr__rf_pnp_05v5_W3p40L3p40 m=1
Xbgr_Q2_6 bgr_R1/R1 gnd gnd sky130_fd_pr__rf_pnp_05v5_W3p40L3p40 m=1
Xldo_MPS vin ldo_MPS/D vin ldo_MPS/G gnd sky130_fd_pr__pfet_g5v0d10v5_7B62CL
Xbgr_Q2_7 bgr_R1/R1 gnd gnd sky130_fd_pr__rf_pnp_05v5_W3p40L3p40 m=1
Xldo_MPT vin ldo_MPX/S2 vin ldo_Rsh/R2 ldo_MPX/S2 vin ldo_Rsh/R2 ldo_MPX/S2 vin ldo_Rsh/R2
+ gnd sky130_fd_pr__pfet_g5v0d10v5_PN8J4Z
Xbgr_MPA vin bgr_MPA/D3 vin bgr_MS2/D bgr_MPA/D3 vin bgr_MS2/D bgr_MPA/D3 vin bgr_MS2/D
+ bgr_MPA/D3 vin bgr_MS2/D gnd sky130_fd_pr__pfet_g5v0d10v5_UFECYT
Xldo_MNS gnd ldo_MNX/S2 gnd ldo_MNB/G ldo_MNX/S2 gnd ldo_MNB/G ldo_MNX/S2 gnd ldo_MNB/G
+ sky130_fd_pr__nfet_g5v0d10v5_3UQFYT
Xbgr_Rf gnd ldo_MN2/G bgr_Rf/R2 sky130_fd_pr__res_xhigh_po_0p35_ADWJQG
Xbgr_MPC vin bgr_MPC/D3 vin bgr_MS2/D bgr_MPC/D3 vin bgr_MS2/D bgr_MPC/D3 vin bgr_MS2/D
+ bgr_MPC/D3 vin bgr_MS2/D gnd sky130_fd_pr__pfet_g5v0d10v5_UFECYT
Xbgr_MPB vin bgr_MPB/D3 vin bgr_MS2/D bgr_MPB/D3 vin bgr_MS2/D bgr_MPB/D3 vin bgr_MS2/D
+ bgr_MPB/D3 vin bgr_MS2/D gnd sky130_fd_pr__pfet_g5v0d10v5_UFECYT
Xbgr_MNA gnd bgr_MNB/G5 bgr_MNB/G5 bgr_MNA/S5 bgr_MNB/G5 bgr_MNB/G5 bgr_MNB/G5 bgr_MNA/S5
+ bgr_MNB/G5 bgr_MNB/G5 bgr_MNB/G5 bgr_MNA/S5 bgr_MNB/G5 bgr_MNB/G5 sky130_fd_pr__nfet_05v0_nvt_ASWYB8
Xbgr_MPOC vin bgr_Rf/R2 bgr_MS2/D bgr_Rf/R2 bgr_MS2/D bgr_Rf/R2 bgr_MS2/D bgr_Rf/R2
+ bgr_MS2/D bgr_MPO/D3 bgr_MS2/D bgr_MPO/D3 bgr_MS2/D bgr_MPO/D3 bgr_MS2/D bgr_MPO/D3
+ bgr_MS2/D bgr_Rf/R2 bgr_MS2/D bgr_Rf/R2 bgr_MS2/D bgr_Rf/R2 bgr_MS2/D bgr_Rf/R2
+ bgr_MS2/D bgr_MPO/D3 bgr_MS2/D bgr_MPO/D3 bgr_MS2/D bgr_MPO/D3 bgr_MS2/D bgr_MPO/D3
+ bgr_MS2/D bgr_Rf/R2 bgr_Rf/R2 bgr_Rf/R2 bgr_Rf/R2 gnd sky130_fd_pr__pfet_g5v0d10v5_TGGT4A
Xbgr_MNB gnd bgr_MNB/D4 bgr_MNB/G5 bgr_R1/R2 bgr_MNB/G5 bgr_MNB/D4 bgr_MNB/G5 bgr_R1/R2
+ bgr_MNB/G5 bgr_MNB/D4 bgr_MNB/G5 bgr_R1/R2 bgr_MNB/G5 bgr_MNB/D4 sky130_fd_pr__nfet_05v0_nvt_ASWYB8
Xldo_Cfp_0 ldo_MPX/S2 vout gnd sky130_fd_pr__cap_mim_m3_1_Y3HN7X
Xldo_MN1 gnd ldo_MP4/G ldo_MN2/S vout sky130_fd_pr__nfet_g5v0d10v5_WMYWGM
Xldo_MP3 vin ldo_MP4/G vin ldo_MP4/G gnd sky130_fd_pr__pfet_g5v0d10v5_DNGK98
Xldo_Cfp_1 ldo_MPX/S2 vout gnd sky130_fd_pr__cap_mim_m3_1_Y3HN7X
Xldo_MN2 gnd ldo_MPS/G ldo_MN2/S ldo_MN2/G sky130_fd_pr__nfet_g5v0d10v5_WMYWGM
Xldo_MPX vin ldo_MPS/G ldo_MPX/S2 ldo_Rsh/R1 ldo_MPS/G ldo_MPX/S2 ldo_Rsh/R1 ldo_MPS/G
+ ldo_MPX/S2 ldo_Rsh/R1 gnd sky130_fd_pr__pfet_g5v0d10v5_PN8J4Z
Xldo_MP4 vin ldo_MPS/G vin ldo_MP4/G gnd sky130_fd_pr__pfet_g5v0d10v5_DNGK98
Xldo_Cfp_2 ldo_MPX/S2 vout gnd sky130_fd_pr__cap_mim_m3_1_Y3HN7X
Xldo_MNX gnd ldo_MPS/G ldo_MN2/G ldo_MNX/S2 ldo_MN2/G ldo_MPS/G ldo_MNX/S2 ldo_MN2/G
+ sky130_fd_pr__nfet_g5v0d10v5_DDWFWJ
Xpor_MI3N gnd rstn gnd por_MH/G sky130_fd_pr__nfet_g5v0d10v5_FZ2B7C
Xldo_Cfn_0 ldo_MNX/S2 vout gnd sky130_fd_pr__cap_mim_m3_1_Y3HN7X
Xldo_Cfp_3 ldo_MPX/S2 vout gnd sky130_fd_pr__cap_mim_m3_1_Y3HN7X
Xldo_Cc vout ldo_MPS/G gnd sky130_fd_pr__cap_mim_m3_1_PP9XRG
Xldo_MN5 gnd ldo_MN2/S gnd ldo_MNB/G ldo_MN2/S gnd ldo_MNB/G ldo_MN2/S gnd ldo_MNB/G
+ ldo_MN2/S gnd ldo_MNB/G sky130_fd_pr__nfet_g5v0d10v5_HA9V6X
Xbgr_MNF gnd vin bgr_MNF/G5 bgr_MS2/D bgr_MNF/G5 vin bgr_MNF/G5 bgr_MS2/D bgr_MNF/G5
+ vin bgr_MNF/G5 bgr_MS2/D bgr_MNF/G5 vin sky130_fd_pr__nfet_05v0_nvt_ASWYB8
Xpor_MI2N gnd por_MH/G gnd por_MI2P/G sky130_fd_pr__nfet_g5v0d10v5_FZ2B7C
Xldo_Cfn_1 ldo_MNX/S2 vout gnd sky130_fd_pr__cap_mim_m3_1_Y3HN7X
Xbgr_MPIC vin ldo_MNB/G bgr_MS2/D ldo_MNB/G bgr_MS2/D ldo_MNB/G bgr_MS2/D ldo_MNB/G
+ bgr_MS2/D bgr_MPI/D0_3 bgr_MS2/D bgr_MPI/D0_3 bgr_MS2/D bgr_MPI/D0_3 bgr_MS2/D bgr_MPI/D0_3
+ bgr_MS2/D ldo_MNB/G bgr_MS2/D ldo_MNB/G bgr_MS2/D ldo_MNB/G bgr_MS2/D ldo_MNB/G
+ bgr_MS2/D bgr_MPI/D0_3 bgr_MS2/D bgr_MPI/D0_3 bgr_MS2/D bgr_MPI/D0_3 bgr_MS2/D bgr_MPI/D0_3
+ bgr_MS2/D ldo_MNB/G bgr_MS2/D ldo_MNB/G bgr_MS2/D ldo_MNB/G bgr_MS2/D ldo_MNB/G
+ bgr_MS2/D bgr_MPI/D0_3 bgr_MS2/D bgr_MPI/D0_3 bgr_MS2/D bgr_MPI/D0_3 bgr_MS2/D bgr_MPI/D0_3
+ bgr_MS2/D ldo_MNB/G bgr_MS2/D ldo_MNB/G bgr_MS2/D ldo_MNB/G bgr_MS2/D ldo_MNB/G
+ bgr_MS2/D bgr_MPI/D0_3 bgr_MS2/D bgr_MPI/D0_3 bgr_MS2/D bgr_MPI/D0_3 bgr_MS2/D bgr_MPI/D0_3
+ bgr_MS2/D ldo_MNB/G ldo_MNB/G ldo_MNB/G ldo_MNB/G gnd sky130_fd_pr__pfet_g5v0d10v5_KMGDV8
Xbgr_MPI vin bgr_MPI/D0_3 bgr_MS2/D bgr_MPI/D0_3 bgr_MS2/D bgr_MPI/D0_3 bgr_MS2/D
+ bgr_MPI/D0_3 bgr_MS2/D vin bgr_MS2/D vin bgr_MS2/D vin bgr_MS2/D vin bgr_MS2/D bgr_MPI/D0_3
+ bgr_MPI/D0_3 bgr_MPI/D0_3 bgr_MPI/D0_3 gnd sky130_fd_pr__pfet_g5v0d10v5_UFWJXT
Xpor_MI1N gnd por_MI2P/G gnd por_MD/D sky130_fd_pr__nfet_g5v0d10v5_F3NX3J
Xpor_MI3P vout rstn vout por_MH/G gnd sky130_fd_pr__pfet_g5v0d10v5_7B62CL
Xldo_Cfn_2 ldo_MNX/S2 vout gnd sky130_fd_pr__cap_mim_m3_1_Y3HN7X
Xpor_MI2P vin por_MH/G vin por_MI2P/G gnd sky130_fd_pr__pfet_g5v0d10v5_7B62CL
Xldo_Cfn_3 ldo_MNX/S2 vout gnd sky130_fd_pr__cap_mim_m3_1_Y3HN7X
Xbgr_MNSK gnd bgr_MS2/D bgr_MNSK/S1 bgr_MNB/G5 bgr_MS2/D bgr_MNSK/S1 bgr_MNB/G5 sky130_fd_pr__nfet_05v0_nvt_6T4HWX
Xbgr_MSN gnd bgr_MSN/D bgr_MSN/S bgr_Rf/R2 sky130_fd_pr__nfet_g5v0d10v5_NUFNY9
Xpor_MI1P vin por_MI2P/G vin por_MD/D gnd sky130_fd_pr__pfet_g5v0d10v5_5EJAKB
C0 bgr_MPB/D3 bgr_R2/R1 3.33e-19
C1 bgr_MNCD/S ldo_MPX/S2 0.156689f
C2 ldo_MN2/G bgr_MSU2/S 0.161556f
C3 ldo_Rsh/R1 vout 4.750213f
C4 bgr_MT3/D bgr_MT4/D 70.84414f
C5 bgr_MNCD/G bgr_MPC/D3 5.536631f
C6 bgr_R2/R1 bgr_R1/R2 0.097741f
C7 ldo_Rsh/R1 vin 10.819161f
C8 ldo_MN2/G bgr_MT4/S 0.309936f
C9 bgr_MPC/D3 bgr_MT3/D 0.064096f
C10 bgr_MNCD/G bgr_MPI/D0_3 2.85676f
C11 ldo_MPS/G ldo_MNX/S2 17.956303f
C12 bgr_R1/R1 ldo_MPX/S2 0.17325f
C13 ldo_MPS/G bgr_MSU1/S 0.217752f
C14 bgr_MNCD/S vout 0.750172f
C15 ldo_MN2/S ldo_Rsh/R1 9.277821f
C16 ldo_Rsh/R1 por_MH/D 4.4e-19
C17 bgr_MT3/D bgr_MPI/D0_3 0.064454f
C18 bgr_R1/R1 bgr_MPO/D3 0.278236f
C19 bgr_MNCD/S vin 0.752846f
C20 bgr_MS2/D bgr_MT2/D 2.27696f
C21 ldo_MNB/G bgr_MT1/D 0.545236f
C22 rstn bgr_MT4/D 0.147175f
C23 bgr_MNB/D4 bgr_Rf/R2 0.815622f
C24 bgr_MS2/D bgr_Rf/R2 20.40193f
C25 bgr_MNCD/G bgr_MNB/G5 13.984f
C26 bgr_R1/R2 bgr_MNSK/S1 0.123392f
C27 por_MH/G por_MD/G 0.171293f
C28 bgr_MNSK/S1 bgr_MSN/S 15.240364f
C29 bgr_MNF/G5 bgr_MNB/D4 0.320789f
C30 bgr_MS2/D bgr_MNF/G5 48.94292f
C31 bgr_MPB/D3 ldo_MNB/G 0.073588f
C32 bgr_R2/R1 bgr_MT4/S 0.292832f
C33 bgr_R1/R1 vout 0.858173f
C34 ldo_MPX/S2 bgr_MNA/S5 0.156689f
C35 bgr_MT3/D bgr_MNB/G5 0.064573f
C36 bgr_MPC/D3 rstn 0.073588f
C37 ldo_MPX/S2 ldo_MP4/G 0.219886f
C38 bgr_R1/R2 ldo_MNB/G 0.51713f
C39 ldo_Rsh/R2 ldo_MNB/G 0.268292f
C40 bgr_R1/R1 vin 2.749615f
C41 por_MD/D rstn 29.716444f
C42 ldo_Rsh/R1 bgr_MT2/D 0.128192f
C43 ldo_Rsh/R1 bgr_Rf/R2 0.144578f
C44 rstn bgr_MPI/D0_3 0.073588f
C45 ldo_MN2/G bgr_MSN/D 0.317321f
C46 ldo_Rsh/R1 bgr_MNF/G5 0.217817f
C47 vout bgr_MNA/S5 0.750172f
C48 por_MI2P/G por_MD/G 27.380116f
C49 bgr_MT4/S bgr_MNSK/S1 0.078021f
C50 vout ldo_MP4/G 2.821965f
C51 bgr_MS2/D bgr_MPA/D3 26.771738f
C52 rstn bgr_MNB/G5 0.458519f
C53 vin bgr_MNA/S5 0.758179f
C54 ldo_MNX/S2 bgr_MT4/D 0.157726f
C55 bgr_MNCD/S bgr_Rf/R2 2.556171f
C56 vin ldo_MP4/G 7.638774f
C57 bgr_MNCD/S bgr_MNF/G5 0.531319f
C58 bgr_MT4/S ldo_MNB/G 0.544884f
C59 bgr_MSU3/S por_MH/G 0.185902f
C60 ldo_MPX/S2 por_MH/G 2.72e-19
C61 ldo_MN2/G bgr_MNCD/G 0.529898f
C62 ldo_MNX/S2 bgr_MPC/D3 0.078863f
C63 ldo_MN2/G ldo_MPS/D 0.074097f
C64 ldo_MN2/S ldo_MP4/G 2.970858f
C65 ldo_MN2/G bgr_MT3/D 0.225823f
C66 ldo_Rsh/R1 bgr_MPA/D3 0.341582f
C67 bgr_R1/R1 bgr_MT2/D 0.080569f
C68 bgr_R1/R1 bgr_Rf/R2 0.56672f
C69 ldo_MNX/S2 bgr_MPI/D0_3 0.078863f
C70 por_MD/D bgr_MSU1/S 0.066851f
C71 bgr_MSU2/S por_MD/G 0.18376f
C72 bgr_R1/R1 bgr_MNF/G5 0.356933f
C73 por_MH/G vout 0.876945f
C74 bgr_R2/R1 bgr_MNCD/G 4.20091f
C75 ldo_MPX/S2 bgr_MT1/D 0.140303f
C76 bgr_MS2/D bgr_MNB/D4 0.320025f
C77 bgr_MSU3/S por_MI2P/G 0.184003f
C78 ldo_MPX/S2 por_MI2P/G 3.75e-19
C79 por_MH/G vin 11.354483f
C80 ldo_MNX/S2 bgr_MNB/G5 0.484348f
C81 bgr_MPB/D3 ldo_MPX/S2 0.070151f
C82 bgr_R2/R1 bgr_MT3/D 0.163199f
C83 ldo_MPS/G bgr_MT4/D 0.128192f
C84 bgr_MNA/S5 bgr_Rf/R2 0.176611f
C85 bgr_MPO/D3 bgr_MT1/D 0.074065f
C86 ldo_MN2/G rstn 0.071988f
C87 bgr_MNF/G5 bgr_MNA/S5 0.1749f
C88 ldo_MPX/S2 bgr_R1/R2 0.156689f
C89 ldo_MPX/S2 bgr_MSN/S 0.140303f
C90 bgr_MPB/D3 bgr_MPO/D3 0.002248f
C91 ldo_MPX/S2 ldo_Rsh/R2 0.901159f
C92 ldo_MPS/G bgr_MPC/D3 0.064096f
C93 por_MH/G por_MH/D 0.163197f
C94 vout bgr_MT1/D 1.04032f
C95 bgr_R1/R1 bgr_MPA/D3 0.283717f
C96 ldo_Rsh/R1 bgr_MNB/D4 0.128192f
C97 bgr_R1/R2 bgr_MPO/D3 0.283749f
C98 bgr_MS2/D ldo_Rsh/R1 0.273289f
C99 bgr_MNCD/G bgr_MNSK/S1 0.073588f
C100 por_MI2P/G vout 0.797784f
C101 ldo_MPS/G por_MD/D 0.012855f
C102 bgr_MPB/D3 vout 0.321651f
C103 ldo_MPS/G bgr_MPI/D0_3 0.064096f
C104 bgr_MT1/D vin 2.416066f
C105 bgr_MSU3/S bgr_MSU2/S 24.599802f
C106 ldo_MPX/S2 bgr_MSU2/S 0.140303f
C107 por_MI2P/G vin 5.327387f
C108 bgr_R2/R1 rstn 0.073588f
C109 bgr_R1/R2 vout 0.750172f
C110 vout bgr_MSN/S 0.643301f
C111 bgr_MPB/D3 vin 2.083989f
C112 ldo_Rsh/R2 vout 2.284792f
C113 bgr_MNCD/G ldo_MNB/G 0.584735f
C114 bgr_MSN/D por_MD/G 1.95887f
C115 ldo_MNB/G ldo_MPS/D 0.188761f
C116 bgr_MNCD/S bgr_MNB/D4 0.380067f
C117 bgr_MNCD/S bgr_MS2/D 0.155331f
C118 bgr_R1/R2 vin 1.913846f
C119 ldo_MPX/S2 bgr_MT4/S 0.226927f
C120 ldo_MPS/G bgr_MNB/G5 0.449329f
C121 vin bgr_MSN/S 0.645795f
C122 bgr_MT3/D ldo_MNB/G 0.545236f
C123 ldo_Rsh/R2 vin 8.924252f
C124 bgr_MPA/D3 ldo_MP4/G 0.265241f
C125 ldo_MNX/S2 ldo_MN2/G 1.131655f
C126 por_MH/D por_MI2P/G 22.993824f
C127 ldo_MN2/G bgr_MSU1/S 0.217649f
C128 bgr_MT4/S bgr_MPO/D3 0.231005f
C129 vout bgr_MSU2/S 0.64499f
C130 ldo_MN2/S ldo_Rsh/R2 0.245391f
C131 rstn bgr_MNSK/S1 0.0738f
C132 bgr_MSU2/S vin 4.92441f
C133 bgr_MS2/D bgr_R1/R1 1.508401f
C134 bgr_MNCD/S ldo_Rsh/R1 0.144578f
C135 bgr_MT4/S vout 12.5227f
C136 ldo_MNB/G rstn 3.35006f
C137 bgr_MT2/D bgr_MT1/D 72.13539f
C138 bgr_MT1/D bgr_Rf/R2 0.400078f
C139 bgr_MPC/D3 bgr_MT4/D 0.071973f
C140 ldo_MNX/S2 bgr_R2/R1 0.078863f
C141 bgr_MT4/S vin 2.588655f
C142 bgr_MNF/G5 bgr_MT1/D 0.075622f
C143 por_MH/D bgr_MSU2/S 2.84e-19
C144 bgr_MPB/D3 bgr_MT2/D 0.064096f
C145 ldo_Rsh/R1 bgr_R1/R1 0.161139f
C146 bgr_MPB/D3 bgr_MNF/G5 1.976841f
C147 bgr_MS2/D bgr_MNA/S5 5.75221f
C148 bgr_MPI/D0_3 bgr_MT4/D 0.071973f
C149 bgr_MSU3/S bgr_MSN/D 2.998732f
C150 ldo_MPX/S2 bgr_MSN/D 0.312539f
C151 bgr_MS2/D ldo_MP4/G 4.594201f
C152 bgr_R1/R2 bgr_MT2/D 0.064096f
C153 bgr_R1/R2 bgr_Rf/R2 0.572627f
C154 bgr_Rf/R2 bgr_MSN/S 0.157968f
C155 bgr_R1/R2 bgr_MNF/G5 0.341358f
C156 bgr_MNF/G5 bgr_MSN/S 0.456908f
C157 ldo_MPS/G ldo_MN2/G 3.855996f
C158 bgr_MPC/D3 bgr_MPI/D0_3 17.0151f
C159 bgr_MNB/G5 bgr_MT4/D 0.072299f
C160 ldo_MNX/S2 bgr_MNSK/S1 0.078863f
C161 rstn por_MD/G 0.152966f
C162 bgr_MNCD/S bgr_R1/R1 0.1176f
C163 ldo_Rsh/R1 bgr_MNA/S5 0.144578f
C164 ldo_Rsh/R1 ldo_MP4/G 0.316976f
C165 bgr_MSN/D vout 1.45366f
C166 bgr_MPA/D3 bgr_MT1/D 0.073588f
C167 bgr_MNCD/G ldo_MPX/S2 0.219596f
C168 bgr_MPC/D3 bgr_MNB/G5 0.25023f
C169 ldo_MNX/S2 ldo_MNB/G 0.633536f
C170 bgr_MPB/D3 bgr_MPA/D3 4.92594f
C171 ldo_MPS/G bgr_R2/R1 0.064096f
C172 ldo_MPX/S2 ldo_MPS/D 0.157226f
C173 bgr_MSN/D vin 11.66764f
C174 bgr_MT4/S bgr_MT2/D 0.457355f
C175 ldo_MPX/S2 bgr_MT3/D 0.140303f
C176 bgr_MNCD/G bgr_MPO/D3 10.8904f
C177 bgr_MT4/S bgr_Rf/R2 0.492119f
C178 bgr_MT4/S bgr_MNF/G5 0.293187f
C179 bgr_MPI/D0_3 bgr_MNB/G5 0.237991f
C180 bgr_MPA/D3 bgr_R1/R2 5.32107f
C181 bgr_MPA/D3 ldo_Rsh/R2 0.277518f
C182 bgr_MNCD/S bgr_MNA/S5 0.023704f
C183 bgr_MT3/D bgr_MPO/D3 0.064332f
C184 bgr_MSN/D por_MH/D 8.66e-20
C185 bgr_MNCD/G vout 1.025319f
C186 vout ldo_MPS/D 3.03296f
C187 bgr_MT3/D vout 0.645522f
C188 bgr_MNCD/G vin 6.098502f
C189 ldo_Rsh/R1 por_MH/G 3.75e-19
C190 ldo_MNX/S2 por_MD/G 3.75e-19
C191 ldo_MPS/G bgr_MNSK/S1 0.0738f
C192 bgr_R1/R1 bgr_MNA/S5 0.137737f
C193 bgr_MSU1/S por_MD/G 0.076607f
C194 ldo_MN2/G bgr_MT4/D 0.225823f
C195 bgr_MSU3/S rstn 0.137896f
C196 ldo_MPX/S2 rstn 0.073588f
C197 vin ldo_MPS/D 15.2238f
C198 bgr_MS2/D bgr_MT1/D 22.4843f
C199 bgr_MT3/D vin 2.092286f
C200 bgr_MPA/D3 bgr_MT4/S 1.69676f
C201 ldo_MPS/G ldo_MNB/G 58.77746f
C202 rstn bgr_MPO/D3 0.073588f
C203 bgr_MPB/D3 bgr_MS2/D 25.449575f
C204 ldo_MN2/G bgr_MPC/D3 0.071796f
C205 ldo_MN2/S ldo_MPS/D 4.110057f
C206 bgr_MSN/D bgr_Rf/R2 0.182233f
C207 bgr_MSN/D bgr_MNF/G5 0.07208f
C208 bgr_R1/R2 bgr_MNB/D4 14.158496f
C209 bgr_MS2/D bgr_R1/R2 0.210795f
C210 bgr_MNB/D4 bgr_MSN/S 0.320025f
C211 bgr_MS2/D bgr_MSN/S 1.292661f
C212 ldo_MN2/G por_MD/D 0.162326f
C213 bgr_MS2/D ldo_Rsh/R2 0.001426f
C214 ldo_MN2/G bgr_MPI/D0_3 0.071796f
C215 rstn vout 10.832535f
C216 ldo_Rsh/R1 bgr_MT1/D 0.128192f
C217 bgr_R2/R1 bgr_MT4/D 0.170431f
C218 ldo_Rsh/R1 por_MI2P/G 5.5e-19
C219 bgr_MPB/D3 ldo_Rsh/R1 0.064096f
C220 rstn vin 58.0383f
C221 bgr_R2/R1 bgr_MPC/D3 4.63e-19
C222 ldo_Rsh/R1 bgr_R1/R2 0.144578f
C223 ldo_MPS/G por_MD/G 3.11143f
C224 ldo_MN2/G bgr_MNB/G5 7.805263f
C225 bgr_MNCD/G bgr_MT2/D 0.064573f
C226 ldo_Rsh/R1 bgr_MSN/S 0.128192f
C227 ldo_Rsh/R1 ldo_Rsh/R2 9.267134f
C228 bgr_MNCD/G bgr_Rf/R2 2.133121f
C229 ldo_MNX/S2 bgr_MSU3/S 0.1742f
C230 bgr_MNCD/G bgr_MNF/G5 19.451126f
C231 ldo_MNX/S2 ldo_MPX/S2 32.84047f
C232 bgr_MSU3/S bgr_MSU1/S 0.097161f
C233 ldo_MPX/S2 bgr_MSU1/S 0.210454f
C234 ldo_MN2/S rstn 0.073588f
C235 bgr_R2/R1 bgr_MPI/D0_3 0.001164f
C236 por_MH/D rstn 0.141218f
C237 bgr_MT3/D bgr_MT2/D 71.73089f
C238 bgr_MT3/D bgr_Rf/R2 0.400965f
C239 bgr_MS2/D bgr_MT4/S 19.729967f
C240 bgr_MT3/D bgr_MNF/G5 0.06486f
C241 ldo_MNX/S2 bgr_MPO/D3 0.078863f
C242 ldo_Rsh/R1 bgr_MSU2/S 0.128192f
C243 bgr_MNCD/S bgr_R1/R2 0.101521f
C244 bgr_MNCD/S bgr_MSN/S 31.868177f
C245 bgr_R1/R1 bgr_MT1/D 0.090061f
C246 bgr_R2/R1 bgr_MNB/G5 1.67507f
C247 ldo_MNX/S2 vout 13.627312f
C248 ldo_MNB/G bgr_MT4/D 0.545236f
C249 bgr_MSU1/S vout 0.964952f
C250 ldo_Rsh/R1 bgr_MT4/S 0.208761f
C251 bgr_MPB/D3 bgr_R1/R1 0.278601f
C252 ldo_MNX/S2 vin 11.903499f
C253 bgr_MNCD/G bgr_MPA/D3 4.84e-19
C254 bgr_MSU1/S vin 3.578352f
C255 rstn bgr_MT2/D 0.147175f
C256 bgr_MPC/D3 ldo_MNB/G 2.259231f
C257 rstn bgr_Rf/R2 0.163775f
C258 bgr_MNF/G5 rstn 0.246717f
C259 bgr_R1/R1 bgr_R1/R2 3.723171f
C260 bgr_R1/R1 bgr_MSN/S 0.010403f
C261 bgr_MPA/D3 ldo_MPS/D 0.256446f
C262 ldo_MPS/G bgr_MSU3/S 0.160425f
C263 bgr_MPA/D3 bgr_MT3/D 0.064096f
C264 ldo_MPS/G ldo_MPX/S2 3.715064f
C265 ldo_MN2/S ldo_MNX/S2 14.485394f
C266 ldo_MNB/G bgr_MPI/D0_3 10.796541f
C267 ldo_MNX/S2 por_MH/D 1.36e-19
C268 bgr_MS2/D bgr_MSN/D 21.382858f
C269 bgr_MNCD/S bgr_MT4/S 5.908823f
C270 por_MH/D bgr_MSU1/S 1.45e-19
C271 bgr_MSN/D bgr_MNB/D4 0.385672f
C272 bgr_MNB/G5 bgr_MNSK/S1 0.284983f
C273 ldo_MPS/G bgr_MPO/D3 0.064096f
C274 bgr_R1/R2 bgr_MNA/S5 2.79783f
C275 bgr_MNA/S5 bgr_MSN/S 1.350109f
C276 ldo_MNB/G bgr_MNB/G5 0.175002f
C277 ldo_Rsh/R2 ldo_MP4/G 0.328125f
C278 ldo_MPS/G vout 15.654761f
C279 ldo_MN2/G bgr_R2/R1 0.167926f
C280 bgr_R1/R1 bgr_MT4/S 41.83953f
C281 ldo_Rsh/R1 bgr_MSN/D 0.288317f
C282 bgr_MPA/D3 rstn 0.163649f
C283 por_MD/D por_MD/G 0.5446f
C284 ldo_MPS/G vin 15.240517f
C285 bgr_MNCD/G bgr_MNB/D4 3.576538f
C286 bgr_MS2/D bgr_MNCD/G 20.724936f
C287 ldo_MNX/S2 bgr_MT2/D 0.157726f
C288 ldo_MNX/S2 bgr_Rf/R2 0.174113f
C289 ldo_MNX/S2 bgr_MNF/G5 0.262119f
C290 bgr_MSU1/S bgr_Rf/R2 19.547653f
C291 bgr_MNF/G5 bgr_MSU1/S 0.078923f
C292 bgr_MS2/D ldo_MPS/D 11.208927f
C293 bgr_MS2/D bgr_MT3/D 2.27489f
C294 ldo_MN2/S ldo_MPS/G 3.76989f
C295 por_MH/G por_MI2P/G 58.556534f
C296 ldo_MPS/G por_MH/D 0.026083f
C297 bgr_MT4/S bgr_MNA/S5 0.086608f
C298 bgr_MNCD/S bgr_MSN/D 0.111751f
C299 ldo_Rsh/R1 bgr_MNCD/G 0.20143f
C300 ldo_MN2/G bgr_MNSK/S1 0.110588f
C301 ldo_MPX/S2 bgr_MT4/D 0.140303f
C302 ldo_Rsh/R1 ldo_MPS/D 0.257833f
C303 ldo_Rsh/R1 bgr_MT3/D 0.128192f
C304 bgr_MPO/D3 bgr_MT4/D 0.072152f
C305 ldo_MN2/G ldo_MNB/G 1.270768f
C306 ldo_MPX/S2 bgr_MPC/D3 0.070151f
C307 ldo_MNX/S2 bgr_MPA/D3 0.345558f
C308 bgr_MNB/D4 rstn 0.147601f
C309 bgr_MS2/D rstn 0.394574f
C310 por_MH/G bgr_MSU2/S 0.185601f
C311 bgr_MNCD/S bgr_MNCD/G 1.308202f
C312 ldo_MPS/G bgr_MT2/D 0.128192f
C313 bgr_MSU3/S por_MD/D 0.391515f
C314 ldo_MPX/S2 por_MD/D 2.06e-19
C315 bgr_MPB/D3 bgr_MT1/D 0.073767f
C316 ldo_MPS/G bgr_Rf/R2 0.154283f
C317 bgr_MPC/D3 bgr_MPO/D3 0.270427f
C318 ldo_MPS/G bgr_MNF/G5 0.237226f
C319 ldo_MPX/S2 bgr_MPI/D0_3 0.070151f
C320 vout bgr_MT4/D 0.644995f
C321 bgr_R1/R2 bgr_MT1/D 0.073588f
C322 bgr_MPI/D0_3 bgr_MPO/D3 11.2226f
C323 vin bgr_MT4/D 2.124756f
C324 bgr_MPB/D3 bgr_R1/R2 1.97049f
C325 bgr_MPC/D3 vout 0.321651f
C326 ldo_Rsh/R1 rstn 0.156967f
C327 bgr_R2/R1 ldo_MNB/G 0.533956f
C328 bgr_MNCD/G bgr_R1/R1 0.368228f
C329 ldo_MN2/G por_MD/G 0.145853f
C330 ldo_MPX/S2 bgr_MNB/G5 0.440789f
C331 por_MD/D vout 0.92771f
C332 bgr_R1/R2 bgr_MSN/S 0.477511f
C333 bgr_MPC/D3 vin 2.947839f
C334 bgr_MPI/D0_3 vout 0.321651f
C335 bgr_R1/R1 bgr_MT3/D 0.080569f
C336 bgr_MPO/D3 bgr_MNB/G5 1.968301f
C337 por_MI2P/G bgr_MSU2/S 0.183294f
C338 por_MD/D vin 2.852642f
C339 bgr_MPI/D0_3 vin 3.997761f
C340 ldo_MNX/S2 bgr_MS2/D 0.33184f
C341 bgr_MNCD/S rstn 0.163987f
C342 ldo_MPS/G bgr_MPA/D3 0.594616f
C343 ldo_MNX/S2 bgr_MNB/D4 0.157726f
C344 bgr_MNB/D4 bgr_MSU1/S 14.234329f
C345 bgr_MS2/D bgr_MSU1/S 0.51021f
C346 bgr_MT4/S bgr_MT1/D 2.41798f
C347 bgr_MNCD/G bgr_MNA/S5 0.196596f
C348 vout bgr_MNB/G5 2.134832f
C349 bgr_MPB/D3 bgr_MT4/S 0.231742f
C350 por_MD/D por_MH/D 0.19152f
C351 ldo_MP4/G ldo_MPS/D 24.1067f
C352 bgr_MNB/G5 vin 15.496812f
C353 bgr_MSN/D por_MH/G 0.201363f
C354 bgr_R1/R2 bgr_MT4/S 25.2657f
C355 bgr_R1/R1 rstn 0.180335f
C356 ldo_MNX/S2 ldo_Rsh/R1 7.208094f
C357 bgr_MT4/S bgr_MSN/S 4.518501f
C358 bgr_MT2/D bgr_MT4/D 0.16158f
C359 bgr_MT4/D bgr_Rf/R2 22.18475f
C360 ldo_Rsh/R1 bgr_MSU1/S 0.192287f
C361 bgr_MNF/G5 bgr_MT4/D 0.07245f
C362 ldo_MN2/G bgr_MSU3/S 0.145853f
C363 ldo_MN2/G ldo_MPX/S2 0.152882f
C364 bgr_MPC/D3 bgr_MT2/D 0.064275f
C365 bgr_MPC/D3 bgr_Rf/R2 0.266476f
C366 bgr_MPC/D3 bgr_MNF/G5 0.23767f
C367 ldo_MN2/G bgr_MPO/D3 0.071796f
C368 ldo_MNX/S2 bgr_MNCD/S 0.174113f
C369 ldo_MPS/G bgr_MS2/D 0.30857f
C370 rstn bgr_MNA/S5 0.163987f
C371 bgr_MPI/D0_3 bgr_MT2/D 0.064568f
C372 ldo_MPS/G bgr_MNB/D4 0.147601f
C373 bgr_MPI/D0_3 bgr_Rf/R2 1.968311f
C374 bgr_MNCD/S bgr_MSU1/S 0.091191f
C375 bgr_MNF/G5 bgr_MPI/D0_3 0.237769f
C376 rstn ldo_MP4/G 0.147644f
C377 bgr_MSN/D por_MI2P/G 0.199003f
C378 ldo_MN2/G vout 55.688183f
C379 bgr_MPA/D3 bgr_MT4/D 0.071973f
C380 bgr_R2/R1 ldo_MPX/S2 0.070151f
C381 bgr_MT2/D bgr_MNB/G5 0.06486f
C382 bgr_MNB/G5 bgr_Rf/R2 0.43388f
C383 ldo_MNX/S2 bgr_R1/R1 0.190673f
C384 bgr_R1/R2 bgr_MSN/D 2.77e-19
C385 bgr_MSN/D bgr_MSN/S 0.271474f
C386 ldo_MN2/G vin 23.962934f
C387 bgr_MNF/G5 bgr_MNB/G5 11.0002f
C388 ldo_MPS/G ldo_Rsh/R1 59.189625f
C389 bgr_R2/R1 bgr_MPO/D3 0.001122f
C390 bgr_MPA/D3 bgr_MPC/D3 0.004403f
C391 bgr_MNCD/G bgr_MT1/D 0.074352f
C392 ldo_MN2/S ldo_MN2/G 0.224175f
C393 bgr_MPB/D3 bgr_MNCD/G 0.001029f
C394 ldo_MN2/G por_MH/D 0.071796f
C395 bgr_MPA/D3 bgr_MPI/D0_3 0.001677f
C396 bgr_R2/R1 vout 0.321651f
C397 bgr_MSN/D bgr_MSU2/S 8.523878f
C398 bgr_MT3/D bgr_MT1/D 0.153703f
C399 por_MH/G rstn 1.948907f
C400 ldo_MNX/S2 bgr_MNA/S5 0.174113f
C401 ldo_MPX/S2 bgr_MNSK/S1 0.070151f
C402 ldo_MPS/G bgr_MNCD/S 0.163987f
C403 bgr_MPB/D3 bgr_MT3/D 0.064096f
C404 bgr_MNCD/G bgr_R1/R2 1.66529f
C405 ldo_MNX/S2 ldo_MP4/G 0.001426f
C406 bgr_MNCD/G bgr_MSN/S 18.024992f
C407 bgr_R2/R1 vin 1.509875f
C408 ldo_Rsh/R2 ldo_MPS/D 34.7432f
C409 bgr_MPA/D3 bgr_MNB/G5 3.3e-19
C410 bgr_R1/R2 bgr_MT3/D 0.437424f
C411 ldo_MPX/S2 ldo_MNB/G 0.076162f
C412 bgr_MS2/D bgr_MT4/D 2.26513f
C413 ldo_MPS/G bgr_R1/R1 0.170843f
C414 ldo_MN2/G bgr_MT2/D 0.225823f
C415 ldo_MNB/G bgr_MPO/D3 0.073588f
C416 vout bgr_MNSK/S1 0.324141f
C417 ldo_MN2/G bgr_Rf/R2 1.134638f
C418 ldo_MN2/G bgr_MNF/G5 1.432491f
C419 rstn bgr_MT1/D 0.147175f
C420 bgr_MS2/D bgr_MPC/D3 25.44779f
C421 rstn por_MI2P/G 0.229295f
C422 bgr_MPB/D3 rstn 0.073588f
C423 bgr_MNSK/S1 vin 0.325213f
C424 bgr_MNCD/G bgr_MT4/S 0.304503f
C425 ldo_MNB/G vout 13.838746f
C426 ldo_Rsh/R1 bgr_MT4/D 0.128192f
C427 bgr_MS2/D bgr_MPI/D0_3 50.802265f
C428 bgr_R1/R2 rstn 0.163775f
C429 rstn bgr_MSN/S 0.147601f
C430 ldo_Rsh/R2 rstn 0.147644f
C431 por_MH/G bgr_MSU1/S 0.064656f
C432 ldo_MPS/G bgr_MNA/S5 0.163987f
C433 bgr_MSU3/S por_MD/G 8.88223f
C434 ldo_MPX/S2 por_MD/G 8.81e-19
C435 bgr_MT3/D bgr_MT4/S 0.457132f
C436 ldo_MNB/G vin 34.56137f
C437 ldo_MPS/G ldo_MP4/G 0.79871f
C438 ldo_Rsh/R1 bgr_MPC/D3 0.064096f
C439 bgr_R2/R1 bgr_MT2/D 0.165216f
C440 bgr_R2/R1 bgr_Rf/R2 0.79133f
C441 bgr_R2/R1 bgr_MNF/G5 4.10922f
C442 bgr_MNB/D4 bgr_MNB/G5 0.659407f
C443 bgr_MS2/D bgr_MNB/G5 20.9179f
C444 ldo_Rsh/R1 por_MD/D 2.72e-19
C445 ldo_MN2/S ldo_MNB/G 0.834595f
C446 ldo_Rsh/R1 bgr_MPI/D0_3 0.064096f
C447 ldo_MN2/G bgr_MPA/D3 0.162236f
C448 rstn bgr_MSU2/S 0.137896f
C449 vout por_MD/G 0.644217f
C450 ldo_MNX/S2 bgr_MT1/D 0.157726f
C451 ldo_MNX/S2 por_MI2P/G 2.06e-19
C452 bgr_MT4/S rstn 0.237449f
C453 bgr_MSU1/S por_MI2P/G 0.070588f
C454 ldo_MNX/S2 bgr_MPB/D3 0.078863f
C455 vin por_MD/G 3.67017f
C456 ldo_Rsh/R1 bgr_MNB/G5 0.410511f
C457 bgr_MNSK/S1 bgr_Rf/R2 0.080112f
C458 bgr_MNCD/G bgr_MSN/D 19.21693f
C459 bgr_R1/R1 bgr_MT4/D 0.414844f
C460 bgr_MNF/G5 bgr_MNSK/S1 0.232154f
C461 ldo_MNX/S2 bgr_R1/R2 0.174113f
C462 ldo_MPS/G por_MH/G 0.015563f
C463 ldo_MNX/S2 bgr_MSN/S 0.157726f
C464 ldo_MNX/S2 ldo_Rsh/R2 12.91623f
C465 bgr_R1/R2 bgr_MSU1/S 1.82e-19
C466 bgr_MSU1/S bgr_MSN/S 0.076108f
C467 bgr_R2/R1 bgr_MPA/D3 1.91e-19
C468 bgr_R1/R1 bgr_MPC/D3 0.278349f
C469 ldo_MPX/S2 bgr_MSU3/S 0.156776f
C470 ldo_MNB/G bgr_MT2/D 0.545236f
C471 ldo_MNB/G bgr_Rf/R2 0.472206f
C472 por_MH/D por_MD/G 19.273996f
C473 bgr_MNF/G5 ldo_MNB/G 0.073588f
C474 bgr_MNCD/S bgr_MNB/G5 0.093842f
C475 ldo_MPX/S2 bgr_MPO/D3 0.070151f
C476 bgr_R1/R1 bgr_MPI/D0_3 0.557906f
C477 ldo_MNX/S2 bgr_MSU2/S 0.157726f
C478 ldo_MN2/G bgr_MNB/D4 0.162661f
C479 ldo_MN2/G bgr_MS2/D 0.651314f
C480 bgr_MSU1/S bgr_MSU2/S 14.113523f
C481 ldo_MPS/G bgr_MT1/D 0.128192f
C482 bgr_MSU3/S vout 0.643301f
C483 ldo_MPX/S2 vout 15.676232f
C484 bgr_MNCD/G bgr_MT3/D 0.064422f
C485 ldo_MPS/G por_MI2P/G 0.019716f
C486 ldo_MNX/S2 bgr_MT4/S 0.253063f
C487 bgr_MSN/D rstn 0.31743f
C488 ldo_MPS/G bgr_MPB/D3 0.064096f
C489 bgr_R1/R1 bgr_MNB/G5 0.594903f
C490 bgr_MSU3/S vin 3.496164f
C491 bgr_MPO/D3 vout 0.321651f
C492 ldo_MPX/S2 vin 8.39943f
C493 ldo_MN2/G ldo_Rsh/R1 0.714676f
C494 ldo_MPS/G bgr_R1/R2 0.154283f
C495 bgr_MPA/D3 ldo_MNB/G 0.256798f
C496 ldo_MPS/G bgr_MSN/S 0.147601f
C497 ldo_MPS/G ldo_Rsh/R2 4.225102f
C498 bgr_MS2/D bgr_R2/R1 0.017473f
C499 bgr_MPO/D3 vin 2.392287f
C500 ldo_MN2/S ldo_MPX/S2 6.18975f
C501 bgr_MSU3/S por_MH/D 0.065047f
C502 ldo_MPX/S2 por_MH/D 2.75e-19
C503 bgr_MNB/G5 bgr_MNA/S5 18.56952f
C504 bgr_MNCD/G rstn 0.23033f
C505 ldo_MPS/G bgr_MSU2/S 0.143952f
C506 bgr_MNCD/S ldo_MN2/G 0.162786f
C507 vout vin 0.492863p
C508 rstn ldo_MPS/D 0.147644f
C509 bgr_R2/R1 ldo_Rsh/R1 0.064096f
C510 bgr_MT3/D rstn 0.147175f
C511 bgr_MS2/D bgr_MNSK/S1 5.00875f
C512 ldo_MN2/S vout 3.290896f
C513 ldo_MPS/G bgr_MT4/S 0.218465f
C514 ldo_MNX/S2 bgr_MSN/D 0.347386f
C515 por_MH/G por_MD/D 55.450825f
C516 bgr_MSN/D bgr_MSU1/S 57.21566f
C517 por_MH/D vout 0.56527f
C518 ldo_MN2/G bgr_R1/R1 0.284319f
C519 ldo_MN2/S vin 3.294927f
C520 ldo_MPX/S2 bgr_MT2/D 0.140303f
C521 ldo_MPX/S2 bgr_Rf/R2 0.156689f
C522 bgr_MT1/D bgr_MT4/D 0.157087f
C523 bgr_MS2/D ldo_MNB/G 40.459385f
C524 ldo_MPX/S2 bgr_MNF/G5 0.235983f
C525 por_MH/D vin 1.381918f
C526 bgr_MPB/D3 bgr_MT4/D 0.071973f
C527 bgr_MPO/D3 bgr_MT2/D 0.064422f
C528 ldo_Rsh/R1 bgr_MNSK/S1 0.064096f
C529 bgr_MPO/D3 bgr_Rf/R2 4.60435f
C530 bgr_MNF/G5 bgr_MPO/D3 0.237991f
C531 bgr_MPC/D3 bgr_MT1/D 0.073824f
C532 ldo_MNX/S2 bgr_MNCD/G 0.245732f
C533 bgr_R1/R2 bgr_MT4/D 0.169667f
C534 bgr_MPB/D3 bgr_MPC/D3 8.0123f
C535 bgr_MNCD/G bgr_MSU1/S 0.787782f
C536 ldo_MN2/G bgr_MNA/S5 0.162786f
C537 vout bgr_MT2/D 0.64634f
C538 ldo_MNX/S2 ldo_MPS/D 0.889711f
C539 vout bgr_Rf/R2 0.750172f
C540 ldo_Rsh/R1 ldo_MNB/G 0.640982f
C541 bgr_MPI/D0_3 bgr_MT1/D 0.074239f
C542 ldo_MN2/G ldo_MP4/G 0.370898f
C543 bgr_R2/R1 bgr_R1/R1 0.097694f
C544 por_MD/D por_MI2P/G 0.542222f
C545 ldo_MNX/S2 bgr_MT3/D 0.157726f
C546 bgr_MNF/G5 vout 1.242829f
C547 bgr_R1/R2 bgr_MPC/D3 4.49332f
C548 bgr_MPB/D3 bgr_MPI/D0_3 0.005517f
C549 bgr_MT2/D vin 2.092336f
C550 bgr_MNCD/S bgr_MNSK/S1 0.102918f
C551 vin bgr_Rf/R2 6.748343f
C552 ldo_MPS/G bgr_MSN/D 0.323485f
C553 bgr_MNF/G5 vin 4.229341f
C554 bgr_MPA/D3 ldo_MPX/S2 0.258627f
C555 bgr_R1/R2 bgr_MPI/D0_3 0.557627f
C556 bgr_MNB/G5 bgr_MT1/D 0.0751f
C557 bgr_MPA/D3 bgr_MPO/D3 8.67e-19
C558 bgr_MPB/D3 bgr_MNB/G5 4.24527f
C559 bgr_MT4/S bgr_MT4/D 8.899014f
C560 bgr_R1/R1 bgr_MNSK/S1 0.119241f
C561 ldo_Rsh/R1 por_MD/G 0.001624f
C562 ldo_MNX/S2 rstn 0.073588f
C563 por_MD/D bgr_MSU2/S 0.391364f
C564 bgr_R1/R2 bgr_MNB/G5 3.390391f
C565 bgr_MSU1/S rstn 0.211696f
C566 bgr_MNB/G5 bgr_MSN/S 0.096595f
C567 bgr_MPA/D3 vout 3.3664f
C568 bgr_MPC/D3 bgr_MT4/S 0.231329f
C569 ldo_MPS/G bgr_MNCD/G 0.220839f
C570 ldo_MN2/G por_MH/G 0.145853f
C571 bgr_R1/R1 ldo_MNB/G 0.550083f
C572 ldo_MPS/G ldo_MPS/D 4.585765f
C573 bgr_MPA/D3 vin 4.469138f
C574 ldo_MPS/G bgr_MT3/D 0.128192f
C575 bgr_MT4/S bgr_MPI/D0_3 0.463434f
C576 bgr_MNSK/S1 bgr_MNA/S5 6.512632f
C577 bgr_MT2/D bgr_Rf/R2 0.4003f
C578 bgr_MNF/G5 bgr_MT2/D 0.065608f
C579 ldo_MPX/S2 bgr_MNB/D4 0.140303f
C580 bgr_MS2/D ldo_MPX/S2 0.296992f
C581 bgr_MNF/G5 bgr_Rf/R2 0.123576f
C582 ldo_MN2/S bgr_MPA/D3 0.372096f
C583 ldo_MN2/G bgr_MT1/D 0.225823f
C584 bgr_MT4/S bgr_MNB/G5 0.322996f
C585 bgr_MS2/D bgr_MPO/D3 25.456089f
C586 ldo_MNB/G ldo_MP4/G 0.255387f
C587 ldo_MN2/G por_MI2P/G 0.145853f
C588 bgr_MPB/D3 ldo_MN2/G 0.071796f
C589 ldo_MPS/G rstn 1.30953f
C590 ldo_MNX/S2 bgr_MSU1/S 0.23659f
C591 ldo_Rsh/R1 bgr_MSU3/S 0.144665f
C592 ldo_Rsh/R1 ldo_MPX/S2 36.794056f
C593 bgr_MNB/D4 vout 0.645209f
C594 bgr_MS2/D vout 1.86595f
C595 ldo_MN2/G bgr_R1/R2 0.256074f
C596 ldo_MN2/G bgr_MSN/S 0.146399f
C597 ldo_MN2/G ldo_Rsh/R2 0.412681f
C598 ldo_Rsh/R1 bgr_MPO/D3 0.064096f
C599 bgr_MS2/D vin 53.32715f
C600 bgr_MNB/D4 vin 0.645616f
C601 bgr_MSN/D por_MD/D 0.405029f
C602 bgr_MPA/D3 bgr_MT2/D 0.064096f
C603 bgr_R2/R1 bgr_MT1/D 37.269764f
C604 bgr_MPA/D3 bgr_MNF/G5 4.09942f
C605 bgr_MNCD/G bgr_MT4/D 0.072209f
C606 por_MI2P/G gnd 17.464622f
C607 bgr_MSN/S gnd 9.673849f
C608 bgr_Rf/R2 gnd 52.431274f
C609 vout gnd 0.20388p
C610 ldo_MNX/S2 gnd 0.152881p
C611 por_MH/G gnd 20.076271f
C612 rstn gnd 33.364025f
C613 bgr_MPI/D0_3 gnd 31.305677f
C614 ldo_MNB/G gnd 0.128715p
C615 ldo_MN2/S gnd 34.467594f
C616 ldo_MPS/G gnd 44.993057f
C617 ldo_MP4/G gnd 37.451637f
C618 ldo_MPX/S2 gnd 78.47292f
C619 bgr_R1/R2 gnd 12.237084f
C620 bgr_MNB/G5 gnd 0.191923p
C621 bgr_MNA/S5 gnd 7.502688f
C622 bgr_MPB/D3 gnd 15.630874f
C623 bgr_MPC/D3 gnd 17.640774f
C624 ldo_MPS/D gnd 33.570152f
C625 ldo_Rsh/R2 gnd 17.18667f
C626 por_MD/D gnd 17.868414f
C627 bgr_MSU3/S gnd 46.53367f
C628 bgr_MSN/D gnd 25.713915f
C629 por_MD/G gnd 36.20186f
C630 por_MH/D gnd 18.87944f
C631 bgr_MSU1/S gnd 27.241903f
C632 bgr_MSU2/S gnd 22.569653f
C633 bgr_MNSK/S1 gnd 8.581661f
C634 bgr_R1/R1 gnd 18.848726f
C635 bgr_MT4/D gnd 55.453156f
C636 bgr_MT3/D gnd 25.432686f
C637 bgr_MT2/D gnd 25.867996f
C638 ldo_Rsh/R1 gnd 36.580944f
C639 bgr_MT1/D gnd 29.108677f
C640 bgr_MT4/S gnd 31.654644f
C641 bgr_R2/R1 gnd 22.507309f
C642 bgr_MNB/D4 gnd 29.305902f
C643 bgr_MNF/G5 gnd 0.101353p
C644 bgr_MNCD/G gnd 0.107309p
C645 bgr_MNCD/S gnd 12.671143f
C646 vin gnd 2.385004p
C647 ldo_MN2/G gnd 59.49281f
C648 bgr_MS2/D gnd 0.226235p
C649 bgr_MPA/D3 gnd 65.93936f
C650 bgr_MPO/D3 gnd 16.084173f
.ends
