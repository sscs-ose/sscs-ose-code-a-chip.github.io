* NGSPICE file created from ldo_top.ext - technology: sky130A

.subckt sky130_fd_pr__pfet_g5v0d10v5_UFECYT B D0 S0 G0 D1 S1 G1 D2 S2 G2 D3 S3 G3
+ VSUBS
X0 S2 G2 D2 B sky130_fd_pr__pfet_g5v0d10v5 ad=5.8 pd=40.58 as=5.8 ps=40.58 w=20 l=16
X1 S0 G0 D0 B sky130_fd_pr__pfet_g5v0d10v5 ad=5.8 pd=40.58 as=5.8 ps=40.58 w=20 l=16
X2 S3 G3 D3 B sky130_fd_pr__pfet_g5v0d10v5 ad=5.8 pd=40.58 as=5.8 ps=40.58 w=20 l=16
X3 S1 G1 D1 B sky130_fd_pr__pfet_g5v0d10v5 ad=5.8 pd=40.58 as=5.8 ps=40.58 w=20 l=16
C0 B D2 1.13466f
C1 S3 S2 0.014232f
C2 G1 G0 1.79553f
C3 G2 D2 0.843488f
C4 B D0 1.14186f
C5 S2 S1 0.014232f
C6 G1 D1 0.843488f
C7 B G3 2.90949f
C8 B S0 1.14186f
C9 D3 D2 0.014232f
C10 G3 G2 1.79553f
C11 B G2 1.63817f
C12 G3 S3 0.843488f
C13 G3 D3 0.843488f
C14 B S3 1.14084f
C15 B D3 1.14084f
C16 B G1 1.63817f
C17 G2 G1 1.79553f
C18 B S1 1.13466f
C19 D2 D1 0.014232f
C20 S1 S0 0.014232f
C21 G0 D0 0.843488f
C22 B S2 1.13466f
C23 B G0 2.08018f
C24 G0 S0 0.843488f
C25 D1 D0 0.014232f
C26 G2 S2 0.843488f
C27 B D1 1.13466f
C28 G1 S1 0.843488f
C29 S0 VSUBS 1.63025f
C30 D0 VSUBS 1.63025f
C31 G0 VSUBS 3.53008f
C32 S1 VSUBS 1.62405f
C33 D1 VSUBS 1.62405f
C34 G1 VSUBS 3.28219f
C35 S2 VSUBS 1.62405f
C36 D2 VSUBS 1.62405f
C37 G2 VSUBS 3.28219f
C38 S3 VSUBS 1.6295f
C39 D3 VSUBS 1.6295f
C40 G3 VSUBS 3.33883f
C41 B VSUBS 0.200533p
.ends

.subckt sky130_fd_pr__pfet_g5v0d10v5_TGGT4A B D0_0 G0_0 D0_1 G0_1 D0_2 G0_2 D0_3 G0_3
+ S1_0 G1_0 S1_1 G1_1 S1_2 G1_2 S1_3 G1_3 D2_0 G2_0 D2_1 G2_1 D2_2 G2_2 D2_3 G2_3
+ S3_0 G3_0 S3_1 G3_1 S3_2 G3_2 S3_3 G3_3 a_887_n4118# a_887_n8283# a_887_47# a_887_4212#
+ VSUBS
X0 S3_2 G2_2 D2_2 B sky130_fd_pr__pfet_g5v0d10v5 ad=2.9 pd=20.29 as=2.9 ps=20.29 w=20 l=2
X1 a_887_4212# G3_3 S3_3 B sky130_fd_pr__pfet_g5v0d10v5 ad=5.8 pd=40.58 as=2.9 ps=20.29 w=20 l=2
X2 S1_3 G0_3 D0_3 B sky130_fd_pr__pfet_g5v0d10v5 ad=2.9 pd=20.29 as=5.8 ps=40.58 w=20 l=2
X3 S3_1 G2_1 D2_1 B sky130_fd_pr__pfet_g5v0d10v5 ad=2.9 pd=20.29 as=2.9 ps=20.29 w=20 l=2
X4 S1_0 G0_0 D0_0 B sky130_fd_pr__pfet_g5v0d10v5 ad=2.9 pd=20.29 as=5.8 ps=40.58 w=20 l=2
X5 D2_2 G1_2 S1_2 B sky130_fd_pr__pfet_g5v0d10v5 ad=2.9 pd=20.29 as=2.9 ps=20.29 w=20 l=2
X6 a_887_n8283# G3_0 S3_0 B sky130_fd_pr__pfet_g5v0d10v5 ad=5.8 pd=40.58 as=2.9 ps=20.29 w=20 l=2
X7 S1_2 G0_2 D0_2 B sky130_fd_pr__pfet_g5v0d10v5 ad=2.9 pd=20.29 as=5.8 ps=40.58 w=20 l=2
X8 D2_3 G1_3 S1_3 B sky130_fd_pr__pfet_g5v0d10v5 ad=2.9 pd=20.29 as=2.9 ps=20.29 w=20 l=2
X9 D2_0 G1_0 S1_0 B sky130_fd_pr__pfet_g5v0d10v5 ad=2.9 pd=20.29 as=2.9 ps=20.29 w=20 l=2
X10 S1_1 G0_1 D0_1 B sky130_fd_pr__pfet_g5v0d10v5 ad=2.9 pd=20.29 as=5.8 ps=40.58 w=20 l=2
X11 a_887_n4118# G3_1 S3_1 B sky130_fd_pr__pfet_g5v0d10v5 ad=5.8 pd=40.58 as=2.9 ps=20.29 w=20 l=2
X12 D2_1 G1_1 S1_1 B sky130_fd_pr__pfet_g5v0d10v5 ad=2.9 pd=20.29 as=2.9 ps=20.29 w=20 l=2
X13 a_887_47# G3_2 S3_2 B sky130_fd_pr__pfet_g5v0d10v5 ad=5.8 pd=40.58 as=2.9 ps=20.29 w=20 l=2
X14 S3_0 G2_0 D2_0 B sky130_fd_pr__pfet_g5v0d10v5 ad=2.9 pd=20.29 as=2.9 ps=20.29 w=20 l=2
X15 S3_3 G2_3 D2_3 B sky130_fd_pr__pfet_g5v0d10v5 ad=2.9 pd=20.29 as=2.9 ps=20.29 w=20 l=2
C0 D0_0 G0_0 0.625982f
C1 a_887_47# G3_2 0.625982f
C2 G3_3 S3_3 0.625982f
C3 G1_1 B 0.223127f
C4 D0_3 D0_2 0.014232f
C5 a_887_4212# S3_3 0.614813f
C6 S1_3 B 0.015791f
C7 G1_3 G0_3 0.061903f
C8 G1_1 G2_1 0.061903f
C9 G2_2 G3_2 0.061903f
C10 S3_2 B 0.009616f
C11 D2_0 D2_1 0.014232f
C12 a_887_n4118# S3_1 0.614813f
C13 G2_2 G2_3 0.227831f
C14 G1_1 G0_1 0.061903f
C15 G2_1 B 0.223127f
C16 G1_3 G2_3 0.061903f
C17 S1_3 G0_3 0.625982f
C18 D2_3 D2_2 0.014232f
C19 B G2_0 0.278378f
C20 G2_1 G2_0 0.227831f
C21 S1_2 S1_1 0.014232f
C22 G0_1 B 0.247781f
C23 B S1_0 0.016816f
C24 B G0_3 0.40686f
C25 G1_3 D2_3 0.625982f
C26 G3_1 B 0.247781f
C27 a_887_4212# a_887_47# 0.014232f
C28 G2_1 G3_1 0.061903f
C29 S1_2 D2_2 0.614813f
C30 a_887_n4118# a_887_n8283# 0.014232f
C31 G3_2 S3_2 0.625982f
C32 G3_2 B 0.247781f
C33 B D2_0 0.016816f
C34 B G2_3 0.382207f
C35 G0_2 B 0.247781f
C36 S1_3 D2_3 0.614813f
C37 D2_0 G2_0 0.625982f
C38 G0_0 G1_0 0.061903f
C39 D0_1 S1_1 0.614813f
C40 B G3_0 0.303032f
C41 D2_3 B 0.015791f
C42 D0_2 B 1.13467f
C43 G0_2 G0_1 0.227831f
C44 S1_0 D2_0 0.614813f
C45 B S3_0 0.016816f
C46 G3_1 G3_2 0.227831f
C47 G0_2 G0_3 0.227831f
C48 a_887_47# a_887_n4118# 0.014232f
C49 S1_2 S1_3 0.014232f
C50 G1_2 D2_2 0.625982f
C51 G2_0 G3_0 0.061903f
C52 S3_1 D2_1 0.614813f
C53 S3_0 G2_0 0.625982f
C54 G1_2 G2_2 0.061903f
C55 B D0_0 1.14187f
C56 G1_3 G1_2 0.227831f
C57 S1_2 B 0.009616f
C58 G3_1 G3_0 0.227831f
C59 G3_3 B 0.40686f
C60 a_887_4212# B 1.14085f
C61 S1_0 D0_0 0.614813f
C62 G1_1 G1_2 0.227831f
C63 D2_3 G2_3 0.625982f
C64 G0_2 D0_2 0.625982f
C65 D2_0 S3_0 0.614813f
C66 S3_2 S3_1 0.014232f
C67 B S3_1 0.009616f
C68 G2_1 S3_1 0.625982f
C69 G1_2 B 0.223127f
C70 S3_0 G3_0 0.625982f
C71 G3_3 G3_2 0.227831f
C72 a_887_n4118# B 1.13467f
C73 B D0_1 1.13467f
C74 G0_2 S1_2 0.625982f
C75 G3_3 G2_3 0.061903f
C76 S1_1 D2_1 0.614813f
C77 S3_3 S3_2 0.014232f
C78 B G0_0 0.303032f
C79 S3_3 B 0.015791f
C80 G3_1 S3_1 0.625982f
C81 G1_1 G1_0 0.227831f
C82 D2_2 D2_1 0.014232f
C83 G0_1 D0_1 0.625982f
C84 G2_2 D2_2 0.625982f
C85 D0_2 S1_2 0.614813f
C86 D0_3 S1_3 0.614813f
C87 a_887_n8283# B 1.14187f
C88 G3_1 a_887_n4118# 0.625982f
C89 G0_1 G0_0 0.227831f
C90 G1_1 S1_1 0.625982f
C91 S1_0 G0_0 0.625982f
C92 B G1_0 0.278378f
C93 D0_3 B 1.14085f
C94 G0_2 G1_2 0.061903f
C95 G2_0 G1_0 0.061903f
C96 G3_3 a_887_4212# 0.625982f
C97 B S1_1 0.009616f
C98 G1_1 D2_1 0.625982f
C99 a_887_47# S3_2 0.614813f
C100 S1_0 G1_0 0.625982f
C101 S3_0 S3_1 0.014232f
C102 S3_3 G2_3 0.625982f
C103 a_887_47# B 1.13467f
C104 D0_3 G0_3 0.625982f
C105 D2_2 S3_2 0.614813f
C106 D0_2 D0_1 0.014232f
C107 G1_3 S1_3 0.625982f
C108 D2_2 B 0.009616f
C109 G0_1 S1_1 0.625982f
C110 G2_2 S3_2 0.625982f
C111 S1_0 S1_1 0.014232f
C112 B D2_1 0.009616f
C113 G2_2 B 0.223127f
C114 D2_3 S3_3 0.614813f
C115 G2_1 D2_1 0.625982f
C116 G2_1 G2_2 0.227831f
C117 D2_0 G1_0 0.625982f
C118 G1_3 B 0.382207f
C119 G1_2 S1_2 0.625982f
C120 a_887_n8283# G3_0 0.625982f
C121 D0_0 D0_1 0.014232f
C122 a_887_n8283# S3_0 0.614813f
C123 S3_0 VSUBS 0.863504f
C124 D2_0 VSUBS 0.863504f
C125 S1_0 VSUBS 0.863504f
C126 D0_0 VSUBS 1.12621f
C127 G3_0 VSUBS 0.440605f
C128 G2_0 VSUBS 0.427224f
C129 G1_0 VSUBS 0.427224f
C130 G0_0 VSUBS 0.440605f
C131 S3_1 VSUBS 0.857307f
C132 D2_1 VSUBS 0.857307f
C133 S1_1 VSUBS 0.857307f
C134 D0_1 VSUBS 1.12001f
C135 G3_1 VSUBS 0.409619f
C136 G2_1 VSUBS 0.396239f
C137 G1_1 VSUBS 0.396239f
C138 G0_1 VSUBS 0.409619f
C139 S3_2 VSUBS 0.857307f
C140 D2_2 VSUBS 0.857307f
C141 S1_2 VSUBS 0.857307f
C142 D0_2 VSUBS 1.12001f
C143 G3_2 VSUBS 0.409619f
C144 G2_2 VSUBS 0.396239f
C145 G1_2 VSUBS 0.396239f
C146 G0_2 VSUBS 0.409619f
C147 S3_3 VSUBS 0.862757f
C148 D2_3 VSUBS 0.862757f
C149 S1_3 VSUBS 0.862757f
C150 D0_3 VSUBS 1.12546f
C151 G3_3 VSUBS 0.420067f
C152 G2_3 VSUBS 0.406686f
C153 G1_3 VSUBS 0.406686f
C154 G0_3 VSUBS 0.420067f
C155 B VSUBS 0.12679p
C156 a_887_n8283# VSUBS 1.12621f
C157 a_887_n4118# VSUBS 1.12001f
C158 a_887_47# VSUBS 1.12001f
C159 a_887_4212# VSUBS 1.12546f
.ends

.subckt sky130_fd_pr__nfet_g5v0d10v5_3LMSA7 B D S G
X0 S G D B sky130_fd_pr__nfet_g5v0d10v5 ad=1.45 pd=10.58 as=1.45 ps=10.58 w=5 l=0.5
C0 G D 0.06583f
C1 G S 0.06583f
C2 D S 0.446027f
C3 S B 0.524972f
C4 D B 0.524972f
C5 G B 0.301693f
.ends

.subckt sky130_fd_pr__nfet_g5v0d10v5_C8EBTW B D S G
X0 S G D B sky130_fd_pr__nfet_g5v0d10v5 ad=0.203 pd=1.98 as=0.203 ps=1.98 w=0.7 l=20
C0 G D 0.036799f
C1 G S 0.036799f
C2 S B 0.128043f
C3 D B 0.128043f
C4 G B 8.82479f
.ends

.subckt sky130_fd_pr__nfet_g5v0d10v5_62W55W B D S G
X0 S G D B sky130_fd_pr__nfet_g5v0d10v5 ad=0.29 pd=2.58 as=0.29 ps=2.58 w=1 l=1
C0 G D 0.026809f
C1 G S 0.026809f
C2 D S 0.055609f
C3 S B 0.138407f
C4 D B 0.138407f
C5 G B 0.526365f
.ends

.subckt sky130_fd_pr__cap_mim_m3_1_BTY6QK C2 C1 VSUBS
X0 C1 C2 sky130_fd_pr__cap_mim_m3_1 l=25 w=25
C0 C2 C1 55.2292f
C1 C1 VSUBS 2.59358f
C2 C2 VSUBS 13.8127f
.ends

.subckt sky130_fd_pr__cap_mim_m3_1_V8HUNN C2 C1 VSUBS
X0 C1 C2 sky130_fd_pr__cap_mim_m3_1 l=16 w=16
C0 C2 C1 23.226198f
C1 C1 VSUBS 1.64509f
C2 C2 VSUBS 7.15816f
.ends

.subckt sky130_fd_pr__nfet_05v0_nvt_F4CC77 B D S G
X0 S G D B sky130_fd_pr__nfet_05v0_nvt ad=0.29 pd=2.58 as=0.29 ps=2.58 w=1 l=25
C0 G D 0.049339f
C1 G S 0.049339f
C2 S B 0.169637f
C3 D B 0.169637f
C4 G B 10.926f
.ends

.subckt sky130_fd_pr__nfet_05v0_nvt_ASWYB8 B D0 G0 S1 G1 D2 G2 S3 G3 D4 G4 S5 G5 a_15145_n131#
X0 S3 G2 D2 B sky130_fd_pr__nfet_05v0_nvt ad=0.145 pd=1.29 as=0.145 ps=1.29 w=1 l=25
X1 S1 G0 D0 B sky130_fd_pr__nfet_05v0_nvt ad=0.145 pd=1.29 as=0.29 ps=2.58 w=1 l=25
X2 D2 G1 S1 B sky130_fd_pr__nfet_05v0_nvt ad=0.145 pd=1.29 as=0.145 ps=1.29 w=1 l=25
X3 D4 G3 S3 B sky130_fd_pr__nfet_05v0_nvt ad=0.145 pd=1.29 as=0.145 ps=1.29 w=1 l=25
X4 a_15145_n131# G5 S5 B sky130_fd_pr__nfet_05v0_nvt ad=0.29 pd=2.58 as=0.145 ps=1.29 w=1 l=25
X5 S5 G4 D4 B sky130_fd_pr__nfet_05v0_nvt ad=0.145 pd=1.29 as=0.145 ps=1.29 w=1 l=25
C0 S3 G2 0.049339f
C1 S3 G3 0.049339f
C2 G5 a_15145_n131# 0.049339f
C3 D2 G2 0.049339f
C4 S1 G0 0.049339f
C5 G2 G3 0.05942f
C6 S1 G1 0.049339f
C7 D4 G3 0.049339f
C8 G2 G1 0.05942f
C9 D2 G1 0.049339f
C10 S5 G4 0.049339f
C11 G3 G4 0.05942f
C12 D4 G4 0.049339f
C13 G0 G1 0.05942f
C14 S5 G5 0.049339f
C15 G4 G5 0.05942f
C16 D0 G0 0.049339f
C17 S5 B 0.119853f
C18 D4 B 0.119853f
C19 S3 B 0.119853f
C20 D2 B 0.119853f
C21 S1 B 0.119853f
C22 D0 B 0.169637f
C23 G5 B 10.8897f
C24 G4 B 10.853401f
C25 G3 B 10.853401f
C26 G2 B 10.853401f
C27 G1 B 10.853401f
C28 G0 B 10.8897f
C29 a_15145_n131# B 0.169637f
.ends

.subckt sky130_fd_pr__nfet_g5v0d10v5_NUFNY9 B D S G
X0 S G D B sky130_fd_pr__nfet_g5v0d10v5 ad=0.29 pd=2.58 as=0.29 ps=2.58 w=1 l=4
C0 S D 0.016591f
C1 G D 0.04509f
C2 S G 0.04509f
C3 S B 0.152182f
C4 D B 0.152182f
C5 G B 1.8263f
.ends

.subckt sky130_fd_pr__nfet_g5v0d10v5_A8HTHF B D S G
X0 S G D B sky130_fd_pr__nfet_g5v0d10v5 ad=0.29 pd=2.58 as=0.29 ps=2.58 w=1 l=0.5
C0 S D 0.090631f
C1 G D 0.016273f
C2 S G 0.016273f
C3 S B 0.133548f
C4 D B 0.133548f
C5 G B 0.309709f
.ends

.subckt sky130_fd_pr__res_xhigh_po_0p35_5J6MKL B R1 R2
X0 R2 R1 B sky130_fd_pr__res_xhigh_po_0p35 l=94.73
C0 R2 R1 0.296258f
C1 R2 B 0.387223f
C2 R1 B 0.387223f
.ends

.subckt sky130_fd_pr__nfet_g5v0d10v5_BE4NYT B D S G
X0 S G D B sky130_fd_pr__nfet_g5v0d10v5 ad=0.58 pd=4.58 as=0.58 ps=4.58 w=2 l=4
C0 S D 0.032918f
C1 G D 0.082975f
C2 S G 0.082975f
C3 S B 0.271253f
C4 D B 0.271253f
C5 G B 1.80067f
.ends

.subckt sky130_fd_pr__rf_pnp_05v5_W3p40L3p40 Emitter Collector Base m=1
X0 Collector Base Emitter sky130_fd_pr__pnp_05v5_W3p40L3p40
**devattr s=462400,2720
C0 Base Emitter 0.896583f
C1 Base Collector 1.10722f
.ends

.subckt sky130_fd_pr__res_xhigh_po_0p35_PL9RNS B R1 R2
X0 R2 R1 B sky130_fd_pr__res_xhigh_po_0p35 l=991.66
C0 R1 B 0.595753f
C1 R2 B 0.595753f
.ends

.subckt sky130_fd_pr__nfet_g5v0d10v5_YQMGE2 B D0 G0 S1 G1 D2 G2 S3 G3 D4 G4 S5 G5
+ D6 G6 S7 G7 D8 G8 S9 G9 D10 G10 S11 G11 D12 G12 S13 G13 D14 G14 S15 G15 D16 G16
+ S17 G17 D18 G18 S19 G19 a_8551_n231#
X0 S7 G6 D6 B sky130_fd_pr__nfet_g5v0d10v5 ad=0.29 pd=2.29 as=0.29 ps=2.29 w=2 l=4
X1 D12 G11 S11 B sky130_fd_pr__nfet_g5v0d10v5 ad=0.29 pd=2.29 as=0.29 ps=2.29 w=2 l=4
X2 D18 G17 S17 B sky130_fd_pr__nfet_g5v0d10v5 ad=0.29 pd=2.29 as=0.29 ps=2.29 w=2 l=4
X3 D16 G15 S15 B sky130_fd_pr__nfet_g5v0d10v5 ad=0.29 pd=2.29 as=0.29 ps=2.29 w=2 l=4
X4 D6 G5 S5 B sky130_fd_pr__nfet_g5v0d10v5 ad=0.29 pd=2.29 as=0.29 ps=2.29 w=2 l=4
X5 D8 G7 S7 B sky130_fd_pr__nfet_g5v0d10v5 ad=0.29 pd=2.29 as=0.29 ps=2.29 w=2 l=4
X6 S17 G16 D16 B sky130_fd_pr__nfet_g5v0d10v5 ad=0.29 pd=2.29 as=0.29 ps=2.29 w=2 l=4
X7 S9 G8 D8 B sky130_fd_pr__nfet_g5v0d10v5 ad=0.29 pd=2.29 as=0.29 ps=2.29 w=2 l=4
X8 S1 G0 D0 B sky130_fd_pr__nfet_g5v0d10v5 ad=0.29 pd=2.29 as=0.58 ps=4.58 w=2 l=4
X9 S3 G2 D2 B sky130_fd_pr__nfet_g5v0d10v5 ad=0.29 pd=2.29 as=0.29 ps=2.29 w=2 l=4
X10 D14 G13 S13 B sky130_fd_pr__nfet_g5v0d10v5 ad=0.29 pd=2.29 as=0.29 ps=2.29 w=2 l=4
X11 D2 G1 S1 B sky130_fd_pr__nfet_g5v0d10v5 ad=0.29 pd=2.29 as=0.29 ps=2.29 w=2 l=4
X12 D10 G9 S9 B sky130_fd_pr__nfet_g5v0d10v5 ad=0.29 pd=2.29 as=0.29 ps=2.29 w=2 l=4
X13 D4 G3 S3 B sky130_fd_pr__nfet_g5v0d10v5 ad=0.29 pd=2.29 as=0.29 ps=2.29 w=2 l=4
X14 S15 G14 D14 B sky130_fd_pr__nfet_g5v0d10v5 ad=0.29 pd=2.29 as=0.29 ps=2.29 w=2 l=4
X15 S13 G12 D12 B sky130_fd_pr__nfet_g5v0d10v5 ad=0.29 pd=2.29 as=0.29 ps=2.29 w=2 l=4
X16 a_8551_n231# G19 S19 B sky130_fd_pr__nfet_g5v0d10v5 ad=0.58 pd=4.58 as=0.29 ps=2.29 w=2 l=4
X17 S5 G4 D4 B sky130_fd_pr__nfet_g5v0d10v5 ad=0.29 pd=2.29 as=0.29 ps=2.29 w=2 l=4
X18 S19 G18 D18 B sky130_fd_pr__nfet_g5v0d10v5 ad=0.29 pd=2.29 as=0.29 ps=2.29 w=2 l=4
X19 S11 G10 D10 B sky130_fd_pr__nfet_g5v0d10v5 ad=0.29 pd=2.29 as=0.29 ps=2.29 w=2 l=4
C0 G10 D10 0.082975f
C1 S3 D2 0.032918f
C2 D8 S9 0.032918f
C3 S9 G9 0.082975f
C4 G1 G0 0.05942f
C5 G11 S11 0.082975f
C6 G3 S3 0.082975f
C7 D8 S7 0.032918f
C8 S1 G0 0.082975f
C9 G1 D2 0.082975f
C10 G2 S3 0.082975f
C11 G4 S5 0.082975f
C12 S1 D2 0.032918f
C13 G10 S11 0.082975f
C14 S13 G12 0.082975f
C15 G14 G13 0.05942f
C16 G5 D6 0.082975f
C17 G1 G2 0.05942f
C18 G11 D12 0.082975f
C19 S9 G8 0.082975f
C20 G0 D0 0.082975f
C21 G18 S19 0.082975f
C22 G4 G3 0.05942f
C23 D6 S7 0.032918f
C24 G9 G10 0.05942f
C25 D12 G12 0.082975f
C26 G13 S13 0.082975f
C27 D6 G6 0.082975f
C28 G14 G15 0.05942f
C29 G5 G6 0.05942f
C30 G18 D18 0.082975f
C31 G17 S17 0.082975f
C32 G17 G16 0.05942f
C33 S7 G6 0.082975f
C34 G17 D18 0.082975f
C35 S3 D4 0.032918f
C36 G2 D2 0.082975f
C37 S19 G19 0.082975f
C38 G13 D14 0.082975f
C39 G15 D16 0.082975f
C40 G2 G3 0.05942f
C41 D10 S11 0.032918f
C42 G14 D14 0.082975f
C43 D8 G7 0.082975f
C44 G4 G5 0.05942f
C45 G4 D4 0.082975f
C46 G11 G10 0.05942f
C47 G15 G16 0.05942f
C48 S13 D12 0.032918f
C49 G9 D10 0.082975f
C50 G14 S15 0.082975f
C51 D16 S17 0.032918f
C52 S11 D12 0.032918f
C53 G11 G12 0.05942f
C54 D6 S5 0.032918f
C55 S13 D14 0.032918f
C56 G7 G8 0.05942f
C57 G5 S5 0.082975f
C58 S5 D4 0.032918f
C59 D16 G16 0.082975f
C60 G15 S15 0.082975f
C61 S19 D18 0.032918f
C62 S17 G16 0.082975f
C63 a_8551_n231# G19 0.082975f
C64 S7 G7 0.082975f
C65 D16 S15 0.032918f
C66 G3 D4 0.082975f
C67 G18 G17 0.05942f
C68 S9 D10 0.032918f
C69 G1 S1 0.082975f
C70 S17 D18 0.032918f
C71 G7 G6 0.05942f
C72 G13 G12 0.05942f
C73 S1 D0 0.032918f
C74 D8 G8 0.082975f
C75 G9 G8 0.05942f
C76 D14 S15 0.032918f
C77 G18 G19 0.05942f
C78 a_8551_n231# S19 0.032918f
C79 S19 B 0.144855f
C80 D18 B 0.144855f
C81 S17 B 0.144855f
C82 D16 B 0.144855f
C83 S15 B 0.144855f
C84 D14 B 0.144855f
C85 S13 B 0.144855f
C86 D12 B 0.144855f
C87 S11 B 0.144855f
C88 D10 B 0.144855f
C89 S9 B 0.144855f
C90 D8 B 0.144855f
C91 S7 B 0.144855f
C92 D6 B 0.144855f
C93 S5 B 0.144855f
C94 D4 B 0.144855f
C95 S3 B 0.144855f
C96 D2 B 0.144855f
C97 S1 B 0.144855f
C98 D0 B 0.271253f
C99 G19 B 1.76447f
C100 G18 B 1.72826f
C101 G17 B 1.72826f
C102 G16 B 1.72826f
C103 G15 B 1.72826f
C104 G14 B 1.72826f
C105 G13 B 1.72826f
C106 G12 B 1.72826f
C107 G11 B 1.72826f
C108 G10 B 1.72826f
C109 G9 B 1.72826f
C110 G8 B 1.72826f
C111 G7 B 1.72826f
C112 G6 B 1.72826f
C113 G5 B 1.72826f
C114 G4 B 1.72826f
C115 G3 B 1.72826f
C116 G2 B 1.72826f
C117 G1 B 1.72826f
C118 G0 B 1.76447f
C119 a_8551_n231# B 0.271253f
.ends

.subckt sky130_fd_pr__res_xhigh_po_0p35_R4U9XH B R1 R2
X0 R1 R2 B sky130_fd_pr__res_xhigh_po_0p35 l=3.74
C0 R2 R1 0.00525f
C1 R2 B 0.591075f
C2 R1 B 0.591075f
.ends

.subckt sky130_fd_pr__res_xhigh_po_0p35_XV4KRP B R1 R2
X0 R1 R2 B sky130_fd_pr__res_xhigh_po_0p35 l=7.4
C0 R2 R1 0.002672f
C1 R2 B 0.594177f
C2 R1 B 0.594177f
.ends

.subckt sky130_fd_pr__cap_mim_m3_1_84Z4WG C2 C1 VSUBS
X0 C1 C2 sky130_fd_pr__cap_mim_m3_1 l=22 w=22
C0 C2 C1 43.049f
C1 C1 VSUBS 2.27742f
C2 C2 VSUBS 11.371901f
.ends

.subckt sky130_fd_pr__res_xhigh_po_0p35_4E3LTY B R1 R2
X0 R1 R2 B sky130_fd_pr__res_xhigh_po_0p35 l=14.76
C0 R2 B 0.597536f
C1 R1 B 0.597536f
.ends

.subckt sky130_fd_pr__pfet_g5v0d10v5_32MMT9 B D S G VSUBS
X0 S G D B sky130_fd_pr__pfet_g5v0d10v5 ad=0.1218 pd=1.42 as=0.1218 ps=1.42 w=0.42 l=50
C0 D B 0.049475f
C1 S B 0.049475f
C2 D G 0.025096f
C3 S G 0.025096f
C4 B G 11.7075f
C5 S VSUBS 0.04086f
C6 D VSUBS 0.04086f
C7 G VSUBS 10.6399f
C8 B VSUBS 25.0718f
.ends

.subckt sky130_fd_pr__res_xhigh_po_0p35_VEZ8JB B R1 R2
X0 R1 R2 B sky130_fd_pr__res_xhigh_po_0p35 l=29.46
C0 R2 B 0.597536f
C1 R1 B 0.597536f
.ends

.subckt sky130_fd_pr__pfet_g5v0d10v5_MN82PF B D S G VSUBS
X0 S G D B sky130_fd_pr__pfet_g5v0d10v5 ad=1.16 pd=8.58 as=1.16 ps=8.58 w=4 l=4
C0 D S 0.065571f
C1 D B 0.250339f
C2 S B 0.250339f
C3 D G 0.158746f
C4 S G 0.158746f
C5 B G 0.922222f
C6 S VSUBS 0.263093f
C7 D VSUBS 0.263093f
C8 G VSUBS 0.882827f
C9 B VSUBS 6.46382f
.ends

.subckt sky130_fd_pr__res_xhigh_po_0p35_YNY9WN B R1 R2
X0 R2 R1 B sky130_fd_pr__res_xhigh_po_0p35 l=278.22
C0 R1 B 0.577911f
C1 R2 B 0.577911f
.ends

.subckt sky130_fd_pr__res_xhigh_po_0p35_HGUK4G B R1 R2
X0 R1 R2 B sky130_fd_pr__res_xhigh_po_0p35 l=58.86
C0 R2 B 0.597536f
C1 R1 B 0.597536f
.ends

.subckt sky130_fd_pr__res_xhigh_po_0p35_8Z5M7R B R1 R2
X0 R2 R1 B sky130_fd_pr__res_xhigh_po_0p35 l=467.55
C0 R2 R1 0.035726f
C1 R2 B 0.550181f
C2 R1 B 0.550181f
.ends

.subckt sky130_fd_pr__res_xhigh_po_0p35_KAXJA5 B R1 R2
X0 R2 R1 B sky130_fd_pr__res_xhigh_po_0p35 l=187.59
C0 R2 R1 0.086197f
C1 R2 B 0.493283f
C2 R1 B 0.493283f
.ends

.subckt sky130_fd_pr__pfet_g5v0d10v5_XFEL6A B D S G VSUBS
X0 S G D B sky130_fd_pr__pfet_g5v0d10v5 ad=5.8 pd=40.58 as=5.8 ps=40.58 w=20 l=16
C0 D B 1.14803f
C1 D G 0.843488f
C2 S B 1.14803f
C3 S G 0.843488f
C4 B G 3.34744f
C5 S VSUBS 1.63569f
C6 D VSUBS 1.63569f
C7 G VSUBS 3.58579f
C8 B VSUBS 54.8998f
.ends

.subckt sky130_fd_pr__res_xhigh_po_0p35_NT9K52 B R1 R2
X0 R2 R1 B sky130_fd_pr__res_xhigh_po_0p35 l=583.97
C0 R2 R1 0.02764f
C1 R2 B 0.560383f
C2 R1 B 0.560383f
.ends

.subckt sky130_fd_pr__res_xhigh_po_0p35_J82YCH B R1 R2
X0 R2 R1 B sky130_fd_pr__res_xhigh_po_0p35 l=205.27
C0 R2 R1 0.086197f
C1 R2 B 0.493283f
C2 R1 B 0.493283f
.ends

.subckt sky130_fd_pr__pfet_g5v0d10v5_PSYF8E B D0 G0 S1 G1 D2 G2 S3 G3 D4 G4 S5 G5
+ D6 G6 S7 G7 D8 G8 S9 G9 D10 G10 S11 G11 D12 G12 S13 G13 D14 G14 S15 G15 D16 G16
+ S17 G17 D18 G18 S19 G19 D20 G20 S21 G21 D22 G22 S23 G23 D24 G24 S25 G25 D26 G26
+ S27 G27 D28 G28 S29 G29 D30 G30 S31 G31 D32 G32 S33 G33 D34 G34 S35 G35 D36 G36
+ S37 G37 D38 G38 S39 G39 a_3131_n1036# VSUBS
X0 S17 G16 D16 B sky130_fd_pr__pfet_g5v0d10v5 ad=1.45 pd=10.29 as=1.45 ps=10.29 w=10 l=0.5
X1 S3 G2 D2 B sky130_fd_pr__pfet_g5v0d10v5 ad=1.45 pd=10.29 as=1.45 ps=10.29 w=10 l=0.5
X2 D22 G21 S21 B sky130_fd_pr__pfet_g5v0d10v5 ad=1.45 pd=10.29 as=1.45 ps=10.29 w=10 l=0.5
X3 D2 G1 S1 B sky130_fd_pr__pfet_g5v0d10v5 ad=1.45 pd=10.29 as=1.45 ps=10.29 w=10 l=0.5
X4 D16 G15 S15 B sky130_fd_pr__pfet_g5v0d10v5 ad=1.45 pd=10.29 as=1.45 ps=10.29 w=10 l=0.5
X5 S13 G12 D12 B sky130_fd_pr__pfet_g5v0d10v5 ad=1.45 pd=10.29 as=1.45 ps=10.29 w=10 l=0.5
X6 D12 G11 S11 B sky130_fd_pr__pfet_g5v0d10v5 ad=1.45 pd=10.29 as=1.45 ps=10.29 w=10 l=0.5
X7 D10 G9 S9 B sky130_fd_pr__pfet_g5v0d10v5 ad=1.45 pd=10.29 as=1.45 ps=10.29 w=10 l=0.5
X8 D20 G19 S19 B sky130_fd_pr__pfet_g5v0d10v5 ad=1.45 pd=10.29 as=1.45 ps=10.29 w=10 l=0.5
X9 D30 G29 S29 B sky130_fd_pr__pfet_g5v0d10v5 ad=1.45 pd=10.29 as=1.45 ps=10.29 w=10 l=0.5
X10 D34 G33 S33 B sky130_fd_pr__pfet_g5v0d10v5 ad=1.45 pd=10.29 as=1.45 ps=10.29 w=10 l=0.5
X11 S9 G8 D8 B sky130_fd_pr__pfet_g5v0d10v5 ad=1.45 pd=10.29 as=1.45 ps=10.29 w=10 l=0.5
X12 S19 G18 D18 B sky130_fd_pr__pfet_g5v0d10v5 ad=1.45 pd=10.29 as=1.45 ps=10.29 w=10 l=0.5
X13 S5 G4 D4 B sky130_fd_pr__pfet_g5v0d10v5 ad=1.45 pd=10.29 as=1.45 ps=10.29 w=10 l=0.5
X14 S33 G32 D32 B sky130_fd_pr__pfet_g5v0d10v5 ad=1.45 pd=10.29 as=1.45 ps=10.29 w=10 l=0.5
X15 S37 G36 D36 B sky130_fd_pr__pfet_g5v0d10v5 ad=1.45 pd=10.29 as=1.45 ps=10.29 w=10 l=0.5
X16 S1 G0 D0 B sky130_fd_pr__pfet_g5v0d10v5 ad=1.45 pd=10.29 as=2.9 ps=20.58 w=10 l=0.5
X17 S21 G20 D20 B sky130_fd_pr__pfet_g5v0d10v5 ad=1.45 pd=10.29 as=1.45 ps=10.29 w=10 l=0.5
X18 S23 G22 D22 B sky130_fd_pr__pfet_g5v0d10v5 ad=1.45 pd=10.29 as=1.45 ps=10.29 w=10 l=0.5
X19 D8 G7 S7 B sky130_fd_pr__pfet_g5v0d10v5 ad=1.45 pd=10.29 as=1.45 ps=10.29 w=10 l=0.5
X20 D26 G25 S25 B sky130_fd_pr__pfet_g5v0d10v5 ad=1.45 pd=10.29 as=1.45 ps=10.29 w=10 l=0.5
X21 S11 G10 D10 B sky130_fd_pr__pfet_g5v0d10v5 ad=1.45 pd=10.29 as=1.45 ps=10.29 w=10 l=0.5
X22 S27 G26 D26 B sky130_fd_pr__pfet_g5v0d10v5 ad=1.45 pd=10.29 as=1.45 ps=10.29 w=10 l=0.5
X23 S7 G6 D6 B sky130_fd_pr__pfet_g5v0d10v5 ad=1.45 pd=10.29 as=1.45 ps=10.29 w=10 l=0.5
X24 S35 G34 D34 B sky130_fd_pr__pfet_g5v0d10v5 ad=1.45 pd=10.29 as=1.45 ps=10.29 w=10 l=0.5
X25 D4 G3 S3 B sky130_fd_pr__pfet_g5v0d10v5 ad=1.45 pd=10.29 as=1.45 ps=10.29 w=10 l=0.5
X26 D18 G17 S17 B sky130_fd_pr__pfet_g5v0d10v5 ad=1.45 pd=10.29 as=1.45 ps=10.29 w=10 l=0.5
X27 D38 G37 S37 B sky130_fd_pr__pfet_g5v0d10v5 ad=1.45 pd=10.29 as=1.45 ps=10.29 w=10 l=0.5
X28 S15 G14 D14 B sky130_fd_pr__pfet_g5v0d10v5 ad=1.45 pd=10.29 as=1.45 ps=10.29 w=10 l=0.5
X29 D14 G13 S13 B sky130_fd_pr__pfet_g5v0d10v5 ad=1.45 pd=10.29 as=1.45 ps=10.29 w=10 l=0.5
X30 S39 G38 D38 B sky130_fd_pr__pfet_g5v0d10v5 ad=1.45 pd=10.29 as=1.45 ps=10.29 w=10 l=0.5
X31 D28 G27 S27 B sky130_fd_pr__pfet_g5v0d10v5 ad=1.45 pd=10.29 as=1.45 ps=10.29 w=10 l=0.5
X32 S29 G28 D28 B sky130_fd_pr__pfet_g5v0d10v5 ad=1.45 pd=10.29 as=1.45 ps=10.29 w=10 l=0.5
X33 D24 G23 S23 B sky130_fd_pr__pfet_g5v0d10v5 ad=1.45 pd=10.29 as=1.45 ps=10.29 w=10 l=0.5
X34 S31 G30 D30 B sky130_fd_pr__pfet_g5v0d10v5 ad=1.45 pd=10.29 as=1.45 ps=10.29 w=10 l=0.5
X35 S25 G24 D24 B sky130_fd_pr__pfet_g5v0d10v5 ad=1.45 pd=10.29 as=1.45 ps=10.29 w=10 l=0.5
X36 D32 G31 S31 B sky130_fd_pr__pfet_g5v0d10v5 ad=1.45 pd=10.29 as=1.45 ps=10.29 w=10 l=0.5
X37 D36 G35 S35 B sky130_fd_pr__pfet_g5v0d10v5 ad=1.45 pd=10.29 as=1.45 ps=10.29 w=10 l=0.5
X38 D6 G5 S5 B sky130_fd_pr__pfet_g5v0d10v5 ad=1.45 pd=10.29 as=1.45 ps=10.29 w=10 l=0.5
X39 a_3131_n1036# G39 S39 B sky130_fd_pr__pfet_g5v0d10v5 ad=2.9 pd=20.58 as=1.45 ps=10.29 w=10 l=0.5
C0 G28 D28 0.127776f
C1 S3 D4 0.890272f
C2 G21 D22 0.127776f
C3 S9 B 0.023038f
C4 G9 G8 0.061903f
C5 S37 D38 0.890272f
C6 D18 G18 0.127776f
C7 D36 G35 0.127776f
C8 G13 S13 0.127776f
C9 G22 G21 0.061903f
C10 G17 S17 0.127776f
C11 D12 B 0.023038f
C12 B G20 0.130407f
C13 S7 B 0.023038f
C14 D2 B 0.023038f
C15 B G37 0.130407f
C16 D28 G27 0.127776f
C17 G7 G8 0.061903f
C18 D34 G33 0.127776f
C19 G28 S29 0.127776f
C20 S15 B 0.023038f
C21 G25 B 0.130407f
C22 B G10 0.130407f
C23 S9 D8 0.890272f
C24 S19 G18 0.127776f
C25 G22 G23 0.061903f
C26 G6 G5 0.061903f
C27 D4 B 0.023038f
C28 G13 D14 0.127776f
C29 D6 S5 0.890272f
C30 D18 B 0.023038f
C31 S13 B 0.023038f
C32 D12 S13 0.890272f
C33 D8 B 0.023038f
C34 D34 S35 0.890272f
C35 S7 D8 0.890272f
C36 G32 G31 0.061903f
C37 G36 G35 0.061903f
C38 G23 S23 0.127776f
C39 S9 D10 0.890272f
C40 S21 B 0.023038f
C41 G29 B 0.130407f
C42 S21 G20 0.127776f
C43 G28 G27 0.061903f
C44 G24 G23 0.061903f
C45 D10 B 0.023038f
C46 S5 B 0.023038f
C47 D24 B 0.023038f
C48 S19 B 0.023038f
C49 G32 B 0.130407f
C50 G13 G14 0.061903f
C51 D14 B 0.023038f
C52 B G26 0.130407f
C53 S27 B 0.023038f
C54 D10 G10 0.127776f
C55 S35 G35 0.127776f
C56 G13 G12 0.061903f
C57 G16 G17 0.061903f
C58 S15 D14 0.890272f
C59 G4 G5 0.061903f
C60 G25 G26 0.061903f
C61 G38 D38 0.127776f
C62 G15 B 0.130407f
C63 D16 B 0.023038f
C64 D4 S5 0.890272f
C65 S11 B 0.023038f
C66 D12 S11 0.890272f
C67 D30 B 0.023038f
C68 G30 G31 0.061903f
C69 S25 B 0.023038f
C70 D18 S19 0.890272f
C71 D20 B 0.023038f
C72 G9 S9 0.127776f
C73 S31 G31 0.127776f
C74 D20 G20 0.127776f
C75 S13 D14 0.890272f
C76 G14 B 0.130407f
C77 G15 S15 0.127776f
C78 S15 D16 0.890272f
C79 G19 G18 0.061903f
C80 S33 B 0.023038f
C81 S11 G10 0.127776f
C82 G9 B 0.130407f
C83 G25 S25 0.127776f
C84 G12 B 0.130407f
C85 G12 D12 0.127776f
C86 B G30 0.130407f
C87 D22 B 0.023038f
C88 G14 S15 0.127776f
C89 S17 B 0.023038f
C90 D36 B 0.023038f
C91 S31 B 0.023038f
C92 D26 B 0.023038f
C93 G9 G10 0.061903f
C94 D32 G31 0.127776f
C95 G22 B 0.130407f
C96 G7 B 0.130407f
C97 G7 S7 0.127776f
C98 G29 D30 0.127776f
C99 S21 D20 0.890272f
C100 D6 G6 0.127776f
C101 G25 D26 0.127776f
C102 S27 G26 0.127776f
C103 G34 D34 0.127776f
C104 G19 B 0.130407f
C105 D10 S11 0.890272f
C106 D28 B 0.023038f
C107 G12 S13 0.127776f
C108 S23 B 0.023038f
C109 G19 G20 0.061903f
C110 D18 S17 0.890272f
C111 S37 B 0.023038f
C112 G34 G33 0.061903f
C113 S39 D38 0.890272f
C114 D32 B 0.023038f
C115 D24 S25 0.890272f
C116 G3 G4 0.061903f
C117 S19 D20 0.890272f
C118 S37 G37 0.127776f
C119 G24 B 0.130407f
C120 S21 D22 0.890272f
C121 G9 D10 0.127776f
C122 G14 D14 0.127776f
C123 G29 G30 0.061903f
C124 B G6 0.130407f
C125 G32 S33 0.127776f
C126 G7 D8 0.127776f
C127 G36 B 0.130407f
C128 G15 D16 0.127776f
C129 D6 G5 0.127776f
C130 S7 G6 0.127776f
C131 G34 S35 0.127776f
C132 G24 G25 0.061903f
C133 D34 B 0.023038f
C134 S29 B 0.023038f
C135 G36 G37 0.061903f
C136 D38 B 0.023038f
C137 G34 G35 0.061903f
C138 G28 B 0.130407f
C139 B G33 0.130407f
C140 G15 G14 0.061903f
C141 G17 G18 0.061903f
C142 D38 G37 0.127776f
C143 D26 G26 0.127776f
C144 G16 B 0.130407f
C145 B G11 0.130407f
C146 S27 D26 0.890272f
C147 D0 G0 0.127776f
C148 D12 G11 0.127776f
C149 B G5 0.130407f
C150 G0 G1 0.061903f
C151 D16 S17 0.890272f
C152 D30 G30 0.127776f
C153 S35 B 0.023038f
C154 G19 S19 0.127776f
C155 G39 G38 0.061903f
C156 D24 S23 0.890272f
C157 S9 G8 0.127776f
C158 D30 S31 0.890272f
C159 B G27 0.130407f
C160 G21 B 0.130407f
C161 B G35 0.130407f
C162 S25 D26 0.890272f
C163 G11 G10 0.061903f
C164 G38 S39 0.127776f
C165 G32 D32 0.127776f
C166 G21 G20 0.061903f
C167 G24 D24 0.127776f
C168 S27 D28 0.890272f
C169 B G8 0.130407f
C170 G29 S29 0.127776f
C171 G17 B 0.130407f
C172 B G4 0.130407f
C173 S3 G3 0.127776f
C174 S1 G0 0.127776f
C175 G29 G28 0.061903f
C176 S31 G30 0.127776f
C177 G23 B 0.130407f
C178 G19 D20 0.127776f
C179 G22 D22 0.127776f
C180 G38 B 0.130407f
C181 G3 G2 0.061903f
C182 G32 G33 0.061903f
C183 G24 S25 0.127776f
C184 G38 G37 0.061903f
C185 D4 G4 0.127776f
C186 G0 B 0.15506f
C187 S33 D32 0.890272f
C188 G17 D18 0.127776f
C189 D8 G8 0.127776f
C190 S5 G5 0.127776f
C191 G21 S21 0.127776f
C192 D0 S1 0.890272f
C193 S1 G1 0.127776f
C194 D22 S23 0.890272f
C195 G1 G2 0.061903f
C196 D30 S29 0.890272f
C197 D36 S37 0.890272f
C198 G3 B 0.130407f
C199 G39 a_3131_n1036# 0.127776f
C200 S31 D32 0.890272f
C201 G39 S39 0.127776f
C202 G22 S23 0.127776f
C203 S3 G2 0.127776f
C204 G27 G26 0.061903f
C205 S33 D34 0.890272f
C206 G15 G16 0.061903f
C207 S39 a_3131_n1036# 0.890272f
C208 G16 D16 0.127776f
C209 D0 B 0.58701f
C210 S5 G4 0.127776f
C211 S11 G11 0.127776f
C212 S27 G27 0.127776f
C213 G1 B 0.130407f
C214 S33 G33 0.127776f
C215 G36 D36 0.127776f
C216 D2 G1 0.127776f
C217 D4 G3 0.127776f
C218 G23 D24 0.127776f
C219 S3 B 0.023038f
C220 B G18 0.130407f
C221 G7 G6 0.061903f
C222 G39 B 0.15506f
C223 S3 D2 0.890272f
C224 G13 B 0.130407f
C225 G12 G11 0.061903f
C226 G34 B 0.130407f
C227 a_3131_n1036# B 0.58701f
C228 G16 S17 0.127776f
C229 S39 B 0.023038f
C230 D6 B 0.023038f
C231 S1 B 0.023038f
C232 B G31 0.130407f
C233 D6 S7 0.890272f
C234 G2 B 0.130407f
C235 G36 S37 0.127776f
C236 D28 S29 0.890272f
C237 S1 D2 0.890272f
C238 D2 G2 0.127776f
C239 D36 S35 0.890272f
C240 S39 VSUBS 0.172108f
C241 D38 VSUBS 0.172108f
C242 S37 VSUBS 0.172108f
C243 D36 VSUBS 0.172108f
C244 S35 VSUBS 0.172108f
C245 D34 VSUBS 0.172108f
C246 S33 VSUBS 0.172108f
C247 D32 VSUBS 0.172108f
C248 S31 VSUBS 0.172108f
C249 D30 VSUBS 0.172108f
C250 S29 VSUBS 0.172108f
C251 D28 VSUBS 0.172108f
C252 S27 VSUBS 0.172108f
C253 D26 VSUBS 0.172108f
C254 S25 VSUBS 0.172108f
C255 D24 VSUBS 0.172108f
C256 S23 VSUBS 0.172108f
C257 D22 VSUBS 0.172108f
C258 S21 VSUBS 0.172108f
C259 D20 VSUBS 0.172108f
C260 S19 VSUBS 0.172108f
C261 D18 VSUBS 0.172108f
C262 S17 VSUBS 0.172108f
C263 D16 VSUBS 0.172108f
C264 S15 VSUBS 0.172108f
C265 D14 VSUBS 0.172108f
C266 S13 VSUBS 0.172108f
C267 D12 VSUBS 0.172108f
C268 S11 VSUBS 0.172108f
C269 D10 VSUBS 0.172108f
C270 S9 VSUBS 0.172108f
C271 D8 VSUBS 0.172108f
C272 S7 VSUBS 0.172108f
C273 D6 VSUBS 0.172108f
C274 S5 VSUBS 0.172108f
C275 D4 VSUBS 0.172108f
C276 S3 VSUBS 0.172108f
C277 D2 VSUBS 0.172108f
C278 S1 VSUBS 0.172108f
C279 D0 VSUBS 0.437153f
C280 G39 VSUBS 0.116486f
C281 G38 VSUBS 0.103106f
C282 G37 VSUBS 0.103106f
C283 G36 VSUBS 0.103106f
C284 G35 VSUBS 0.103106f
C285 G34 VSUBS 0.103106f
C286 G33 VSUBS 0.103106f
C287 G32 VSUBS 0.103106f
C288 G31 VSUBS 0.103106f
C289 G30 VSUBS 0.103106f
C290 G29 VSUBS 0.103106f
C291 G28 VSUBS 0.103106f
C292 G27 VSUBS 0.103106f
C293 G26 VSUBS 0.103106f
C294 G25 VSUBS 0.103106f
C295 G24 VSUBS 0.103106f
C296 G23 VSUBS 0.103106f
C297 G22 VSUBS 0.103106f
C298 G21 VSUBS 0.103106f
C299 G20 VSUBS 0.103106f
C300 G19 VSUBS 0.103106f
C301 G18 VSUBS 0.103106f
C302 G17 VSUBS 0.103106f
C303 G16 VSUBS 0.103106f
C304 G15 VSUBS 0.103106f
C305 G14 VSUBS 0.103106f
C306 G13 VSUBS 0.103106f
C307 G12 VSUBS 0.103106f
C308 G11 VSUBS 0.103106f
C309 G10 VSUBS 0.103106f
C310 G9 VSUBS 0.103106f
C311 G8 VSUBS 0.103106f
C312 G7 VSUBS 0.103106f
C313 G6 VSUBS 0.103106f
C314 G5 VSUBS 0.103106f
C315 G4 VSUBS 0.103106f
C316 G3 VSUBS 0.103106f
C317 G2 VSUBS 0.103106f
C318 G1 VSUBS 0.103106f
C319 G0 VSUBS 0.116486f
C320 B VSUBS 56.7882f
C321 a_3131_n1036# VSUBS 0.437153f
.ends

.subckt sky130_fd_pr__pfet_g5v0d10v5_7B62CL B D S G VSUBS
X0 S G D B sky130_fd_pr__pfet_g5v0d10v5 ad=0.2436 pd=2.26 as=0.2436 ps=2.26 w=0.84 l=0.5
C0 S G 0.01429f
C1 B G 0.190892f
C2 D S 0.076415f
C3 D B 0.073078f
C4 D G 0.01429f
C5 S B 0.073078f
C6 S VSUBS 0.045757f
C7 D VSUBS 0.045757f
C8 G VSUBS 0.127382f
C9 B VSUBS 1.74241f
.ends

.subckt sky130_fd_pr__pfet_g5v0d10v5_PN8J4Z B D0 S0 G0 D1 S1 G1 D2 S2 G2 VSUBS
X0 S2 G2 D2 B sky130_fd_pr__pfet_g5v0d10v5 ad=1.16 pd=8.58 as=1.16 ps=8.58 w=4 l=4
X1 S1 G1 D1 B sky130_fd_pr__pfet_g5v0d10v5 ad=1.16 pd=8.58 as=1.16 ps=8.58 w=4 l=4
X2 S0 G0 D0 B sky130_fd_pr__pfet_g5v0d10v5 ad=1.16 pd=8.58 as=1.16 ps=8.58 w=4 l=4
C0 B S1 0.236968f
C1 G1 S1 0.158746f
C2 S2 G2 0.158746f
C3 G1 B 0.469368f
C4 B G2 0.786334f
C5 G1 G2 0.497349f
C6 D1 D2 0.014232f
C7 B G0 0.605257f
C8 D1 S1 0.065571f
C9 S1 S0 0.014232f
C10 G1 G0 0.497349f
C11 D1 B 0.236968f
C12 B S0 0.244168f
C13 D1 G1 0.158746f
C14 B D0 0.244168f
C15 S0 G0 0.158746f
C16 D2 S2 0.065571f
C17 G0 D0 0.158746f
C18 D2 B 0.243139f
C19 S2 S1 0.014232f
C20 D1 D0 0.014232f
C21 S0 D0 0.065571f
C22 D2 G2 0.158746f
C23 S2 B 0.243139f
C24 S0 VSUBS 0.257653f
C25 D0 VSUBS 0.257653f
C26 G0 VSUBS 0.801835f
C27 S1 VSUBS 0.251456f
C28 D1 VSUBS 0.251456f
C29 G1 VSUBS 0.703093f
C30 S2 VSUBS 0.256896f
C31 D2 VSUBS 0.256896f
C32 G2 VSUBS 0.784084f
C33 B VSUBS 15.1219f
.ends

.subckt sky130_fd_pr__res_xhigh_po_0p35_ADWJQG B R1 R2
X0 R2 R1 B sky130_fd_pr__res_xhigh_po_0p35 l=292.92
C0 R1 B 0.577911f
C1 R2 B 0.577911f
.ends

.subckt sky130_fd_pr__nfet_g5v0d10v5_3UQFYT B D0 S0 G0 D1 S1 G1 D2 S2 G2
X0 S0 G0 D0 B sky130_fd_pr__nfet_g5v0d10v5 ad=0.58 pd=4.58 as=0.58 ps=4.58 w=2 l=4
X1 S1 G1 D1 B sky130_fd_pr__nfet_g5v0d10v5 ad=0.58 pd=4.58 as=0.58 ps=4.58 w=2 l=4
X2 S2 G2 D2 B sky130_fd_pr__nfet_g5v0d10v5 ad=0.58 pd=4.58 as=0.58 ps=4.58 w=2 l=4
C0 G0 G1 0.519044f
C1 S2 G2 0.082975f
C2 G0 D0 0.082975f
C3 G0 S0 0.082975f
C4 D1 D2 0.014895f
C5 G1 G2 0.519044f
C6 D1 G1 0.082975f
C7 S1 S2 0.014895f
C8 D0 D1 0.014895f
C9 D0 S0 0.032918f
C10 S1 G1 0.082975f
C11 S1 D1 0.032918f
C12 S0 S1 0.014895f
C13 S2 D2 0.032918f
C14 D2 G2 0.082975f
C15 S0 B 0.259336f
C16 D0 B 0.259336f
C17 G0 B 1.37874f
C18 S1 B 0.245838f
C19 D1 B 0.245838f
C20 G1 B 1.10221f
C21 S2 B 0.257756f
C22 D2 B 0.257756f
C23 G2 B 1.52414f
.ends

.subckt sky130_fd_pr__cap_mim_m3_1_Y3HN7X C2 C1 VSUBS
X0 C1 C2 sky130_fd_pr__cap_mim_m3_1 l=27.5 w=27.5
C0 C1 C2 66.5348f
C1 C1 VSUBS 2.85705f
C2 C2 VSUBS 16.0169f
.ends

.subckt sky130_fd_pr__pfet_g5v0d10v5_DNGK98 B D S G VSUBS
X0 S G D B sky130_fd_pr__pfet_g5v0d10v5 ad=4.64 pd=32.58 as=4.64 ps=32.58 w=16 l=4
C0 G B 0.895007f
C1 S D 0.26149f
C2 G S 0.613371f
C3 G D 0.613371f
C4 B S 0.923613f
C5 B D 0.923613f
C6 S VSUBS 1.03041f
C7 D VSUBS 1.03041f
C8 G VSUBS 0.910237f
C9 B VSUBS 17.1758f
.ends

.subckt sky130_fd_pr__nfet_g5v0d10v5_WMYWGM B D S G
X0 S G D B sky130_fd_pr__nfet_g5v0d10v5 ad=2.32 pd=16.58 as=2.32 ps=16.58 w=8 l=2
C0 D G 0.254328f
C1 D S 0.246248f
C2 G S 0.254328f
C3 S B 0.92443f
C4 D B 0.92443f
C5 G B 0.935471f
.ends

.subckt sky130_fd_pr__cap_mim_m3_1_PP9XRG C2 C1 VSUBS
X0 C1 C2 sky130_fd_pr__cap_mim_m3_1 l=30 w=30
C0 C1 C2 78.8907f
C1 C1 VSUBS 3.12051f
C2 C2 VSUBS 18.375599f
.ends

.subckt sky130_fd_pr__nfet_g5v0d10v5_FZ2B7C B D S G
X0 S G D B sky130_fd_pr__nfet_g5v0d10v5 ad=0.1218 pd=1.42 as=0.1218 ps=1.42 w=0.42 l=0.5
C0 D G 0.009087f
C1 D S 0.039098f
C2 G S 0.009087f
C3 S B 0.076791f
C4 D B 0.076791f
C5 G B 0.314309f
.ends

.subckt sky130_fd_pr__nfet_g5v0d10v5_DDWFWJ B D0 G0 S1 G1 D2 S2 G2
X0 D2 G1 S1 B sky130_fd_pr__nfet_g5v0d10v5 ad=0.58 pd=4.29 as=0.58 ps=4.29 w=4 l=1
X1 S1 G0 D0 B sky130_fd_pr__nfet_g5v0d10v5 ad=0.58 pd=4.29 as=1.16 ps=8.58 w=4 l=1
X2 S2 G2 D2 B sky130_fd_pr__nfet_g5v0d10v5 ad=1.16 pd=8.58 as=0.58 ps=4.29 w=4 l=1
C0 G1 G0 0.05942f
C1 S2 G2 0.090922f
C2 G0 S1 0.090922f
C3 D2 S2 0.219309f
C4 D2 G2 0.090922f
C5 D0 S1 0.219309f
C6 G1 G2 0.05942f
C7 D2 G1 0.090922f
C8 G0 D0 0.090922f
C9 D2 S1 0.219309f
C10 G1 S1 0.090922f
C11 S2 B 0.448578f
C12 D2 B 0.140565f
C13 S1 B 0.140565f
C14 D0 B 0.448578f
C15 G2 B 0.477445f
C16 G1 B 0.441242f
C17 G0 B 0.477445f
.ends

.subckt sky130_fd_pr__nfet_g5v0d10v5_HA9V6X B D0 S0 G0 D1 S1 G1 D2 S2 G2 D3 S3 G3
X0 S1 G1 D1 B sky130_fd_pr__nfet_g5v0d10v5 ad=0.58 pd=4.58 as=0.58 ps=4.58 w=2 l=4
X1 S3 G3 D3 B sky130_fd_pr__nfet_g5v0d10v5 ad=0.58 pd=4.58 as=0.58 ps=4.58 w=2 l=4
X2 S2 G2 D2 B sky130_fd_pr__nfet_g5v0d10v5 ad=0.58 pd=4.58 as=0.58 ps=4.58 w=2 l=4
X3 S0 G0 D0 B sky130_fd_pr__nfet_g5v0d10v5 ad=0.58 pd=4.58 as=0.58 ps=4.58 w=2 l=4
C0 S1 S0 0.014895f
C1 G2 G1 0.519044f
C2 G3 D3 0.082975f
C3 S3 S2 0.014895f
C4 D1 D2 0.014895f
C5 S3 D3 0.032918f
C6 D1 S1 0.032918f
C7 D0 S0 0.032918f
C8 G2 D2 0.082975f
C9 G0 G1 0.519044f
C10 S1 G1 0.082975f
C11 G3 G2 0.519044f
C12 D1 D0 0.014895f
C13 G2 S2 0.082975f
C14 S2 D2 0.032918f
C15 G0 D0 0.082975f
C16 G3 S3 0.082975f
C17 D3 D2 0.014895f
C18 D1 G1 0.082975f
C19 G0 S0 0.082975f
C20 S1 S2 0.014895f
C21 S0 B 0.259336f
C22 D0 B 0.259336f
C23 G0 B 1.37874f
C24 S1 B 0.245838f
C25 D1 B 0.245838f
C26 G1 B 1.10221f
C27 S2 B 0.245838f
C28 D2 B 0.245838f
C29 G2 B 1.10221f
C30 S3 B 0.257756f
C31 D3 B 0.257756f
C32 G3 B 1.52414f
.ends

.subckt sky130_fd_pr__pfet_g5v0d10v5_UFWJXT B D0_0 G0_0 D0_1 G0_1 D0_2 G0_2 D0_3 G0_3
+ S1_0 G1_0 S1_1 G1_1 S1_2 G1_2 S1_3 G1_3 a_3229_n8283# a_3229_4212# a_3229_47# a_3229_n4118#
+ VSUBS
X0 a_3229_47# G1_2 S1_2 B sky130_fd_pr__pfet_g5v0d10v5 ad=5.8 pd=40.58 as=2.9 ps=20.29 w=20 l=16
X1 S1_2 G0_2 D0_2 B sky130_fd_pr__pfet_g5v0d10v5 ad=2.9 pd=20.29 as=5.8 ps=40.58 w=20 l=16
X2 a_3229_n4118# G1_1 S1_1 B sky130_fd_pr__pfet_g5v0d10v5 ad=5.8 pd=40.58 as=2.9 ps=20.29 w=20 l=16
X3 S1_3 G0_3 D0_3 B sky130_fd_pr__pfet_g5v0d10v5 ad=2.9 pd=20.29 as=5.8 ps=40.58 w=20 l=16
X4 S1_0 G0_0 D0_0 B sky130_fd_pr__pfet_g5v0d10v5 ad=2.9 pd=20.29 as=5.8 ps=40.58 w=20 l=16
X5 a_3229_n8283# G1_0 S1_0 B sky130_fd_pr__pfet_g5v0d10v5 ad=5.8 pd=40.58 as=2.9 ps=20.29 w=20 l=16
X6 a_3229_4212# G1_3 S1_3 B sky130_fd_pr__pfet_g5v0d10v5 ad=5.8 pd=40.58 as=2.9 ps=20.29 w=20 l=16
X7 S1_1 G0_1 D0_1 B sky130_fd_pr__pfet_g5v0d10v5 ad=2.9 pd=20.29 as=5.8 ps=40.58 w=20 l=16
C0 G0_2 G0_1 1.79553f
C1 G1_3 G1_2 1.79553f
C2 G0_3 D0_3 0.843488f
C3 a_3229_n8283# G1_0 0.843488f
C4 G1_0 G1_1 1.79553f
C5 G0_2 G1_2 0.061903f
C6 D0_1 B 1.13466f
C7 a_3229_47# B 1.13466f
C8 S1_1 B 0.009589f
C9 S1_1 S1_0 0.014232f
C10 a_3229_4212# B 1.14084f
C11 D0_2 B 1.13466f
C12 G1_3 B 2.88484f
C13 a_3229_n4118# a_3229_n8283# 0.014232f
C14 a_3229_n4118# G1_1 0.843488f
C15 G1_0 B 2.05553f
C16 G0_0 G1_0 0.061903f
C17 G1_1 G0_1 0.061903f
C18 G1_0 S1_0 0.843488f
C19 G0_2 B 1.61352f
C20 G0_3 B 2.88484f
C21 G1_1 G1_2 1.79553f
C22 S1_1 S1_2 0.014232f
C23 S1_3 B 0.015764f
C24 G0_2 S1_2 0.843488f
C25 a_3229_n4118# B 1.13466f
C26 G0_1 B 1.61352f
C27 G0_0 G0_1 1.79553f
C28 D0_3 B 1.14084f
C29 D0_2 D0_1 0.014232f
C30 G1_2 B 1.61352f
C31 a_3229_47# a_3229_4212# 0.014232f
C32 a_3229_n8283# B 1.14186f
C33 G1_1 B 1.61352f
C34 S1_3 S1_2 0.014232f
C35 D0_0 B 1.14186f
C36 G0_0 D0_0 0.843488f
C37 G1_3 a_3229_4212# 0.843488f
C38 D0_2 G0_2 0.843488f
C39 G1_2 S1_2 0.843488f
C40 G1_3 G0_3 0.061903f
C41 D0_1 G0_1 0.843488f
C42 G0_0 B 2.05553f
C43 S1_0 B 0.016789f
C44 G0_0 S1_0 0.843488f
C45 G0_3 G0_2 1.79553f
C46 a_3229_47# a_3229_n4118# 0.014232f
C47 G1_3 S1_3 0.843488f
C48 S1_1 G0_1 0.843488f
C49 D0_1 D0_0 0.014232f
C50 D0_2 D0_3 0.014232f
C51 a_3229_47# G1_2 0.843488f
C52 G0_3 S1_3 0.843488f
C53 S1_1 G1_1 0.843488f
C54 B S1_2 0.009589f
C55 S1_0 VSUBS 1.87158f
C56 D0_0 VSUBS 1.63025f
C57 G1_0 VSUBS 3.5167f
C58 G0_0 VSUBS 3.5167f
C59 S1_1 VSUBS 1.86538f
C60 D0_1 VSUBS 1.62405f
C61 G1_1 VSUBS 3.26881f
C62 G0_1 VSUBS 3.26881f
C63 S1_2 VSUBS 1.86538f
C64 D0_2 VSUBS 1.62405f
C65 G1_2 VSUBS 3.26881f
C66 G0_2 VSUBS 3.26881f
C67 S1_3 VSUBS 1.87083f
C68 D0_3 VSUBS 1.6295f
C69 G1_3 VSUBS 3.32544f
C70 G0_3 VSUBS 3.32544f
C71 B VSUBS 0.369011p
C72 a_3229_n8283# VSUBS 1.63025f
C73 a_3229_n4118# VSUBS 1.62405f
C74 a_3229_47# VSUBS 1.62405f
C75 a_3229_4212# VSUBS 1.6295f
.ends

.subckt sky130_fd_pr__nfet_g5v0d10v5_F3NX3J B D S G
X0 S G D B sky130_fd_pr__nfet_g5v0d10v5 ad=0.1218 pd=1.42 as=0.1218 ps=1.42 w=0.42 l=4
C0 D G 0.023116f
C1 D S 0.007122f
C2 S G 0.023116f
C3 S B 0.083121f
C4 D B 0.083121f
C5 G B 1.85725f
.ends

.subckt sky130_fd_pr__pfet_g5v0d10v5_KMGDV8 B D0_0 G0_0 D0_1 G0_1 D0_2 G0_2 D0_3 G0_3
+ S1_0 G1_0 S1_1 G1_1 S1_2 G1_2 S1_3 G1_3 D2_0 G2_0 D2_1 G2_1 D2_2 G2_2 D2_3 G2_3
+ S3_0 G3_0 S3_1 G3_1 S3_2 G3_2 S3_3 G3_3 D4_0 G4_0 D4_1 G4_1 D4_2 G4_2 D4_3 G4_3
+ S5_0 G5_0 S5_1 G5_1 S5_2 G5_2 S5_3 G5_3 D6_0 G6_0 D6_1 G6_1 D6_2 G6_2 D6_3 G6_3
+ S7_0 G7_0 S7_1 G7_1 S7_2 G7_2 S7_3 G7_3 a_1803_n8283# a_1803_4212# a_1803_n4118#
+ a_1803_47# VSUBS
X0 a_1803_4212# G7_3 S7_3 B sky130_fd_pr__pfet_g5v0d10v5 ad=5.8 pd=40.58 as=2.9 ps=20.29 w=20 l=2
X1 S5_2 G4_2 D4_2 B sky130_fd_pr__pfet_g5v0d10v5 ad=2.9 pd=20.29 as=2.9 ps=20.29 w=20 l=2
X2 D6_3 G5_3 S5_3 B sky130_fd_pr__pfet_g5v0d10v5 ad=2.9 pd=20.29 as=2.9 ps=20.29 w=20 l=2
X3 S3_3 G2_3 D2_3 B sky130_fd_pr__pfet_g5v0d10v5 ad=2.9 pd=20.29 as=2.9 ps=20.29 w=20 l=2
X4 S5_1 G4_1 D4_1 B sky130_fd_pr__pfet_g5v0d10v5 ad=2.9 pd=20.29 as=2.9 ps=20.29 w=20 l=2
X5 S3_0 G2_0 D2_0 B sky130_fd_pr__pfet_g5v0d10v5 ad=2.9 pd=20.29 as=2.9 ps=20.29 w=20 l=2
X6 S1_3 G0_3 D0_3 B sky130_fd_pr__pfet_g5v0d10v5 ad=2.9 pd=20.29 as=5.8 ps=40.58 w=20 l=2
X7 D4_2 G3_2 S3_2 B sky130_fd_pr__pfet_g5v0d10v5 ad=2.9 pd=20.29 as=2.9 ps=20.29 w=20 l=2
X8 D2_0 G1_0 S1_0 B sky130_fd_pr__pfet_g5v0d10v5 ad=2.9 pd=20.29 as=2.9 ps=20.29 w=20 l=2
X9 D6_0 G5_0 S5_0 B sky130_fd_pr__pfet_g5v0d10v5 ad=2.9 pd=20.29 as=2.9 ps=20.29 w=20 l=2
X10 a_1803_n8283# G7_0 S7_0 B sky130_fd_pr__pfet_g5v0d10v5 ad=5.8 pd=40.58 as=2.9 ps=20.29 w=20 l=2
X11 S3_2 G2_2 D2_2 B sky130_fd_pr__pfet_g5v0d10v5 ad=2.9 pd=20.29 as=2.9 ps=20.29 w=20 l=2
X12 S7_0 G6_0 D6_0 B sky130_fd_pr__pfet_g5v0d10v5 ad=2.9 pd=20.29 as=2.9 ps=20.29 w=20 l=2
X13 D4_3 G3_3 S3_3 B sky130_fd_pr__pfet_g5v0d10v5 ad=2.9 pd=20.29 as=2.9 ps=20.29 w=20 l=2
X14 S1_0 G0_0 D0_0 B sky130_fd_pr__pfet_g5v0d10v5 ad=2.9 pd=20.29 as=5.8 ps=40.58 w=20 l=2
X15 D4_0 G3_0 S3_0 B sky130_fd_pr__pfet_g5v0d10v5 ad=2.9 pd=20.29 as=2.9 ps=20.29 w=20 l=2
X16 S7_3 G6_3 D6_3 B sky130_fd_pr__pfet_g5v0d10v5 ad=2.9 pd=20.29 as=2.9 ps=20.29 w=20 l=2
X17 S3_1 G2_1 D2_1 B sky130_fd_pr__pfet_g5v0d10v5 ad=2.9 pd=20.29 as=2.9 ps=20.29 w=20 l=2
X18 D6_1 G5_1 S5_1 B sky130_fd_pr__pfet_g5v0d10v5 ad=2.9 pd=20.29 as=2.9 ps=20.29 w=20 l=2
X19 D2_1 G1_1 S1_1 B sky130_fd_pr__pfet_g5v0d10v5 ad=2.9 pd=20.29 as=2.9 ps=20.29 w=20 l=2
X20 a_1803_n4118# G7_1 S7_1 B sky130_fd_pr__pfet_g5v0d10v5 ad=5.8 pd=40.58 as=2.9 ps=20.29 w=20 l=2
X21 S1_1 G0_1 D0_1 B sky130_fd_pr__pfet_g5v0d10v5 ad=2.9 pd=20.29 as=5.8 ps=40.58 w=20 l=2
X22 S7_1 G6_1 D6_1 B sky130_fd_pr__pfet_g5v0d10v5 ad=2.9 pd=20.29 as=2.9 ps=20.29 w=20 l=2
X23 D2_3 G1_3 S1_3 B sky130_fd_pr__pfet_g5v0d10v5 ad=2.9 pd=20.29 as=2.9 ps=20.29 w=20 l=2
X24 D4_1 G3_1 S3_1 B sky130_fd_pr__pfet_g5v0d10v5 ad=2.9 pd=20.29 as=2.9 ps=20.29 w=20 l=2
X25 D6_2 G5_2 S5_2 B sky130_fd_pr__pfet_g5v0d10v5 ad=2.9 pd=20.29 as=2.9 ps=20.29 w=20 l=2
X26 D2_2 G1_2 S1_2 B sky130_fd_pr__pfet_g5v0d10v5 ad=2.9 pd=20.29 as=2.9 ps=20.29 w=20 l=2
X27 a_1803_47# G7_2 S7_2 B sky130_fd_pr__pfet_g5v0d10v5 ad=5.8 pd=40.58 as=2.9 ps=20.29 w=20 l=2
X28 S5_0 G4_0 D4_0 B sky130_fd_pr__pfet_g5v0d10v5 ad=2.9 pd=20.29 as=2.9 ps=20.29 w=20 l=2
X29 S7_2 G6_2 D6_2 B sky130_fd_pr__pfet_g5v0d10v5 ad=2.9 pd=20.29 as=2.9 ps=20.29 w=20 l=2
X30 S5_3 G4_3 D4_3 B sky130_fd_pr__pfet_g5v0d10v5 ad=2.9 pd=20.29 as=2.9 ps=20.29 w=20 l=2
X31 S1_2 G0_2 D0_2 B sky130_fd_pr__pfet_g5v0d10v5 ad=2.9 pd=20.29 as=5.8 ps=40.58 w=20 l=2
C0 G3_0 B 0.278378f
C1 G1_1 G0_1 0.061903f
C2 D2_3 B 0.015791f
C3 B G3_2 0.223127f
C4 G4_0 G3_0 0.061903f
C5 G0_0 B 0.303032f
C6 D2_2 G2_2 0.625982f
C7 D6_3 G6_3 0.625982f
C8 S5_2 G5_2 0.625982f
C9 S3_0 D4_0 0.614813f
C10 D4_2 G4_2 0.625982f
C11 G1_3 B 0.382207f
C12 G7_2 G6_2 0.061903f
C13 G3_0 D4_0 0.625982f
C14 D2_0 G1_0 0.625982f
C15 G2_0 S3_0 0.625982f
C16 G0_1 S1_1 0.625982f
C17 G7_0 G7_1 0.227831f
C18 S3_1 D4_1 0.614813f
C19 S7_3 G6_3 0.625982f
C20 G3_0 G2_0 0.061903f
C21 S3_1 S3_2 0.014232f
C22 G1_2 G1_1 0.227831f
C23 D2_0 B 0.016816f
C24 G2_1 S3_1 0.625982f
C25 D4_2 D4_3 0.014232f
C26 G4_1 S5_1 0.625982f
C27 D6_1 B 0.009616f
C28 S3_1 B 0.009616f
C29 a_1803_n4118# a_1803_n8283# 0.014232f
C30 D6_3 B 0.015791f
C31 a_1803_n4118# S7_1 0.614813f
C32 D6_1 G6_1 0.625982f
C33 G3_2 G3_3 0.227831f
C34 S3_2 S3_3 0.014232f
C35 S7_2 D6_2 0.614813f
C36 S7_0 a_1803_n8283# 0.614813f
C37 S7_0 S7_1 0.014232f
C38 D2_1 D2_0 0.014232f
C39 G3_0 S3_0 0.625982f
C40 S5_0 S5_1 0.014232f
C41 D2_0 G2_0 0.625982f
C42 S7_3 B 0.015791f
C43 B S3_3 0.015791f
C44 G0_1 D0_1 0.625982f
C45 S7_3 G7_3 0.625982f
C46 S3_1 D2_1 0.614813f
C47 G1_2 S1_2 0.625982f
C48 G6_2 S7_2 0.625982f
C49 G1_2 D2_2 0.625982f
C50 D6_0 B 0.016816f
C51 S5_2 S5_1 0.014232f
C52 G4_1 D4_1 0.625982f
C53 G6_0 B 0.278378f
C54 G7_0 B 0.303032f
C55 a_1803_n4118# G7_1 0.625982f
C56 D2_3 G1_3 0.625982f
C57 G6_0 G6_1 0.227831f
C58 a_1803_47# a_1803_4212# 0.014232f
C59 D6_3 S5_3 0.614813f
C60 G4_1 B 0.223127f
C61 G4_1 G4_0 0.227831f
C62 D2_0 S3_0 0.614813f
C63 G7_2 G7_1 0.227831f
C64 G3_1 D4_1 0.625982f
C65 a_1803_4212# B 1.14085f
C66 S3_1 S3_0 0.014232f
C67 a_1803_4212# G7_3 0.625982f
C68 G2_1 G3_1 0.061903f
C69 G1_1 S1_1 0.625982f
C70 G5_3 G5_2 0.227831f
C71 G2_2 S3_2 0.625982f
C72 G5_2 G5_1 0.227831f
C73 S7_1 S7_2 0.014232f
C74 G3_1 B 0.223127f
C75 S5_0 B 0.016816f
C76 G6_2 D6_2 0.625982f
C77 S3_3 G3_3 0.625982f
C78 G2_1 G2_2 0.227831f
C79 G4_0 S5_0 0.625982f
C80 G5_0 B 0.278378f
C81 G2_2 B 0.223127f
C82 G4_0 G5_0 0.061903f
C83 G5_2 G4_2 0.061903f
C84 a_1803_47# a_1803_n4118# 0.014232f
C85 S5_2 B 0.009616f
C86 G5_2 D6_2 0.625982f
C87 D2_3 S3_3 0.614813f
C88 G4_3 G5_3 0.061903f
C89 S5_0 D4_0 0.614813f
C90 a_1803_n4118# B 1.13467f
C91 a_1803_47# G7_2 0.625982f
C92 S1_1 S1_2 0.014232f
C93 S1_3 S1_2 0.014232f
C94 G7_2 B 0.247781f
C95 G6_2 G5_2 0.061903f
C96 S7_0 B 0.016816f
C97 G4_3 G4_2 0.227831f
C98 G7_2 G7_3 0.227831f
C99 G0_2 G0_1 0.227831f
C100 G0_1 B 0.247781f
C101 D4_2 D4_1 0.014232f
C102 D4_2 S3_2 0.614813f
C103 D2_2 S1_2 0.614813f
C104 S5_1 G5_1 0.625982f
C105 D6_3 S7_3 0.614813f
C106 D4_2 B 0.009616f
C107 S1_1 D0_1 0.614813f
C108 G4_3 D4_3 0.625982f
C109 S5_2 S5_3 0.014232f
C110 G3_1 G3_0 0.227831f
C111 G3_1 G3_2 0.227831f
C112 D6_1 D6_0 0.014232f
C113 D0_2 S1_2 0.614813f
C114 G1_2 G0_2 0.061903f
C115 G2_2 G3_2 0.061903f
C116 G5_3 G6_3 0.061903f
C117 G1_2 B 0.223127f
C118 G0_3 S1_3 0.625982f
C119 a_1803_47# S7_2 0.614813f
C120 B S7_2 0.009616f
C121 S1_1 S1_0 0.014232f
C122 G2_3 B 0.382207f
C123 D0_2 D0_1 0.014232f
C124 G6_0 D6_0 0.625982f
C125 G3_1 S3_1 0.625982f
C126 G5_3 B 0.382207f
C127 B G5_1 0.223127f
C128 G0_1 G0_0 0.227831f
C129 G6_0 G7_0 0.061903f
C130 S7_3 a_1803_4212# 0.614813f
C131 G1_1 G1_0 0.227831f
C132 G6_2 G6_3 0.227831f
C133 G5_1 G6_1 0.061903f
C134 G2_1 G1_1 0.061903f
C135 D4_2 G3_2 0.625982f
C136 G1_1 B 0.223127f
C137 B G4_2 0.223127f
C138 B D6_2 0.009616f
C139 S7_1 G7_1 0.625982f
C140 S5_0 D6_0 0.614813f
C141 D0_0 D0_1 0.014232f
C142 G2_3 G3_3 0.061903f
C143 G5_0 D6_0 0.625982f
C144 B D4_3 0.015791f
C145 S1_1 B 0.009616f
C146 G6_2 B 0.223127f
C147 G1_1 D2_1 0.625982f
C148 B S1_3 0.015791f
C149 G6_0 G5_0 0.061903f
C150 G4_1 G3_1 0.061903f
C151 D2_2 S3_2 0.614813f
C152 G5_3 S5_3 0.625982f
C153 G1_2 G1_3 0.227831f
C154 D2_3 G2_3 0.625982f
C155 G6_2 G6_1 0.227831f
C156 G0_2 S1_2 0.625982f
C157 B S1_2 0.009616f
C158 D2_2 B 0.009616f
C159 B G5_2 0.223127f
C160 D0_0 S1_0 0.614813f
C161 D2_1 S1_1 0.614813f
C162 G2_3 G1_3 0.061903f
C163 S7_0 D6_0 0.614813f
C164 G0_2 D0_2 0.625982f
C165 G6_0 S7_0 0.625982f
C166 D0_2 B 1.13467f
C167 G5_0 S5_0 0.625982f
C168 S7_0 G7_0 0.625982f
C169 a_1803_n8283# B 1.14187f
C170 S7_1 B 0.009616f
C171 D0_1 B 1.13467f
C172 G4_3 B 0.382207f
C173 D2_2 D2_1 0.014232f
C174 D4_3 S5_3 0.614813f
C175 G4_2 G3_2 0.061903f
C176 D0_3 S1_3 0.614813f
C177 S7_1 G6_1 0.625982f
C178 D4_3 G3_3 0.625982f
C179 G0_2 G0_3 0.227831f
C180 G0_3 B 0.40686f
C181 G1_0 S1_0 0.625982f
C182 D4_1 S5_1 0.614813f
C183 D6_1 G5_1 0.625982f
C184 D6_3 G5_3 0.625982f
C185 D2_3 S1_3 0.614813f
C186 S7_3 S7_2 0.014232f
C187 B S1_0 0.016816f
C188 G2_3 S3_3 0.625982f
C189 G7_1 B 0.247781f
C190 D0_2 D0_3 0.014232f
C191 S5_1 B 0.009616f
C192 D0_0 B 1.14187f
C193 D2_3 D2_2 0.014232f
C194 G1_3 S1_3 0.625982f
C195 G7_1 G6_1 0.061903f
C196 D6_1 D6_2 0.014232f
C197 G4_3 S5_3 0.625982f
C198 D6_3 D6_2 0.014232f
C199 G4_3 G3_3 0.061903f
C200 G6_3 B 0.382207f
C201 D0_3 G0_3 0.625982f
C202 G7_3 G6_3 0.061903f
C203 S5_2 D4_2 0.614813f
C204 G1_2 G2_2 0.061903f
C205 G4_1 G5_1 0.061903f
C206 D4_1 B 0.009616f
C207 B S3_2 0.009616f
C208 G1_0 B 0.278378f
C209 a_1803_47# B 1.13467f
C210 G2_1 B 0.223127f
C211 G2_2 G2_3 0.227831f
C212 D4_3 S3_3 0.614813f
C213 G0_2 B 0.247781f
C214 G4_0 B 0.278378f
C215 G4_1 G4_2 0.227831f
C216 G7_3 B 0.40686f
C217 D4_1 D4_0 0.014232f
C218 B G6_1 0.223127f
C219 G0_0 S1_0 0.625982f
C220 G1_3 G0_3 0.061903f
C221 D6_1 S7_1 0.614813f
C222 G5_0 G5_1 0.227831f
C223 G0_0 D0_0 0.625982f
C224 G2_0 G1_0 0.061903f
C225 G2_1 D2_1 0.625982f
C226 D4_0 B 0.016816f
C227 G4_0 D4_0 0.625982f
C228 G2_1 G2_0 0.227831f
C229 G7_2 S7_2 0.625982f
C230 D2_1 B 0.009616f
C231 G2_0 B 0.278378f
C232 S5_2 G4_2 0.625982f
C233 D2_0 S1_0 0.614813f
C234 D0_3 B 1.14085f
C235 S5_2 D6_2 0.614813f
C236 B S5_3 0.015791f
C237 B G3_3 0.382207f
C238 D6_1 S5_1 0.614813f
C239 G7_0 a_1803_n8283# 0.625982f
C240 S3_2 G3_2 0.625982f
C241 G0_0 G1_0 0.061903f
C242 S3_0 B 0.016816f
C243 S7_0 VSUBS 0.863504f
C244 D6_0 VSUBS 0.863504f
C245 S5_0 VSUBS 0.863504f
C246 D4_0 VSUBS 0.863504f
C247 S3_0 VSUBS 0.863504f
C248 D2_0 VSUBS 0.863504f
C249 S1_0 VSUBS 0.863504f
C250 D0_0 VSUBS 1.12621f
C251 G7_0 VSUBS 0.440605f
C252 G6_0 VSUBS 0.427224f
C253 G5_0 VSUBS 0.427224f
C254 G4_0 VSUBS 0.427224f
C255 G3_0 VSUBS 0.427224f
C256 G2_0 VSUBS 0.427224f
C257 G1_0 VSUBS 0.427224f
C258 G0_0 VSUBS 0.440605f
C259 S7_1 VSUBS 0.857307f
C260 D6_1 VSUBS 0.857307f
C261 S5_1 VSUBS 0.857307f
C262 D4_1 VSUBS 0.857307f
C263 S3_1 VSUBS 0.857307f
C264 D2_1 VSUBS 0.857307f
C265 S1_1 VSUBS 0.857307f
C266 D0_1 VSUBS 1.12001f
C267 G7_1 VSUBS 0.409619f
C268 G6_1 VSUBS 0.396239f
C269 G5_1 VSUBS 0.396239f
C270 G4_1 VSUBS 0.396239f
C271 G3_1 VSUBS 0.396239f
C272 G2_1 VSUBS 0.396239f
C273 G1_1 VSUBS 0.396239f
C274 G0_1 VSUBS 0.409619f
C275 S7_2 VSUBS 0.857307f
C276 D6_2 VSUBS 0.857307f
C277 S5_2 VSUBS 0.857307f
C278 D4_2 VSUBS 0.857307f
C279 S3_2 VSUBS 0.857307f
C280 D2_2 VSUBS 0.857307f
C281 S1_2 VSUBS 0.857307f
C282 D0_2 VSUBS 1.12001f
C283 G7_2 VSUBS 0.409619f
C284 G6_2 VSUBS 0.396239f
C285 G5_2 VSUBS 0.396239f
C286 G4_2 VSUBS 0.396239f
C287 G3_2 VSUBS 0.396239f
C288 G2_2 VSUBS 0.396239f
C289 G1_2 VSUBS 0.396239f
C290 G0_2 VSUBS 0.409619f
C291 S7_3 VSUBS 0.862757f
C292 D6_3 VSUBS 0.862757f
C293 S5_3 VSUBS 0.862757f
C294 D4_3 VSUBS 0.862757f
C295 S3_3 VSUBS 0.862757f
C296 D2_3 VSUBS 0.862757f
C297 S1_3 VSUBS 0.862757f
C298 D0_3 VSUBS 1.12546f
C299 G7_3 VSUBS 0.420067f
C300 G6_3 VSUBS 0.406686f
C301 G5_3 VSUBS 0.406686f
C302 G4_3 VSUBS 0.406686f
C303 G3_3 VSUBS 0.406686f
C304 G2_3 VSUBS 0.406686f
C305 G1_3 VSUBS 0.406686f
C306 G0_3 VSUBS 0.420067f
C307 B VSUBS 0.221525p
C308 a_1803_n8283# VSUBS 1.12621f
C309 a_1803_n4118# VSUBS 1.12001f
C310 a_1803_47# VSUBS 1.12001f
C311 a_1803_4212# VSUBS 1.12546f
.ends

.subckt sky130_fd_pr__nfet_05v0_nvt_6T4HWX B D0 S0 G0 D1 S1 G1
X0 S1 G1 D1 B sky130_fd_pr__nfet_05v0_nvt ad=0.29 pd=2.58 as=0.29 ps=2.58 w=1 l=25
X1 S0 G0 D0 B sky130_fd_pr__nfet_05v0_nvt ad=0.29 pd=2.58 as=0.29 ps=2.58 w=1 l=25
C0 G1 S1 0.049339f
C1 G1 D1 0.049339f
C2 D0 D1 0.014895f
C3 S0 S1 0.014895f
C4 G0 G1 3.42782f
C5 G0 D0 0.049339f
C6 S0 G0 0.049339f
C7 S0 B 0.157719f
C8 D0 B 0.157719f
C9 G0 B 8.145109f
C10 S1 B 0.156139f
C11 D1 B 0.156139f
C12 G1 B 8.90423f
.ends

.subckt sky130_fd_pr__pfet_g5v0d10v5_5EJAKB B D S G VSUBS
X0 S G D B sky130_fd_pr__pfet_g5v0d10v5 ad=0.2436 pd=2.26 as=0.2436 ps=2.26 w=0.84 l=4
C0 G D 0.039028f
C1 B D 0.073044f
C2 B G 0.982043f
C3 S D 0.013979f
C4 S G 0.039028f
C5 S B 0.073044f
C6 S VSUBS 0.061032f
C7 D VSUBS 0.061032f
C8 G VSUBS 0.873669f
C9 B VSUBS 3.60478f
.ends

.subckt ldo_top vin vout rstn gnd
Xbgr_MPO vin bgr_MPO/D3 vin bgr_MS2/D bgr_MPO/D3 vin bgr_MS2/D bgr_MPO/D3 vin bgr_MS2/D
+ bgr_MPO/D3 vin bgr_MS2/D gnd sky130_fd_pr__pfet_g5v0d10v5_UFECYT
Xbgr_MPCC vin bgr_MNCD/G bgr_MS2/D bgr_MNCD/G bgr_MS2/D bgr_MNCD/G bgr_MS2/D bgr_MNCD/G
+ bgr_MS2/D bgr_MPC/D3 bgr_MS2/D bgr_MPC/D3 bgr_MS2/D bgr_MPC/D3 bgr_MS2/D bgr_MPC/D3
+ bgr_MS2/D bgr_MNCD/G bgr_MS2/D bgr_MNCD/G bgr_MS2/D bgr_MNCD/G bgr_MS2/D bgr_MNCD/G
+ bgr_MS2/D bgr_MPC/D3 bgr_MS2/D bgr_MPC/D3 bgr_MS2/D bgr_MPC/D3 bgr_MS2/D bgr_MPC/D3
+ bgr_MS2/D bgr_MNCD/G bgr_MNCD/G bgr_MNCD/G bgr_MNCD/G gnd sky130_fd_pr__pfet_g5v0d10v5_TGGT4A
Xbgr_MT0 gnd bgr_R2/R1 bgr_MT1/D gnd sky130_fd_pr__nfet_g5v0d10v5_3LMSA7
Xbgr_MPBC vin bgr_MNB/G5 bgr_MS2/D bgr_MNB/G5 bgr_MS2/D bgr_MNB/G5 bgr_MS2/D bgr_MNB/G5
+ bgr_MS2/D bgr_MPB/D3 bgr_MS2/D bgr_MPB/D3 bgr_MS2/D bgr_MPB/D3 bgr_MS2/D bgr_MPB/D3
+ bgr_MS2/D bgr_MNB/G5 bgr_MS2/D bgr_MNB/G5 bgr_MS2/D bgr_MNB/G5 bgr_MS2/D bgr_MNB/G5
+ bgr_MS2/D bgr_MPB/D3 bgr_MS2/D bgr_MPB/D3 bgr_MS2/D bgr_MPB/D3 bgr_MS2/D bgr_MPB/D3
+ bgr_MS2/D bgr_MNB/G5 bgr_MNB/G5 bgr_MNB/G5 bgr_MNB/G5 gnd sky130_fd_pr__pfet_g5v0d10v5_TGGT4A
Xbgr_MT1 gnd bgr_MT1/D bgr_MT2/D gnd sky130_fd_pr__nfet_g5v0d10v5_3LMSA7
Xpor_MD gnd por_MD/D gnd por_MD/G sky130_fd_pr__nfet_g5v0d10v5_C8EBTW
Xbgr_MPAC vin bgr_MNF/G5 bgr_MS2/D bgr_MNF/G5 bgr_MS2/D bgr_MNF/G5 bgr_MS2/D bgr_MNF/G5
+ bgr_MS2/D bgr_MPA/D3 bgr_MS2/D bgr_MPA/D3 bgr_MS2/D bgr_MPA/D3 bgr_MS2/D bgr_MPA/D3
+ bgr_MS2/D bgr_MNF/G5 bgr_MS2/D bgr_MNF/G5 bgr_MS2/D bgr_MNF/G5 bgr_MS2/D bgr_MNF/G5
+ bgr_MS2/D bgr_MPA/D3 bgr_MS2/D bgr_MPA/D3 bgr_MS2/D bgr_MPA/D3 bgr_MS2/D bgr_MPA/D3
+ bgr_MS2/D bgr_MNF/G5 bgr_MNF/G5 bgr_MNF/G5 bgr_MNF/G5 gnd sky130_fd_pr__pfet_g5v0d10v5_TGGT4A
Xbgr_MT2 gnd bgr_MT2/D bgr_MT3/D gnd sky130_fd_pr__nfet_g5v0d10v5_3LMSA7
Xbgr_MS2 gnd bgr_MS2/D gnd bgr_MSN/D sky130_fd_pr__nfet_g5v0d10v5_62W55W
Xbgr_MT3 gnd bgr_MT3/D bgr_MT4/D gnd sky130_fd_pr__nfet_g5v0d10v5_3LMSA7
Xbgr_Cvr0 gnd ldo_MN2/G gnd sky130_fd_pr__cap_mim_m3_1_BTY6QK
Xldo_Cff_0 ldo_MNX/S2 vin gnd sky130_fd_pr__cap_mim_m3_1_V8HUNN
Xbgr_MNCD gnd bgr_MNCD/G bgr_MNCD/S bgr_MNCD/G sky130_fd_pr__nfet_05v0_nvt_F4CC77
Xbgr_MNBC gnd bgr_MNF/G5 bgr_MNCD/G bgr_MNB/D4 bgr_MNCD/G bgr_MNF/G5 bgr_MNCD/G bgr_MNB/D4
+ bgr_MNCD/G bgr_MNF/G5 bgr_MNCD/G bgr_MNB/D4 bgr_MNCD/G bgr_MNF/G5 sky130_fd_pr__nfet_05v0_nvt_ASWYB8
Xbgr_MT4 gnd bgr_MT4/D bgr_MT4/S vin sky130_fd_pr__nfet_g5v0d10v5_3LMSA7
Xbgr_Cvr1 gnd ldo_MN2/G gnd sky130_fd_pr__cap_mim_m3_1_BTY6QK
Xldo_MNA gnd ldo_MPS/D gnd ldo_MPS/D sky130_fd_pr__nfet_g5v0d10v5_NUFNY9
Xldo_Cff_1 ldo_MNX/S2 vin gnd sky130_fd_pr__cap_mim_m3_1_V8HUNN
Xbgr_Cvr2 gnd ldo_MN2/G gnd sky130_fd_pr__cap_mim_m3_1_BTY6QK
Xpor_MH gnd por_MH/D gnd por_MH/G sky130_fd_pr__nfet_g5v0d10v5_A8HTHF
Xbgr_R1 gnd bgr_R1/R1 bgr_R1/R2 sky130_fd_pr__res_xhigh_po_0p35_5J6MKL
Xldo_MNB gnd ldo_MNB/G gnd ldo_MNB/G sky130_fd_pr__nfet_g5v0d10v5_BE4NYT
Xldo_Cff_2 ldo_MNX/S2 vin gnd sky130_fd_pr__cap_mim_m3_1_V8HUNN
Xbgr_Cvr3 gnd ldo_MN2/G gnd sky130_fd_pr__cap_mim_m3_1_BTY6QK
Xbgr_Q1 bgr_MNA/S5 gnd gnd sky130_fd_pr__rf_pnp_05v5_W3p40L3p40 m=1
Xbgr_R2 gnd bgr_R2/R1 bgr_Rf/R2 sky130_fd_pr__res_xhigh_po_0p35_PL9RNS
Xldo_MNBL gnd vout ldo_MNB/G gnd ldo_MNB/G vout ldo_MNB/G gnd ldo_MNB/G vout ldo_MNB/G
+ gnd ldo_MNB/G vout ldo_MNB/G gnd ldo_MNB/G vout ldo_MNB/G gnd ldo_MNB/G vout ldo_MNB/G
+ gnd ldo_MNB/G vout ldo_MNB/G gnd ldo_MNB/G vout ldo_MNB/G gnd ldo_MNB/G vout ldo_MNB/G
+ gnd ldo_MNB/G vout ldo_MNB/G gnd ldo_MNB/G vout sky130_fd_pr__nfet_g5v0d10v5_YQMGE2
Xldo_Cff_3 ldo_MNX/S2 vin gnd sky130_fd_pr__cap_mim_m3_1_V8HUNN
Xbgr_Q3 bgr_MT4/S gnd gnd sky130_fd_pr__rf_pnp_05v5_W3p40L3p40 m=1
Xbgr_QD0 gnd gnd gnd sky130_fd_pr__rf_pnp_05v5_W3p40L3p40 m=1
Xbgr_RT0 gnd bgr_MT1/D bgr_R2/R1 sky130_fd_pr__res_xhigh_po_0p35_R4U9XH
Xbgr_Q5 bgr_MNCD/S gnd gnd sky130_fd_pr__rf_pnp_05v5_W3p40L3p40 m=1
Xbgr_QD1 gnd gnd gnd sky130_fd_pr__rf_pnp_05v5_W3p40L3p40 m=1
Xbgr_RT1 gnd bgr_MT2/D bgr_MT1/D sky130_fd_pr__res_xhigh_po_0p35_XV4KRP
Xldo_Cbp gnd ldo_Rsh/R1 gnd sky130_fd_pr__cap_mim_m3_1_84Z4WG
Xbgr_RT2 gnd bgr_MT3/D bgr_MT2/D sky130_fd_pr__res_xhigh_po_0p35_4E3LTY
Xbgr_MSU0 vin bgr_MSU1/S vin bgr_MSU1/S gnd sky130_fd_pr__pfet_g5v0d10v5_32MMT9
Xbgr_Q7 bgr_MSN/S gnd gnd sky130_fd_pr__rf_pnp_05v5_W3p40L3p40 m=1
Xbgr_MSU1 vin bgr_MSU2/S bgr_MSU1/S bgr_MSU2/S gnd sky130_fd_pr__pfet_g5v0d10v5_32MMT9
Xbgr_RT3 gnd bgr_MT4/D bgr_MT3/D sky130_fd_pr__res_xhigh_po_0p35_VEZ8JB
Xbgr_Q8 bgr_MNSK/S1 gnd gnd sky130_fd_pr__rf_pnp_05v5_W3p40L3p40 m=1
Xldo_MPB2 vin ldo_Rsh/R2 vin ldo_Rsh/R2 gnd sky130_fd_pr__pfet_g5v0d10v5_MN82PF
Xpor_R1 gnd por_MD/G vin sky130_fd_pr__res_xhigh_po_0p35_YNY9WN
Xbgr_Q2_0 bgr_R1/R1 gnd gnd sky130_fd_pr__rf_pnp_05v5_W3p40L3p40 m=1
Xbgr_RT4 gnd bgr_MT4/S bgr_MT4/D sky130_fd_pr__res_xhigh_po_0p35_HGUK4G
Xbgr_MSU2 vin bgr_MSU3/S bgr_MSU2/S bgr_MSU3/S gnd sky130_fd_pr__pfet_g5v0d10v5_32MMT9
Xpor_R2 gnd por_MH/D por_MD/G sky130_fd_pr__res_xhigh_po_0p35_8Z5M7R
Xbgr_Q2_1 bgr_R1/R1 gnd gnd sky130_fd_pr__rf_pnp_05v5_W3p40L3p40 m=1
Xbgr_MSU3 vin bgr_MSN/D bgr_MSU3/S bgr_MSN/D gnd sky130_fd_pr__pfet_g5v0d10v5_32MMT9
Xpor_R3 gnd gnd por_MH/D sky130_fd_pr__res_xhigh_po_0p35_KAXJA5
Xbgr_Q2_2 bgr_R1/R1 gnd gnd sky130_fd_pr__rf_pnp_05v5_W3p40L3p40 m=1
Xbgr_MPD0 vin vin vin vin gnd sky130_fd_pr__pfet_g5v0d10v5_XFEL6A
Xpor_Rpu gnd por_MD/D vin sky130_fd_pr__res_xhigh_po_0p35_NT9K52
Xbgr_Q2_3 bgr_R1/R1 gnd gnd sky130_fd_pr__rf_pnp_05v5_W3p40L3p40 m=1
Xbgr_MPD1 vin vin vin vin gnd sky130_fd_pr__pfet_g5v0d10v5_XFEL6A
Xldo_Rsh gnd ldo_Rsh/R1 ldo_Rsh/R2 sky130_fd_pr__res_xhigh_po_0p35_J82YCH
Xldo_MNA2 gnd ldo_MN2/S gnd ldo_MPS/D sky130_fd_pr__nfet_g5v0d10v5_NUFNY9
Xldo_MNB3 gnd ldo_Rsh/R1 gnd ldo_MNB/G sky130_fd_pr__nfet_g5v0d10v5_BE4NYT
Xbgr_Q2_4 bgr_R1/R1 gnd gnd sky130_fd_pr__rf_pnp_05v5_W3p40L3p40 m=1
Xldo_MPP vin vout ldo_MPS/G vin ldo_MPS/G vout ldo_MPS/G vin ldo_MPS/G vout ldo_MPS/G
+ vin ldo_MPS/G vout ldo_MPS/G vin ldo_MPS/G vout ldo_MPS/G vin ldo_MPS/G vout ldo_MPS/G
+ vin ldo_MPS/G vout ldo_MPS/G vin ldo_MPS/G vout ldo_MPS/G vin ldo_MPS/G vout ldo_MPS/G
+ vin ldo_MPS/G vout ldo_MPS/G vin ldo_MPS/G vout ldo_MPS/G vin ldo_MPS/G vout ldo_MPS/G
+ vin ldo_MPS/G vout ldo_MPS/G vin ldo_MPS/G vout ldo_MPS/G vin ldo_MPS/G vout ldo_MPS/G
+ vin ldo_MPS/G vout ldo_MPS/G vin ldo_MPS/G vout ldo_MPS/G vin ldo_MPS/G vout ldo_MPS/G
+ vin ldo_MPS/G vout ldo_MPS/G vin ldo_MPS/G vout ldo_MPS/G vin ldo_MPS/G vout gnd
+ sky130_fd_pr__pfet_g5v0d10v5_PSYF8E
Xbgr_Q2_5 bgr_R1/R1 gnd gnd sky130_fd_pr__rf_pnp_05v5_W3p40L3p40 m=1
Xbgr_Q2_6 bgr_R1/R1 gnd gnd sky130_fd_pr__rf_pnp_05v5_W3p40L3p40 m=1
Xbgr_Q2_7 bgr_R1/R1 gnd gnd sky130_fd_pr__rf_pnp_05v5_W3p40L3p40 m=1
Xldo_MPS vin ldo_MPS/D vin ldo_MPS/G gnd sky130_fd_pr__pfet_g5v0d10v5_7B62CL
Xbgr_MPA vin bgr_MPA/D3 vin bgr_MS2/D bgr_MPA/D3 vin bgr_MS2/D bgr_MPA/D3 vin bgr_MS2/D
+ bgr_MPA/D3 vin bgr_MS2/D gnd sky130_fd_pr__pfet_g5v0d10v5_UFECYT
Xldo_MPT vin ldo_MPX/S2 vin ldo_Rsh/R2 ldo_MPX/S2 vin ldo_Rsh/R2 ldo_MPX/S2 vin ldo_Rsh/R2
+ gnd sky130_fd_pr__pfet_g5v0d10v5_PN8J4Z
Xbgr_MPB vin bgr_MPB/D3 vin bgr_MS2/D bgr_MPB/D3 vin bgr_MS2/D bgr_MPB/D3 vin bgr_MS2/D
+ bgr_MPB/D3 vin bgr_MS2/D gnd sky130_fd_pr__pfet_g5v0d10v5_UFECYT
Xbgr_Rf gnd ldo_MN2/G bgr_Rf/R2 sky130_fd_pr__res_xhigh_po_0p35_ADWJQG
Xldo_MNS gnd ldo_MNX/S2 gnd ldo_MNB/G ldo_MNX/S2 gnd ldo_MNB/G ldo_MNX/S2 gnd ldo_MNB/G
+ sky130_fd_pr__nfet_g5v0d10v5_3UQFYT
Xbgr_MNA gnd bgr_MNB/G5 bgr_MNB/G5 bgr_MNA/S5 bgr_MNB/G5 bgr_MNB/G5 bgr_MNB/G5 bgr_MNA/S5
+ bgr_MNB/G5 bgr_MNB/G5 bgr_MNB/G5 bgr_MNA/S5 bgr_MNB/G5 bgr_MNB/G5 sky130_fd_pr__nfet_05v0_nvt_ASWYB8
Xbgr_MPC vin bgr_MPC/D3 vin bgr_MS2/D bgr_MPC/D3 vin bgr_MS2/D bgr_MPC/D3 vin bgr_MS2/D
+ bgr_MPC/D3 vin bgr_MS2/D gnd sky130_fd_pr__pfet_g5v0d10v5_UFECYT
Xldo_Cfp_0 ldo_MPX/S2 vout gnd sky130_fd_pr__cap_mim_m3_1_Y3HN7X
Xbgr_MPOC vin bgr_Rf/R2 bgr_MS2/D bgr_Rf/R2 bgr_MS2/D bgr_Rf/R2 bgr_MS2/D bgr_Rf/R2
+ bgr_MS2/D bgr_MPO/D3 bgr_MS2/D bgr_MPO/D3 bgr_MS2/D bgr_MPO/D3 bgr_MS2/D bgr_MPO/D3
+ bgr_MS2/D bgr_Rf/R2 bgr_MS2/D bgr_Rf/R2 bgr_MS2/D bgr_Rf/R2 bgr_MS2/D bgr_Rf/R2
+ bgr_MS2/D bgr_MPO/D3 bgr_MS2/D bgr_MPO/D3 bgr_MS2/D bgr_MPO/D3 bgr_MS2/D bgr_MPO/D3
+ bgr_MS2/D bgr_Rf/R2 bgr_Rf/R2 bgr_Rf/R2 bgr_Rf/R2 gnd sky130_fd_pr__pfet_g5v0d10v5_TGGT4A
Xbgr_MNB gnd bgr_MNB/D4 bgr_MNB/G5 bgr_R1/R2 bgr_MNB/G5 bgr_MNB/D4 bgr_MNB/G5 bgr_R1/R2
+ bgr_MNB/G5 bgr_MNB/D4 bgr_MNB/G5 bgr_R1/R2 bgr_MNB/G5 bgr_MNB/D4 sky130_fd_pr__nfet_05v0_nvt_ASWYB8
Xldo_MP3 vin ldo_MP4/G vin ldo_MP4/G gnd sky130_fd_pr__pfet_g5v0d10v5_DNGK98
Xldo_MN1 gnd ldo_MP4/G ldo_MN2/S vout sky130_fd_pr__nfet_g5v0d10v5_WMYWGM
Xldo_Cfp_1 ldo_MPX/S2 vout gnd sky130_fd_pr__cap_mim_m3_1_Y3HN7X
Xldo_MPX vin ldo_MPS/G ldo_MPX/S2 ldo_Rsh/R1 ldo_MPS/G ldo_MPX/S2 ldo_Rsh/R1 ldo_MPS/G
+ ldo_MPX/S2 ldo_Rsh/R1 gnd sky130_fd_pr__pfet_g5v0d10v5_PN8J4Z
Xldo_Cfp_2 ldo_MPX/S2 vout gnd sky130_fd_pr__cap_mim_m3_1_Y3HN7X
Xldo_MP4 vin ldo_MPS/G vin ldo_MP4/G gnd sky130_fd_pr__pfet_g5v0d10v5_DNGK98
Xldo_MN2 gnd ldo_MPS/G ldo_MN2/S ldo_MN2/G sky130_fd_pr__nfet_g5v0d10v5_WMYWGM
Xldo_Cfp_3 ldo_MPX/S2 vout gnd sky130_fd_pr__cap_mim_m3_1_Y3HN7X
Xldo_Cfn_0 ldo_MNX/S2 vout gnd sky130_fd_pr__cap_mim_m3_1_Y3HN7X
Xldo_Cc vout ldo_MPS/G gnd sky130_fd_pr__cap_mim_m3_1_PP9XRG
Xpor_MI3N gnd rstn gnd por_MH/G sky130_fd_pr__nfet_g5v0d10v5_FZ2B7C
Xldo_MNX gnd ldo_MPS/G ldo_MN2/G ldo_MNX/S2 ldo_MN2/G ldo_MPS/G ldo_MNX/S2 ldo_MN2/G
+ sky130_fd_pr__nfet_g5v0d10v5_DDWFWJ
Xldo_Cfn_1 ldo_MNX/S2 vout gnd sky130_fd_pr__cap_mim_m3_1_Y3HN7X
Xbgr_MNF gnd vin bgr_MNF/G5 bgr_MS2/D bgr_MNF/G5 vin bgr_MNF/G5 bgr_MS2/D bgr_MNF/G5
+ vin bgr_MNF/G5 bgr_MS2/D bgr_MNF/G5 vin sky130_fd_pr__nfet_05v0_nvt_ASWYB8
Xpor_MI2N gnd por_MH/G gnd por_MI2P/G sky130_fd_pr__nfet_g5v0d10v5_FZ2B7C
Xldo_MN5 gnd ldo_MN2/S gnd ldo_MNB/G ldo_MN2/S gnd ldo_MNB/G ldo_MN2/S gnd ldo_MNB/G
+ ldo_MN2/S gnd ldo_MNB/G sky130_fd_pr__nfet_g5v0d10v5_HA9V6X
Xbgr_MPI vin bgr_MPI/D0_3 bgr_MS2/D bgr_MPI/D0_3 bgr_MS2/D bgr_MPI/D0_3 bgr_MS2/D
+ bgr_MPI/D0_3 bgr_MS2/D vin bgr_MS2/D vin bgr_MS2/D vin bgr_MS2/D vin bgr_MS2/D bgr_MPI/D0_3
+ bgr_MPI/D0_3 bgr_MPI/D0_3 bgr_MPI/D0_3 gnd sky130_fd_pr__pfet_g5v0d10v5_UFWJXT
Xldo_Cfn_2 ldo_MNX/S2 vout gnd sky130_fd_pr__cap_mim_m3_1_Y3HN7X
Xpor_MI3P vout rstn vout por_MH/G gnd sky130_fd_pr__pfet_g5v0d10v5_7B62CL
Xpor_MI1N gnd por_MI2P/G gnd por_MD/D sky130_fd_pr__nfet_g5v0d10v5_F3NX3J
Xbgr_MPIC vin ldo_MNB/G bgr_MS2/D ldo_MNB/G bgr_MS2/D ldo_MNB/G bgr_MS2/D ldo_MNB/G
+ bgr_MS2/D bgr_MPI/D0_3 bgr_MS2/D bgr_MPI/D0_3 bgr_MS2/D bgr_MPI/D0_3 bgr_MS2/D bgr_MPI/D0_3
+ bgr_MS2/D ldo_MNB/G bgr_MS2/D ldo_MNB/G bgr_MS2/D ldo_MNB/G bgr_MS2/D ldo_MNB/G
+ bgr_MS2/D bgr_MPI/D0_3 bgr_MS2/D bgr_MPI/D0_3 bgr_MS2/D bgr_MPI/D0_3 bgr_MS2/D bgr_MPI/D0_3
+ bgr_MS2/D ldo_MNB/G bgr_MS2/D ldo_MNB/G bgr_MS2/D ldo_MNB/G bgr_MS2/D ldo_MNB/G
+ bgr_MS2/D bgr_MPI/D0_3 bgr_MS2/D bgr_MPI/D0_3 bgr_MS2/D bgr_MPI/D0_3 bgr_MS2/D bgr_MPI/D0_3
+ bgr_MS2/D ldo_MNB/G bgr_MS2/D ldo_MNB/G bgr_MS2/D ldo_MNB/G bgr_MS2/D ldo_MNB/G
+ bgr_MS2/D bgr_MPI/D0_3 bgr_MS2/D bgr_MPI/D0_3 bgr_MS2/D bgr_MPI/D0_3 bgr_MS2/D bgr_MPI/D0_3
+ bgr_MS2/D ldo_MNB/G ldo_MNB/G ldo_MNB/G ldo_MNB/G gnd sky130_fd_pr__pfet_g5v0d10v5_KMGDV8
Xldo_Cfn_3 ldo_MNX/S2 vout gnd sky130_fd_pr__cap_mim_m3_1_Y3HN7X
Xpor_MI2P vin por_MH/G vin por_MI2P/G gnd sky130_fd_pr__pfet_g5v0d10v5_7B62CL
Xbgr_MSN gnd bgr_MSN/D bgr_MSN/S bgr_Rf/R2 sky130_fd_pr__nfet_g5v0d10v5_NUFNY9
Xbgr_MNSK gnd bgr_MS2/D bgr_MNSK/S1 bgr_MNB/G5 bgr_MS2/D bgr_MNSK/S1 bgr_MNB/G5 sky130_fd_pr__nfet_05v0_nvt_6T4HWX
Xpor_MI1P vin por_MI2P/G vin por_MD/D gnd sky130_fd_pr__pfet_g5v0d10v5_5EJAKB
C0 bgr_MSU2/S ldo_MN2/G 0.161556f
C1 por_MD/G por_MD/D 0.5446f
C2 vout bgr_MNSK/S1 0.321651f
C3 ldo_Rsh/R1 bgr_MPO/D3 0.064096f
C4 ldo_Rsh/R2 ldo_MNB/G 0.268292f
C5 rstn bgr_R1/R1 0.180335f
C6 ldo_MPX/S2 bgr_MT3/D 0.140303f
C7 bgr_MNB/G5 bgr_Rf/R2 0.576919f
C8 bgr_MT2/D vin 1.050456f
C9 bgr_R2/R1 rstn 0.147388f
C10 bgr_R1/R2 bgr_MSN/D 2.77e-19
C11 bgr_MT4/D ldo_MNB/G 0.471649f
C12 vin vout 0.37129p
C13 ldo_Rsh/R1 bgr_R1/R2 0.144578f
C14 bgr_MNB/G5 bgr_MNCD/G 29.901197f
C15 ldo_MPX/S2 bgr_MNSK/S1 0.070151f
C16 bgr_R1/R2 bgr_MNCD/S 0.101521f
C17 bgr_MT4/S ldo_Rsh/R1 0.144665f
C18 bgr_MNB/G5 bgr_MNB/D4 0.659407f
C19 vin bgr_MPB/D3 4.862237f
C20 por_MH/D ldo_MNX/S2 1.36e-19
C21 ldo_Rsh/R1 bgr_MNF/G5 0.217817f
C22 bgr_MT4/S bgr_MNCD/S 11.5394f
C23 bgr_MNF/G5 bgr_MSN/D 0.07208f
C24 bgr_MNCD/S bgr_MNF/G5 0.531319f
C25 por_MD/D vout 0.92771f
C26 bgr_MT2/D ldo_MNB/G 9.22e-20
C27 vin ldo_MPX/S2 6.047121f
C28 ldo_Rsh/R1 ldo_MN2/S 9.277821f
C29 ldo_MNX/S2 bgr_MNA/S5 0.174113f
C30 vout ldo_MNB/G 13.838746f
C31 por_MH/D bgr_MSU3/S 0.065047f
C32 bgr_MSN/S bgr_MT3/D 0.280297f
C33 bgr_MNB/G5 bgr_MS2/D 20.924772f
C34 ldo_MPS/G bgr_MSN/D 0.323485f
C35 vin bgr_MPC/D3 5.180164f
C36 ldo_MPS/G ldo_Rsh/R1 59.088165f
C37 vin bgr_MPA/D3 3.957036f
C38 ldo_MNB/G bgr_MPB/D3 0.073689f
C39 ldo_MPS/G bgr_MNCD/S 0.163987f
C40 por_MD/D ldo_MPX/S2 2.06e-19
C41 bgr_MPO/D3 ldo_MN2/G 0.071796f
C42 bgr_MT1/D bgr_MNA/S5 0.280335f
C43 ldo_MNX/S2 ldo_MP4/G 0.001426f
C44 por_MH/D por_MD/G 19.273996f
C45 bgr_MSN/S bgr_MNSK/S1 22.569399f
C46 ldo_MNB/G ldo_MPX/S2 0.076162f
C47 ldo_MNX/S2 bgr_MPI/D0_3 0.078863f
C48 bgr_R1/R1 bgr_MPO/D3 0.278277f
C49 rstn bgr_MT3/D 0.147601f
C50 bgr_R1/R2 ldo_MN2/G 0.256074f
C51 bgr_MPC/D3 ldo_MNB/G 0.52671f
C52 ldo_MNB/G bgr_MPA/D3 0.073588f
C53 vin bgr_MSN/S 0.643301f
C54 bgr_R2/R1 bgr_MPO/D3 0.001029f
C55 ldo_Rsh/R1 bgr_Rf/R2 0.160761f
C56 bgr_MSN/D bgr_Rf/R2 0.182233f
C57 bgr_MT4/S ldo_MN2/G 0.157165f
C58 bgr_MSU3/S ldo_MNX/S2 0.1742f
C59 bgr_MT1/D ldo_MNX/S2 0.157726f
C60 bgr_MNCD/S bgr_Rf/R2 2.546211f
C61 bgr_R1/R2 bgr_R1/R1 33.84626f
C62 rstn bgr_MNSK/S1 0.0738f
C63 bgr_MT4/D bgr_MNA/S5 0.210093f
C64 bgr_MNF/G5 ldo_MN2/G 0.267401f
C65 ldo_Rsh/R1 ldo_MPS/D 0.257833f
C66 ldo_Rsh/R2 ldo_MP4/G 0.328125f
C67 ldo_Rsh/R1 bgr_MNCD/G 0.20143f
C68 bgr_MNCD/G bgr_MSN/D 19.21693f
C69 por_MH/G bgr_MSN/D 0.201363f
C70 ldo_Rsh/R1 por_MH/G 3.75e-19
C71 bgr_MNCD/S bgr_MNCD/G 1.308202f
C72 bgr_MT4/S bgr_R1/R1 26.176622f
C73 ldo_MN2/S ldo_MN2/G 0.224174f
C74 ldo_Rsh/R1 bgr_MSU1/S 0.192287f
C75 bgr_MSU1/S bgr_MSN/D 57.21566f
C76 bgr_R1/R2 bgr_R2/R1 0.097694f
C77 ldo_MNX/S2 ldo_Rsh/R2 12.91623f
C78 bgr_MNF/G5 bgr_R1/R1 0.356933f
C79 por_MD/G ldo_MNX/S2 3.75e-19
C80 por_MH/D vout 0.56527f
C81 bgr_MNCD/S bgr_MSU1/S 0.091191f
C82 ldo_Rsh/R1 bgr_MNB/D4 0.128192f
C83 bgr_MNB/D4 bgr_MSN/D 0.385672f
C84 vin rstn 57.899303f
C85 bgr_MNCD/S bgr_MNB/D4 0.380067f
C86 bgr_MT4/S bgr_R2/R1 0.221148f
C87 bgr_MT2/D bgr_MNA/S5 0.280335f
C88 ldo_MPS/G ldo_MN2/G 3.855995f
C89 vin bgr_MSU2/S 4.92441f
C90 bgr_MNF/G5 bgr_R2/R1 18.7886f
C91 bgr_MT4/D bgr_MPI/D0_3 7.64e-19
C92 bgr_MT4/D ldo_MNX/S2 0.23659f
C93 vout bgr_MNA/S5 0.750172f
C94 por_MD/G bgr_MSU3/S 8.88223f
C95 ldo_MPS/G bgr_R1/R1 0.170843f
C96 por_MH/D ldo_MPX/S2 2.75e-19
C97 bgr_MS2/D bgr_MSN/D 21.382858f
C98 ldo_Rsh/R1 bgr_MS2/D 0.289244f
C99 por_MD/D rstn 29.716444f
C100 bgr_MNCD/S bgr_MS2/D 0.154557f
C101 por_MD/D bgr_MSU2/S 0.391364f
C102 por_MI2P/G ldo_Rsh/R1 5.5e-19
C103 por_MI2P/G bgr_MSN/D 0.199003f
C104 bgr_MT4/D bgr_MT1/D 0.163929f
C105 rstn ldo_MNB/G 2.75975f
C106 ldo_MPS/G bgr_R2/R1 0.137896f
C107 vout ldo_MP4/G 2.881584f
C108 bgr_MT2/D ldo_MNX/S2 0.157726f
C109 ldo_MPX/S2 bgr_MNA/S5 0.156689f
C110 vout bgr_MPI/D0_3 0.321651f
C111 ldo_MNX/S2 vout 13.627312f
C112 bgr_Rf/R2 ldo_MN2/G 1.393938f
C113 ldo_MPS/D ldo_MN2/G 0.074097f
C114 bgr_MPI/D0_3 bgr_MPB/D3 0.164454f
C115 ldo_MNX/S2 bgr_MPB/D3 0.078863f
C116 bgr_MT1/D bgr_MT2/D 20.90819f
C117 bgr_MNCD/G ldo_MN2/G 0.521139f
C118 ldo_MPX/S2 ldo_MP4/G 0.219886f
C119 bgr_R1/R1 bgr_Rf/R2 0.556759f
C120 por_MH/G ldo_MN2/G 0.145853f
C121 bgr_MSU1/S ldo_MN2/G 0.217649f
C122 bgr_MSU3/S vout 0.643301f
C123 bgr_MT1/D vout 0.643301f
C124 bgr_MPI/D0_3 ldo_MPX/S2 0.070151f
C125 bgr_MNB/D4 ldo_MN2/G 0.162661f
C126 ldo_MNX/S2 ldo_MPX/S2 34.01577f
C127 bgr_MNCD/G bgr_R1/R1 0.368248f
C128 bgr_R2/R1 bgr_Rf/R2 0.75709f
C129 bgr_MT4/S bgr_MT3/D 0.280297f
C130 bgr_MNF/G5 bgr_MT3/D 0.01484f
C131 vout ldo_Rsh/R2 2.284792f
C132 bgr_R1/R2 bgr_MNSK/S1 0.123392f
C133 por_MD/G vout 0.644217f
C134 vin bgr_MPO/D3 3.39482f
C135 bgr_MPI/D0_3 bgr_MPC/D3 23.3097f
C136 bgr_MNCD/G bgr_R2/R1 1.65333f
C137 ldo_MNX/S2 bgr_MPC/D3 0.078863f
C138 bgr_MPI/D0_3 bgr_MPA/D3 0.161083f
C139 bgr_MSU3/S ldo_MPX/S2 0.156776f
C140 ldo_MNX/S2 bgr_MPA/D3 0.078863f
C141 bgr_MT1/D ldo_MPX/S2 0.140303f
C142 bgr_MSN/S bgr_MNA/S5 1.54042f
C143 bgr_MT4/D bgr_MT2/D 0.178911f
C144 bgr_MS2/D ldo_MN2/G 0.308001f
C145 bgr_MT4/S bgr_MNSK/S1 0.123077f
C146 bgr_MNB/G5 ldo_Rsh/R1 0.394038f
C147 bgr_MNF/G5 bgr_MNSK/S1 0.064096f
C148 bgr_MT4/D vout 0.964952f
C149 por_MI2P/G ldo_MN2/G 0.145853f
C150 ldo_MPS/G bgr_MT3/D 0.147601f
C151 bgr_MNB/G5 bgr_MNCD/S 0.064096f
C152 por_MH/D rstn 0.141218f
C153 bgr_R1/R2 vin 2.452469f
C154 ldo_Rsh/R2 ldo_MPX/S2 0.902493f
C155 por_MD/G ldo_MPX/S2 8.81e-19
C156 bgr_MS2/D bgr_R1/R1 1.677025f
C157 por_MH/D bgr_MSU2/S 2.84e-19
C158 bgr_MT4/D bgr_MPB/D3 2.41e-19
C159 ldo_MNB/G bgr_MPO/D3 0.481307f
C160 bgr_MT4/S vin 1.125964f
C161 vin bgr_MNF/G5 6.738822f
C162 rstn bgr_MNA/S5 0.163987f
C163 ldo_MNX/S2 bgr_MSN/S 0.157726f
C164 bgr_MS2/D bgr_R2/R1 7.597209f
C165 ldo_MPS/G bgr_MNSK/S1 0.0738f
C166 bgr_MT2/D vout 0.643301f
C167 bgr_MT4/D ldo_MPX/S2 0.210454f
C168 vin ldo_MN2/S 2.955387f
C169 bgr_R1/R2 ldo_MNB/G 0.51713f
C170 rstn ldo_MP4/G 0.156787f
C171 bgr_MT4/D bgr_MPC/D3 3.18e-19
C172 bgr_MT1/D bgr_MSN/S 0.280335f
C173 bgr_Rf/R2 bgr_MT3/D 0.140303f
C174 ldo_MPS/G vin 12.540257f
C175 vout bgr_MPB/D3 0.321651f
C176 bgr_MT4/S ldo_MNB/G 0.090091f
C177 bgr_MT2/D ldo_MPX/S2 0.140303f
C178 rstn bgr_MPI/D0_3 0.073588f
C179 bgr_MNF/G5 ldo_MNB/G 0.074352f
C180 ldo_MNX/S2 rstn 0.073588f
C181 vout ldo_MPX/S2 15.676232f
C182 ldo_MNX/S2 bgr_MSU2/S 0.157726f
C183 ldo_MNB/G ldo_MN2/S 0.834595f
C184 bgr_MNSK/S1 bgr_Rf/R2 0.070151f
C185 por_MD/D ldo_MPS/G 0.012855f
C186 bgr_MNB/G5 ldo_MN2/G 11.893293f
C187 ldo_MPX/S2 bgr_MPB/D3 0.070151f
C188 bgr_MSU3/S rstn 0.137896f
C189 bgr_MT1/D rstn 0.147601f
C190 vout bgr_MPC/D3 0.321651f
C191 vout bgr_MPA/D3 0.321651f
C192 bgr_MNCD/G bgr_MNSK/S1 0.073588f
C193 ldo_MPS/G ldo_MNB/G 55.03886f
C194 bgr_MT4/D bgr_MSN/S 0.210093f
C195 bgr_MSU3/S bgr_MSU2/S 24.599802f
C196 vin bgr_Rf/R2 6.241746f
C197 bgr_MNB/G5 bgr_R1/R1 0.356995f
C198 bgr_MPC/D3 bgr_MPB/D3 20.897163f
C199 ldo_Rsh/R1 bgr_MSN/D 0.288317f
C200 bgr_MPB/D3 bgr_MPA/D3 19.712105f
C201 ldo_Rsh/R2 rstn 0.147644f
C202 bgr_MS2/D bgr_MT3/D 0.455424f
C203 por_MD/G rstn 0.152966f
C204 vin ldo_MPS/D 11.09746f
C205 bgr_MNCD/S bgr_MSN/D 0.111751f
C206 ldo_Rsh/R1 bgr_MNCD/S 0.144578f
C207 vin bgr_MNCD/G 4.828146f
C208 bgr_MNB/G5 bgr_R2/R1 0.789856f
C209 por_MD/G bgr_MSU2/S 0.18376f
C210 bgr_MPC/D3 ldo_MPX/S2 0.070151f
C211 vin por_MH/G 11.354483f
C212 ldo_MPX/S2 bgr_MPA/D3 0.070151f
C213 bgr_MT2/D bgr_MSN/S 0.280335f
C214 vin bgr_MSU1/S 3.578352f
C215 vin bgr_MNB/D4 0.645616f
C216 bgr_MT4/D rstn 0.221188f
C217 vout bgr_MSN/S 0.643301f
C218 bgr_MS2/D bgr_MNSK/S1 3.66049f
C219 ldo_MNB/G bgr_Rf/R2 22.73764f
C220 bgr_MPC/D3 bgr_MPA/D3 0.084405f
C221 por_MD/D por_MH/G 55.450825f
C222 bgr_R1/R2 bgr_MNA/S5 3.1925f
C223 ldo_MNB/G ldo_MPS/D 0.188761f
C224 por_MD/D bgr_MSU1/S 0.066851f
C225 bgr_MNCD/G ldo_MNB/G 0.533956f
C226 bgr_MT2/D rstn 0.147601f
C227 bgr_MSN/S ldo_MPX/S2 0.140303f
C228 bgr_MPI/D0_3 bgr_MPO/D3 24.549042f
C229 vin bgr_MS2/D 59.046646f
C230 bgr_MT4/S bgr_MNA/S5 0.0858f
C231 ldo_MNX/S2 bgr_MPO/D3 0.078863f
C232 bgr_MNF/G5 bgr_MNA/S5 0.161052f
C233 vout rstn 10.832535f
C234 por_MI2P/G vin 5.327387f
C235 vout bgr_MSU2/S 0.64499f
C236 por_MH/D ldo_MPS/G 0.026083f
C237 rstn bgr_MPB/D3 0.073588f
C238 bgr_R1/R2 bgr_MPI/D0_3 0.532704f
C239 bgr_R1/R2 ldo_MNX/S2 0.174113f
C240 bgr_MSN/D ldo_MN2/G 0.317321f
C241 ldo_Rsh/R1 ldo_MN2/G 0.418195f
C242 ldo_MPS/G bgr_MNA/S5 0.163987f
C243 por_MI2P/G por_MD/D 0.542222f
C244 bgr_MNCD/S ldo_MN2/G 0.162149f
C245 rstn ldo_MPX/S2 0.073588f
C246 bgr_MT4/S bgr_MPI/D0_3 3.54e-20
C247 bgr_MS2/D ldo_MNB/G 40.484127f
C248 bgr_MT4/S ldo_MNX/S2 0.1742f
C249 bgr_MNB/G5 bgr_MT3/D 9.57e-19
C250 bgr_MNF/G5 bgr_MPI/D0_3 0.238278f
C251 ldo_MN2/S ldo_MP4/G 1.958208f
C252 bgr_MSU2/S ldo_MPX/S2 0.140303f
C253 ldo_MNX/S2 bgr_MNF/G5 0.262119f
C254 ldo_Rsh/R1 bgr_R1/R1 0.161139f
C255 bgr_MNCD/S bgr_R1/R1 0.09261f
C256 rstn bgr_MPC/D3 0.073588f
C257 ldo_MNX/S2 ldo_MN2/S 14.485394f
C258 rstn bgr_MPA/D3 0.073588f
C259 ldo_MPS/G ldo_MP4/G 0.798709f
C260 bgr_MT1/D bgr_MT4/S 0.280335f
C261 bgr_MNB/G5 bgr_MNSK/S1 0.255237f
C262 ldo_Rsh/R1 bgr_R2/R1 0.128192f
C263 bgr_MT4/D bgr_MPO/D3 6.43e-19
C264 bgr_MT1/D bgr_MNF/G5 0.011498f
C265 bgr_MNCD/S bgr_R2/R1 0.221148f
C266 ldo_MPS/G bgr_MPI/D0_3 0.064096f
C267 ldo_MPS/G ldo_MNX/S2 12.488002f
C268 por_MH/D por_MH/G 0.163197f
C269 bgr_Rf/R2 bgr_MNA/S5 0.16665f
C270 por_MH/D bgr_MSU1/S 1.45e-19
C271 bgr_MNB/G5 vin 14.70256f
C272 bgr_MT4/D bgr_R1/R2 0.097694f
C273 bgr_MSU3/S ldo_MPS/G 0.160425f
C274 bgr_MNCD/G bgr_MNA/S5 0.196596f
C275 bgr_MT1/D ldo_MPS/G 0.147601f
C276 rstn bgr_MSN/S 0.147601f
C277 ldo_Rsh/R2 ldo_MN2/S 0.245391f
C278 vout bgr_MPO/D3 0.321651f
C279 bgr_MT4/D bgr_MT4/S 3.749435f
C280 bgr_MT4/D bgr_MNF/G5 0.057081f
C281 ldo_MP4/G ldo_MPS/D 21.575f
C282 bgr_MPI/D0_3 bgr_Rf/R2 6.56e-19
C283 ldo_MPS/G ldo_Rsh/R2 4.225102f
C284 por_MD/G ldo_MPS/G 3.11143f
C285 ldo_MNX/S2 bgr_Rf/R2 0.190296f
C286 bgr_MPB/D3 bgr_MPO/D3 0.08087f
C287 bgr_MNB/G5 ldo_MNB/G 1.905331f
C288 bgr_R1/R2 vout 0.750172f
C289 ldo_MNX/S2 ldo_MPS/D 0.889711f
C290 por_MI2P/G por_MH/D 22.993824f
C291 bgr_MNCD/G bgr_MPI/D0_3 0.007837f
C292 bgr_R1/R1 ldo_MN2/G 0.274804f
C293 bgr_MT4/S bgr_MT2/D 0.280335f
C294 ldo_MPX/S2 bgr_MPO/D3 0.070151f
C295 ldo_MNX/S2 bgr_MNCD/G 0.245732f
C296 bgr_MT4/D ldo_MPS/G 0.211696f
C297 bgr_MT2/D bgr_MNF/G5 0.013018f
C298 bgr_MS2/D bgr_MNA/S5 15.638101f
C299 bgr_MT4/S vout 12.9935f
C300 ldo_MNX/S2 bgr_MSU1/S 0.23659f
C301 bgr_MSU2/S rstn 0.137896f
C302 bgr_MT1/D bgr_Rf/R2 0.140348f
C303 bgr_R1/R2 bgr_MPB/D3 0.961638f
C304 ldo_Rsh/R1 bgr_MT3/D 0.128192f
C305 ldo_MNX/S2 bgr_MNB/D4 0.157726f
C306 bgr_R2/R1 ldo_MN2/G 0.241892f
C307 vout bgr_MNF/G5 1.134093f
C308 bgr_MNCD/S bgr_MT3/D 0.280297f
C309 bgr_MPC/D3 bgr_MPO/D3 0.947352f
C310 bgr_MPO/D3 bgr_MPA/D3 0.079846f
C311 bgr_MT4/S bgr_MPB/D3 1.54e-19
C312 bgr_R1/R2 ldo_MPX/S2 0.156689f
C313 bgr_MSU3/S por_MH/G 0.185902f
C314 vout ldo_MN2/S 3.290896f
C315 bgr_MNF/G5 bgr_MPB/D3 0.247305f
C316 bgr_MSU3/S bgr_MSU1/S 0.097161f
C317 bgr_R2/R1 bgr_R1/R1 0.36683f
C318 ldo_MPS/G bgr_MT2/D 0.147601f
C319 bgr_MT4/S ldo_MPX/S2 0.156776f
C320 ldo_Rsh/R1 bgr_MNSK/S1 0.064096f
C321 ldo_Rsh/R2 ldo_MPS/D 32.211597f
C322 ldo_MPS/G vout 15.654761f
C323 bgr_MNF/G5 ldo_MPX/S2 0.235983f
C324 bgr_R1/R2 bgr_MPC/D3 1.93343f
C325 bgr_MNCD/S bgr_MNSK/S1 0.10204f
C326 bgr_MS2/D bgr_MPI/D0_3 50.641514f
C327 ldo_MNX/S2 bgr_MS2/D 0.348313f
C328 bgr_R1/R2 bgr_MPA/D3 20.018501f
C329 por_MD/G por_MH/G 0.171293f
C330 bgr_MT4/D bgr_Rf/R2 33.72385f
C331 por_MI2P/G ldo_MNX/S2 2.06e-19
C332 por_MD/G bgr_MSU1/S 0.076607f
C333 ldo_MPX/S2 ldo_MN2/S 6.18975f
C334 ldo_MPS/G bgr_MPB/D3 0.064096f
C335 bgr_MT4/S bgr_MPC/D3 1.21e-19
C336 bgr_MT4/S bgr_MPA/D3 2.05e-19
C337 vin bgr_MSN/D 11.66764f
C338 ldo_Rsh/R1 vin 10.819013f
C339 bgr_MNF/G5 bgr_MPC/D3 0.237829f
C340 bgr_MT4/D bgr_MNCD/G 0.001029f
C341 bgr_MNF/G5 bgr_MPA/D3 3.9732f
C342 bgr_MT1/D bgr_MS2/D 0.58092f
C343 vin bgr_MNCD/S 0.750172f
C344 ldo_MPS/G ldo_MPX/S2 3.178953f
C345 por_MI2P/G bgr_MSU3/S 0.184003f
C346 bgr_MT2/D bgr_Rf/R2 0.140303f
C347 bgr_R1/R2 bgr_MSN/S 0.477511f
C348 vout bgr_Rf/R2 0.750172f
C349 por_MD/D ldo_Rsh/R1 2.72e-19
C350 por_MD/D bgr_MSN/D 0.405029f
C351 ldo_MPS/G bgr_MPC/D3 0.064096f
C352 ldo_MPS/G bgr_MPA/D3 0.064096f
C353 bgr_MNB/G5 bgr_MNA/S5 18.539707f
C354 bgr_MT3/D ldo_MN2/G 0.281472f
C355 rstn bgr_MPO/D3 0.073588f
C356 bgr_MT4/S bgr_MSN/S 4.94451f
C357 vout ldo_MPS/D 3.03296f
C358 ldo_Rsh/R1 ldo_MNB/G 0.640982f
C359 por_MI2P/G por_MD/G 27.380116f
C360 vout bgr_MNCD/G 1.025319f
C361 bgr_MNF/G5 bgr_MSN/S 0.456638f
C362 por_MH/G vout 0.876945f
C363 bgr_MT4/D bgr_MS2/D 0.350196f
C364 vout bgr_MSU1/S 0.964952f
C365 bgr_R1/R1 bgr_MT3/D 0.344004f
C366 vout bgr_MNB/D4 0.645209f
C367 bgr_MNCD/G bgr_MPB/D3 0.001029f
C368 ldo_MPX/S2 bgr_Rf/R2 0.172872f
C369 bgr_R1/R2 rstn 0.163775f
C370 bgr_MNSK/S1 ldo_MN2/G 0.073966f
C371 bgr_R2/R1 bgr_MT3/D 0.147693f
C372 ldo_MPX/S2 ldo_MPS/D 0.157226f
C373 bgr_MNB/G5 bgr_MPI/D0_3 0.23893f
C374 bgr_MNCD/G ldo_MPX/S2 0.219596f
C375 bgr_MNB/G5 ldo_MNX/S2 0.467875f
C376 ldo_MPS/G bgr_MSN/S 0.147601f
C377 por_MH/G ldo_MPX/S2 2.72e-19
C378 bgr_MT4/S rstn 0.163861f
C379 bgr_MPC/D3 bgr_Rf/R2 0.298337f
C380 bgr_MT2/D bgr_MS2/D 0.49855f
C381 bgr_R1/R1 bgr_MNSK/S1 0.093855f
C382 bgr_MSU1/S ldo_MPX/S2 0.210454f
C383 bgr_MNF/G5 rstn 0.246717f
C384 vin ldo_MN2/G 31.631578f
C385 bgr_MNB/D4 ldo_MPX/S2 0.140303f
C386 vout bgr_MS2/D 1.46101f
C387 rstn ldo_MN2/S 0.073588f
C388 bgr_MNCD/G bgr_MPC/D3 4.73177f
C389 bgr_MNCD/G bgr_MPA/D3 6.43e-19
C390 bgr_R2/R1 bgr_MNSK/S1 0.221148f
C391 bgr_MNB/G5 bgr_MT1/D 5.54849f
C392 por_MI2P/G vout 0.797784f
C393 vin bgr_R1/R1 3.563889f
C394 bgr_MS2/D bgr_MPB/D3 25.458517f
C395 ldo_MPS/G rstn 1.80087f
C396 por_MD/D ldo_MN2/G 0.162326f
C397 ldo_MPS/G bgr_MSU2/S 0.143952f
C398 bgr_MS2/D ldo_MPX/S2 0.313466f
C399 vin bgr_R2/R1 2.369795f
C400 bgr_MSN/S bgr_Rf/R2 0.148007f
C401 por_MH/D bgr_MSN/D 8.66e-20
C402 ldo_MNB/G ldo_MN2/G 1.270768f
C403 por_MH/D ldo_Rsh/R1 4.4e-19
C404 por_MI2P/G ldo_MPX/S2 3.75e-19
C405 bgr_MNCD/G bgr_MSN/S 18.024992f
C406 bgr_MS2/D bgr_MPC/D3 25.461086f
C407 bgr_MNB/G5 bgr_MT4/D 0.102352f
C408 bgr_MS2/D bgr_MPA/D3 25.458498f
C409 bgr_R1/R1 ldo_MNB/G 0.550083f
C410 bgr_MSU1/S bgr_MSN/S 0.076108f
C411 ldo_Rsh/R1 bgr_MNA/S5 0.144578f
C412 bgr_MNB/D4 bgr_MSN/S 0.320025f
C413 bgr_MNCD/S bgr_MNA/S5 0.00258f
C414 bgr_R2/R1 ldo_MNB/G 0.533956f
C415 rstn bgr_Rf/R2 0.163775f
C416 bgr_R1/R2 bgr_MPO/D3 0.271288f
C417 rstn ldo_MPS/D 0.147644f
C418 ldo_Rsh/R1 ldo_MP4/G 0.316976f
C419 bgr_MNB/G5 bgr_MT2/D 0.002266f
C420 bgr_MNCD/G rstn 0.23033f
C421 por_MH/G rstn 1.948907f
C422 bgr_MT4/S bgr_MPO/D3 1.77e-20
C423 bgr_MNSK/S1 bgr_MT3/D 0.280297f
C424 bgr_MNB/G5 vout 2.027392f
C425 bgr_MSU1/S rstn 0.211696f
C426 ldo_Rsh/R1 bgr_MPI/D0_3 0.064096f
C427 bgr_MNF/G5 bgr_MPO/D3 0.238461f
C428 bgr_MS2/D bgr_MSN/S 1.291891f
C429 ldo_MNX/S2 bgr_MSN/D 0.347386f
C430 ldo_Rsh/R1 ldo_MNX/S2 7.208094f
C431 por_MH/G bgr_MSU2/S 0.185601f
C432 bgr_MNB/D4 rstn 0.147601f
C433 bgr_MNCD/S ldo_MNX/S2 0.174113f
C434 bgr_MSU2/S bgr_MSU1/S 14.113523f
C435 bgr_MNB/G5 bgr_MPB/D3 4.11898f
C436 bgr_MT4/S bgr_R1/R2 1.1787f
C437 vin bgr_MT3/D 1.050086f
C438 bgr_R1/R2 bgr_MNF/G5 0.341358f
C439 bgr_MSU3/S ldo_Rsh/R1 0.144665f
C440 bgr_MSU3/S bgr_MSN/D 2.998732f
C441 bgr_MT1/D ldo_Rsh/R1 0.128192f
C442 bgr_MNB/G5 ldo_MPX/S2 0.424315f
C443 ldo_MPS/G bgr_MPO/D3 0.064096f
C444 por_MH/D ldo_MN2/G 0.071796f
C445 bgr_MT1/D bgr_MNCD/S 0.280335f
C446 bgr_MS2/D rstn 0.327849f
C447 bgr_MT4/S bgr_MNF/G5 0.064113f
C448 por_MI2P/G rstn 0.229295f
C449 bgr_MNB/G5 bgr_MPC/D3 0.250485f
C450 vin bgr_MNSK/S1 0.322487f
C451 ldo_Rsh/R1 ldo_Rsh/R2 7.734384f
C452 bgr_MNA/S5 ldo_MN2/G 0.162149f
C453 por_MD/G ldo_Rsh/R1 0.001624f
C454 por_MD/G bgr_MSN/D 1.95887f
C455 bgr_MNB/G5 bgr_MPA/D3 5.4e-19
C456 ldo_MPS/G bgr_R1/R2 0.154283f
C457 por_MI2P/G bgr_MSU2/S 0.183294f
C458 ldo_MPS/G bgr_MT4/S 0.15437f
C459 bgr_R1/R1 bgr_MNA/S5 0.134507f
C460 bgr_MT4/D ldo_Rsh/R1 0.192287f
C461 ldo_MPS/G bgr_MNF/G5 0.237226f
C462 ldo_MP4/G ldo_MN2/G 0.370898f
C463 bgr_MT4/D bgr_MNCD/S 0.210093f
C464 bgr_Rf/R2 bgr_MPO/D3 4.49766f
C465 bgr_R2/R1 bgr_MNA/S5 0.221148f
C466 ldo_MPS/G ldo_MN2/S 2.75724f
C467 bgr_MPI/D0_3 ldo_MN2/G 0.071796f
C468 ldo_MNX/S2 ldo_MN2/G 1.131655f
C469 bgr_MNB/G5 bgr_MSN/S 0.066849f
C470 bgr_MNCD/G bgr_MPO/D3 23.874802f
C471 bgr_MT2/D ldo_Rsh/R1 0.128192f
C472 bgr_R1/R2 bgr_Rf/R2 0.572627f
C473 por_MD/D vin 2.852642f
C474 bgr_MPI/D0_3 bgr_R1/R1 0.557978f
C475 bgr_MT2/D bgr_MNCD/S 0.280335f
C476 ldo_MNX/S2 bgr_R1/R1 0.190673f
C477 vout bgr_MSN/D 1.45366f
C478 ldo_Rsh/R1 vout 4.750213f
C479 bgr_MSU3/S ldo_MN2/G 0.145853f
C480 vin ldo_MNB/G 41.134876f
C481 bgr_MT1/D ldo_MN2/G 0.148553f
C482 bgr_MNCD/S vout 0.750172f
C483 bgr_MT4/S bgr_Rf/R2 0.091684f
C484 bgr_R1/R2 bgr_MNCD/G 2.15655f
C485 bgr_R2/R1 bgr_MPI/D0_3 0.00112f
C486 bgr_MNF/G5 bgr_Rf/R2 0.125033f
C487 ldo_MNX/S2 bgr_R2/R1 0.157726f
C488 ldo_Rsh/R1 bgr_MPB/D3 0.064096f
C489 bgr_R1/R2 bgr_MSU1/S 1.82e-19
C490 bgr_MNB/G5 rstn 0.442045f
C491 bgr_MT1/D bgr_R1/R1 0.34408f
C492 bgr_R1/R2 bgr_MNB/D4 14.158496f
C493 bgr_MT4/S bgr_MNCD/G 0.07363f
C494 ldo_Rsh/R2 ldo_MN2/G 0.412681f
C495 por_MD/G ldo_MN2/G 0.145853f
C496 bgr_MNF/G5 bgr_MNCD/G 19.451126f
C497 bgr_MSN/D ldo_MPX/S2 0.312539f
C498 bgr_MS2/D bgr_MPO/D3 25.453285f
C499 ldo_Rsh/R1 ldo_MPX/S2 39.22429f
C500 ldo_MN2/S ldo_MPS/D 4.110057f
C501 bgr_MNCD/S ldo_MPX/S2 0.156689f
C502 bgr_MSU1/S bgr_MNF/G5 0.078923f
C503 bgr_MT1/D bgr_R2/R1 15.568563f
C504 ldo_MPS/G bgr_Rf/R2 0.170466f
C505 bgr_MNF/G5 bgr_MNB/D4 0.320789f
C506 bgr_MT4/D ldo_MN2/G 0.40566f
C507 ldo_Rsh/R1 bgr_MPC/D3 0.064096f
C508 ldo_Rsh/R1 bgr_MPA/D3 0.064096f
C509 ldo_MPS/G ldo_MPS/D 4.585765f
C510 bgr_R1/R2 bgr_MS2/D 0.219058f
C511 ldo_MPS/G bgr_MNCD/G 0.220839f
C512 bgr_MNA/S5 bgr_MT3/D 0.280297f
C513 ldo_MPS/G por_MH/G 0.015563f
C514 ldo_MPS/G bgr_MSU1/S 0.217752f
C515 bgr_MT4/D bgr_R1/R1 0.572835f
C516 bgr_MT4/S bgr_MS2/D 25.271173f
C517 ldo_MPS/G bgr_MNB/D4 0.147601f
C518 bgr_MNF/G5 bgr_MS2/D 51.822216f
C519 bgr_MT2/D ldo_MN2/G 0.148301f
C520 bgr_MT4/D bgr_R2/R1 26.2769f
C521 bgr_MNSK/S1 bgr_MNA/S5 16.399302f
C522 vout ldo_MN2/G 55.585377f
C523 por_MH/D vin 1.381918f
C524 ldo_Rsh/R1 bgr_MSN/S 0.128192f
C525 bgr_MSN/D bgr_MSN/S 0.271474f
C526 bgr_MT2/D bgr_R1/R1 0.34408f
C527 ldo_MNX/S2 bgr_MT3/D 0.157726f
C528 bgr_MNCD/S bgr_MSN/S 37.88801f
C529 bgr_MPB/D3 ldo_MN2/G 0.071796f
C530 ldo_MPS/G bgr_MS2/D 0.318357f
C531 vout bgr_R1/R1 0.858173f
C532 bgr_MNCD/G bgr_Rf/R2 3.866041f
C533 vin bgr_MNA/S5 0.755686f
C534 bgr_MT2/D bgr_R2/R1 0.150271f
C535 por_MI2P/G ldo_MPS/G 0.019716f
C536 bgr_MSU1/S bgr_Rf/R2 19.547653f
C537 ldo_MPX/S2 ldo_MN2/G 0.152882f
C538 bgr_R1/R1 bgr_MPB/D3 0.278981f
C539 por_MH/D por_MD/D 0.19152f
C540 bgr_MNB/D4 bgr_Rf/R2 0.815622f
C541 vout bgr_R2/R1 0.643301f
C542 bgr_MNB/G5 bgr_MPO/D3 0.23977f
C543 bgr_MT1/D bgr_MT3/D 0.153612f
C544 ldo_MNX/S2 bgr_MNSK/S1 0.078863f
C545 bgr_MSU1/S bgr_MNCD/G 0.787782f
C546 bgr_MSN/D rstn 0.31743f
C547 por_MH/G bgr_MSU1/S 0.064656f
C548 ldo_Rsh/R1 rstn 0.156967f
C549 bgr_R1/R1 ldo_MPX/S2 0.17325f
C550 bgr_MNB/D4 bgr_MNCD/G 3.576538f
C551 vin ldo_MP4/G 6.079892f
C552 bgr_R2/R1 bgr_MPB/D3 3.18e-19
C553 bgr_MNCD/S rstn 0.163987f
C554 bgr_MPC/D3 ldo_MN2/G 0.071796f
C555 ldo_Rsh/R1 bgr_MSU2/S 0.128192f
C556 bgr_MSU2/S bgr_MSN/D 8.523878f
C557 bgr_MPA/D3 ldo_MN2/G 0.071796f
C558 bgr_MSU1/S bgr_MNB/D4 14.234329f
C559 bgr_MNB/G5 bgr_R1/R2 3.390391f
C560 vin bgr_MPI/D0_3 6.346921f
C561 bgr_MT1/D bgr_MNSK/S1 0.280335f
C562 vin ldo_MNX/S2 11.903499f
C563 bgr_R2/R1 ldo_MPX/S2 0.140303f
C564 bgr_MS2/D bgr_Rf/R2 20.386625f
C565 bgr_MPC/D3 bgr_R1/R1 0.278498f
C566 bgr_R1/R1 bgr_MPA/D3 0.280451f
C567 bgr_MNB/G5 bgr_MT4/S 0.064113f
C568 bgr_MT4/D bgr_MT3/D 20.16244f
C569 bgr_MNB/G5 bgr_MNF/G5 30.54294f
C570 bgr_MNCD/G bgr_MS2/D 20.730665f
C571 bgr_R2/R1 bgr_MPC/D3 4.39e-19
C572 bgr_MSU3/S vin 3.496164f
C573 bgr_MT1/D vin 1.051416f
C574 bgr_R2/R1 bgr_MPA/D3 2.41e-19
C575 bgr_MSU1/S bgr_MS2/D 0.51021f
C576 ldo_MNB/G ldo_MP4/G 0.255387f
C577 por_MI2P/G por_MH/G 58.556534f
C578 bgr_MSN/S ldo_MN2/G 0.145762f
C579 bgr_MNB/D4 bgr_MS2/D 0.320025f
C580 por_MI2P/G bgr_MSU1/S 0.070588f
C581 bgr_MPI/D0_3 ldo_MNB/G 8.767353f
C582 ldo_MNX/S2 ldo_MNB/G 0.633537f
C583 bgr_MT4/D bgr_MNSK/S1 0.210193f
C584 bgr_MNB/G5 ldo_MPS/G 0.432856f
C585 vin ldo_Rsh/R2 6.924948f
C586 bgr_MT2/D bgr_MT3/D 20.50359f
C587 por_MD/G vin 3.67017f
C588 bgr_R1/R1 bgr_MSN/S 0.004244f
C589 por_MD/D bgr_MSU3/S 0.391515f
C590 vout bgr_MT3/D 0.643301f
C591 bgr_MT1/D ldo_MNB/G 1.4e-19
C592 bgr_R2/R1 bgr_MSN/S 0.221148f
C593 bgr_MT4/D vin 3.078416f
C594 rstn ldo_MN2/G 0.071988f
C595 bgr_MT2/D bgr_MNSK/S1 0.280335f
C596 por_MI2P/G gnd 17.464622f
C597 bgr_MSN/S gnd 15.207279f
C598 bgr_Rf/R2 gnd 36.545094f
C599 por_MH/G gnd 20.076271f
C600 vout gnd 0.167985p
C601 ldo_MNX/S2 gnd 0.149226p
C602 ldo_MNB/G gnd 0.106386p
C603 rstn gnd 33.16786f
C604 bgr_MPI/D0_3 gnd 31.231134f
C605 ldo_MN2/S gnd 26.131058f
C606 ldo_MPS/G gnd 39.84754f
C607 ldo_MP4/G gnd 33.179596f
C608 bgr_R1/R2 gnd 14.621557f
C609 bgr_MNB/G5 gnd 0.20224p
C610 ldo_MPX/S2 gnd 76.27293f
C611 bgr_MPC/D3 gnd 17.31881f
C612 bgr_MNA/S5 gnd 12.422413f
C613 bgr_MPB/D3 gnd 16.477213f
C614 bgr_MPA/D3 gnd 17.108612f
C615 ldo_MPS/D gnd 37.49163f
C616 ldo_Rsh/R2 gnd 13.985748f
C617 por_MD/D gnd 17.868414f
C618 bgr_MSN/D gnd 25.713915f
C619 por_MD/G gnd 36.20186f
C620 por_MH/D gnd 18.87944f
C621 bgr_MSU3/S gnd 46.53367f
C622 bgr_R1/R1 gnd 47.29789f
C623 bgr_MNSK/S1 gnd 15.236314f
C624 bgr_MT3/D gnd 11.977405f
C625 bgr_MSU1/S gnd 27.241903f
C626 bgr_MSU2/S gnd 22.569653f
C627 bgr_MT2/D gnd 12.730652f
C628 ldo_Rsh/R1 gnd 31.72648f
C629 bgr_MT1/D gnd 12.948739f
C630 bgr_R2/R1 gnd 15.641191f
C631 bgr_MT4/S gnd 18.049871f
C632 bgr_MNB/D4 gnd 29.305902f
C633 bgr_MNF/G5 gnd 0.104438p
C634 bgr_MNCD/G gnd 0.110959p
C635 bgr_MNCD/S gnd 16.304754f
C636 vin gnd 2.488288p
C637 ldo_MN2/G gnd 60.518642f
C638 bgr_MT4/D gnd 28.19207f
C639 bgr_MS2/D gnd 0.180332p
C640 bgr_MPO/D3 gnd 17.06311f
.ends
