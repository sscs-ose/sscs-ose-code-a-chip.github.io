* NGSPICE file created from ldo_top.ext - technology: sky130A

.subckt sky130_fd_pr__pfet_g5v0d10v5_UFECYT B D0 S0 G0 D1 S1 G1 D2 S2 G2 D3 S3 G3
+ VSUBS
X0 S2 G2 D2 B sky130_fd_pr__pfet_g5v0d10v5 ad=5.8 pd=40.58 as=5.8 ps=40.58 w=20 l=16
X1 S0 G0 D0 B sky130_fd_pr__pfet_g5v0d10v5 ad=5.8 pd=40.58 as=5.8 ps=40.58 w=20 l=16
X2 S3 G3 D3 B sky130_fd_pr__pfet_g5v0d10v5 ad=5.8 pd=40.58 as=5.8 ps=40.58 w=20 l=16
X3 S1 G1 D1 B sky130_fd_pr__pfet_g5v0d10v5 ad=5.8 pd=40.58 as=5.8 ps=40.58 w=20 l=16
C0 B S1 1.13466f
C1 D0 D1 0.014232f
C2 B G3 2.90949f
C3 B G0 2.08018f
C4 G2 S2 0.843488f
C5 S3 S2 0.014232f
C6 G2 G1 1.79553f
C7 D0 B 1.14186f
C8 D0 G0 0.843488f
C9 G2 D2 0.843488f
C10 S0 S1 0.014232f
C11 D3 D2 0.014232f
C12 S0 B 1.14186f
C13 S0 G0 0.843488f
C14 S1 S2 0.014232f
C15 D1 G1 0.843488f
C16 G2 G3 1.79553f
C17 G2 B 1.63817f
C18 S3 G3 0.843488f
C19 D3 G3 0.843488f
C20 S3 B 1.14084f
C21 D3 B 1.14084f
C22 B S2 1.13466f
C23 S1 G1 0.843488f
C24 D1 D2 0.014232f
C25 B G1 1.63817f
C26 G0 G1 1.79553f
C27 B D2 1.13466f
C28 B D1 1.13466f
C29 S0 VSUBS 1.63025f
C30 D0 VSUBS 1.63025f
C31 G0 VSUBS 3.53008f
C32 S1 VSUBS 1.62405f
C33 D1 VSUBS 1.62405f
C34 G1 VSUBS 3.28219f
C35 S2 VSUBS 1.62405f
C36 D2 VSUBS 1.62405f
C37 G2 VSUBS 3.28219f
C38 S3 VSUBS 1.6295f
C39 D3 VSUBS 1.6295f
C40 G3 VSUBS 3.33883f
C41 B VSUBS 0.200533p
.ends

.subckt sky130_fd_pr__nfet_g5v0d10v5_3LMSA7 B D S G
X0 S G D B sky130_fd_pr__nfet_g5v0d10v5 ad=1.45 pd=10.58 as=1.45 ps=10.58 w=5 l=0.5
C0 D G 0.06583f
C1 S G 0.06583f
C2 D S 0.446027f
C3 S B 0.524972f
C4 D B 0.524972f
C5 G B 0.301693f
.ends

.subckt sky130_fd_pr__pfet_g5v0d10v5_TGGT4A B D0_0 G0_0 D0_1 G0_1 D0_2 G0_2 D0_3 G0_3
+ S1_0 G1_0 S1_1 G1_1 S1_2 G1_2 S1_3 G1_3 D2_0 G2_0 D2_1 G2_1 D2_2 G2_2 D2_3 G2_3
+ S3_0 G3_0 S3_1 G3_1 S3_2 G3_2 S3_3 G3_3 a_887_n4118# a_887_n8283# a_887_47# a_887_4212#
+ VSUBS
X0 S3_2 G2_2 D2_2 B sky130_fd_pr__pfet_g5v0d10v5 ad=2.9 pd=20.29 as=2.9 ps=20.29 w=20 l=2
X1 a_887_4212# G3_3 S3_3 B sky130_fd_pr__pfet_g5v0d10v5 ad=5.8 pd=40.58 as=2.9 ps=20.29 w=20 l=2
X2 S1_3 G0_3 D0_3 B sky130_fd_pr__pfet_g5v0d10v5 ad=2.9 pd=20.29 as=5.8 ps=40.58 w=20 l=2
X3 S3_1 G2_1 D2_1 B sky130_fd_pr__pfet_g5v0d10v5 ad=2.9 pd=20.29 as=2.9 ps=20.29 w=20 l=2
X4 S1_0 G0_0 D0_0 B sky130_fd_pr__pfet_g5v0d10v5 ad=2.9 pd=20.29 as=5.8 ps=40.58 w=20 l=2
X5 D2_2 G1_2 S1_2 B sky130_fd_pr__pfet_g5v0d10v5 ad=2.9 pd=20.29 as=2.9 ps=20.29 w=20 l=2
X6 a_887_n8283# G3_0 S3_0 B sky130_fd_pr__pfet_g5v0d10v5 ad=5.8 pd=40.58 as=2.9 ps=20.29 w=20 l=2
X7 S1_2 G0_2 D0_2 B sky130_fd_pr__pfet_g5v0d10v5 ad=2.9 pd=20.29 as=5.8 ps=40.58 w=20 l=2
X8 D2_3 G1_3 S1_3 B sky130_fd_pr__pfet_g5v0d10v5 ad=2.9 pd=20.29 as=2.9 ps=20.29 w=20 l=2
X9 D2_0 G1_0 S1_0 B sky130_fd_pr__pfet_g5v0d10v5 ad=2.9 pd=20.29 as=2.9 ps=20.29 w=20 l=2
X10 S1_1 G0_1 D0_1 B sky130_fd_pr__pfet_g5v0d10v5 ad=2.9 pd=20.29 as=5.8 ps=40.58 w=20 l=2
X11 a_887_n4118# G3_1 S3_1 B sky130_fd_pr__pfet_g5v0d10v5 ad=5.8 pd=40.58 as=2.9 ps=20.29 w=20 l=2
X12 D2_1 G1_1 S1_1 B sky130_fd_pr__pfet_g5v0d10v5 ad=2.9 pd=20.29 as=2.9 ps=20.29 w=20 l=2
X13 a_887_47# G3_2 S3_2 B sky130_fd_pr__pfet_g5v0d10v5 ad=5.8 pd=40.58 as=2.9 ps=20.29 w=20 l=2
X14 S3_0 G2_0 D2_0 B sky130_fd_pr__pfet_g5v0d10v5 ad=2.9 pd=20.29 as=2.9 ps=20.29 w=20 l=2
X15 S3_3 G2_3 D2_3 B sky130_fd_pr__pfet_g5v0d10v5 ad=2.9 pd=20.29 as=2.9 ps=20.29 w=20 l=2
C0 S3_2 S3_3 0.014232f
C1 S3_2 a_887_47# 0.614813f
C2 B G1_3 0.382207f
C3 a_887_n4118# a_887_n8283# 0.014232f
C4 D2_0 S3_0 0.614813f
C5 G2_3 S3_3 0.625982f
C6 G0_2 B 0.247781f
C7 S3_2 S3_1 0.014232f
C8 S3_1 D2_1 0.614813f
C9 G1_0 D2_0 0.625982f
C10 B D0_1 1.13467f
C11 G0_1 G0_2 0.227831f
C12 D2_2 G2_2 0.625982f
C13 B S3_3 0.015791f
C14 B a_887_47# 1.13467f
C15 D2_2 S3_2 0.614813f
C16 B S1_0 0.016816f
C17 G0_1 D0_1 0.625982f
C18 D2_2 D2_1 0.014232f
C19 G0_3 S1_3 0.625982f
C20 G3_1 G3_0 0.227831f
C21 G0_0 G1_0 0.061903f
C22 G3_1 G3_2 0.227831f
C23 B S3_1 0.009616f
C24 S3_0 a_887_n8283# 0.614813f
C25 D2_0 D2_1 0.014232f
C26 D2_2 B 0.009616f
C27 G1_2 G2_2 0.061903f
C28 B a_887_n4118# 1.13467f
C29 B D2_0 0.016816f
C30 G3_2 G3_3 0.227831f
C31 G0_3 D0_3 0.625982f
C32 B G0_0 0.303032f
C33 S1_1 D2_1 0.614813f
C34 G0_3 G1_3 0.061903f
C35 G3_3 a_887_4212# 0.625982f
C36 G0_1 G0_0 0.227831f
C37 G0_2 G0_3 0.227831f
C38 G1_2 B 0.223127f
C39 B a_887_n8283# 1.14187f
C40 B S1_1 0.009616f
C41 B S3_0 0.016816f
C42 S3_2 G2_2 0.625982f
C43 G0_1 S1_1 0.625982f
C44 G2_2 G2_3 0.227831f
C45 B G1_0 0.278378f
C46 G2_1 S3_1 0.625982f
C47 G2_2 B 0.223127f
C48 G1_1 G1_2 0.227831f
C49 S3_2 B 0.009616f
C50 B D2_1 0.009616f
C51 G2_0 D2_0 0.625982f
C52 G1_1 S1_1 0.625982f
C53 B G2_3 0.382207f
C54 G3_1 S3_1 0.625982f
C55 G1_1 G1_0 0.227831f
C56 S3_3 G3_3 0.625982f
C57 G0_1 B 0.247781f
C58 S1_3 D2_3 0.614813f
C59 S1_3 D0_3 0.614813f
C60 G3_1 a_887_n4118# 0.625982f
C61 G2_0 S3_0 0.625982f
C62 G1_1 D2_1 0.625982f
C63 S1_3 S1_2 0.014232f
C64 D0_2 D0_3 0.014232f
C65 G3_2 a_887_47# 0.625982f
C66 D0_2 S1_2 0.614813f
C67 G1_0 G2_0 0.061903f
C68 S1_3 G1_3 0.625982f
C69 G1_1 B 0.223127f
C70 G2_1 G2_2 0.227831f
C71 S3_3 a_887_4212# 0.614813f
C72 G0_2 D0_2 0.625982f
C73 a_887_47# a_887_4212# 0.014232f
C74 G1_1 G0_1 0.061903f
C75 D0_0 D0_1 0.014232f
C76 G2_1 D2_1 0.625982f
C77 D0_2 D0_1 0.014232f
C78 D0_0 S1_0 0.614813f
C79 D2_3 G1_3 0.625982f
C80 B G2_0 0.278378f
C81 G2_1 B 0.223127f
C82 B G0_3 0.40686f
C83 G0_2 S1_2 0.625982f
C84 D2_3 S3_3 0.614813f
C85 G3_0 a_887_n8283# 0.625982f
C86 G3_0 S3_0 0.625982f
C87 G0_0 D0_0 0.625982f
C88 G3_1 B 0.247781f
C89 G1_1 G2_1 0.061903f
C90 D2_2 D2_3 0.014232f
C91 D2_2 S1_2 0.614813f
C92 G2_2 G3_2 0.061903f
C93 G2_3 G3_3 0.061903f
C94 S3_2 G3_2 0.625982f
C95 B G3_3 0.40686f
C96 G2_1 G2_0 0.227831f
C97 B G3_0 0.303032f
C98 B G3_2 0.247781f
C99 G1_2 S1_2 0.625982f
C100 a_887_47# a_887_n4118# 0.014232f
C101 G1_2 G1_3 0.227831f
C102 S1_0 D2_0 0.614813f
C103 S1_2 S1_1 0.014232f
C104 G0_2 G1_2 0.061903f
C105 B a_887_4212# 1.14085f
C106 S3_1 a_887_n4118# 0.614813f
C107 G0_0 S1_0 0.625982f
C108 B S1_3 0.015791f
C109 G2_1 G3_1 0.061903f
C110 B D0_0 1.14187f
C111 B D0_2 1.13467f
C112 D0_1 S1_1 0.614813f
C113 S1_0 S1_1 0.014232f
C114 G2_3 D2_3 0.625982f
C115 S3_1 S3_0 0.014232f
C116 G1_0 S1_0 0.625982f
C117 D2_2 G1_2 0.625982f
C118 B D2_3 0.015791f
C119 B D0_3 1.14085f
C120 G2_3 G1_3 0.061903f
C121 B S1_2 0.009616f
C122 G2_0 G3_0 0.061903f
C123 S3_0 VSUBS 0.863504f
C124 D2_0 VSUBS 0.863504f
C125 S1_0 VSUBS 0.863504f
C126 D0_0 VSUBS 1.12621f
C127 G3_0 VSUBS 0.440605f
C128 G2_0 VSUBS 0.427224f
C129 G1_0 VSUBS 0.427224f
C130 G0_0 VSUBS 0.440605f
C131 S3_1 VSUBS 0.857307f
C132 D2_1 VSUBS 0.857307f
C133 S1_1 VSUBS 0.857307f
C134 D0_1 VSUBS 1.12001f
C135 G3_1 VSUBS 0.409619f
C136 G2_1 VSUBS 0.396239f
C137 G1_1 VSUBS 0.396239f
C138 G0_1 VSUBS 0.409619f
C139 S3_2 VSUBS 0.857307f
C140 D2_2 VSUBS 0.857307f
C141 S1_2 VSUBS 0.857307f
C142 D0_2 VSUBS 1.12001f
C143 G3_2 VSUBS 0.409619f
C144 G2_2 VSUBS 0.396239f
C145 G1_2 VSUBS 0.396239f
C146 G0_2 VSUBS 0.409619f
C147 S3_3 VSUBS 0.862757f
C148 D2_3 VSUBS 0.862757f
C149 S1_3 VSUBS 0.862757f
C150 D0_3 VSUBS 1.12546f
C151 G3_3 VSUBS 0.420067f
C152 G2_3 VSUBS 0.406686f
C153 G1_3 VSUBS 0.406686f
C154 G0_3 VSUBS 0.420067f
C155 B VSUBS 0.12679p
C156 a_887_n8283# VSUBS 1.12621f
C157 a_887_n4118# VSUBS 1.12001f
C158 a_887_47# VSUBS 1.12001f
C159 a_887_4212# VSUBS 1.12546f
.ends

.subckt sky130_fd_pr__nfet_g5v0d10v5_C8EBTW B D S G
X0 S G D B sky130_fd_pr__nfet_g5v0d10v5 ad=0.203 pd=1.98 as=0.203 ps=1.98 w=0.7 l=20
C0 G S 0.036799f
C1 G D 0.036799f
C2 S B 0.128043f
C3 D B 0.128043f
C4 G B 8.82479f
.ends

.subckt sky130_fd_pr__nfet_g5v0d10v5_62W55W B D S G
X0 S G D B sky130_fd_pr__nfet_g5v0d10v5 ad=0.29 pd=2.58 as=0.29 ps=2.58 w=1 l=1
C0 G S 0.026809f
C1 D S 0.055609f
C2 G D 0.026809f
C3 S B 0.138407f
C4 D B 0.138407f
C5 G B 0.526365f
.ends

.subckt sky130_fd_pr__cap_mim_m3_1_BTY6QK C2 C1 VSUBS
X0 C1 C2 sky130_fd_pr__cap_mim_m3_1 l=25 w=25
C0 C2 C1 55.2292f
C1 C1 VSUBS 2.59358f
C2 C2 VSUBS 13.8127f
.ends

.subckt sky130_fd_pr__cap_mim_m3_1_V8HUNN C2 C1 VSUBS
X0 C1 C2 sky130_fd_pr__cap_mim_m3_1 l=16 w=16
C0 C2 C1 23.226198f
C1 C1 VSUBS 1.64509f
C2 C2 VSUBS 7.15816f
.ends

.subckt sky130_fd_pr__nfet_g5v0d10v5_NUFNY9 B D S G
X0 S G D B sky130_fd_pr__nfet_g5v0d10v5 ad=0.29 pd=2.58 as=0.29 ps=2.58 w=1 l=4
C0 G S 0.04509f
C1 D S 0.016591f
C2 G D 0.04509f
C3 S B 0.152182f
C4 D B 0.152182f
C5 G B 1.8263f
.ends

.subckt sky130_fd_pr__nfet_05v0_nvt_F4CC77 B D S G
X0 S G D B sky130_fd_pr__nfet_05v0_nvt ad=0.29 pd=2.58 as=0.29 ps=2.58 w=1 l=25
C0 G S 0.049339f
C1 G D 0.049339f
C2 S B 0.169637f
C3 D B 0.169637f
C4 G B 10.926f
.ends

.subckt sky130_fd_pr__nfet_05v0_nvt_ASWYB8 B D0 G0 S1 G1 D2 G2 S3 G3 D4 G4 S5 G5 a_15145_n131#
X0 S3 G2 D2 B sky130_fd_pr__nfet_05v0_nvt ad=0.145 pd=1.29 as=0.145 ps=1.29 w=1 l=25
X1 S1 G0 D0 B sky130_fd_pr__nfet_05v0_nvt ad=0.145 pd=1.29 as=0.29 ps=2.58 w=1 l=25
X2 D2 G1 S1 B sky130_fd_pr__nfet_05v0_nvt ad=0.145 pd=1.29 as=0.145 ps=1.29 w=1 l=25
X3 D4 G3 S3 B sky130_fd_pr__nfet_05v0_nvt ad=0.145 pd=1.29 as=0.145 ps=1.29 w=1 l=25
X4 a_15145_n131# G5 S5 B sky130_fd_pr__nfet_05v0_nvt ad=0.29 pd=2.58 as=0.145 ps=1.29 w=1 l=25
X5 S5 G4 D4 B sky130_fd_pr__nfet_05v0_nvt ad=0.145 pd=1.29 as=0.145 ps=1.29 w=1 l=25
C0 G5 a_15145_n131# 0.049339f
C1 D4 G3 0.049339f
C2 G3 G4 0.05942f
C3 D4 G4 0.049339f
C4 G0 G1 0.05942f
C5 G1 D2 0.049339f
C6 G0 S1 0.049339f
C7 G1 S1 0.049339f
C8 G5 S5 0.049339f
C9 G2 D2 0.049339f
C10 G1 G2 0.05942f
C11 G2 S3 0.049339f
C12 G0 D0 0.049339f
C13 G4 S5 0.049339f
C14 G3 S3 0.049339f
C15 G2 G3 0.05942f
C16 G5 G4 0.05942f
C17 S5 B 0.119853f
C18 D4 B 0.119853f
C19 S3 B 0.119853f
C20 D2 B 0.119853f
C21 S1 B 0.119853f
C22 D0 B 0.169637f
C23 G5 B 10.8897f
C24 G4 B 10.853401f
C25 G3 B 10.853401f
C26 G2 B 10.853401f
C27 G1 B 10.853401f
C28 G0 B 10.8897f
C29 a_15145_n131# B 0.169637f
.ends

.subckt sky130_fd_pr__nfet_g5v0d10v5_BE4NYT B D S G
X0 S G D B sky130_fd_pr__nfet_g5v0d10v5 ad=0.58 pd=4.58 as=0.58 ps=4.58 w=2 l=4
C0 D S 0.032918f
C1 D G 0.082975f
C2 S G 0.082975f
C3 S B 0.271253f
C4 D B 0.271253f
C5 G B 1.80067f
.ends

.subckt sky130_fd_pr__res_xhigh_po_0p35_5J6MKL B R1 R2
X0 R2 R1 B sky130_fd_pr__res_xhigh_po_0p35 l=94.73
C0 R1 R2 0.296258f
C1 R2 B 0.387223f
C2 R1 B 0.387223f
.ends

.subckt sky130_fd_pr__nfet_g5v0d10v5_A8HTHF B D S G
X0 S G D B sky130_fd_pr__nfet_g5v0d10v5 ad=0.29 pd=2.58 as=0.29 ps=2.58 w=1 l=0.5
C0 D S 0.090631f
C1 D G 0.016273f
C2 S G 0.016273f
C3 S B 0.133548f
C4 D B 0.133548f
C5 G B 0.309709f
.ends

.subckt sky130_fd_pr__nfet_g5v0d10v5_YQMGE2 B D0 G0 S1 G1 D2 G2 S3 G3 D4 G4 S5 G5
+ D6 G6 S7 G7 D8 G8 S9 G9 D10 G10 S11 G11 D12 G12 S13 G13 D14 G14 S15 G15 D16 G16
+ S17 G17 D18 G18 S19 G19 a_8551_n231#
X0 S7 G6 D6 B sky130_fd_pr__nfet_g5v0d10v5 ad=0.29 pd=2.29 as=0.29 ps=2.29 w=2 l=4
X1 D12 G11 S11 B sky130_fd_pr__nfet_g5v0d10v5 ad=0.29 pd=2.29 as=0.29 ps=2.29 w=2 l=4
X2 D18 G17 S17 B sky130_fd_pr__nfet_g5v0d10v5 ad=0.29 pd=2.29 as=0.29 ps=2.29 w=2 l=4
X3 D16 G15 S15 B sky130_fd_pr__nfet_g5v0d10v5 ad=0.29 pd=2.29 as=0.29 ps=2.29 w=2 l=4
X4 D6 G5 S5 B sky130_fd_pr__nfet_g5v0d10v5 ad=0.29 pd=2.29 as=0.29 ps=2.29 w=2 l=4
X5 D8 G7 S7 B sky130_fd_pr__nfet_g5v0d10v5 ad=0.29 pd=2.29 as=0.29 ps=2.29 w=2 l=4
X6 S17 G16 D16 B sky130_fd_pr__nfet_g5v0d10v5 ad=0.29 pd=2.29 as=0.29 ps=2.29 w=2 l=4
X7 S9 G8 D8 B sky130_fd_pr__nfet_g5v0d10v5 ad=0.29 pd=2.29 as=0.29 ps=2.29 w=2 l=4
X8 S1 G0 D0 B sky130_fd_pr__nfet_g5v0d10v5 ad=0.29 pd=2.29 as=0.58 ps=4.58 w=2 l=4
X9 S3 G2 D2 B sky130_fd_pr__nfet_g5v0d10v5 ad=0.29 pd=2.29 as=0.29 ps=2.29 w=2 l=4
X10 D14 G13 S13 B sky130_fd_pr__nfet_g5v0d10v5 ad=0.29 pd=2.29 as=0.29 ps=2.29 w=2 l=4
X11 D2 G1 S1 B sky130_fd_pr__nfet_g5v0d10v5 ad=0.29 pd=2.29 as=0.29 ps=2.29 w=2 l=4
X12 D10 G9 S9 B sky130_fd_pr__nfet_g5v0d10v5 ad=0.29 pd=2.29 as=0.29 ps=2.29 w=2 l=4
X13 D4 G3 S3 B sky130_fd_pr__nfet_g5v0d10v5 ad=0.29 pd=2.29 as=0.29 ps=2.29 w=2 l=4
X14 S15 G14 D14 B sky130_fd_pr__nfet_g5v0d10v5 ad=0.29 pd=2.29 as=0.29 ps=2.29 w=2 l=4
X15 S13 G12 D12 B sky130_fd_pr__nfet_g5v0d10v5 ad=0.29 pd=2.29 as=0.29 ps=2.29 w=2 l=4
X16 a_8551_n231# G19 S19 B sky130_fd_pr__nfet_g5v0d10v5 ad=0.58 pd=4.58 as=0.29 ps=2.29 w=2 l=4
X17 S5 G4 D4 B sky130_fd_pr__nfet_g5v0d10v5 ad=0.29 pd=2.29 as=0.29 ps=2.29 w=2 l=4
X18 S19 G18 D18 B sky130_fd_pr__nfet_g5v0d10v5 ad=0.29 pd=2.29 as=0.29 ps=2.29 w=2 l=4
X19 S11 G10 D10 B sky130_fd_pr__nfet_g5v0d10v5 ad=0.29 pd=2.29 as=0.29 ps=2.29 w=2 l=4
C0 D6 G6 0.082975f
C1 S3 G2 0.082975f
C2 G15 G16 0.05942f
C3 G18 G17 0.05942f
C4 D10 G9 0.082975f
C5 S17 G16 0.082975f
C6 S17 D18 0.032918f
C7 D10 G10 0.082975f
C8 S7 G7 0.082975f
C9 G14 G15 0.05942f
C10 D6 S7 0.032918f
C11 G14 D14 0.082975f
C12 G4 G5 0.05942f
C13 S3 D2 0.032918f
C14 G2 D2 0.082975f
C15 S15 G15 0.082975f
C16 G4 D4 0.082975f
C17 S11 D12 0.032918f
C18 G19 a_8551_n231# 0.082975f
C19 D10 S9 0.032918f
C20 D18 S19 0.032918f
C21 S11 G10 0.082975f
C22 D14 S15 0.032918f
C23 G17 S17 0.082975f
C24 D14 S13 0.032918f
C25 D12 G12 0.082975f
C26 S7 G6 0.082975f
C27 D16 G15 0.082975f
C28 S17 D16 0.032918f
C29 S5 G5 0.082975f
C30 G10 G9 0.05942f
C31 G17 G16 0.05942f
C32 G17 D18 0.082975f
C33 G14 S15 0.082975f
C34 D4 S5 0.032918f
C35 S13 G12 0.082975f
C36 D16 G16 0.082975f
C37 G11 S11 0.082975f
C38 D12 S13 0.032918f
C39 D6 S5 0.032918f
C40 D8 S9 0.032918f
C41 S1 G0 0.082975f
C42 G7 D8 0.082975f
C43 G19 G18 0.05942f
C44 G0 G1 0.05942f
C45 G11 G12 0.05942f
C46 G8 D8 0.082975f
C47 G11 D12 0.082975f
C48 G11 G10 0.05942f
C49 D4 G3 0.082975f
C50 G9 S9 0.082975f
C51 D0 G0 0.082975f
C52 S1 G1 0.082975f
C53 S15 D16 0.032918f
C54 G8 G9 0.05942f
C55 S1 D0 0.032918f
C56 S3 G3 0.082975f
C57 G2 G3 0.05942f
C58 D14 G13 0.082975f
C59 S19 a_8551_n231# 0.032918f
C60 G8 S9 0.082975f
C61 S7 D8 0.032918f
C62 G4 S5 0.082975f
C63 G12 G13 0.05942f
C64 G8 G7 0.05942f
C65 G14 G13 0.05942f
C66 G2 G1 0.05942f
C67 D6 G5 0.082975f
C68 G18 D18 0.082975f
C69 G19 S19 0.082975f
C70 S13 G13 0.082975f
C71 G4 G3 0.05942f
C72 D2 S1 0.032918f
C73 S3 D4 0.032918f
C74 D2 G1 0.082975f
C75 G18 S19 0.082975f
C76 D10 S11 0.032918f
C77 G6 G5 0.05942f
C78 G6 G7 0.05942f
C79 S19 B 0.144855f
C80 D18 B 0.144855f
C81 S17 B 0.144855f
C82 D16 B 0.144855f
C83 S15 B 0.144855f
C84 D14 B 0.144855f
C85 S13 B 0.144855f
C86 D12 B 0.144855f
C87 S11 B 0.144855f
C88 D10 B 0.144855f
C89 S9 B 0.144855f
C90 D8 B 0.144855f
C91 S7 B 0.144855f
C92 D6 B 0.144855f
C93 S5 B 0.144855f
C94 D4 B 0.144855f
C95 S3 B 0.144855f
C96 D2 B 0.144855f
C97 S1 B 0.144855f
C98 D0 B 0.271253f
C99 G19 B 1.76447f
C100 G18 B 1.72826f
C101 G17 B 1.72826f
C102 G16 B 1.72826f
C103 G15 B 1.72826f
C104 G14 B 1.72826f
C105 G13 B 1.72826f
C106 G12 B 1.72826f
C107 G11 B 1.72826f
C108 G10 B 1.72826f
C109 G9 B 1.72826f
C110 G8 B 1.72826f
C111 G7 B 1.72826f
C112 G6 B 1.72826f
C113 G5 B 1.72826f
C114 G4 B 1.72826f
C115 G3 B 1.72826f
C116 G2 B 1.72826f
C117 G1 B 1.72826f
C118 G0 B 1.76447f
C119 a_8551_n231# B 0.271253f
.ends

.subckt sky130_fd_pr__res_xhigh_po_0p35_PL9RNS B R1 R2
X0 R2 R1 B sky130_fd_pr__res_xhigh_po_0p35 l=991.66
C0 R1 B 0.595753f
C1 R2 B 0.595753f
.ends

.subckt sky130_fd_pr__rf_pnp_05v5_W3p40L3p40 Emitter Collector Base m=1
X0 Collector Base Emitter sky130_fd_pr__pnp_05v5_W3p40L3p40
**devattr s=462400,2720
C0 Base Emitter 0.896583f
C1 Base Collector 1.10722f
.ends

.subckt sky130_fd_pr__res_xhigh_po_0p35_R4U9XH B R1 R2
X0 R1 R2 B sky130_fd_pr__res_xhigh_po_0p35 l=3.74
C0 R1 R2 0.00525f
C1 R2 B 0.591075f
C2 R1 B 0.591075f
.ends

.subckt sky130_fd_pr__res_xhigh_po_0p35_XV4KRP B R1 R2
X0 R1 R2 B sky130_fd_pr__res_xhigh_po_0p35 l=7.4
C0 R1 R2 0.002672f
C1 R2 B 0.594177f
C2 R1 B 0.594177f
.ends

.subckt sky130_fd_pr__cap_mim_m3_1_84Z4WG C2 C1 VSUBS
X0 C1 C2 sky130_fd_pr__cap_mim_m3_1 l=22 w=22
C0 C2 C1 43.049f
C1 C1 VSUBS 2.27742f
C2 C2 VSUBS 11.371901f
.ends

.subckt sky130_fd_pr__res_xhigh_po_0p35_4E3LTY B R1 R2
X0 R1 R2 B sky130_fd_pr__res_xhigh_po_0p35 l=14.76
C0 R2 B 0.597536f
C1 R1 B 0.597536f
.ends

.subckt sky130_fd_pr__pfet_g5v0d10v5_32MMT9 B D S G VSUBS
X0 S G D B sky130_fd_pr__pfet_g5v0d10v5 ad=0.1218 pd=1.42 as=0.1218 ps=1.42 w=0.42 l=50
C0 S B 0.049475f
C1 S G 0.025096f
C2 B G 11.7075f
C3 B D 0.049475f
C4 G D 0.025096f
C5 S VSUBS 0.04086f
C6 D VSUBS 0.04086f
C7 G VSUBS 10.6399f
C8 B VSUBS 25.0718f
.ends

.subckt sky130_fd_pr__pfet_g5v0d10v5_MN82PF B D S G VSUBS
X0 S G D B sky130_fd_pr__pfet_g5v0d10v5 ad=1.16 pd=8.58 as=1.16 ps=8.58 w=4 l=4
C0 S B 0.250339f
C1 S G 0.158746f
C2 B G 0.922222f
C3 S D 0.065571f
C4 B D 0.250339f
C5 G D 0.158746f
C6 S VSUBS 0.263093f
C7 D VSUBS 0.263093f
C8 G VSUBS 0.882827f
C9 B VSUBS 6.46382f
.ends

.subckt sky130_fd_pr__res_xhigh_po_0p35_VEZ8JB B R1 R2
X0 R1 R2 B sky130_fd_pr__res_xhigh_po_0p35 l=29.46
C0 R2 B 0.597536f
C1 R1 B 0.597536f
.ends

.subckt sky130_fd_pr__res_xhigh_po_0p35_HGUK4G B R1 R2
X0 R1 R2 B sky130_fd_pr__res_xhigh_po_0p35 l=58.86
C0 R2 B 0.597536f
C1 R1 B 0.597536f
.ends

.subckt sky130_fd_pr__res_xhigh_po_0p35_YNY9WN B R1 R2
X0 R2 R1 B sky130_fd_pr__res_xhigh_po_0p35 l=278.22
C0 R1 B 0.577911f
C1 R2 B 0.577911f
.ends

.subckt sky130_fd_pr__res_xhigh_po_0p35_8Z5M7R B R1 R2
X0 R2 R1 B sky130_fd_pr__res_xhigh_po_0p35 l=467.55
C0 R1 R2 0.035726f
C1 R2 B 0.550181f
C2 R1 B 0.550181f
.ends

.subckt sky130_fd_pr__res_xhigh_po_0p35_KAXJA5 B R1 R2
X0 R2 R1 B sky130_fd_pr__res_xhigh_po_0p35 l=187.59
C0 R1 R2 0.086197f
C1 R2 B 0.493283f
C2 R1 B 0.493283f
.ends

.subckt sky130_fd_pr__res_xhigh_po_0p35_NT9K52 B R1 R2
X0 R2 R1 B sky130_fd_pr__res_xhigh_po_0p35 l=583.97
C0 R1 R2 0.02764f
C1 R2 B 0.560383f
C2 R1 B 0.560383f
.ends

.subckt sky130_fd_pr__res_xhigh_po_0p35_J82YCH B R1 R2
X0 R2 R1 B sky130_fd_pr__res_xhigh_po_0p35 l=205.27
C0 R1 R2 0.086197f
C1 R2 B 0.493283f
C2 R1 B 0.493283f
.ends

.subckt sky130_fd_pr__pfet_g5v0d10v5_PSYF8E B D0 G0 S1 G1 D2 G2 S3 G3 D4 G4 S5 G5
+ D6 G6 S7 G7 D8 G8 S9 G9 D10 G10 S11 G11 D12 G12 S13 G13 D14 G14 S15 G15 D16 G16
+ S17 G17 D18 G18 S19 G19 D20 G20 S21 G21 D22 G22 S23 G23 D24 G24 S25 G25 D26 G26
+ S27 G27 D28 G28 S29 G29 D30 G30 S31 G31 D32 G32 S33 G33 D34 G34 S35 G35 D36 G36
+ S37 G37 D38 G38 S39 G39 a_3131_n1036# VSUBS
X0 S17 G16 D16 B sky130_fd_pr__pfet_g5v0d10v5 ad=1.45 pd=10.29 as=1.45 ps=10.29 w=10 l=0.5
X1 S3 G2 D2 B sky130_fd_pr__pfet_g5v0d10v5 ad=1.45 pd=10.29 as=1.45 ps=10.29 w=10 l=0.5
X2 D22 G21 S21 B sky130_fd_pr__pfet_g5v0d10v5 ad=1.45 pd=10.29 as=1.45 ps=10.29 w=10 l=0.5
X3 D2 G1 S1 B sky130_fd_pr__pfet_g5v0d10v5 ad=1.45 pd=10.29 as=1.45 ps=10.29 w=10 l=0.5
X4 D16 G15 S15 B sky130_fd_pr__pfet_g5v0d10v5 ad=1.45 pd=10.29 as=1.45 ps=10.29 w=10 l=0.5
X5 S13 G12 D12 B sky130_fd_pr__pfet_g5v0d10v5 ad=1.45 pd=10.29 as=1.45 ps=10.29 w=10 l=0.5
X6 D12 G11 S11 B sky130_fd_pr__pfet_g5v0d10v5 ad=1.45 pd=10.29 as=1.45 ps=10.29 w=10 l=0.5
X7 D10 G9 S9 B sky130_fd_pr__pfet_g5v0d10v5 ad=1.45 pd=10.29 as=1.45 ps=10.29 w=10 l=0.5
X8 D20 G19 S19 B sky130_fd_pr__pfet_g5v0d10v5 ad=1.45 pd=10.29 as=1.45 ps=10.29 w=10 l=0.5
X9 D30 G29 S29 B sky130_fd_pr__pfet_g5v0d10v5 ad=1.45 pd=10.29 as=1.45 ps=10.29 w=10 l=0.5
X10 D34 G33 S33 B sky130_fd_pr__pfet_g5v0d10v5 ad=1.45 pd=10.29 as=1.45 ps=10.29 w=10 l=0.5
X11 S9 G8 D8 B sky130_fd_pr__pfet_g5v0d10v5 ad=1.45 pd=10.29 as=1.45 ps=10.29 w=10 l=0.5
X12 S19 G18 D18 B sky130_fd_pr__pfet_g5v0d10v5 ad=1.45 pd=10.29 as=1.45 ps=10.29 w=10 l=0.5
X13 S5 G4 D4 B sky130_fd_pr__pfet_g5v0d10v5 ad=1.45 pd=10.29 as=1.45 ps=10.29 w=10 l=0.5
X14 S33 G32 D32 B sky130_fd_pr__pfet_g5v0d10v5 ad=1.45 pd=10.29 as=1.45 ps=10.29 w=10 l=0.5
X15 S37 G36 D36 B sky130_fd_pr__pfet_g5v0d10v5 ad=1.45 pd=10.29 as=1.45 ps=10.29 w=10 l=0.5
X16 S1 G0 D0 B sky130_fd_pr__pfet_g5v0d10v5 ad=1.45 pd=10.29 as=2.9 ps=20.58 w=10 l=0.5
X17 S21 G20 D20 B sky130_fd_pr__pfet_g5v0d10v5 ad=1.45 pd=10.29 as=1.45 ps=10.29 w=10 l=0.5
X18 S23 G22 D22 B sky130_fd_pr__pfet_g5v0d10v5 ad=1.45 pd=10.29 as=1.45 ps=10.29 w=10 l=0.5
X19 D8 G7 S7 B sky130_fd_pr__pfet_g5v0d10v5 ad=1.45 pd=10.29 as=1.45 ps=10.29 w=10 l=0.5
X20 D26 G25 S25 B sky130_fd_pr__pfet_g5v0d10v5 ad=1.45 pd=10.29 as=1.45 ps=10.29 w=10 l=0.5
X21 S11 G10 D10 B sky130_fd_pr__pfet_g5v0d10v5 ad=1.45 pd=10.29 as=1.45 ps=10.29 w=10 l=0.5
X22 S27 G26 D26 B sky130_fd_pr__pfet_g5v0d10v5 ad=1.45 pd=10.29 as=1.45 ps=10.29 w=10 l=0.5
X23 S7 G6 D6 B sky130_fd_pr__pfet_g5v0d10v5 ad=1.45 pd=10.29 as=1.45 ps=10.29 w=10 l=0.5
X24 S35 G34 D34 B sky130_fd_pr__pfet_g5v0d10v5 ad=1.45 pd=10.29 as=1.45 ps=10.29 w=10 l=0.5
X25 D4 G3 S3 B sky130_fd_pr__pfet_g5v0d10v5 ad=1.45 pd=10.29 as=1.45 ps=10.29 w=10 l=0.5
X26 D18 G17 S17 B sky130_fd_pr__pfet_g5v0d10v5 ad=1.45 pd=10.29 as=1.45 ps=10.29 w=10 l=0.5
X27 D38 G37 S37 B sky130_fd_pr__pfet_g5v0d10v5 ad=1.45 pd=10.29 as=1.45 ps=10.29 w=10 l=0.5
X28 S15 G14 D14 B sky130_fd_pr__pfet_g5v0d10v5 ad=1.45 pd=10.29 as=1.45 ps=10.29 w=10 l=0.5
X29 D14 G13 S13 B sky130_fd_pr__pfet_g5v0d10v5 ad=1.45 pd=10.29 as=1.45 ps=10.29 w=10 l=0.5
X30 S39 G38 D38 B sky130_fd_pr__pfet_g5v0d10v5 ad=1.45 pd=10.29 as=1.45 ps=10.29 w=10 l=0.5
X31 D28 G27 S27 B sky130_fd_pr__pfet_g5v0d10v5 ad=1.45 pd=10.29 as=1.45 ps=10.29 w=10 l=0.5
X32 S29 G28 D28 B sky130_fd_pr__pfet_g5v0d10v5 ad=1.45 pd=10.29 as=1.45 ps=10.29 w=10 l=0.5
X33 D24 G23 S23 B sky130_fd_pr__pfet_g5v0d10v5 ad=1.45 pd=10.29 as=1.45 ps=10.29 w=10 l=0.5
X34 S31 G30 D30 B sky130_fd_pr__pfet_g5v0d10v5 ad=1.45 pd=10.29 as=1.45 ps=10.29 w=10 l=0.5
X35 S25 G24 D24 B sky130_fd_pr__pfet_g5v0d10v5 ad=1.45 pd=10.29 as=1.45 ps=10.29 w=10 l=0.5
X36 D32 G31 S31 B sky130_fd_pr__pfet_g5v0d10v5 ad=1.45 pd=10.29 as=1.45 ps=10.29 w=10 l=0.5
X37 D36 G35 S35 B sky130_fd_pr__pfet_g5v0d10v5 ad=1.45 pd=10.29 as=1.45 ps=10.29 w=10 l=0.5
X38 D6 G5 S5 B sky130_fd_pr__pfet_g5v0d10v5 ad=1.45 pd=10.29 as=1.45 ps=10.29 w=10 l=0.5
X39 a_3131_n1036# G39 S39 B sky130_fd_pr__pfet_g5v0d10v5 ad=2.9 pd=20.58 as=1.45 ps=10.29 w=10 l=0.5
C0 G37 B 0.130407f
C1 D14 S15 0.890272f
C2 G15 B 0.130407f
C3 D28 G28 0.127776f
C4 G2 S3 0.127776f
C5 G16 G17 0.061903f
C6 G36 G37 0.061903f
C7 S37 D38 0.890272f
C8 S19 D18 0.890272f
C9 G21 B 0.130407f
C10 S21 G21 0.127776f
C11 D4 S5 0.890272f
C12 G15 G14 0.061903f
C13 G27 D28 0.127776f
C14 G38 D38 0.127776f
C15 G1 G2 0.061903f
C16 D6 G5 0.127776f
C17 G35 G34 0.061903f
C18 G25 D26 0.127776f
C19 S29 D30 0.890272f
C20 S19 D20 0.890272f
C21 S17 D18 0.890272f
C22 S29 G28 0.127776f
C23 G3 S3 0.127776f
C24 S7 B 0.023038f
C25 G24 S25 0.127776f
C26 G11 B 0.130407f
C27 D20 G20 0.127776f
C28 D28 B 0.023038f
C29 D16 B 0.023038f
C30 D32 S33 0.890272f
C31 G7 G8 0.061903f
C32 B S37 0.023038f
C33 B D26 0.023038f
C34 G38 S39 0.127776f
C35 G27 S27 0.127776f
C36 S11 G11 0.127776f
C37 B S3 0.023038f
C38 S23 D24 0.890272f
C39 G35 B 0.130407f
C40 B G38 0.130407f
C41 G36 S37 0.127776f
C42 S19 B 0.023038f
C43 D22 B 0.023038f
C44 G21 G22 0.061903f
C45 S21 D22 0.890272f
C46 S19 G18 0.127776f
C47 G36 G35 0.061903f
C48 G6 B 0.130407f
C49 B G20 0.130407f
C50 G35 S35 0.127776f
C51 G1 B 0.130407f
C52 S21 G20 0.127776f
C53 S1 D2 0.890272f
C54 S29 B 0.023038f
C55 S17 B 0.023038f
C56 S5 D6 0.890272f
C57 G3 G4 0.061903f
C58 a_3131_n1036# S39 0.890272f
C59 B S27 0.023038f
C60 D10 G9 0.127776f
C61 G26 D26 0.127776f
C62 G2 G3 0.061903f
C63 G11 G10 0.061903f
C64 D12 G11 0.127776f
C65 G27 G28 0.061903f
C66 G39 G38 0.061903f
C67 S9 G9 0.127776f
C68 a_3131_n1036# B 0.58701f
C69 S23 B 0.023038f
C70 D8 S9 0.890272f
C71 S37 D36 0.890272f
C72 G31 G32 0.061903f
C73 B G4 0.130407f
C74 G33 G32 0.061903f
C75 B G9 0.130407f
C76 B G13 0.130407f
C77 G35 D36 0.127776f
C78 G2 B 0.130407f
C79 G1 G0 0.061903f
C80 G34 D34 0.127776f
C81 G34 G33 0.061903f
C82 D22 G22 0.127776f
C83 S15 G15 0.127776f
C84 S13 G13 0.127776f
C85 D30 B 0.023038f
C86 D18 B 0.023038f
C87 D8 B 0.023038f
C88 G7 S7 0.127776f
C89 D38 S39 0.890272f
C90 B G28 0.130407f
C91 G26 S27 0.127776f
C92 G39 a_3131_n1036# 0.127776f
C93 D18 G18 0.127776f
C94 S17 G17 0.127776f
C95 B G32 0.130407f
C96 G14 G13 0.061903f
C97 B D38 0.023038f
C98 D10 S9 0.890272f
C99 D24 B 0.023038f
C100 B G34 0.130407f
C101 G33 D34 0.127776f
C102 G27 B 0.130407f
C103 G5 G6 0.061903f
C104 D20 B 0.023038f
C105 D20 S21 0.890272f
C106 B G25 0.130407f
C107 G3 B 0.130407f
C108 D30 G30 0.127776f
C109 D10 B 0.023038f
C110 G34 S35 0.127776f
C111 S23 G22 0.127776f
C112 G12 G11 0.061903f
C113 G7 G6 0.061903f
C114 D30 S31 0.890272f
C115 G31 B 0.130407f
C116 B G33 0.130407f
C117 B D34 0.023038f
C118 G23 S23 0.127776f
C119 S9 B 0.023038f
C120 D4 S3 0.890272f
C121 G9 G10 0.061903f
C122 D0 B 0.58701f
C123 D18 G17 0.127776f
C124 D10 S11 0.890272f
C125 B S39 0.023038f
C126 G16 G15 0.061903f
C127 D34 S35 0.890272f
C128 S15 D16 0.890272f
C129 S21 B 0.023038f
C130 G5 G4 0.061903f
C131 G26 G27 0.061903f
C132 G18 B 0.130407f
C133 S13 B 0.023038f
C134 G31 G30 0.061903f
C135 G26 G25 0.061903f
C136 G36 B 0.130407f
C137 S11 B 0.023038f
C138 G31 S31 0.127776f
C139 B S35 0.023038f
C140 G23 D24 0.127776f
C141 G14 B 0.130407f
C142 G39 S39 0.127776f
C143 D0 G0 0.127776f
C144 D10 G10 0.127776f
C145 D14 G13 0.127776f
C146 G7 D8 0.127776f
C147 G24 D24 0.127776f
C148 B G30 0.130407f
C149 G39 B 0.15506f
C150 D4 G4 0.127776f
C151 B S31 0.023038f
C152 D6 S7 0.890272f
C153 B G0 0.15506f
C154 S29 G29 0.127776f
C155 G26 B 0.130407f
C156 S1 G1 0.127776f
C157 G24 G25 0.061903f
C158 G17 B 0.130407f
C159 G12 G13 0.061903f
C160 B G10 0.130407f
C161 D12 B 0.023038f
C162 S3 D2 0.890272f
C163 G18 G17 0.061903f
C164 D16 G16 0.127776f
C165 B D36 0.023038f
C166 B G22 0.130407f
C167 S13 D12 0.890272f
C168 G23 B 0.130407f
C169 S19 G19 0.127776f
C170 S11 G10 0.127776f
C171 S11 D12 0.890272f
C172 G36 D36 0.127776f
C173 G30 S31 0.127776f
C174 S25 D26 0.890272f
C175 D6 G6 0.127776f
C176 G1 D2 0.127776f
C177 S5 G4 0.127776f
C178 G5 B 0.130407f
C179 G24 B 0.130407f
C180 S35 D36 0.890272f
C181 D32 G32 0.127776f
C182 D30 G29 0.127776f
C183 G19 G20 0.061903f
C184 D4 G3 0.127776f
C185 G28 G29 0.061903f
C186 G7 B 0.130407f
C187 S17 G16 0.127776f
C188 D16 G15 0.127776f
C189 G37 S37 0.127776f
C190 D14 B 0.023038f
C191 G31 D32 0.127776f
C192 S13 D14 0.890272f
C193 G37 G38 0.061903f
C194 D4 B 0.023038f
C195 G2 D2 0.127776f
C196 S33 G32 0.127776f
C197 D14 G14 0.127776f
C198 G12 B 0.130407f
C199 G23 G22 0.061903f
C200 G21 D22 0.127776f
C201 B D32 0.023038f
C202 S13 G12 0.127776f
C203 G8 G9 0.061903f
C204 S15 B 0.023038f
C205 D0 S1 0.890272f
C206 G24 G23 0.061903f
C207 B G29 0.130407f
C208 G21 G20 0.061903f
C209 G8 D8 0.127776f
C210 D34 S33 0.890272f
C211 G33 S33 0.127776f
C212 S5 B 0.023038f
C213 S1 B 0.023038f
C214 D20 G19 0.127776f
C215 S15 G14 0.127776f
C216 D24 S25 0.890272f
C217 S31 D32 0.890272f
C218 B S33 0.023038f
C219 S7 G6 0.127776f
C220 G29 G30 0.061903f
C221 D12 G12 0.127776f
C222 G25 S25 0.127776f
C223 B D2 0.023038f
C224 G37 D38 0.127776f
C225 G8 S9 0.127776f
C226 D6 B 0.023038f
C227 G19 B 0.130407f
C228 S1 G0 0.127776f
C229 D28 S29 0.890272f
C230 D16 S17 0.890272f
C231 G16 B 0.130407f
C232 D28 S27 0.890272f
C233 G19 G18 0.061903f
C234 D26 S27 0.890272f
C235 G8 B 0.130407f
C236 B S25 0.023038f
C237 S5 G5 0.127776f
C238 S7 D8 0.890272f
C239 D22 S23 0.890272f
C240 S39 VSUBS 0.172108f
C241 D38 VSUBS 0.172108f
C242 S37 VSUBS 0.172108f
C243 D36 VSUBS 0.172108f
C244 S35 VSUBS 0.172108f
C245 D34 VSUBS 0.172108f
C246 S33 VSUBS 0.172108f
C247 D32 VSUBS 0.172108f
C248 S31 VSUBS 0.172108f
C249 D30 VSUBS 0.172108f
C250 S29 VSUBS 0.172108f
C251 D28 VSUBS 0.172108f
C252 S27 VSUBS 0.172108f
C253 D26 VSUBS 0.172108f
C254 S25 VSUBS 0.172108f
C255 D24 VSUBS 0.172108f
C256 S23 VSUBS 0.172108f
C257 D22 VSUBS 0.172108f
C258 S21 VSUBS 0.172108f
C259 D20 VSUBS 0.172108f
C260 S19 VSUBS 0.172108f
C261 D18 VSUBS 0.172108f
C262 S17 VSUBS 0.172108f
C263 D16 VSUBS 0.172108f
C264 S15 VSUBS 0.172108f
C265 D14 VSUBS 0.172108f
C266 S13 VSUBS 0.172108f
C267 D12 VSUBS 0.172108f
C268 S11 VSUBS 0.172108f
C269 D10 VSUBS 0.172108f
C270 S9 VSUBS 0.172108f
C271 D8 VSUBS 0.172108f
C272 S7 VSUBS 0.172108f
C273 D6 VSUBS 0.172108f
C274 S5 VSUBS 0.172108f
C275 D4 VSUBS 0.172108f
C276 S3 VSUBS 0.172108f
C277 D2 VSUBS 0.172108f
C278 S1 VSUBS 0.172108f
C279 D0 VSUBS 0.437153f
C280 G39 VSUBS 0.116486f
C281 G38 VSUBS 0.103106f
C282 G37 VSUBS 0.103106f
C283 G36 VSUBS 0.103106f
C284 G35 VSUBS 0.103106f
C285 G34 VSUBS 0.103106f
C286 G33 VSUBS 0.103106f
C287 G32 VSUBS 0.103106f
C288 G31 VSUBS 0.103106f
C289 G30 VSUBS 0.103106f
C290 G29 VSUBS 0.103106f
C291 G28 VSUBS 0.103106f
C292 G27 VSUBS 0.103106f
C293 G26 VSUBS 0.103106f
C294 G25 VSUBS 0.103106f
C295 G24 VSUBS 0.103106f
C296 G23 VSUBS 0.103106f
C297 G22 VSUBS 0.103106f
C298 G21 VSUBS 0.103106f
C299 G20 VSUBS 0.103106f
C300 G19 VSUBS 0.103106f
C301 G18 VSUBS 0.103106f
C302 G17 VSUBS 0.103106f
C303 G16 VSUBS 0.103106f
C304 G15 VSUBS 0.103106f
C305 G14 VSUBS 0.103106f
C306 G13 VSUBS 0.103106f
C307 G12 VSUBS 0.103106f
C308 G11 VSUBS 0.103106f
C309 G10 VSUBS 0.103106f
C310 G9 VSUBS 0.103106f
C311 G8 VSUBS 0.103106f
C312 G7 VSUBS 0.103106f
C313 G6 VSUBS 0.103106f
C314 G5 VSUBS 0.103106f
C315 G4 VSUBS 0.103106f
C316 G3 VSUBS 0.103106f
C317 G2 VSUBS 0.103106f
C318 G1 VSUBS 0.103106f
C319 G0 VSUBS 0.116486f
C320 B VSUBS 56.7882f
C321 a_3131_n1036# VSUBS 0.437153f
.ends

.subckt sky130_fd_pr__pfet_g5v0d10v5_7B62CL B D S G VSUBS
X0 S G D B sky130_fd_pr__pfet_g5v0d10v5 ad=0.2436 pd=2.26 as=0.2436 ps=2.26 w=0.84 l=0.5
C0 S B 0.073078f
C1 S G 0.01429f
C2 S D 0.076415f
C3 B G 0.190892f
C4 B D 0.073078f
C5 G D 0.01429f
C6 S VSUBS 0.045757f
C7 D VSUBS 0.045757f
C8 G VSUBS 0.127382f
C9 B VSUBS 1.74241f
.ends

.subckt sky130_fd_pr__pfet_g5v0d10v5_PN8J4Z B D0 S0 G0 D1 S1 G1 D2 S2 G2 VSUBS
X0 S2 G2 D2 B sky130_fd_pr__pfet_g5v0d10v5 ad=1.16 pd=8.58 as=1.16 ps=8.58 w=4 l=4
X1 S1 G1 D1 B sky130_fd_pr__pfet_g5v0d10v5 ad=1.16 pd=8.58 as=1.16 ps=8.58 w=4 l=4
X2 S0 G0 D0 B sky130_fd_pr__pfet_g5v0d10v5 ad=1.16 pd=8.58 as=1.16 ps=8.58 w=4 l=4
C0 S1 G1 0.158746f
C1 G0 G1 0.497349f
C2 S0 S1 0.014232f
C3 S1 B 0.236968f
C4 S2 B 0.243139f
C5 S0 G0 0.158746f
C6 S1 D1 0.065571f
C7 G0 B 0.605257f
C8 S2 G2 0.158746f
C9 S2 D2 0.065571f
C10 G1 B 0.469368f
C11 G1 D1 0.158746f
C12 S0 B 0.244168f
C13 G1 G2 0.497349f
C14 D1 B 0.236968f
C15 D0 G0 0.158746f
C16 B G2 0.786334f
C17 B D2 0.243139f
C18 D1 D2 0.014232f
C19 G2 D2 0.158746f
C20 S0 D0 0.065571f
C21 D0 B 0.244168f
C22 D0 D1 0.014232f
C23 S1 S2 0.014232f
C24 S0 VSUBS 0.257653f
C25 D0 VSUBS 0.257653f
C26 G0 VSUBS 0.801835f
C27 S1 VSUBS 0.251456f
C28 D1 VSUBS 0.251456f
C29 G1 VSUBS 0.703093f
C30 S2 VSUBS 0.256896f
C31 D2 VSUBS 0.256896f
C32 G2 VSUBS 0.784084f
C33 B VSUBS 15.1219f
.ends

.subckt sky130_fd_pr__nfet_g5v0d10v5_3UQFYT B D0 S0 G0 D1 S1 G1 D2 S2 G2
X0 S0 G0 D0 B sky130_fd_pr__nfet_g5v0d10v5 ad=0.58 pd=4.58 as=0.58 ps=4.58 w=2 l=4
X1 S1 G1 D1 B sky130_fd_pr__nfet_g5v0d10v5 ad=0.58 pd=4.58 as=0.58 ps=4.58 w=2 l=4
X2 S2 G2 D2 B sky130_fd_pr__nfet_g5v0d10v5 ad=0.58 pd=4.58 as=0.58 ps=4.58 w=2 l=4
C0 D1 D0 0.014895f
C1 G1 G0 0.519044f
C2 D2 D1 0.014895f
C3 G0 D0 0.082975f
C4 G2 G1 0.519044f
C5 S2 S1 0.014895f
C6 D2 S2 0.032918f
C7 S1 S0 0.014895f
C8 D2 G2 0.082975f
C9 D0 S0 0.032918f
C10 G0 S0 0.082975f
C11 S2 G2 0.082975f
C12 G1 D1 0.082975f
C13 G1 S1 0.082975f
C14 D1 S1 0.032918f
C15 S0 B 0.259336f
C16 D0 B 0.259336f
C17 G0 B 1.37874f
C18 S1 B 0.245838f
C19 D1 B 0.245838f
C20 G1 B 1.10221f
C21 S2 B 0.257756f
C22 D2 B 0.257756f
C23 G2 B 1.52414f
.ends

.subckt sky130_fd_pr__res_xhigh_po_0p35_ADWJQG B R1 R2
X0 R2 R1 B sky130_fd_pr__res_xhigh_po_0p35 l=292.92
C0 R1 B 0.577911f
C1 R2 B 0.577911f
.ends

.subckt sky130_fd_pr__cap_mim_m3_1_Y3HN7X C2 C1 VSUBS
X0 C1 C2 sky130_fd_pr__cap_mim_m3_1 l=27.5 w=27.5
C0 C2 C1 66.5348f
C1 C1 VSUBS 2.85705f
C2 C2 VSUBS 16.0169f
.ends

.subckt sky130_fd_pr__nfet_g5v0d10v5_WMYWGM B D S G
X0 S G D B sky130_fd_pr__nfet_g5v0d10v5 ad=2.32 pd=16.58 as=2.32 ps=16.58 w=8 l=2
C0 S D 0.246248f
C1 S G 0.254328f
C2 G D 0.254328f
C3 S B 0.92443f
C4 D B 0.92443f
C5 G B 0.935471f
.ends

.subckt sky130_fd_pr__pfet_g5v0d10v5_DNGK98 B D S G VSUBS
X0 S G D B sky130_fd_pr__pfet_g5v0d10v5 ad=4.64 pd=32.58 as=4.64 ps=32.58 w=16 l=4
C0 D S 0.26149f
C1 S G 0.613371f
C2 D G 0.613371f
C3 S B 0.923613f
C4 D B 0.923613f
C5 B G 0.895007f
C6 S VSUBS 1.03041f
C7 D VSUBS 1.03041f
C8 G VSUBS 0.910237f
C9 B VSUBS 17.1758f
.ends

.subckt sky130_fd_pr__nfet_g5v0d10v5_DDWFWJ B D0 G0 S1 G1 D2 S2 G2
X0 D2 G1 S1 B sky130_fd_pr__nfet_g5v0d10v5 ad=0.58 pd=4.29 as=0.58 ps=4.29 w=4 l=1
X1 S1 G0 D0 B sky130_fd_pr__nfet_g5v0d10v5 ad=0.58 pd=4.29 as=1.16 ps=8.58 w=4 l=1
X2 S2 G2 D2 B sky130_fd_pr__nfet_g5v0d10v5 ad=1.16 pd=8.58 as=0.58 ps=4.29 w=4 l=1
C0 S2 D2 0.219309f
C1 G2 D2 0.090922f
C2 S1 D2 0.219309f
C3 D2 G1 0.090922f
C4 G2 S2 0.090922f
C5 S1 D0 0.219309f
C6 G2 G1 0.05942f
C7 S1 G1 0.090922f
C8 D0 G0 0.090922f
C9 S1 G0 0.090922f
C10 G0 G1 0.05942f
C11 S2 B 0.448578f
C12 D2 B 0.140565f
C13 S1 B 0.140565f
C14 D0 B 0.448578f
C15 G2 B 0.477445f
C16 G1 B 0.441242f
C17 G0 B 0.477445f
.ends

.subckt sky130_fd_pr__nfet_g5v0d10v5_FZ2B7C B D S G
X0 S G D B sky130_fd_pr__nfet_g5v0d10v5 ad=0.1218 pd=1.42 as=0.1218 ps=1.42 w=0.42 l=0.5
C0 G D 0.009087f
C1 G S 0.009087f
C2 S D 0.039098f
C3 S B 0.076791f
C4 D B 0.076791f
C5 G B 0.314309f
.ends

.subckt sky130_fd_pr__cap_mim_m3_1_PP9XRG C2 C1 VSUBS
X0 C1 C2 sky130_fd_pr__cap_mim_m3_1 l=30 w=30
C0 C2 C1 78.8907f
C1 C1 VSUBS 3.12051f
C2 C2 VSUBS 18.375599f
.ends

.subckt sky130_fd_pr__nfet_g5v0d10v5_HA9V6X B D0 S0 G0 D1 S1 G1 D2 S2 G2 D3 S3 G3
X0 S1 G1 D1 B sky130_fd_pr__nfet_g5v0d10v5 ad=0.58 pd=4.58 as=0.58 ps=4.58 w=2 l=4
X1 S3 G3 D3 B sky130_fd_pr__nfet_g5v0d10v5 ad=0.58 pd=4.58 as=0.58 ps=4.58 w=2 l=4
X2 S2 G2 D2 B sky130_fd_pr__nfet_g5v0d10v5 ad=0.58 pd=4.58 as=0.58 ps=4.58 w=2 l=4
X3 S0 G0 D0 B sky130_fd_pr__nfet_g5v0d10v5 ad=0.58 pd=4.58 as=0.58 ps=4.58 w=2 l=4
C0 D0 G0 0.082975f
C1 G1 G2 0.519044f
C2 G3 D3 0.082975f
C3 G3 S3 0.082975f
C4 D1 G1 0.082975f
C5 G3 G2 0.519044f
C6 D0 D1 0.014895f
C7 S2 S1 0.014895f
C8 S0 D0 0.032918f
C9 S2 D2 0.032918f
C10 D3 D2 0.014895f
C11 G2 D2 0.082975f
C12 D1 S1 0.032918f
C13 D1 D2 0.014895f
C14 S2 S3 0.014895f
C15 S2 G2 0.082975f
C16 G1 S1 0.082975f
C17 S3 D3 0.032918f
C18 S0 S1 0.014895f
C19 G1 G0 0.519044f
C20 S0 G0 0.082975f
C21 S0 B 0.259336f
C22 D0 B 0.259336f
C23 G0 B 1.37874f
C24 S1 B 0.245838f
C25 D1 B 0.245838f
C26 G1 B 1.10221f
C27 S2 B 0.245838f
C28 D2 B 0.245838f
C29 G2 B 1.10221f
C30 S3 B 0.257756f
C31 D3 B 0.257756f
C32 G3 B 1.52414f
.ends

.subckt sky130_fd_pr__pfet_g5v0d10v5_KMGDV8 B D0_0 G0_0 D0_1 G0_1 D0_2 G0_2 D0_3 G0_3
+ S1_0 G1_0 S1_1 G1_1 S1_2 G1_2 S1_3 G1_3 D2_0 G2_0 D2_1 G2_1 D2_2 G2_2 D2_3 G2_3
+ S3_0 G3_0 S3_1 G3_1 S3_2 G3_2 S3_3 G3_3 D4_0 G4_0 D4_1 G4_1 D4_2 G4_2 D4_3 G4_3
+ S5_0 G5_0 S5_1 G5_1 S5_2 G5_2 S5_3 G5_3 D6_0 G6_0 D6_1 G6_1 D6_2 G6_2 D6_3 G6_3
+ S7_0 G7_0 S7_1 G7_1 S7_2 G7_2 S7_3 G7_3 a_1803_n8283# a_1803_4212# a_1803_n4118#
+ a_1803_47# VSUBS
X0 a_1803_4212# G7_3 S7_3 B sky130_fd_pr__pfet_g5v0d10v5 ad=5.8 pd=40.58 as=2.9 ps=20.29 w=20 l=2
X1 S5_2 G4_2 D4_2 B sky130_fd_pr__pfet_g5v0d10v5 ad=2.9 pd=20.29 as=2.9 ps=20.29 w=20 l=2
X2 D6_3 G5_3 S5_3 B sky130_fd_pr__pfet_g5v0d10v5 ad=2.9 pd=20.29 as=2.9 ps=20.29 w=20 l=2
X3 S3_3 G2_3 D2_3 B sky130_fd_pr__pfet_g5v0d10v5 ad=2.9 pd=20.29 as=2.9 ps=20.29 w=20 l=2
X4 S5_1 G4_1 D4_1 B sky130_fd_pr__pfet_g5v0d10v5 ad=2.9 pd=20.29 as=2.9 ps=20.29 w=20 l=2
X5 S3_0 G2_0 D2_0 B sky130_fd_pr__pfet_g5v0d10v5 ad=2.9 pd=20.29 as=2.9 ps=20.29 w=20 l=2
X6 S1_3 G0_3 D0_3 B sky130_fd_pr__pfet_g5v0d10v5 ad=2.9 pd=20.29 as=5.8 ps=40.58 w=20 l=2
X7 D4_2 G3_2 S3_2 B sky130_fd_pr__pfet_g5v0d10v5 ad=2.9 pd=20.29 as=2.9 ps=20.29 w=20 l=2
X8 D2_0 G1_0 S1_0 B sky130_fd_pr__pfet_g5v0d10v5 ad=2.9 pd=20.29 as=2.9 ps=20.29 w=20 l=2
X9 D6_0 G5_0 S5_0 B sky130_fd_pr__pfet_g5v0d10v5 ad=2.9 pd=20.29 as=2.9 ps=20.29 w=20 l=2
X10 a_1803_n8283# G7_0 S7_0 B sky130_fd_pr__pfet_g5v0d10v5 ad=5.8 pd=40.58 as=2.9 ps=20.29 w=20 l=2
X11 S3_2 G2_2 D2_2 B sky130_fd_pr__pfet_g5v0d10v5 ad=2.9 pd=20.29 as=2.9 ps=20.29 w=20 l=2
X12 S7_0 G6_0 D6_0 B sky130_fd_pr__pfet_g5v0d10v5 ad=2.9 pd=20.29 as=2.9 ps=20.29 w=20 l=2
X13 D4_3 G3_3 S3_3 B sky130_fd_pr__pfet_g5v0d10v5 ad=2.9 pd=20.29 as=2.9 ps=20.29 w=20 l=2
X14 S1_0 G0_0 D0_0 B sky130_fd_pr__pfet_g5v0d10v5 ad=2.9 pd=20.29 as=5.8 ps=40.58 w=20 l=2
X15 D4_0 G3_0 S3_0 B sky130_fd_pr__pfet_g5v0d10v5 ad=2.9 pd=20.29 as=2.9 ps=20.29 w=20 l=2
X16 S7_3 G6_3 D6_3 B sky130_fd_pr__pfet_g5v0d10v5 ad=2.9 pd=20.29 as=2.9 ps=20.29 w=20 l=2
X17 S3_1 G2_1 D2_1 B sky130_fd_pr__pfet_g5v0d10v5 ad=2.9 pd=20.29 as=2.9 ps=20.29 w=20 l=2
X18 D6_1 G5_1 S5_1 B sky130_fd_pr__pfet_g5v0d10v5 ad=2.9 pd=20.29 as=2.9 ps=20.29 w=20 l=2
X19 D2_1 G1_1 S1_1 B sky130_fd_pr__pfet_g5v0d10v5 ad=2.9 pd=20.29 as=2.9 ps=20.29 w=20 l=2
X20 a_1803_n4118# G7_1 S7_1 B sky130_fd_pr__pfet_g5v0d10v5 ad=5.8 pd=40.58 as=2.9 ps=20.29 w=20 l=2
X21 S1_1 G0_1 D0_1 B sky130_fd_pr__pfet_g5v0d10v5 ad=2.9 pd=20.29 as=5.8 ps=40.58 w=20 l=2
X22 S7_1 G6_1 D6_1 B sky130_fd_pr__pfet_g5v0d10v5 ad=2.9 pd=20.29 as=2.9 ps=20.29 w=20 l=2
X23 D2_3 G1_3 S1_3 B sky130_fd_pr__pfet_g5v0d10v5 ad=2.9 pd=20.29 as=2.9 ps=20.29 w=20 l=2
X24 D4_1 G3_1 S3_1 B sky130_fd_pr__pfet_g5v0d10v5 ad=2.9 pd=20.29 as=2.9 ps=20.29 w=20 l=2
X25 D6_2 G5_2 S5_2 B sky130_fd_pr__pfet_g5v0d10v5 ad=2.9 pd=20.29 as=2.9 ps=20.29 w=20 l=2
X26 D2_2 G1_2 S1_2 B sky130_fd_pr__pfet_g5v0d10v5 ad=2.9 pd=20.29 as=2.9 ps=20.29 w=20 l=2
X27 a_1803_47# G7_2 S7_2 B sky130_fd_pr__pfet_g5v0d10v5 ad=5.8 pd=40.58 as=2.9 ps=20.29 w=20 l=2
X28 S5_0 G4_0 D4_0 B sky130_fd_pr__pfet_g5v0d10v5 ad=2.9 pd=20.29 as=2.9 ps=20.29 w=20 l=2
X29 S7_2 G6_2 D6_2 B sky130_fd_pr__pfet_g5v0d10v5 ad=2.9 pd=20.29 as=2.9 ps=20.29 w=20 l=2
X30 S5_3 G4_3 D4_3 B sky130_fd_pr__pfet_g5v0d10v5 ad=2.9 pd=20.29 as=2.9 ps=20.29 w=20 l=2
X31 S1_2 G0_2 D0_2 B sky130_fd_pr__pfet_g5v0d10v5 ad=2.9 pd=20.29 as=5.8 ps=40.58 w=20 l=2
C0 S5_2 D6_2 0.614813f
C1 G7_2 G7_3 0.227831f
C2 D6_2 B 0.009616f
C3 G4_3 S5_3 0.625982f
C4 G1_0 S1_0 0.625982f
C5 G1_1 S1_1 0.625982f
C6 a_1803_n8283# B 1.14187f
C7 D4_1 D4_2 0.014232f
C8 D4_1 G4_1 0.625982f
C9 G6_3 B 0.382207f
C10 G7_2 S7_2 0.625982f
C11 S5_0 D6_0 0.614813f
C12 S5_0 S5_1 0.014232f
C13 a_1803_n4118# a_1803_47# 0.014232f
C14 B S7_0 0.016816f
C15 G1_2 G1_3 0.227831f
C16 G1_2 G0_2 0.061903f
C17 D6_0 G6_0 0.625982f
C18 G6_2 G7_2 0.061903f
C19 G6_2 G5_2 0.061903f
C20 D4_3 D4_2 0.014232f
C21 G7_1 B 0.247781f
C22 a_1803_n4118# B 1.13467f
C23 D2_1 D2_0 0.014232f
C24 B G4_0 0.278378f
C25 S7_1 B 0.009616f
C26 B D2_0 0.016816f
C27 a_1803_4212# G7_3 0.625982f
C28 G5_3 G6_3 0.061903f
C29 G2_0 D2_0 0.625982f
C30 G1_3 G0_3 0.061903f
C31 G3_1 B 0.223127f
C32 G0_3 G0_2 0.227831f
C33 G2_2 G2_1 0.227831f
C34 G4_0 D4_0 0.625982f
C35 G5_1 D6_1 0.625982f
C36 G4_2 G5_2 0.061903f
C37 B D4_1 0.009616f
C38 G6_0 G7_0 0.061903f
C39 G0_1 S1_1 0.625982f
C40 B D6_1 0.009616f
C41 S5_1 G4_1 0.625982f
C42 G3_0 B 0.278378f
C43 G0_2 S1_2 0.625982f
C44 a_1803_47# G7_2 0.625982f
C45 G5_0 G4_0 0.061903f
C46 G2_0 G3_0 0.061903f
C47 G4_2 G4_3 0.227831f
C48 G1_3 B 0.382207f
C49 G0_3 S1_3 0.625982f
C50 D6_3 S5_3 0.614813f
C51 D0_0 G0_0 0.625982f
C52 G2_2 G2_3 0.227831f
C53 B G0_2 0.247781f
C54 S3_3 B 0.015791f
C55 D2_3 G1_3 0.625982f
C56 G7_3 S7_3 0.625982f
C57 G6_2 S7_2 0.625982f
C58 G5_1 G5_2 0.227831f
C59 B G0_0 0.303032f
C60 a_1803_4212# S7_3 0.614813f
C61 D4_1 D4_0 0.014232f
C62 D2_3 S3_3 0.614813f
C63 S5_2 G5_2 0.625982f
C64 D0_0 D0_1 0.014232f
C65 G3_0 D4_0 0.625982f
C66 S3_1 D2_1 0.614813f
C67 B G7_2 0.247781f
C68 B D0_1 1.13467f
C69 B G5_2 0.223127f
C70 S7_2 S7_3 0.014232f
C71 B D4_3 0.015791f
C72 B S3_1 0.009616f
C73 G3_2 D4_2 0.625982f
C74 D0_0 S1_0 0.614813f
C75 S1_3 S1_2 0.014232f
C76 D2_1 G2_1 0.625982f
C77 S1_0 B 0.016816f
C78 G2_2 G3_2 0.061903f
C79 G4_3 B 0.382207f
C80 S3_3 G3_3 0.625982f
C81 S3_3 S3_2 0.014232f
C82 B G2_1 0.223127f
C83 B S1_3 0.015791f
C84 G2_0 G2_1 0.227831f
C85 B S3_0 0.016816f
C86 S1_3 D0_3 0.614813f
C87 G5_1 S5_1 0.625982f
C88 D2_3 S1_3 0.614813f
C89 G6_1 G7_1 0.061903f
C90 G2_0 S3_0 0.625982f
C91 G2_1 G1_1 0.061903f
C92 a_1803_47# a_1803_4212# 0.014232f
C93 G1_2 G2_2 0.061903f
C94 G3_3 D4_3 0.625982f
C95 S7_1 G6_1 0.625982f
C96 S3_2 S3_1 0.014232f
C97 S5_2 S5_1 0.014232f
C98 S5_0 B 0.016816f
C99 S5_2 S5_3 0.014232f
C100 B D6_0 0.016816f
C101 B S5_1 0.009616f
C102 G3_3 G4_3 0.061903f
C103 G5_3 G5_2 0.227831f
C104 B S5_3 0.015791f
C105 D6_3 S7_3 0.614813f
C106 G1_0 B 0.278378f
C107 a_1803_47# S7_2 0.614813f
C108 D0_2 G0_2 0.625982f
C109 S3_0 D4_0 0.614813f
C110 G4_2 G3_2 0.061903f
C111 a_1803_n8283# S7_0 0.614813f
C112 B G6_0 0.278378f
C113 G1_0 G2_0 0.061903f
C114 B G2_3 0.382207f
C115 B G7_3 0.40686f
C116 G5_3 G4_3 0.061903f
C117 B a_1803_4212# 1.14085f
C118 G1_0 G1_1 0.227831f
C119 S5_0 D4_0 0.614813f
C120 D0_2 D0_1 0.014232f
C121 G4_2 D4_2 0.625982f
C122 D2_3 G2_3 0.625982f
C123 G4_2 G4_1 0.227831f
C124 B S7_2 0.009616f
C125 G6_1 D6_1 0.625982f
C126 a_1803_n8283# a_1803_n4118# 0.014232f
C127 G0_2 G0_1 0.227831f
C128 S5_0 G5_0 0.625982f
C129 G0_0 G0_1 0.227831f
C130 G5_0 D6_0 0.625982f
C131 G3_3 G2_3 0.061903f
C132 B G3_2 0.223127f
C133 G5_3 S5_3 0.625982f
C134 G1_2 S1_2 0.625982f
C135 B G6_2 0.223127f
C136 B G7_0 0.303032f
C137 S5_2 D4_2 0.614813f
C138 G5_1 G4_1 0.061903f
C139 D0_1 G0_1 0.625982f
C140 S7_1 S7_0 0.014232f
C141 G5_0 G6_0 0.061903f
C142 B D4_2 0.009616f
C143 G1_2 B 0.223127f
C144 B G2_2 0.223127f
C145 B G4_1 0.223127f
C146 B S7_3 0.015791f
C147 G3_3 G3_2 0.227831f
C148 S3_2 G3_2 0.625982f
C149 a_1803_n4118# G7_1 0.625982f
C150 D6_2 D6_1 0.014232f
C151 D6_3 B 0.015791f
C152 G1_2 G1_1 0.227831f
C153 G1_2 D2_2 0.625982f
C154 S7_1 G7_1 0.625982f
C155 S7_1 a_1803_n4118# 0.614813f
C156 D2_2 G2_2 0.625982f
C157 S3_2 D4_2 0.614813f
C158 S5_2 G4_2 0.625982f
C159 S3_2 G2_2 0.625982f
C160 G0_3 B 0.40686f
C161 D0_1 S1_1 0.614813f
C162 G4_2 B 0.223127f
C163 G0_3 D0_3 0.625982f
C164 D6_2 G5_2 0.625982f
C165 S1_0 S1_1 0.014232f
C166 a_1803_47# B 1.13467f
C167 G6_1 G6_0 0.227831f
C168 G5_3 D6_3 0.625982f
C169 B S1_2 0.009616f
C170 G5_1 B 0.223127f
C171 G3_0 G4_0 0.061903f
C172 S7_1 D6_1 0.614813f
C173 B D2_1 0.009616f
C174 G3_1 D4_1 0.625982f
C175 D0_0 B 1.14187f
C176 S5_2 B 0.009616f
C177 G3_0 G3_1 0.227831f
C178 D2_2 S1_2 0.614813f
C179 G2_0 B 0.278378f
C180 D2_1 G1_1 0.625982f
C181 B D0_3 1.14085f
C182 D2_3 B 0.015791f
C183 D2_2 D2_1 0.014232f
C184 G7_1 G7_2 0.227831f
C185 B G1_1 0.223127f
C186 D2_2 B 0.009616f
C187 G6_1 G6_2 0.227831f
C188 D2_3 D2_2 0.014232f
C189 B D4_0 0.016816f
C190 D6_0 S7_0 0.614813f
C191 G3_3 B 0.382207f
C192 S3_2 B 0.009616f
C193 G5_0 G5_1 0.227831f
C194 S1_0 D2_0 0.614813f
C195 G3_1 S3_1 0.625982f
C196 G6_0 S7_0 0.625982f
C197 G6_3 G7_3 0.061903f
C198 D6_2 S7_2 0.614813f
C199 G5_3 B 0.382207f
C200 S3_0 D2_0 0.614813f
C201 S3_2 D2_2 0.614813f
C202 G5_0 B 0.278378f
C203 G3_1 G2_1 0.061903f
C204 D0_2 S1_2 0.614813f
C205 S5_0 G4_0 0.625982f
C206 D4_1 S3_1 0.614813f
C207 D6_2 G6_2 0.625982f
C208 D0_2 B 1.13467f
C209 a_1803_n8283# G7_0 0.625982f
C210 D0_2 D0_3 0.014232f
C211 G1_0 D2_0 0.625982f
C212 G6_3 G6_2 0.227831f
C213 S3_3 D4_3 0.614813f
C214 G7_0 S7_0 0.625982f
C215 G3_0 S3_0 0.625982f
C216 D6_3 D6_2 0.014232f
C217 S1_0 G0_0 0.625982f
C218 G1_3 S1_3 0.625982f
C219 G6_3 S7_3 0.625982f
C220 G5_1 G6_1 0.061903f
C221 S7_1 S7_2 0.014232f
C222 D4_1 S5_1 0.614813f
C223 B G0_1 0.247781f
C224 D6_1 D6_0 0.014232f
C225 D6_1 S5_1 0.614813f
C226 D6_3 G6_3 0.625982f
C227 G7_1 G7_0 0.227831f
C228 G6_1 B 0.223127f
C229 G4_3 D4_3 0.625982f
C230 G1_1 G0_1 0.061903f
C231 S3_1 G2_1 0.625982f
C232 G3_1 G3_2 0.227831f
C233 S3_1 S3_0 0.014232f
C234 G1_0 G0_0 0.061903f
C235 S1_2 S1_1 0.014232f
C236 G1_3 G2_3 0.061903f
C237 G4_0 G4_1 0.227831f
C238 D2_1 S1_1 0.614813f
C239 S3_3 G2_3 0.625982f
C240 D4_3 S5_3 0.614813f
C241 G3_1 G4_1 0.061903f
C242 B S1_1 0.009616f
C243 S7_0 VSUBS 0.863504f
C244 D6_0 VSUBS 0.863504f
C245 S5_0 VSUBS 0.863504f
C246 D4_0 VSUBS 0.863504f
C247 S3_0 VSUBS 0.863504f
C248 D2_0 VSUBS 0.863504f
C249 S1_0 VSUBS 0.863504f
C250 D0_0 VSUBS 1.12621f
C251 G7_0 VSUBS 0.440605f
C252 G6_0 VSUBS 0.427224f
C253 G5_0 VSUBS 0.427224f
C254 G4_0 VSUBS 0.427224f
C255 G3_0 VSUBS 0.427224f
C256 G2_0 VSUBS 0.427224f
C257 G1_0 VSUBS 0.427224f
C258 G0_0 VSUBS 0.440605f
C259 S7_1 VSUBS 0.857307f
C260 D6_1 VSUBS 0.857307f
C261 S5_1 VSUBS 0.857307f
C262 D4_1 VSUBS 0.857307f
C263 S3_1 VSUBS 0.857307f
C264 D2_1 VSUBS 0.857307f
C265 S1_1 VSUBS 0.857307f
C266 D0_1 VSUBS 1.12001f
C267 G7_1 VSUBS 0.409619f
C268 G6_1 VSUBS 0.396239f
C269 G5_1 VSUBS 0.396239f
C270 G4_1 VSUBS 0.396239f
C271 G3_1 VSUBS 0.396239f
C272 G2_1 VSUBS 0.396239f
C273 G1_1 VSUBS 0.396239f
C274 G0_1 VSUBS 0.409619f
C275 S7_2 VSUBS 0.857307f
C276 D6_2 VSUBS 0.857307f
C277 S5_2 VSUBS 0.857307f
C278 D4_2 VSUBS 0.857307f
C279 S3_2 VSUBS 0.857307f
C280 D2_2 VSUBS 0.857307f
C281 S1_2 VSUBS 0.857307f
C282 D0_2 VSUBS 1.12001f
C283 G7_2 VSUBS 0.409619f
C284 G6_2 VSUBS 0.396239f
C285 G5_2 VSUBS 0.396239f
C286 G4_2 VSUBS 0.396239f
C287 G3_2 VSUBS 0.396239f
C288 G2_2 VSUBS 0.396239f
C289 G1_2 VSUBS 0.396239f
C290 G0_2 VSUBS 0.409619f
C291 S7_3 VSUBS 0.862757f
C292 D6_3 VSUBS 0.862757f
C293 S5_3 VSUBS 0.862757f
C294 D4_3 VSUBS 0.862757f
C295 S3_3 VSUBS 0.862757f
C296 D2_3 VSUBS 0.862757f
C297 S1_3 VSUBS 0.862757f
C298 D0_3 VSUBS 1.12546f
C299 G7_3 VSUBS 0.420067f
C300 G6_3 VSUBS 0.406686f
C301 G5_3 VSUBS 0.406686f
C302 G4_3 VSUBS 0.406686f
C303 G3_3 VSUBS 0.406686f
C304 G2_3 VSUBS 0.406686f
C305 G1_3 VSUBS 0.406686f
C306 G0_3 VSUBS 0.420067f
C307 B VSUBS 0.221525p
C308 a_1803_n8283# VSUBS 1.12621f
C309 a_1803_n4118# VSUBS 1.12001f
C310 a_1803_47# VSUBS 1.12001f
C311 a_1803_4212# VSUBS 1.12546f
.ends

.subckt sky130_fd_pr__pfet_g5v0d10v5_UFWJXT B D0_0 G0_0 D0_1 G0_1 D0_2 G0_2 D0_3 G0_3
+ S1_0 G1_0 S1_1 G1_1 S1_2 G1_2 S1_3 G1_3 a_3229_n8283# a_3229_4212# a_3229_47# a_3229_n4118#
+ VSUBS
X0 a_3229_47# G1_2 S1_2 B sky130_fd_pr__pfet_g5v0d10v5 ad=5.8 pd=40.58 as=2.9 ps=20.29 w=20 l=16
X1 S1_2 G0_2 D0_2 B sky130_fd_pr__pfet_g5v0d10v5 ad=2.9 pd=20.29 as=5.8 ps=40.58 w=20 l=16
X2 a_3229_n4118# G1_1 S1_1 B sky130_fd_pr__pfet_g5v0d10v5 ad=5.8 pd=40.58 as=2.9 ps=20.29 w=20 l=16
X3 S1_3 G0_3 D0_3 B sky130_fd_pr__pfet_g5v0d10v5 ad=2.9 pd=20.29 as=5.8 ps=40.58 w=20 l=16
X4 S1_0 G0_0 D0_0 B sky130_fd_pr__pfet_g5v0d10v5 ad=2.9 pd=20.29 as=5.8 ps=40.58 w=20 l=16
X5 a_3229_n8283# G1_0 S1_0 B sky130_fd_pr__pfet_g5v0d10v5 ad=5.8 pd=40.58 as=2.9 ps=20.29 w=20 l=16
X6 a_3229_4212# G1_3 S1_3 B sky130_fd_pr__pfet_g5v0d10v5 ad=5.8 pd=40.58 as=2.9 ps=20.29 w=20 l=16
X7 S1_1 G0_1 D0_1 B sky130_fd_pr__pfet_g5v0d10v5 ad=2.9 pd=20.29 as=5.8 ps=40.58 w=20 l=16
C0 B a_3229_47# 1.13466f
C1 G0_2 G0_1 1.79553f
C2 G1_3 G0_3 0.061903f
C3 a_3229_n8283# B 1.14186f
C4 B D0_0 1.14186f
C5 G1_1 G0_1 0.061903f
C6 S1_3 G0_3 0.843488f
C7 D0_3 B 1.14084f
C8 B S1_2 0.009589f
C9 G0_0 G0_1 1.79553f
C10 G1_3 G1_2 1.79553f
C11 G1_3 a_3229_4212# 0.843488f
C12 B G0_1 1.61352f
C13 B D0_1 1.13466f
C14 D0_0 D0_1 0.014232f
C15 G1_1 a_3229_n4118# 0.843488f
C16 D0_2 G0_2 0.843488f
C17 D0_1 G0_1 0.843488f
C18 G1_3 B 2.88484f
C19 S1_3 B 0.015764f
C20 a_3229_47# a_3229_n4118# 0.014232f
C21 S1_3 S1_2 0.014232f
C22 a_3229_n8283# a_3229_n4118# 0.014232f
C23 B a_3229_n4118# 1.13466f
C24 S1_1 S1_0 0.014232f
C25 D0_2 B 1.13466f
C26 D0_3 D0_2 0.014232f
C27 S1_1 G1_1 0.843488f
C28 G0_2 G0_3 1.79553f
C29 S1_1 B 0.009589f
C30 D0_2 D0_1 0.014232f
C31 S1_1 S1_2 0.014232f
C32 G0_2 G1_2 0.061903f
C33 G1_3 S1_3 0.843488f
C34 G1_2 G1_1 1.79553f
C35 S1_1 G0_1 0.843488f
C36 S1_0 G1_0 0.843488f
C37 B G0_3 2.88484f
C38 D0_3 G0_3 0.843488f
C39 G1_1 G1_0 1.79553f
C40 G1_2 a_3229_47# 0.843488f
C41 a_3229_47# a_3229_4212# 0.014232f
C42 G0_0 G1_0 0.061903f
C43 G1_2 B 1.61352f
C44 G0_0 S1_0 0.843488f
C45 B a_3229_4212# 1.14084f
C46 G1_2 S1_2 0.843488f
C47 a_3229_n8283# G1_0 0.843488f
C48 G1_0 B 2.05553f
C49 S1_0 B 0.016789f
C50 G0_2 B 1.61352f
C51 G0_2 S1_2 0.843488f
C52 G1_1 B 1.61352f
C53 G0_0 B 2.05553f
C54 G0_0 D0_0 0.843488f
C55 S1_0 VSUBS 1.87158f
C56 D0_0 VSUBS 1.63025f
C57 G1_0 VSUBS 3.5167f
C58 G0_0 VSUBS 3.5167f
C59 S1_1 VSUBS 1.86538f
C60 D0_1 VSUBS 1.62405f
C61 G1_1 VSUBS 3.26881f
C62 G0_1 VSUBS 3.26881f
C63 S1_2 VSUBS 1.86538f
C64 D0_2 VSUBS 1.62405f
C65 G1_2 VSUBS 3.26881f
C66 G0_2 VSUBS 3.26881f
C67 S1_3 VSUBS 1.87083f
C68 D0_3 VSUBS 1.6295f
C69 G1_3 VSUBS 3.32544f
C70 G0_3 VSUBS 3.32544f
C71 B VSUBS 0.369011p
C72 a_3229_n8283# VSUBS 1.63025f
C73 a_3229_n4118# VSUBS 1.62405f
C74 a_3229_47# VSUBS 1.62405f
C75 a_3229_4212# VSUBS 1.6295f
.ends

.subckt sky130_fd_pr__nfet_g5v0d10v5_F3NX3J B D S G
X0 S G D B sky130_fd_pr__nfet_g5v0d10v5 ad=0.1218 pd=1.42 as=0.1218 ps=1.42 w=0.42 l=4
C0 G S 0.023116f
C1 G D 0.023116f
C2 D S 0.007122f
C3 S B 0.083121f
C4 D B 0.083121f
C5 G B 1.85725f
.ends

.subckt sky130_fd_pr__nfet_05v0_nvt_6T4HWX B D0 S0 G0 D1 S1 G1
X0 S1 G1 D1 B sky130_fd_pr__nfet_05v0_nvt ad=0.29 pd=2.58 as=0.29 ps=2.58 w=1 l=25
X1 S0 G0 D0 B sky130_fd_pr__nfet_05v0_nvt ad=0.29 pd=2.58 as=0.29 ps=2.58 w=1 l=25
C0 G1 S1 0.049339f
C1 G1 D1 0.049339f
C2 G1 G0 3.42782f
C3 S0 S1 0.014895f
C4 S0 G0 0.049339f
C5 D1 D0 0.014895f
C6 D0 G0 0.049339f
C7 S0 B 0.157719f
C8 D0 B 0.157719f
C9 G0 B 8.145109f
C10 S1 B 0.156139f
C11 D1 B 0.156139f
C12 G1 B 8.90423f
.ends

.subckt sky130_fd_pr__pfet_g5v0d10v5_5EJAKB B D S G VSUBS
X0 S G D B sky130_fd_pr__pfet_g5v0d10v5 ad=0.2436 pd=2.26 as=0.2436 ps=2.26 w=0.84 l=4
C0 B D 0.073044f
C1 B G 0.982043f
C2 B S 0.073044f
C3 G D 0.039028f
C4 D S 0.013979f
C5 G S 0.039028f
C6 S VSUBS 0.061032f
C7 D VSUBS 0.061032f
C8 G VSUBS 0.873669f
C9 B VSUBS 3.60478f
.ends

.subckt ldo_top vin vout rstn gnd
Xbgr_MPO vin bgr_MPO/D3 vin bgr_MS2/D bgr_MPO/D3 vin bgr_MS2/D bgr_MPO/D3 vin bgr_MS2/D
+ bgr_MPO/D3 vin bgr_MS2/D gnd sky130_fd_pr__pfet_g5v0d10v5_UFECYT
Xbgr_MT0 gnd bgr_R2/R1 bgr_MT1/D gnd sky130_fd_pr__nfet_g5v0d10v5_3LMSA7
Xbgr_MPCC vin bgr_MNCD/G bgr_MS2/D bgr_MNCD/G bgr_MS2/D bgr_MNCD/G bgr_MS2/D bgr_MNCD/G
+ bgr_MS2/D bgr_MPC/D3 bgr_MS2/D bgr_MPC/D3 bgr_MS2/D bgr_MPC/D3 bgr_MS2/D bgr_MPC/D3
+ bgr_MS2/D bgr_MNCD/G bgr_MS2/D bgr_MNCD/G bgr_MS2/D bgr_MNCD/G bgr_MS2/D bgr_MNCD/G
+ bgr_MS2/D bgr_MPC/D3 bgr_MS2/D bgr_MPC/D3 bgr_MS2/D bgr_MPC/D3 bgr_MS2/D bgr_MPC/D3
+ bgr_MS2/D bgr_MNCD/G bgr_MNCD/G bgr_MNCD/G bgr_MNCD/G gnd sky130_fd_pr__pfet_g5v0d10v5_TGGT4A
Xbgr_MT1 gnd bgr_MT1/D bgr_MT2/D gnd sky130_fd_pr__nfet_g5v0d10v5_3LMSA7
Xbgr_MPBC vin bgr_MNB/G5 bgr_MS2/D bgr_MNB/G5 bgr_MS2/D bgr_MNB/G5 bgr_MS2/D bgr_MNB/G5
+ bgr_MS2/D bgr_MPB/D3 bgr_MS2/D bgr_MPB/D3 bgr_MS2/D bgr_MPB/D3 bgr_MS2/D bgr_MPB/D3
+ bgr_MS2/D bgr_MNB/G5 bgr_MS2/D bgr_MNB/G5 bgr_MS2/D bgr_MNB/G5 bgr_MS2/D bgr_MNB/G5
+ bgr_MS2/D bgr_MPB/D3 bgr_MS2/D bgr_MPB/D3 bgr_MS2/D bgr_MPB/D3 bgr_MS2/D bgr_MPB/D3
+ bgr_MS2/D bgr_MNB/G5 bgr_MNB/G5 bgr_MNB/G5 bgr_MNB/G5 gnd sky130_fd_pr__pfet_g5v0d10v5_TGGT4A
Xpor_MD gnd por_MD/D gnd por_MD/G sky130_fd_pr__nfet_g5v0d10v5_C8EBTW
Xbgr_MT2 gnd bgr_MT2/D bgr_MT3/D gnd sky130_fd_pr__nfet_g5v0d10v5_3LMSA7
Xbgr_MPAC vin bgr_MNF/G5 bgr_MS2/D bgr_MNF/G5 bgr_MS2/D bgr_MNF/G5 bgr_MS2/D bgr_MNF/G5
+ bgr_MS2/D bgr_MPA/D3 bgr_MS2/D bgr_MPA/D3 bgr_MS2/D bgr_MPA/D3 bgr_MS2/D bgr_MPA/D3
+ bgr_MS2/D bgr_MNF/G5 bgr_MS2/D bgr_MNF/G5 bgr_MS2/D bgr_MNF/G5 bgr_MS2/D bgr_MNF/G5
+ bgr_MS2/D bgr_MPA/D3 bgr_MS2/D bgr_MPA/D3 bgr_MS2/D bgr_MPA/D3 bgr_MS2/D bgr_MPA/D3
+ bgr_MS2/D bgr_MNF/G5 bgr_MNF/G5 bgr_MNF/G5 bgr_MNF/G5 gnd sky130_fd_pr__pfet_g5v0d10v5_TGGT4A
Xbgr_MT3 gnd bgr_MT3/D bgr_MT4/D gnd sky130_fd_pr__nfet_g5v0d10v5_3LMSA7
Xbgr_MS2 gnd bgr_MS2/D gnd bgr_MSN/D sky130_fd_pr__nfet_g5v0d10v5_62W55W
Xbgr_Cvr0 gnd ldo_MN2/G gnd sky130_fd_pr__cap_mim_m3_1_BTY6QK
Xldo_Cff_0 ldo_MNX/S2 vin gnd sky130_fd_pr__cap_mim_m3_1_V8HUNN
Xldo_MNA gnd ldo_MPS/D gnd ldo_MPS/D sky130_fd_pr__nfet_g5v0d10v5_NUFNY9
Xbgr_MT4 gnd bgr_MT4/D bgr_MT4/S vin sky130_fd_pr__nfet_g5v0d10v5_3LMSA7
Xbgr_MNCD gnd bgr_MNCD/G bgr_MNCD/S bgr_MNCD/G sky130_fd_pr__nfet_05v0_nvt_F4CC77
Xbgr_MNBC gnd bgr_MNF/G5 bgr_MNCD/G bgr_MNB/D4 bgr_MNCD/G bgr_MNF/G5 bgr_MNCD/G bgr_MNB/D4
+ bgr_MNCD/G bgr_MNF/G5 bgr_MNCD/G bgr_MNB/D4 bgr_MNCD/G bgr_MNF/G5 sky130_fd_pr__nfet_05v0_nvt_ASWYB8
Xbgr_Cvr1 gnd ldo_MN2/G gnd sky130_fd_pr__cap_mim_m3_1_BTY6QK
Xldo_Cff_1 ldo_MNX/S2 vin gnd sky130_fd_pr__cap_mim_m3_1_V8HUNN
Xldo_MNB gnd ldo_MNB/G gnd ldo_MNB/G sky130_fd_pr__nfet_g5v0d10v5_BE4NYT
Xbgr_R1 gnd bgr_R1/R1 bgr_R1/R2 sky130_fd_pr__res_xhigh_po_0p35_5J6MKL
Xpor_MH gnd por_MH/D gnd por_MH/G sky130_fd_pr__nfet_g5v0d10v5_A8HTHF
Xbgr_Cvr2 gnd ldo_MN2/G gnd sky130_fd_pr__cap_mim_m3_1_BTY6QK
Xldo_Cff_2 ldo_MNX/S2 vin gnd sky130_fd_pr__cap_mim_m3_1_V8HUNN
Xldo_MNBL gnd vout ldo_MNB/G gnd ldo_MNB/G vout ldo_MNB/G gnd ldo_MNB/G vout ldo_MNB/G
+ gnd ldo_MNB/G vout ldo_MNB/G gnd ldo_MNB/G vout ldo_MNB/G gnd ldo_MNB/G vout ldo_MNB/G
+ gnd ldo_MNB/G vout ldo_MNB/G gnd ldo_MNB/G vout ldo_MNB/G gnd ldo_MNB/G vout ldo_MNB/G
+ gnd ldo_MNB/G vout ldo_MNB/G gnd ldo_MNB/G vout sky130_fd_pr__nfet_g5v0d10v5_YQMGE2
Xbgr_R2 gnd bgr_R2/R1 bgr_Rf/R2 sky130_fd_pr__res_xhigh_po_0p35_PL9RNS
Xbgr_Q1 bgr_MNA/S5 gnd gnd sky130_fd_pr__rf_pnp_05v5_W3p40L3p40 m=1
Xbgr_Cvr3 gnd ldo_MN2/G gnd sky130_fd_pr__cap_mim_m3_1_BTY6QK
Xldo_Cff_3 ldo_MNX/S2 vin gnd sky130_fd_pr__cap_mim_m3_1_V8HUNN
Xbgr_Q3 bgr_MT4/S gnd gnd sky130_fd_pr__rf_pnp_05v5_W3p40L3p40 m=1
Xbgr_RT0 gnd bgr_MT1/D bgr_R2/R1 sky130_fd_pr__res_xhigh_po_0p35_R4U9XH
Xbgr_Q5 bgr_MNCD/S gnd gnd sky130_fd_pr__rf_pnp_05v5_W3p40L3p40 m=1
Xbgr_RT1 gnd bgr_MT2/D bgr_MT1/D sky130_fd_pr__res_xhigh_po_0p35_XV4KRP
Xldo_Cbp gnd ldo_Rsh/R1 gnd sky130_fd_pr__cap_mim_m3_1_84Z4WG
Xbgr_RT2 gnd bgr_MT3/D bgr_MT2/D sky130_fd_pr__res_xhigh_po_0p35_4E3LTY
Xbgr_Q7 bgr_MSN/S gnd gnd sky130_fd_pr__rf_pnp_05v5_W3p40L3p40 m=1
Xbgr_MSU0 vin bgr_MSU1/S vin bgr_MSU1/S gnd sky130_fd_pr__pfet_g5v0d10v5_32MMT9
Xldo_MPB2 vin ldo_Rsh/R2 vin ldo_Rsh/R2 gnd sky130_fd_pr__pfet_g5v0d10v5_MN82PF
Xbgr_RT3 gnd bgr_MT4/D bgr_MT3/D sky130_fd_pr__res_xhigh_po_0p35_VEZ8JB
Xbgr_RT4 gnd bgr_MT4/S bgr_MT4/D sky130_fd_pr__res_xhigh_po_0p35_HGUK4G
Xbgr_Q2_0 bgr_R1/R1 gnd gnd sky130_fd_pr__rf_pnp_05v5_W3p40L3p40 m=1
Xbgr_Q8 bgr_MNSK/S1 gnd gnd sky130_fd_pr__rf_pnp_05v5_W3p40L3p40 m=1
Xpor_R1 gnd por_MD/G vin sky130_fd_pr__res_xhigh_po_0p35_YNY9WN
Xbgr_MSU1 vin bgr_MSU2/S bgr_MSU1/S bgr_MSU2/S gnd sky130_fd_pr__pfet_g5v0d10v5_32MMT9
Xbgr_Q2_1 bgr_R1/R1 gnd gnd sky130_fd_pr__rf_pnp_05v5_W3p40L3p40 m=1
Xpor_R2 gnd por_MH/D por_MD/G sky130_fd_pr__res_xhigh_po_0p35_8Z5M7R
Xbgr_MSU3 vin bgr_MSN/D bgr_MSU3/S bgr_MSN/D gnd sky130_fd_pr__pfet_g5v0d10v5_32MMT9
Xbgr_MSU2 vin bgr_MSU3/S bgr_MSU2/S bgr_MSU3/S gnd sky130_fd_pr__pfet_g5v0d10v5_32MMT9
Xbgr_Q2_2 bgr_R1/R1 gnd gnd sky130_fd_pr__rf_pnp_05v5_W3p40L3p40 m=1
Xpor_R3 gnd gnd por_MH/D sky130_fd_pr__res_xhigh_po_0p35_KAXJA5
Xpor_Rpu gnd por_MD/D vin sky130_fd_pr__res_xhigh_po_0p35_NT9K52
Xldo_MNA2 gnd ldo_MN2/S gnd ldo_MPS/D sky130_fd_pr__nfet_g5v0d10v5_NUFNY9
Xldo_MNB3 gnd ldo_Rsh/R1 gnd ldo_MNB/G sky130_fd_pr__nfet_g5v0d10v5_BE4NYT
Xldo_Rsh gnd ldo_Rsh/R1 ldo_Rsh/R2 sky130_fd_pr__res_xhigh_po_0p35_J82YCH
Xbgr_Q2_3 bgr_R1/R1 gnd gnd sky130_fd_pr__rf_pnp_05v5_W3p40L3p40 m=1
Xldo_MPP vin vout ldo_MPS/G vin ldo_MPS/G vout ldo_MPS/G vin ldo_MPS/G vout ldo_MPS/G
+ vin ldo_MPS/G vout ldo_MPS/G vin ldo_MPS/G vout ldo_MPS/G vin ldo_MPS/G vout ldo_MPS/G
+ vin ldo_MPS/G vout ldo_MPS/G vin ldo_MPS/G vout ldo_MPS/G vin ldo_MPS/G vout ldo_MPS/G
+ vin ldo_MPS/G vout ldo_MPS/G vin ldo_MPS/G vout ldo_MPS/G vin ldo_MPS/G vout ldo_MPS/G
+ vin ldo_MPS/G vout ldo_MPS/G vin ldo_MPS/G vout ldo_MPS/G vin ldo_MPS/G vout ldo_MPS/G
+ vin ldo_MPS/G vout ldo_MPS/G vin ldo_MPS/G vout ldo_MPS/G vin ldo_MPS/G vout ldo_MPS/G
+ vin ldo_MPS/G vout ldo_MPS/G vin ldo_MPS/G vout ldo_MPS/G vin ldo_MPS/G vout gnd
+ sky130_fd_pr__pfet_g5v0d10v5_PSYF8E
Xbgr_Q2_5 bgr_R1/R1 gnd gnd sky130_fd_pr__rf_pnp_05v5_W3p40L3p40 m=1
Xbgr_Q2_4 bgr_R1/R1 gnd gnd sky130_fd_pr__rf_pnp_05v5_W3p40L3p40 m=1
Xbgr_Q2_6 bgr_R1/R1 gnd gnd sky130_fd_pr__rf_pnp_05v5_W3p40L3p40 m=1
Xldo_MPS vin ldo_MPS/D vin ldo_MPS/G gnd sky130_fd_pr__pfet_g5v0d10v5_7B62CL
Xbgr_Q2_7 bgr_R1/R1 gnd gnd sky130_fd_pr__rf_pnp_05v5_W3p40L3p40 m=1
Xldo_MPT vin ldo_MPX/S2 vin ldo_Rsh/R2 ldo_MPX/S2 vin ldo_Rsh/R2 ldo_MPX/S2 vin ldo_Rsh/R2
+ gnd sky130_fd_pr__pfet_g5v0d10v5_PN8J4Z
Xbgr_MPA vin bgr_MPA/D3 vin bgr_MS2/D bgr_MPA/D3 vin bgr_MS2/D bgr_MPA/D3 vin bgr_MS2/D
+ bgr_MPA/D3 vin bgr_MS2/D gnd sky130_fd_pr__pfet_g5v0d10v5_UFECYT
Xldo_MNS gnd ldo_MNX/S2 gnd ldo_MNB/G ldo_MNX/S2 gnd ldo_MNB/G ldo_MNX/S2 gnd ldo_MNB/G
+ sky130_fd_pr__nfet_g5v0d10v5_3UQFYT
Xbgr_Rf gnd ldo_MN2/G bgr_Rf/R2 sky130_fd_pr__res_xhigh_po_0p35_ADWJQG
Xbgr_MPC vin bgr_MPC/D3 vin bgr_MS2/D bgr_MPC/D3 vin bgr_MS2/D bgr_MPC/D3 vin bgr_MS2/D
+ bgr_MPC/D3 vin bgr_MS2/D gnd sky130_fd_pr__pfet_g5v0d10v5_UFECYT
Xbgr_MPB vin bgr_MPB/D3 vin bgr_MS2/D bgr_MPB/D3 vin bgr_MS2/D bgr_MPB/D3 vin bgr_MS2/D
+ bgr_MPB/D3 vin bgr_MS2/D gnd sky130_fd_pr__pfet_g5v0d10v5_UFECYT
Xbgr_MNA gnd bgr_MNB/G5 bgr_MNB/G5 bgr_MNA/S5 bgr_MNB/G5 bgr_MNB/G5 bgr_MNB/G5 bgr_MNA/S5
+ bgr_MNB/G5 bgr_MNB/G5 bgr_MNB/G5 bgr_MNA/S5 bgr_MNB/G5 bgr_MNB/G5 sky130_fd_pr__nfet_05v0_nvt_ASWYB8
Xbgr_MPOC vin bgr_Rf/R2 bgr_MS2/D bgr_Rf/R2 bgr_MS2/D bgr_Rf/R2 bgr_MS2/D bgr_Rf/R2
+ bgr_MS2/D bgr_MPO/D3 bgr_MS2/D bgr_MPO/D3 bgr_MS2/D bgr_MPO/D3 bgr_MS2/D bgr_MPO/D3
+ bgr_MS2/D bgr_Rf/R2 bgr_MS2/D bgr_Rf/R2 bgr_MS2/D bgr_Rf/R2 bgr_MS2/D bgr_Rf/R2
+ bgr_MS2/D bgr_MPO/D3 bgr_MS2/D bgr_MPO/D3 bgr_MS2/D bgr_MPO/D3 bgr_MS2/D bgr_MPO/D3
+ bgr_MS2/D bgr_Rf/R2 bgr_Rf/R2 bgr_Rf/R2 bgr_Rf/R2 gnd sky130_fd_pr__pfet_g5v0d10v5_TGGT4A
Xbgr_MNB gnd bgr_MNB/D4 bgr_MNB/G5 bgr_R1/R2 bgr_MNB/G5 bgr_MNB/D4 bgr_MNB/G5 bgr_R1/R2
+ bgr_MNB/G5 bgr_MNB/D4 bgr_MNB/G5 bgr_R1/R2 bgr_MNB/G5 bgr_MNB/D4 sky130_fd_pr__nfet_05v0_nvt_ASWYB8
Xldo_Cfp_0 ldo_MPX/S2 vout gnd sky130_fd_pr__cap_mim_m3_1_Y3HN7X
Xldo_MN1 gnd ldo_MP4/G ldo_MN2/S vout sky130_fd_pr__nfet_g5v0d10v5_WMYWGM
Xldo_MP3 vin ldo_MP4/G vin ldo_MP4/G gnd sky130_fd_pr__pfet_g5v0d10v5_DNGK98
Xldo_Cfp_1 ldo_MPX/S2 vout gnd sky130_fd_pr__cap_mim_m3_1_Y3HN7X
Xldo_MN2 gnd ldo_MPS/G ldo_MN2/S ldo_MN2/G sky130_fd_pr__nfet_g5v0d10v5_WMYWGM
Xldo_MPX vin ldo_MPS/G ldo_MPX/S2 ldo_Rsh/R1 ldo_MPS/G ldo_MPX/S2 ldo_Rsh/R1 ldo_MPS/G
+ ldo_MPX/S2 ldo_Rsh/R1 gnd sky130_fd_pr__pfet_g5v0d10v5_PN8J4Z
Xldo_MP4 vin ldo_MPS/G vin ldo_MP4/G gnd sky130_fd_pr__pfet_g5v0d10v5_DNGK98
Xldo_Cfp_2 ldo_MPX/S2 vout gnd sky130_fd_pr__cap_mim_m3_1_Y3HN7X
Xldo_MNX gnd ldo_MPS/G ldo_MN2/G ldo_MNX/S2 ldo_MN2/G ldo_MPS/G ldo_MNX/S2 ldo_MN2/G
+ sky130_fd_pr__nfet_g5v0d10v5_DDWFWJ
Xpor_MI3N gnd rstn gnd por_MH/G sky130_fd_pr__nfet_g5v0d10v5_FZ2B7C
Xldo_Cfn_0 ldo_MNX/S2 vout gnd sky130_fd_pr__cap_mim_m3_1_Y3HN7X
Xldo_Cfp_3 ldo_MPX/S2 vout gnd sky130_fd_pr__cap_mim_m3_1_Y3HN7X
Xldo_Cc vout ldo_MPS/G gnd sky130_fd_pr__cap_mim_m3_1_PP9XRG
Xldo_MN5 gnd ldo_MN2/S gnd ldo_MNB/G ldo_MN2/S gnd ldo_MNB/G ldo_MN2/S gnd ldo_MNB/G
+ ldo_MN2/S gnd ldo_MNB/G sky130_fd_pr__nfet_g5v0d10v5_HA9V6X
Xbgr_MNF gnd vin bgr_MNF/G5 bgr_MS2/D bgr_MNF/G5 vin bgr_MNF/G5 bgr_MS2/D bgr_MNF/G5
+ vin bgr_MNF/G5 bgr_MS2/D bgr_MNF/G5 vin sky130_fd_pr__nfet_05v0_nvt_ASWYB8
Xpor_MI2N gnd por_MH/G gnd por_MI2P/G sky130_fd_pr__nfet_g5v0d10v5_FZ2B7C
Xldo_Cfn_1 ldo_MNX/S2 vout gnd sky130_fd_pr__cap_mim_m3_1_Y3HN7X
Xbgr_MPIC vin ldo_MNB/G bgr_MS2/D ldo_MNB/G bgr_MS2/D ldo_MNB/G bgr_MS2/D ldo_MNB/G
+ bgr_MS2/D bgr_MPI/D0_3 bgr_MS2/D bgr_MPI/D0_3 bgr_MS2/D bgr_MPI/D0_3 bgr_MS2/D bgr_MPI/D0_3
+ bgr_MS2/D ldo_MNB/G bgr_MS2/D ldo_MNB/G bgr_MS2/D ldo_MNB/G bgr_MS2/D ldo_MNB/G
+ bgr_MS2/D bgr_MPI/D0_3 bgr_MS2/D bgr_MPI/D0_3 bgr_MS2/D bgr_MPI/D0_3 bgr_MS2/D bgr_MPI/D0_3
+ bgr_MS2/D ldo_MNB/G bgr_MS2/D ldo_MNB/G bgr_MS2/D ldo_MNB/G bgr_MS2/D ldo_MNB/G
+ bgr_MS2/D bgr_MPI/D0_3 bgr_MS2/D bgr_MPI/D0_3 bgr_MS2/D bgr_MPI/D0_3 bgr_MS2/D bgr_MPI/D0_3
+ bgr_MS2/D ldo_MNB/G bgr_MS2/D ldo_MNB/G bgr_MS2/D ldo_MNB/G bgr_MS2/D ldo_MNB/G
+ bgr_MS2/D bgr_MPI/D0_3 bgr_MS2/D bgr_MPI/D0_3 bgr_MS2/D bgr_MPI/D0_3 bgr_MS2/D bgr_MPI/D0_3
+ bgr_MS2/D ldo_MNB/G ldo_MNB/G ldo_MNB/G ldo_MNB/G gnd sky130_fd_pr__pfet_g5v0d10v5_KMGDV8
Xbgr_MPI vin bgr_MPI/D0_3 bgr_MS2/D bgr_MPI/D0_3 bgr_MS2/D bgr_MPI/D0_3 bgr_MS2/D
+ bgr_MPI/D0_3 bgr_MS2/D vin bgr_MS2/D vin bgr_MS2/D vin bgr_MS2/D vin bgr_MS2/D bgr_MPI/D0_3
+ bgr_MPI/D0_3 bgr_MPI/D0_3 bgr_MPI/D0_3 gnd sky130_fd_pr__pfet_g5v0d10v5_UFWJXT
Xpor_MI1N gnd por_MI2P/G gnd por_MD/D sky130_fd_pr__nfet_g5v0d10v5_F3NX3J
Xpor_MI3P vout rstn vout por_MH/G gnd sky130_fd_pr__pfet_g5v0d10v5_7B62CL
Xldo_Cfn_2 ldo_MNX/S2 vout gnd sky130_fd_pr__cap_mim_m3_1_Y3HN7X
Xpor_MI2P vin por_MH/G vin por_MI2P/G gnd sky130_fd_pr__pfet_g5v0d10v5_7B62CL
Xldo_Cfn_3 ldo_MNX/S2 vout gnd sky130_fd_pr__cap_mim_m3_1_Y3HN7X
Xbgr_MNSK gnd bgr_MS2/D bgr_MNSK/S1 bgr_MNB/G5 bgr_MS2/D bgr_MNSK/S1 bgr_MNB/G5 sky130_fd_pr__nfet_05v0_nvt_6T4HWX
Xbgr_MSN gnd bgr_MSN/D bgr_MSN/S bgr_Rf/R2 sky130_fd_pr__nfet_g5v0d10v5_NUFNY9
Xpor_MI1P vin por_MI2P/G vin por_MD/D gnd sky130_fd_pr__pfet_g5v0d10v5_5EJAKB
C0 ldo_MPS/G bgr_R1/R1 0.170843f
C1 ldo_MNB/G bgr_MPO/D3 0.073588f
C2 ldo_MN2/G bgr_MSU3/S 0.145853f
C3 ldo_MN2/G ldo_MPX/S2 0.152882f
C4 vout bgr_MNSK/S1 0.324141f
C5 ldo_MNX/S2 bgr_MS2/D 0.33184f
C6 rstn bgr_MT1/D 0.147175f
C7 bgr_MS2/D bgr_MSU1/S 0.51021f
C8 rstn por_MI2P/G 0.229295f
C9 bgr_MPB/D3 rstn 0.073588f
C10 ldo_MN2/G bgr_MPO/D3 0.071796f
C11 bgr_MNSK/S1 vin 0.325213f
C12 bgr_MNCD/G bgr_MT4/S 0.304503f
C13 ldo_MNB/G vout 13.838746f
C14 ldo_Rsh/R1 bgr_MT4/D 0.128192f
C15 bgr_R1/R2 rstn 0.163775f
C16 rstn bgr_MSN/S 0.147601f
C17 ldo_Rsh/R2 rstn 0.147644f
C18 por_MH/G bgr_MSU1/S 0.064656f
C19 ldo_MPS/G bgr_MNA/S5 0.163987f
C20 bgr_MSU3/S por_MD/G 8.88223f
C21 ldo_MPX/S2 por_MD/G 8.81e-19
C22 bgr_MT3/D bgr_MT4/S 0.457132f
C23 ldo_MNB/G vin 34.56137f
C24 ldo_MN2/G vout 55.688183f
C25 ldo_MPS/G ldo_MP4/G 0.79871f
C26 ldo_Rsh/R1 bgr_MPC/D3 0.064096f
C27 bgr_R2/R1 bgr_MT2/D 0.165216f
C28 bgr_R2/R1 bgr_Rf/R2 0.79133f
C29 bgr_R2/R1 bgr_MNF/G5 4.10922f
C30 bgr_MNB/D4 bgr_MNB/G5 0.659407f
C31 ldo_MN2/G vin 23.962934f
C32 ldo_Rsh/R1 por_MD/D 2.72e-19
C33 ldo_MN2/S ldo_MNB/G 0.834595f
C34 ldo_Rsh/R1 bgr_MPI/D0_3 0.064096f
C35 rstn bgr_MSU2/S 0.137896f
C36 vout por_MD/G 0.644217f
C37 ldo_MN2/S ldo_MN2/G 0.224175f
C38 ldo_MPS/G bgr_MS2/D 0.30857f
C39 ldo_MNX/S2 bgr_MT1/D 0.157726f
C40 bgr_R2/R1 bgr_MPA/D3 1.91e-19
C41 ldo_MN2/G por_MH/D 0.071796f
C42 ldo_MNX/S2 por_MI2P/G 2.06e-19
C43 bgr_MT4/S rstn 0.237449f
C44 bgr_MSU1/S por_MI2P/G 0.070588f
C45 ldo_MNX/S2 bgr_MPB/D3 0.078863f
C46 vin por_MD/G 3.67017f
C47 ldo_Rsh/R1 bgr_MNB/G5 0.410511f
C48 bgr_MNSK/S1 bgr_Rf/R2 0.080112f
C49 bgr_MNCD/G bgr_MSN/D 19.21693f
C50 bgr_R1/R1 bgr_MT4/D 0.414844f
C51 bgr_MNF/G5 bgr_MNSK/S1 0.232154f
C52 ldo_MNX/S2 bgr_R1/R2 0.174113f
C53 ldo_MPS/G por_MH/G 0.015563f
C54 ldo_MNX/S2 bgr_MSN/S 0.157726f
C55 ldo_MNX/S2 ldo_Rsh/R2 12.91623f
C56 bgr_R1/R2 bgr_MSU1/S 1.82e-19
C57 bgr_MSU1/S bgr_MSN/S 0.076108f
C58 bgr_R1/R1 bgr_MPC/D3 0.278349f
C59 ldo_MPX/S2 bgr_MSU3/S 0.156776f
C60 ldo_MNB/G bgr_MT2/D 0.545236f
C61 ldo_MNB/G bgr_Rf/R2 0.472206f
C62 por_MH/D por_MD/G 19.273996f
C63 bgr_MNF/G5 ldo_MNB/G 0.073588f
C64 bgr_MNCD/S bgr_MNB/G5 0.093842f
C65 ldo_MPX/S2 bgr_MPO/D3 0.070151f
C66 ldo_MN2/G bgr_MT2/D 0.225823f
C67 bgr_R1/R1 bgr_MPI/D0_3 0.557906f
C68 ldo_MN2/G bgr_Rf/R2 1.134638f
C69 ldo_MNX/S2 bgr_MSU2/S 0.157726f
C70 ldo_MN2/G bgr_MNF/G5 1.432491f
C71 bgr_MSU1/S bgr_MSU2/S 14.113523f
C72 bgr_MPA/D3 ldo_MNB/G 0.256798f
C73 ldo_MPS/G bgr_MT1/D 0.128192f
C74 bgr_MSU3/S vout 0.643301f
C75 ldo_MPX/S2 vout 15.676232f
C76 bgr_MNCD/G bgr_MT3/D 0.064422f
C77 ldo_MPS/G por_MI2P/G 0.019716f
C78 ldo_MNX/S2 bgr_MT4/S 0.253063f
C79 bgr_MSN/D rstn 0.31743f
C80 ldo_MPS/G bgr_MPB/D3 0.064096f
C81 bgr_R1/R1 bgr_MNB/G5 0.594903f
C82 ldo_MN2/G bgr_MPA/D3 0.162236f
C83 bgr_MSU3/S vin 3.496164f
C84 bgr_MPO/D3 vout 0.321651f
C85 ldo_MPX/S2 vin 8.39943f
C86 ldo_MPS/G bgr_R1/R2 0.154283f
C87 bgr_MS2/D bgr_MT4/D 2.26513f
C88 ldo_MPS/G bgr_MSN/S 0.147601f
C89 ldo_MPS/G ldo_Rsh/R2 4.225102f
C90 bgr_MPO/D3 vin 2.392287f
C91 ldo_MN2/S ldo_MPX/S2 6.18975f
C92 bgr_MS2/D bgr_MPC/D3 25.44779f
C93 bgr_MSU3/S por_MH/D 0.065047f
C94 ldo_MPX/S2 por_MH/D 2.75e-19
C95 bgr_MNB/G5 bgr_MNA/S5 18.56952f
C96 bgr_MNCD/G rstn 0.23033f
C97 ldo_MPS/G bgr_MSU2/S 0.143952f
C98 vout vin 0.492863p
C99 rstn ldo_MPS/D 0.147644f
C100 bgr_MS2/D bgr_MPI/D0_3 50.802265f
C101 bgr_R2/R1 ldo_Rsh/R1 0.064096f
C102 bgr_MT3/D rstn 0.147175f
C103 ldo_MN2/S vout 3.290896f
C104 ldo_MNX/S2 bgr_MSN/D 0.347386f
C105 ldo_MPS/G bgr_MT4/S 0.218465f
C106 por_MH/G por_MD/D 55.450825f
C107 bgr_MSN/D bgr_MSU1/S 57.21566f
C108 por_MH/D vout 0.56527f
C109 bgr_MS2/D bgr_MNB/G5 20.9179f
C110 ldo_MN2/S vin 3.294927f
C111 ldo_MPX/S2 bgr_MT2/D 0.140303f
C112 ldo_MPX/S2 bgr_Rf/R2 0.156689f
C113 bgr_MT1/D bgr_MT4/D 0.157087f
C114 ldo_MPX/S2 bgr_MNF/G5 0.235983f
C115 por_MH/D vin 1.381918f
C116 bgr_MPB/D3 bgr_MT4/D 0.071973f
C117 bgr_MPO/D3 bgr_MT2/D 0.064422f
C118 bgr_MPO/D3 bgr_Rf/R2 4.60435f
C119 ldo_Rsh/R1 bgr_MNSK/S1 0.064096f
C120 bgr_MNF/G5 bgr_MPO/D3 0.237991f
C121 ldo_MN2/G bgr_MNB/D4 0.162661f
C122 bgr_MPC/D3 bgr_MT1/D 0.073824f
C123 bgr_R1/R2 bgr_MT4/D 0.169667f
C124 ldo_MNX/S2 bgr_MNCD/G 0.245732f
C125 bgr_MPA/D3 ldo_MPX/S2 0.258627f
C126 bgr_MPB/D3 bgr_MPC/D3 8.0123f
C127 bgr_MNCD/G bgr_MSU1/S 0.787782f
C128 vout bgr_MT2/D 0.64634f
C129 ldo_MNX/S2 ldo_MPS/D 0.889711f
C130 vout bgr_Rf/R2 0.750172f
C131 ldo_Rsh/R1 ldo_MNB/G 0.640982f
C132 bgr_MPI/D0_3 bgr_MT1/D 0.074239f
C133 bgr_R2/R1 bgr_R1/R1 0.097694f
C134 por_MD/D por_MI2P/G 0.542222f
C135 ldo_MNX/S2 bgr_MT3/D 0.157726f
C136 bgr_MNF/G5 vout 1.242829f
C137 bgr_R1/R2 bgr_MPC/D3 4.49332f
C138 bgr_MPA/D3 bgr_MPO/D3 8.67e-19
C139 bgr_MPB/D3 bgr_MPI/D0_3 0.005517f
C140 bgr_MT2/D vin 2.092336f
C141 bgr_MNCD/S bgr_MNSK/S1 0.102918f
C142 vin bgr_Rf/R2 6.748343f
C143 ldo_MN2/G ldo_Rsh/R1 0.714676f
C144 ldo_MPS/G bgr_MSN/D 0.323485f
C145 bgr_MNF/G5 vin 4.229341f
C146 bgr_R1/R2 bgr_MPI/D0_3 0.557627f
C147 bgr_MNB/G5 bgr_MT1/D 0.0751f
C148 bgr_MPA/D3 vout 3.3664f
C149 bgr_MPB/D3 bgr_MNB/G5 4.24527f
C150 bgr_MT4/S bgr_MT4/D 8.899014f
C151 bgr_MPA/D3 vin 4.469138f
C152 bgr_R1/R1 bgr_MNSK/S1 0.119241f
C153 ldo_Rsh/R1 por_MD/G 0.001624f
C154 ldo_MNX/S2 rstn 0.073588f
C155 bgr_MNCD/S ldo_MN2/G 0.162786f
C156 por_MD/D bgr_MSU2/S 0.391364f
C157 bgr_R1/R2 bgr_MNB/G5 3.390391f
C158 bgr_MSU1/S rstn 0.211696f
C159 bgr_MNB/G5 bgr_MSN/S 0.096595f
C160 bgr_MPC/D3 bgr_MT4/S 0.231329f
C161 ldo_MPS/G bgr_MNCD/G 0.220839f
C162 ldo_MN2/S bgr_MPA/D3 0.372096f
C163 bgr_R1/R1 ldo_MNB/G 0.550083f
C164 ldo_MPS/G ldo_MPS/D 4.585765f
C165 ldo_MPS/G bgr_MT3/D 0.128192f
C166 bgr_MT4/S bgr_MPI/D0_3 0.463434f
C167 bgr_MS2/D bgr_R2/R1 0.017473f
C168 ldo_MN2/G bgr_R1/R1 0.284319f
C169 bgr_MNSK/S1 bgr_MNA/S5 6.512632f
C170 bgr_MT2/D bgr_Rf/R2 0.4003f
C171 bgr_MNF/G5 bgr_MT2/D 0.065608f
C172 ldo_MPX/S2 bgr_MNB/D4 0.140303f
C173 bgr_MNF/G5 bgr_Rf/R2 0.123576f
C174 bgr_MT4/S bgr_MNB/G5 0.322996f
C175 ldo_MNB/G ldo_MP4/G 0.255387f
C176 bgr_MPA/D3 bgr_MT2/D 0.064096f
C177 ldo_MN2/G bgr_MNA/S5 0.162786f
C178 ldo_MPS/G rstn 1.30953f
C179 bgr_MPA/D3 bgr_MNF/G5 4.09942f
C180 ldo_Rsh/R1 bgr_MSU3/S 0.144665f
C181 ldo_MNX/S2 bgr_MSU1/S 0.23659f
C182 bgr_MS2/D bgr_MNSK/S1 5.00875f
C183 ldo_Rsh/R1 ldo_MPX/S2 36.794056f
C184 ldo_MN2/G ldo_MP4/G 0.370898f
C185 bgr_MNB/D4 vout 0.645209f
C186 ldo_Rsh/R1 bgr_MPO/D3 0.064096f
C187 bgr_MNB/D4 vin 0.645616f
C188 bgr_MSN/D por_MD/D 0.405029f
C189 bgr_MS2/D ldo_MNB/G 40.459385f
C190 bgr_R2/R1 bgr_MT1/D 37.269764f
C191 bgr_MNCD/G bgr_MT4/D 0.072209f
C192 bgr_MS2/D ldo_MN2/G 0.651314f
C193 bgr_MPB/D3 bgr_R2/R1 3.33e-19
C194 bgr_MNCD/S ldo_MPX/S2 0.156689f
C195 ldo_Rsh/R1 vout 4.750213f
C196 bgr_MT3/D bgr_MT4/D 70.84414f
C197 bgr_MNCD/G bgr_MPC/D3 5.536631f
C198 bgr_R2/R1 bgr_R1/R2 0.097741f
C199 ldo_Rsh/R1 vin 10.819161f
C200 ldo_MN2/G por_MH/G 0.145853f
C201 bgr_MPC/D3 bgr_MT3/D 0.064096f
C202 bgr_MNCD/G bgr_MPI/D0_3 2.85676f
C203 ldo_MPS/G ldo_MNX/S2 17.956303f
C204 bgr_R1/R1 ldo_MPX/S2 0.17325f
C205 ldo_MPS/G bgr_MSU1/S 0.217752f
C206 bgr_MNCD/S vout 0.750172f
C207 ldo_MN2/S ldo_Rsh/R1 9.277821f
C208 ldo_Rsh/R1 por_MH/D 4.4e-19
C209 bgr_MT3/D bgr_MPI/D0_3 0.064454f
C210 bgr_R1/R1 bgr_MPO/D3 0.278236f
C211 bgr_MNCD/S vin 0.752846f
C212 ldo_MNB/G bgr_MT1/D 0.545236f
C213 rstn bgr_MT4/D 0.147175f
C214 bgr_MNB/D4 bgr_Rf/R2 0.815622f
C215 bgr_MNCD/G bgr_MNB/G5 13.984f
C216 bgr_R1/R2 bgr_MNSK/S1 0.123392f
C217 por_MH/G por_MD/G 0.171293f
C218 bgr_MNSK/S1 bgr_MSN/S 15.240364f
C219 bgr_MNF/G5 bgr_MNB/D4 0.320789f
C220 bgr_MPB/D3 ldo_MNB/G 0.073588f
C221 bgr_R2/R1 bgr_MT4/S 0.292832f
C222 ldo_MPX/S2 bgr_MNA/S5 0.156689f
C223 bgr_R1/R1 vout 0.858173f
C224 ldo_MN2/G bgr_MT1/D 0.225823f
C225 bgr_MPC/D3 rstn 0.073588f
C226 bgr_MT3/D bgr_MNB/G5 0.064573f
C227 ldo_MN2/G por_MI2P/G 0.145853f
C228 ldo_MPX/S2 ldo_MP4/G 0.219886f
C229 bgr_R1/R2 ldo_MNB/G 0.51713f
C230 bgr_MPB/D3 ldo_MN2/G 0.071796f
C231 ldo_Rsh/R2 ldo_MNB/G 0.268292f
C232 bgr_R1/R1 vin 2.749615f
C233 por_MD/D rstn 29.716444f
C234 ldo_Rsh/R1 bgr_MT2/D 0.128192f
C235 ldo_Rsh/R1 bgr_Rf/R2 0.144578f
C236 rstn bgr_MPI/D0_3 0.073588f
C237 ldo_Rsh/R1 bgr_MNF/G5 0.217817f
C238 ldo_MN2/G bgr_R1/R2 0.256074f
C239 ldo_MN2/G bgr_MSN/S 0.146399f
C240 ldo_MN2/G ldo_Rsh/R2 0.412681f
C241 vout bgr_MNA/S5 0.750172f
C242 bgr_MS2/D ldo_MPX/S2 0.296992f
C243 por_MI2P/G por_MD/G 27.380116f
C244 bgr_MT4/S bgr_MNSK/S1 0.078021f
C245 vout ldo_MP4/G 2.821965f
C246 rstn bgr_MNB/G5 0.458519f
C247 ldo_Rsh/R1 bgr_MPA/D3 0.341582f
C248 vin bgr_MNA/S5 0.758179f
C249 ldo_MNX/S2 bgr_MT4/D 0.157726f
C250 bgr_MS2/D bgr_MPO/D3 25.456089f
C251 ldo_MN2/G bgr_MSU2/S 0.161556f
C252 bgr_MNCD/S bgr_Rf/R2 2.556171f
C253 vin ldo_MP4/G 7.638774f
C254 bgr_MNCD/S bgr_MNF/G5 0.531319f
C255 bgr_MT4/S ldo_MNB/G 0.544884f
C256 bgr_MSU3/S por_MH/G 0.185902f
C257 ldo_MPX/S2 por_MH/G 2.72e-19
C258 ldo_MNX/S2 bgr_MPC/D3 0.078863f
C259 ldo_MN2/G bgr_MT4/S 0.309936f
C260 bgr_MS2/D vout 1.86595f
C261 ldo_MN2/S ldo_MP4/G 2.970858f
C262 bgr_R1/R1 bgr_MT2/D 0.080569f
C263 bgr_R1/R1 bgr_Rf/R2 0.56672f
C264 ldo_MNX/S2 bgr_MPI/D0_3 0.078863f
C265 por_MD/D bgr_MSU1/S 0.066851f
C266 bgr_MSU2/S por_MD/G 0.18376f
C267 bgr_R1/R1 bgr_MNF/G5 0.356933f
C268 bgr_MS2/D vin 53.32715f
C269 por_MH/G vout 0.876945f
C270 bgr_R2/R1 bgr_MNCD/G 4.20091f
C271 ldo_MPX/S2 bgr_MT1/D 0.140303f
C272 bgr_MSU3/S por_MI2P/G 0.184003f
C273 ldo_MPX/S2 por_MI2P/G 3.75e-19
C274 por_MH/G vin 11.354483f
C275 ldo_MNX/S2 bgr_MNB/G5 0.484348f
C276 bgr_R1/R1 bgr_MPA/D3 0.283717f
C277 bgr_MPB/D3 ldo_MPX/S2 0.070151f
C278 ldo_MPS/G bgr_MT4/D 0.128192f
C279 bgr_R2/R1 bgr_MT3/D 0.163199f
C280 bgr_MNA/S5 bgr_Rf/R2 0.176611f
C281 bgr_MPO/D3 bgr_MT1/D 0.074065f
C282 bgr_MNF/G5 bgr_MNA/S5 0.1749f
C283 ldo_MPX/S2 bgr_R1/R2 0.156689f
C284 ldo_MPX/S2 bgr_MSN/S 0.140303f
C285 bgr_MPB/D3 bgr_MPO/D3 0.002248f
C286 ldo_MPX/S2 ldo_Rsh/R2 0.901159f
C287 ldo_MPS/G bgr_MPC/D3 0.064096f
C288 por_MH/G por_MH/D 0.163197f
C289 ldo_MN2/G bgr_MSN/D 0.317321f
C290 vout bgr_MT1/D 1.04032f
C291 ldo_Rsh/R1 bgr_MNB/D4 0.128192f
C292 bgr_R1/R2 bgr_MPO/D3 0.283749f
C293 bgr_MNCD/G bgr_MNSK/S1 0.073588f
C294 por_MI2P/G vout 0.797784f
C295 ldo_MPS/G por_MD/D 0.012855f
C296 bgr_MPB/D3 vout 0.321651f
C297 ldo_MPS/G bgr_MPI/D0_3 0.064096f
C298 bgr_MPA/D3 ldo_MP4/G 0.265241f
C299 bgr_MT1/D vin 2.416066f
C300 bgr_MSU3/S bgr_MSU2/S 24.599802f
C301 ldo_MPX/S2 bgr_MSU2/S 0.140303f
C302 bgr_MS2/D bgr_MT2/D 2.27696f
C303 bgr_MS2/D bgr_Rf/R2 20.40193f
C304 por_MI2P/G vin 5.327387f
C305 bgr_R2/R1 rstn 0.073588f
C306 bgr_MS2/D bgr_MNF/G5 48.94292f
C307 bgr_R1/R2 vout 0.750172f
C308 vout bgr_MSN/S 0.643301f
C309 bgr_MPB/D3 vin 2.083989f
C310 ldo_Rsh/R2 vout 2.284792f
C311 bgr_MNCD/G ldo_MNB/G 0.584735f
C312 bgr_MSN/D por_MD/G 1.95887f
C313 ldo_MNB/G ldo_MPS/D 0.188761f
C314 bgr_MNCD/S bgr_MNB/D4 0.380067f
C315 bgr_R1/R2 vin 1.913846f
C316 ldo_MPX/S2 bgr_MT4/S 0.226927f
C317 ldo_MPS/G bgr_MNB/G5 0.449329f
C318 vin bgr_MSN/S 0.645795f
C319 bgr_MT3/D ldo_MNB/G 0.545236f
C320 ldo_MN2/G bgr_MNCD/G 0.529898f
C321 ldo_Rsh/R2 vin 8.924252f
C322 por_MH/D por_MI2P/G 22.993824f
C323 bgr_MS2/D bgr_MPA/D3 26.771738f
C324 ldo_MN2/G ldo_MPS/D 0.074097f
C325 bgr_MT4/S bgr_MPO/D3 0.231005f
C326 vout bgr_MSU2/S 0.64499f
C327 ldo_MN2/G bgr_MT3/D 0.225823f
C328 ldo_MN2/S ldo_Rsh/R2 0.245391f
C329 rstn bgr_MNSK/S1 0.0738f
C330 bgr_MSU2/S vin 4.92441f
C331 bgr_MNCD/S ldo_Rsh/R1 0.144578f
C332 bgr_MT4/S vout 12.5227f
C333 ldo_MNB/G rstn 3.35006f
C334 bgr_MT2/D bgr_MT1/D 72.13539f
C335 bgr_MT1/D bgr_Rf/R2 0.400078f
C336 bgr_MPC/D3 bgr_MT4/D 0.071973f
C337 ldo_MNX/S2 bgr_R2/R1 0.078863f
C338 bgr_MT4/S vin 2.588655f
C339 bgr_MNF/G5 bgr_MT1/D 0.075622f
C340 por_MH/D bgr_MSU2/S 2.84e-19
C341 bgr_MPB/D3 bgr_MT2/D 0.064096f
C342 ldo_MN2/G rstn 0.071988f
C343 ldo_Rsh/R1 bgr_R1/R1 0.161139f
C344 bgr_MPB/D3 bgr_MNF/G5 1.976841f
C345 bgr_MPI/D0_3 bgr_MT4/D 0.071973f
C346 bgr_MSU3/S bgr_MSN/D 2.998732f
C347 ldo_MPX/S2 bgr_MSN/D 0.312539f
C348 bgr_R1/R2 bgr_MT2/D 0.064096f
C349 bgr_R1/R2 bgr_Rf/R2 0.572627f
C350 bgr_Rf/R2 bgr_MSN/S 0.157968f
C351 bgr_R1/R2 bgr_MNF/G5 0.341358f
C352 bgr_MNF/G5 bgr_MSN/S 0.456908f
C353 bgr_MPA/D3 bgr_MT1/D 0.073588f
C354 bgr_MPC/D3 bgr_MPI/D0_3 17.0151f
C355 bgr_MPB/D3 bgr_MPA/D3 4.92594f
C356 bgr_MNB/G5 bgr_MT4/D 0.072299f
C357 ldo_MNX/S2 bgr_MNSK/S1 0.078863f
C358 rstn por_MD/G 0.152966f
C359 bgr_MNCD/S bgr_R1/R1 0.1176f
C360 ldo_Rsh/R1 bgr_MNA/S5 0.144578f
C361 bgr_MPA/D3 bgr_R1/R2 5.32107f
C362 bgr_MPA/D3 ldo_Rsh/R2 0.277518f
C363 bgr_MSN/D vout 1.45366f
C364 bgr_MS2/D bgr_MNB/D4 0.320025f
C365 ldo_Rsh/R1 ldo_MP4/G 0.316976f
C366 bgr_MNCD/G ldo_MPX/S2 0.219596f
C367 bgr_MPC/D3 bgr_MNB/G5 0.25023f
C368 ldo_MNX/S2 ldo_MNB/G 0.633536f
C369 ldo_MPS/G bgr_R2/R1 0.064096f
C370 bgr_MSN/D vin 11.66764f
C371 ldo_MPX/S2 ldo_MPS/D 0.157226f
C372 bgr_MT4/S bgr_MT2/D 0.457355f
C373 ldo_MPX/S2 bgr_MT3/D 0.140303f
C374 bgr_MNCD/G bgr_MPO/D3 10.8904f
C375 bgr_MT4/S bgr_Rf/R2 0.492119f
C376 bgr_MT4/S bgr_MNF/G5 0.293187f
C377 bgr_MPI/D0_3 bgr_MNB/G5 0.237991f
C378 ldo_MNX/S2 ldo_MN2/G 1.131655f
C379 bgr_MNCD/S bgr_MNA/S5 0.023704f
C380 ldo_MN2/G bgr_MSU1/S 0.217649f
C381 bgr_MT3/D bgr_MPO/D3 0.064332f
C382 bgr_MS2/D ldo_Rsh/R1 0.273289f
C383 bgr_MSN/D por_MH/D 8.66e-20
C384 bgr_MNCD/G vout 1.025319f
C385 bgr_MPA/D3 bgr_MT4/S 1.69676f
C386 vout ldo_MPS/D 3.03296f
C387 bgr_MT3/D vout 0.645522f
C388 bgr_MNCD/G vin 6.098502f
C389 ldo_Rsh/R1 por_MH/G 3.75e-19
C390 ldo_MNX/S2 por_MD/G 3.75e-19
C391 ldo_MPS/G bgr_MNSK/S1 0.0738f
C392 bgr_R1/R1 bgr_MNA/S5 0.137737f
C393 bgr_MSU1/S por_MD/G 0.076607f
C394 bgr_MSU3/S rstn 0.137896f
C395 ldo_MPX/S2 rstn 0.073588f
C396 vin ldo_MPS/D 15.2238f
C397 bgr_MNCD/S bgr_MS2/D 0.155331f
C398 bgr_MT3/D vin 2.092286f
C399 ldo_MPS/G ldo_MNB/G 58.77746f
C400 rstn bgr_MPO/D3 0.073588f
C401 ldo_MN2/S ldo_MPS/D 4.110057f
C402 bgr_MSN/D bgr_Rf/R2 0.182233f
C403 bgr_MSN/D bgr_MNF/G5 0.07208f
C404 bgr_R1/R2 bgr_MNB/D4 14.158496f
C405 bgr_MNB/D4 bgr_MSN/S 0.320025f
C406 ldo_MPS/G ldo_MN2/G 3.855996f
C407 bgr_MS2/D bgr_R1/R1 1.508401f
C408 rstn vout 10.832535f
C409 ldo_Rsh/R1 bgr_MT1/D 0.128192f
C410 bgr_R2/R1 bgr_MT4/D 0.170431f
C411 ldo_Rsh/R1 por_MI2P/G 5.5e-19
C412 bgr_MPB/D3 ldo_Rsh/R1 0.064096f
C413 rstn vin 58.0383f
C414 bgr_R2/R1 bgr_MPC/D3 4.63e-19
C415 ldo_MPS/G por_MD/G 3.11143f
C416 ldo_Rsh/R1 bgr_R1/R2 0.144578f
C417 bgr_MNCD/G bgr_MT2/D 0.064573f
C418 ldo_Rsh/R1 bgr_MSN/S 0.128192f
C419 ldo_Rsh/R1 ldo_Rsh/R2 9.267134f
C420 bgr_MNCD/G bgr_Rf/R2 2.133121f
C421 ldo_MNX/S2 bgr_MSU3/S 0.1742f
C422 bgr_MNCD/G bgr_MNF/G5 19.451126f
C423 ldo_MNX/S2 ldo_MPX/S2 32.84047f
C424 bgr_MSU3/S bgr_MSU1/S 0.097161f
C425 bgr_MS2/D bgr_MNA/S5 5.75221f
C426 ldo_MPX/S2 bgr_MSU1/S 0.210454f
C427 ldo_MN2/S rstn 0.073588f
C428 bgr_MS2/D ldo_MP4/G 4.594201f
C429 bgr_R2/R1 bgr_MPI/D0_3 0.001164f
C430 por_MH/D rstn 0.141218f
C431 bgr_MT3/D bgr_MT2/D 71.73089f
C432 bgr_MT3/D bgr_Rf/R2 0.400965f
C433 bgr_MT3/D bgr_MNF/G5 0.06486f
C434 ldo_MNX/S2 bgr_MPO/D3 0.078863f
C435 ldo_Rsh/R1 bgr_MSU2/S 0.128192f
C436 bgr_MNCD/G bgr_MPA/D3 4.84e-19
C437 bgr_MNCD/S bgr_R1/R2 0.101521f
C438 bgr_MNCD/S bgr_MSN/S 31.868177f
C439 bgr_MPA/D3 ldo_MPS/D 0.256446f
C440 ldo_MNX/S2 vout 13.627312f
C441 bgr_R1/R1 bgr_MT1/D 0.090061f
C442 bgr_R2/R1 bgr_MNB/G5 1.67507f
C443 ldo_MNB/G bgr_MT4/D 0.545236f
C444 bgr_MSU1/S vout 0.964952f
C445 bgr_MPA/D3 bgr_MT3/D 0.064096f
C446 ldo_Rsh/R1 bgr_MT4/S 0.208761f
C447 bgr_MPB/D3 bgr_R1/R1 0.278601f
C448 ldo_MNX/S2 vin 11.903499f
C449 ldo_MN2/G bgr_MT4/D 0.225823f
C450 bgr_MSU1/S vin 3.578352f
C451 rstn bgr_MT2/D 0.147175f
C452 bgr_MPC/D3 ldo_MNB/G 2.259231f
C453 rstn bgr_Rf/R2 0.163775f
C454 bgr_MNF/G5 rstn 0.246717f
C455 bgr_R1/R1 bgr_R1/R2 3.723171f
C456 bgr_R1/R1 bgr_MSN/S 0.010403f
C457 ldo_MPS/G bgr_MSU3/S 0.160425f
C458 ldo_MPS/G ldo_MPX/S2 3.715064f
C459 ldo_MN2/G bgr_MPC/D3 0.071796f
C460 ldo_MN2/S ldo_MNX/S2 14.485394f
C461 ldo_MNB/G bgr_MPI/D0_3 10.79654f
C462 ldo_MNX/S2 por_MH/D 1.36e-19
C463 bgr_MSN/D bgr_MNB/D4 0.385672f
C464 bgr_MNCD/S bgr_MT4/S 5.908823f
C465 por_MH/D bgr_MSU1/S 1.45e-19
C466 bgr_MNB/G5 bgr_MNSK/S1 0.284983f
C467 ldo_MPS/G bgr_MPO/D3 0.064096f
C468 ldo_MN2/G por_MD/D 0.162326f
C469 bgr_MPA/D3 rstn 0.163649f
C470 ldo_MN2/G bgr_MPI/D0_3 0.071796f
C471 bgr_R1/R2 bgr_MNA/S5 2.79783f
C472 bgr_MNA/S5 bgr_MSN/S 1.350109f
C473 ldo_MNB/G bgr_MNB/G5 0.175002f
C474 ldo_Rsh/R2 ldo_MP4/G 0.328125f
C475 ldo_MPS/G vout 15.654761f
C476 bgr_R1/R1 bgr_MT4/S 41.83953f
C477 bgr_MS2/D bgr_MT1/D 22.4843f
C478 ldo_Rsh/R1 bgr_MSN/D 0.288317f
C479 ldo_MN2/G bgr_MNB/G5 7.805263f
C480 por_MD/D por_MD/G 0.5446f
C481 ldo_MPS/G vin 15.240517f
C482 bgr_MNCD/G bgr_MNB/D4 3.576538f
C483 ldo_MNX/S2 bgr_MT2/D 0.157726f
C484 bgr_MS2/D bgr_MPB/D3 25.449575f
C485 ldo_MNX/S2 bgr_Rf/R2 0.174113f
C486 ldo_MNX/S2 bgr_MNF/G5 0.262119f
C487 bgr_MSU1/S bgr_Rf/R2 19.547653f
C488 bgr_MNF/G5 bgr_MSU1/S 0.078923f
C489 bgr_MS2/D bgr_R1/R2 0.210795f
C490 bgr_MS2/D ldo_Rsh/R2 0.001426f
C491 bgr_MS2/D bgr_MSN/S 1.292661f
C492 ldo_MN2/S ldo_MPS/G 3.76989f
C493 por_MH/G por_MI2P/G 58.556534f
C494 ldo_MPS/G por_MH/D 0.026083f
C495 bgr_MT4/S bgr_MNA/S5 0.086608f
C496 bgr_MNCD/S bgr_MSN/D 0.111751f
C497 ldo_MNX/S2 bgr_MPA/D3 0.345558f
C498 ldo_Rsh/R1 bgr_MNCD/G 0.20143f
C499 ldo_MPX/S2 bgr_MT4/D 0.140303f
C500 ldo_Rsh/R1 ldo_MPS/D 0.257833f
C501 ldo_Rsh/R1 bgr_MT3/D 0.128192f
C502 bgr_MPO/D3 bgr_MT4/D 0.072152f
C503 ldo_MPX/S2 bgr_MPC/D3 0.070151f
C504 bgr_MNB/D4 rstn 0.147601f
C505 bgr_MS2/D bgr_MT4/S 19.729967f
C506 por_MH/G bgr_MSU2/S 0.185601f
C507 bgr_MNCD/S bgr_MNCD/G 1.308202f
C508 ldo_MPS/G bgr_MT2/D 0.128192f
C509 bgr_MSU3/S por_MD/D 0.391515f
C510 bgr_MPB/D3 bgr_MT1/D 0.073767f
C511 ldo_MPS/G bgr_Rf/R2 0.154283f
C512 ldo_MPX/S2 por_MD/D 2.06e-19
C513 bgr_MPC/D3 bgr_MPO/D3 0.270427f
C514 ldo_MPS/G bgr_MNF/G5 0.237226f
C515 ldo_MPX/S2 bgr_MPI/D0_3 0.070151f
C516 vout bgr_MT4/D 0.644995f
C517 bgr_R1/R2 bgr_MT1/D 0.073588f
C518 bgr_MPI/D0_3 bgr_MPO/D3 11.2226f
C519 vin bgr_MT4/D 2.124756f
C520 bgr_MPB/D3 bgr_R1/R2 1.97049f
C521 bgr_MPC/D3 vout 0.321651f
C522 ldo_Rsh/R1 rstn 0.156967f
C523 bgr_R2/R1 ldo_MNB/G 0.533956f
C524 bgr_MNCD/G bgr_R1/R1 0.368228f
C525 ldo_MPS/G bgr_MPA/D3 0.594616f
C526 ldo_MPX/S2 bgr_MNB/G5 0.440789f
C527 por_MD/D vout 0.92771f
C528 bgr_R1/R2 bgr_MSN/S 0.477511f
C529 bgr_MPC/D3 vin 2.947839f
C530 bgr_MPI/D0_3 vout 0.321651f
C531 ldo_MN2/G bgr_R2/R1 0.167926f
C532 bgr_R1/R1 bgr_MT3/D 0.080569f
C533 bgr_MPO/D3 bgr_MNB/G5 1.968301f
C534 por_MI2P/G bgr_MSU2/S 0.183294f
C535 por_MD/D vin 2.852642f
C536 bgr_MPI/D0_3 vin 3.997761f
C537 bgr_MNCD/S rstn 0.163987f
C538 ldo_MNX/S2 bgr_MNB/D4 0.157726f
C539 bgr_MNB/D4 bgr_MSU1/S 14.234329f
C540 bgr_MS2/D bgr_MSN/D 21.382858f
C541 bgr_MNCD/G bgr_MNA/S5 0.196596f
C542 bgr_MT4/S bgr_MT1/D 2.41798f
C543 vout bgr_MNB/G5 2.134832f
C544 bgr_MPB/D3 bgr_MT4/S 0.231742f
C545 por_MD/D por_MH/D 0.19152f
C546 ldo_MP4/G ldo_MPS/D 24.1067f
C547 bgr_MNB/G5 vin 15.496812f
C548 ldo_MN2/G bgr_MNSK/S1 0.110588f
C549 bgr_MSN/D por_MH/G 0.201363f
C550 bgr_R1/R1 rstn 0.180335f
C551 bgr_R1/R2 bgr_MT4/S 25.2657f
C552 ldo_MNX/S2 ldo_Rsh/R1 7.208094f
C553 bgr_MT4/S bgr_MSN/S 4.518501f
C554 bgr_MT2/D bgr_MT4/D 0.16158f
C555 bgr_MT4/D bgr_Rf/R2 22.18475f
C556 ldo_Rsh/R1 bgr_MSU1/S 0.192287f
C557 bgr_MNF/G5 bgr_MT4/D 0.07245f
C558 bgr_MS2/D bgr_MNCD/G 20.724936f
C559 ldo_MN2/G ldo_MNB/G 1.270768f
C560 bgr_MPC/D3 bgr_MT2/D 0.064275f
C561 bgr_MPC/D3 bgr_Rf/R2 0.266476f
C562 bgr_MPC/D3 bgr_MNF/G5 0.23767f
C563 bgr_MS2/D ldo_MPS/D 11.208927f
C564 bgr_MS2/D bgr_MT3/D 2.27489f
C565 bgr_MPA/D3 bgr_MT4/D 0.071973f
C566 rstn bgr_MNA/S5 0.163987f
C567 ldo_MNX/S2 bgr_MNCD/S 0.174113f
C568 ldo_MPS/G bgr_MNB/D4 0.147601f
C569 bgr_MPI/D0_3 bgr_MT2/D 0.064568f
C570 bgr_MNCD/S bgr_MSU1/S 0.091191f
C571 bgr_MPI/D0_3 bgr_Rf/R2 1.968311f
C572 bgr_MNF/G5 bgr_MPI/D0_3 0.237769f
C573 rstn ldo_MP4/G 0.147644f
C574 bgr_MSN/D por_MI2P/G 0.199003f
C575 bgr_MPA/D3 bgr_MPC/D3 0.004403f
C576 bgr_R2/R1 ldo_MPX/S2 0.070151f
C577 bgr_MT2/D bgr_MNB/G5 0.06486f
C578 bgr_MNB/G5 bgr_Rf/R2 0.43388f
C579 ldo_MN2/G por_MD/G 0.145853f
C580 ldo_MNX/S2 bgr_R1/R1 0.190673f
C581 bgr_MPA/D3 bgr_MPI/D0_3 0.001677f
C582 bgr_R1/R2 bgr_MSN/D 2.77e-19
C583 bgr_MSN/D bgr_MSN/S 0.271474f
C584 bgr_MNF/G5 bgr_MNB/G5 11.0002f
C585 ldo_MPS/G ldo_Rsh/R1 59.189625f
C586 bgr_R2/R1 bgr_MPO/D3 0.001122f
C587 bgr_MS2/D rstn 0.394574f
C588 bgr_MNCD/G bgr_MT1/D 0.074352f
C589 bgr_MPA/D3 bgr_MNB/G5 3.3e-19
C590 bgr_MPB/D3 bgr_MNCD/G 0.001029f
C591 bgr_R2/R1 vout 0.321651f
C592 bgr_MSN/D bgr_MSU2/S 8.523878f
C593 bgr_MT3/D bgr_MT1/D 0.153703f
C594 por_MH/G rstn 1.948907f
C595 ldo_MNX/S2 bgr_MNA/S5 0.174113f
C596 ldo_MPS/G bgr_MNCD/S 0.163987f
C597 ldo_MPX/S2 bgr_MNSK/S1 0.070151f
C598 bgr_MNCD/G bgr_R1/R2 1.66529f
C599 bgr_MPB/D3 bgr_MT3/D 0.064096f
C600 ldo_MNX/S2 ldo_MP4/G 0.001426f
C601 bgr_MNCD/G bgr_MSN/S 18.024992f
C602 bgr_R2/R1 vin 1.509875f
C603 ldo_Rsh/R2 ldo_MPS/D 34.7432f
C604 bgr_R1/R2 bgr_MT3/D 0.437424f
C605 ldo_MPX/S2 ldo_MNB/G 0.076162f
C606 por_MI2P/G gnd 17.464622f
C607 bgr_MSN/S gnd 9.673849f
C608 bgr_Rf/R2 gnd 52.431274f
C609 vout gnd 0.20388p
C610 ldo_MNX/S2 gnd 0.152881p
C611 por_MH/G gnd 20.076271f
C612 rstn gnd 33.364025f
C613 bgr_MPI/D0_3 gnd 31.305677f
C614 ldo_MNB/G gnd 0.128715p
C615 ldo_MN2/S gnd 34.467594f
C616 ldo_MPS/G gnd 44.993057f
C617 ldo_MP4/G gnd 37.451637f
C618 ldo_MPX/S2 gnd 78.47292f
C619 bgr_R1/R2 gnd 12.237084f
C620 bgr_MNB/G5 gnd 0.191923p
C621 bgr_MNA/S5 gnd 7.502688f
C622 bgr_MPB/D3 gnd 15.630874f
C623 bgr_MPC/D3 gnd 17.640774f
C624 ldo_MPS/D gnd 33.570152f
C625 ldo_Rsh/R2 gnd 17.18667f
C626 por_MD/D gnd 17.868414f
C627 bgr_MSU3/S gnd 46.53367f
C628 bgr_MSN/D gnd 25.713915f
C629 por_MD/G gnd 36.20186f
C630 por_MH/D gnd 18.87944f
C631 bgr_MSU1/S gnd 27.241903f
C632 bgr_MSU2/S gnd 22.569653f
C633 bgr_MNSK/S1 gnd 8.581661f
C634 bgr_R1/R1 gnd 18.848726f
C635 bgr_MT4/D gnd 55.453156f
C636 bgr_MT3/D gnd 25.432686f
C637 bgr_MT2/D gnd 25.867996f
C638 ldo_Rsh/R1 gnd 36.580944f
C639 bgr_MT1/D gnd 29.108677f
C640 bgr_MT4/S gnd 31.654644f
C641 bgr_R2/R1 gnd 22.507309f
C642 bgr_MNB/D4 gnd 29.305902f
C643 bgr_MNF/G5 gnd 0.101353p
C644 bgr_MNCD/G gnd 0.107309p
C645 bgr_MNCD/S gnd 12.671143f
C646 vin gnd 2.385004p
C647 ldo_MN2/G gnd 59.49281f
C648 bgr_MS2/D gnd 0.226235p
C649 bgr_MPA/D3 gnd 65.93936f
C650 bgr_MPO/D3 gnd 16.084173f
.ends
