.subckt ldo_top vin vout rstn gnd
Xldo_MNB nbx nbx gnd gnd sky130_fd_pr__nfet_g5v0d10v5 W=2.0 L=4.0 nf=1 m=1
Xldo_MN5 ldo_tail nbx gnd gnd sky130_fd_pr__nfet_g5v0d10v5 W=2.0 L=4.0 nf=1 m=4
Xldo_MN1 ldo_n1 vout ldo_tail gnd sky130_fd_pr__nfet_g5v0d10v5 W=8.0 L=2.0 nf=1 m=1
Xldo_MN2 ldo_vg vref ldo_tail gnd sky130_fd_pr__nfet_g5v0d10v5 W=8.0 L=2.0 nf=1 m=1
Xldo_MP3 ldo_n1 ldo_n1 vin vin sky130_fd_pr__pfet_g5v0d10v5 W=16.0 L=4.0 nf=1 m=1
Xldo_MP4 ldo_vg ldo_n1 vin vin sky130_fd_pr__pfet_g5v0d10v5 W=16.0 L=4.0 nf=1 m=1
Xldo_MPP vout ldo_vg vin vin sky130_fd_pr__pfet_g5v0d10v5 W=400.0 L=0.5 nf=40 m=1
Xldo_MPS ldo_na ldo_vg vin vin sky130_fd_pr__pfet_g5v0d10v5 W=0.84 L=0.5 nf=1 m=1
Xldo_MNA ldo_na ldo_na gnd gnd sky130_fd_pr__nfet_g5v0d10v5 W=1.0 L=4.0 nf=1 m=1
Xldo_MNA2 ldo_tail ldo_na gnd gnd sky130_fd_pr__nfet_g5v0d10v5 W=1.0 L=4.0 nf=1 m=1
Xldo_MNBL vout nbx gnd gnd sky130_fd_pr__nfet_g5v0d10v5 W=40.0 L=4.0 nf=20 m=1
Xldo_Cc_0 ldo_vg vout sky130_fd_pr__cap_mim_m3_1 W=30.0 L=30.0
Xldo_MPB2 ldo_pa ldo_pa vin vin sky130_fd_pr__pfet_g5v0d10v5 W=4.0 L=4.0 nf=1 m=1
Xldo_Rsh ldo_pa ldo_vbp gnd sky130_fd_pr__res_xhigh_po_0p35 L=205.87
Xldo_MNB3 ldo_vbp nbx gnd gnd sky130_fd_pr__nfet_g5v0d10v5 W=2.0 L=4.0 nf=1 m=1
Xldo_MPT ldo_tx ldo_pa vin vin sky130_fd_pr__pfet_g5v0d10v5 W=4.0 L=4.0 nf=1 m=3
Xldo_MPX ldo_vg ldo_vbp ldo_tx vin sky130_fd_pr__pfet_g5v0d10v5 W=4.0 L=4.0 nf=1 m=3
Xldo_MNX ldo_vg vref ldo_sx gnd sky130_fd_pr__nfet_g5v0d10v5 W=12.0 L=1.0 nf=3 m=1
Xldo_MNS ldo_sx nbx gnd gnd sky130_fd_pr__nfet_g5v0d10v5 W=2.0 L=4.0 nf=1 m=3
Xldo_Cfp_0 vout ldo_tx sky130_fd_pr__cap_mim_m3_1 W=27.5 L=27.5
Xldo_Cfp_1 vout ldo_tx sky130_fd_pr__cap_mim_m3_1 W=27.5 L=27.5
Xldo_Cfp_2 vout ldo_tx sky130_fd_pr__cap_mim_m3_1 W=27.5 L=27.5
Xldo_Cfp_3 vout ldo_tx sky130_fd_pr__cap_mim_m3_1 W=27.5 L=27.5
Xldo_Cfn_0 vout ldo_sx sky130_fd_pr__cap_mim_m3_1 W=27.5 L=27.5
Xldo_Cfn_1 vout ldo_sx sky130_fd_pr__cap_mim_m3_1 W=27.5 L=27.5
Xldo_Cfn_2 vout ldo_sx sky130_fd_pr__cap_mim_m3_1 W=27.5 L=27.5
Xldo_Cfn_3 vout ldo_sx sky130_fd_pr__cap_mim_m3_1 W=27.5 L=27.5
Xldo_Cff_0 vin ldo_sx sky130_fd_pr__cap_mim_m3_1 W=16.0 L=16.0
Xldo_Cff_1 vin ldo_sx sky130_fd_pr__cap_mim_m3_1 W=16.0 L=16.0
Xldo_Cff_2 vin ldo_sx sky130_fd_pr__cap_mim_m3_1 W=16.0 L=16.0
Xldo_Cff_3 vin ldo_sx sky130_fd_pr__cap_mim_m3_1 W=16.0 L=16.0
Xldo_Cbp_0 ldo_vbp gnd sky130_fd_pr__cap_mim_m3_1 W=22.0 L=22.0
Xpor_R1 vin por_div gnd sky130_fd_pr__res_xhigh_po_0p35 L=279.42
Xpor_R2 por_div por_dm gnd sky130_fd_pr__res_xhigh_po_0p35 L=470.55
Xpor_R3 por_dm gnd gnd sky130_fd_pr__res_xhigh_po_0p35 L=188.19
Xpor_MH por_dm por_pgb gnd gnd sky130_fd_pr__nfet_g5v0d10v5 W=1.0 L=0.5 nf=1 m=1
Xpor_Rpu vin por_x gnd sky130_fd_pr__res_xhigh_po_0p35 L=588.17
Xpor_MD por_x por_div gnd gnd sky130_fd_pr__nfet_g5v0d10v5 W=0.7 L=20.0 nf=1 m=1
Xpor_MI1P por_pg por_x vin vin sky130_fd_pr__pfet_g5v0d10v5 W=0.84 L=4.0 nf=1 m=1
Xpor_MI1N por_pg por_x gnd gnd sky130_fd_pr__nfet_g5v0d10v5 W=0.42 L=4.0 nf=1 m=1
Xpor_MI2P por_pgb por_pg vin vin sky130_fd_pr__pfet_g5v0d10v5 W=0.84 L=0.5 nf=1 m=1
Xpor_MI2N por_pgb por_pg gnd gnd sky130_fd_pr__nfet_g5v0d10v5 W=0.42 L=0.5 nf=1 m=1
Xpor_MI3P rstn por_pgb vout vout sky130_fd_pr__pfet_g5v0d10v5 W=0.84 L=0.5 nf=1 m=1
Xpor_MI3N rstn por_pgb gnd gnd sky130_fd_pr__nfet_g5v0d10v5 W=0.42 L=0.5 nf=1 m=1
Xbgr_MPA bgr_mpa_m bgr_pg vin vin sky130_fd_pr__pfet_g5v0d10v5 W=20.0 L=16.0 nf=1 m=4
Xbgr_MPAC bgr_pd bgr_pg bgr_mpa_m vin sky130_fd_pr__pfet_g5v0d10v5 W=80.0 L=2.0 nf=4 m=4
Xbgr_MPB bgr_mpb_m bgr_pg vin vin sky130_fd_pr__pfet_g5v0d10v5 W=20.0 L=16.0 nf=1 m=4
Xbgr_MPBC bgr_ng bgr_pg bgr_mpb_m vin sky130_fd_pr__pfet_g5v0d10v5 W=80.0 L=2.0 nf=4 m=4
Xbgr_MPO bgr_mpo_m bgr_pg vin vin sky130_fd_pr__pfet_g5v0d10v5 W=20.0 L=16.0 nf=1 m=4
Xbgr_MPOC bgr_vr bgr_pg bgr_mpo_m vin sky130_fd_pr__pfet_g5v0d10v5 W=80.0 L=2.0 nf=4 m=4
Xbgr_MPI bgr_mpi_m bgr_pg vin vin sky130_fd_pr__pfet_g5v0d10v5 W=40.0 L=16.0 nf=2 m=4
Xbgr_MPIC nbx bgr_pg bgr_mpi_m vin sky130_fd_pr__pfet_g5v0d10v5 W=160.0 L=2.0 nf=8 m=4
Xbgr_MPC bgr_mpc_m bgr_pg vin vin sky130_fd_pr__pfet_g5v0d10v5 W=20.0 L=16.0 nf=1 m=4
Xbgr_MPCC bgr_ncas bgr_pg bgr_mpc_m vin sky130_fd_pr__pfet_g5v0d10v5 W=80.0 L=2.0 nf=4 m=4
Xbgr_MNF vin bgr_pd bgr_pg gnd sky130_fd_pr__nfet_05v0_nvt W=6.0 L=25.0 nf=6 m=1
Xbgr_MNSK bgr_pg bgr_ng bgr_e8 gnd sky130_fd_pr__nfet_05v0_nvt W=1.0 L=25.0 nf=1 m=2
Xbgr_Q8_0 gnd gnd bgr_e8 sky130_fd_pr__pnp_05v5_W3p40L3p40
Xbgr_MNA bgr_ng bgr_ng bgr_ea gnd sky130_fd_pr__nfet_05v0_nvt W=6.0 L=25.0 nf=6 m=1
Xbgr_MNB bgr_xb bgr_ng bgr_eb gnd sky130_fd_pr__nfet_05v0_nvt W=6.0 L=25.0 nf=6 m=1
Xbgr_MNBC bgr_pd bgr_ncas bgr_xb gnd sky130_fd_pr__nfet_05v0_nvt W=6.0 L=25.0 nf=6 m=1
Xbgr_MNCD bgr_ncas bgr_ncas bgr_e5 gnd sky130_fd_pr__nfet_05v0_nvt W=1.0 L=25.0 nf=1 m=1
Xbgr_Q5_0 gnd gnd bgr_e5 sky130_fd_pr__pnp_05v5_W3p40L3p40
Xbgr_Q1_0 gnd gnd bgr_ea sky130_fd_pr__pnp_05v5_W3p40L3p40
Xbgr_R1 bgr_eb bgr_e2 gnd sky130_fd_pr__res_xhigh_po_0p35 L=94.13
Xbgr_Q2_0 gnd gnd bgr_e2 sky130_fd_pr__pnp_05v5_W3p40L3p40
Xbgr_Q2_1 gnd gnd bgr_e2 sky130_fd_pr__pnp_05v5_W3p40L3p40
Xbgr_Q2_2 gnd gnd bgr_e2 sky130_fd_pr__pnp_05v5_W3p40L3p40
Xbgr_Q2_3 gnd gnd bgr_e2 sky130_fd_pr__pnp_05v5_W3p40L3p40
Xbgr_Q2_4 gnd gnd bgr_e2 sky130_fd_pr__pnp_05v5_W3p40L3p40
Xbgr_Q2_5 gnd gnd bgr_e2 sky130_fd_pr__pnp_05v5_W3p40L3p40
Xbgr_Q2_6 gnd gnd bgr_e2 sky130_fd_pr__pnp_05v5_W3p40L3p40
Xbgr_Q2_7 gnd gnd bgr_e2 sky130_fd_pr__pnp_05v5_W3p40L3p40
Xbgr_R2 bgr_vr bgr_t0 gnd sky130_fd_pr__res_xhigh_po_0p35 L=1000.06
Xbgr_RT0 bgr_t0 bgr_t1 gnd sky130_fd_pr__res_xhigh_po_0p35 L=3.74
Xbgr_MT0 bgr_t0 gnd bgr_t1 gnd sky130_fd_pr__nfet_g5v0d10v5 W=5.0 L=0.5 nf=1 m=1
Xbgr_RT1 bgr_t1 bgr_t2 gnd sky130_fd_pr__res_xhigh_po_0p35 L=7.4
Xbgr_MT1 bgr_t1 gnd bgr_t2 gnd sky130_fd_pr__nfet_g5v0d10v5 W=5.0 L=0.5 nf=1 m=1
Xbgr_RT2 bgr_t2 bgr_t3 gnd sky130_fd_pr__res_xhigh_po_0p35 L=14.76
Xbgr_MT2 bgr_t2 gnd bgr_t3 gnd sky130_fd_pr__nfet_g5v0d10v5 W=5.0 L=0.5 nf=1 m=1
Xbgr_RT3 bgr_t3 bgr_t4 gnd sky130_fd_pr__res_xhigh_po_0p35 L=29.46
Xbgr_MT3 bgr_t3 gnd bgr_t4 gnd sky130_fd_pr__nfet_g5v0d10v5 W=5.0 L=0.5 nf=1 m=1
Xbgr_RT4 bgr_t4 bgr_e3 gnd sky130_fd_pr__res_xhigh_po_0p35 L=58.86
Xbgr_MT4 bgr_t4 vin bgr_e3 gnd sky130_fd_pr__nfet_g5v0d10v5 W=5.0 L=0.5 nf=1 m=1
Xbgr_Q3_0 gnd gnd bgr_e3 sky130_fd_pr__pnp_05v5_W3p40L3p40
Xbgr_MSU0 bgr_su1 bgr_su1 vin vin sky130_fd_pr__pfet_g5v0d10v5 W=0.42 L=50.0 nf=1 m=1
Xbgr_MSU1 bgr_su2 bgr_su2 bgr_su1 vin sky130_fd_pr__pfet_g5v0d10v5 W=0.42 L=50.0 nf=1 m=1
Xbgr_MSU2 bgr_su3 bgr_su3 bgr_su2 vin sky130_fd_pr__pfet_g5v0d10v5 W=0.42 L=50.0 nf=1 m=1
Xbgr_MSU3 bgr_st bgr_st bgr_su3 vin sky130_fd_pr__pfet_g5v0d10v5 W=0.42 L=50.0 nf=1 m=1
Xbgr_MSN bgr_st bgr_vr bgr_e7 gnd sky130_fd_pr__nfet_g5v0d10v5 W=1.0 L=4.0 nf=1 m=1
Xbgr_Q7_0 gnd gnd bgr_e7 sky130_fd_pr__pnp_05v5_W3p40L3p40
Xbgr_MS2 bgr_pg bgr_st gnd gnd sky130_fd_pr__nfet_g5v0d10v5 W=1.0 L=1.0 nf=1 m=1
Xbgr_QD0_0 gnd gnd gnd sky130_fd_pr__pnp_05v5_W3p40L3p40
Xbgr_QD1_0 gnd gnd gnd sky130_fd_pr__pnp_05v5_W3p40L3p40
Xbgr_MPD0 vin vin vin vin sky130_fd_pr__pfet_g5v0d10v5 W=20.0 L=16.0 nf=1 m=1
Xbgr_MPD1 vin vin vin vin sky130_fd_pr__pfet_g5v0d10v5 W=20.0 L=16.0 nf=1 m=1
Xbgr_Rf bgr_vr vref gnd sky130_fd_pr__res_xhigh_po_0p35 L=294.12
Xbgr_Cvr0_0 vref gnd sky130_fd_pr__cap_mim_m3_1 W=25.0 L=25.0
Xbgr_Cvr1_0 vref gnd sky130_fd_pr__cap_mim_m3_1 W=25.0 L=25.0
Xbgr_Cvr2_0 vref gnd sky130_fd_pr__cap_mim_m3_1 W=25.0 L=25.0
Xbgr_Cvr3_0 vref gnd sky130_fd_pr__cap_mim_m3_1 W=25.0 L=25.0
.ends ldo_top
