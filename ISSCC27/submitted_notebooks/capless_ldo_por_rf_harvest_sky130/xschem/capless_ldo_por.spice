** sch_path: /home/poggy/cac/xs/capless_ldo_por.sch
**.subckt capless_ldo_por VIN GND VREF VOUT RST_N
*.iopin VIN
*.iopin GND
*.ipin VREF
*.opin VOUT
*.opin RST_N
Iref VIN nb 2.5e-07
XMNB nb nb GND GND sky130_fd_pr__nfet_g5v0d10v5 L=4 W=2 nf=1 ad=0.58 as=0.58 pd=4.58 ps=4.58
+ nrd=0.145 nrs=0.145 sa=0 sb=0 sd=0 mult=1 m=1
XMN5 tail nb GND GND sky130_fd_pr__nfet_g5v0d10v5 L=4 W=2 nf=1 ad=0.58 as=0.58 pd=4.58 ps=4.58
+ nrd=0.145 nrs=0.145 sa=0 sb=0 sd=0 mult=4 m=4
XMN1 n1 VOUT tail GND sky130_fd_pr__nfet_g5v0d10v5 L=2 W=8 nf=1 ad=2.32 as=2.32 pd=16.58 ps=16.58
+ nrd=0.03625 nrs=0.03625 sa=0 sb=0 sd=0 mult=1 m=1
XMN2 vg VREF tail GND sky130_fd_pr__nfet_g5v0d10v5 L=2 W=8 nf=1 ad=2.32 as=2.32 pd=16.58 ps=16.58
+ nrd=0.03625 nrs=0.03625 sa=0 sb=0 sd=0 mult=1 m=1
XMP3 n1 n1 VIN VIN sky130_fd_pr__pfet_g5v0d10v5 L=4 W=16 nf=1 ad=4.64 as=4.64 pd=32.58 ps=32.58
+ nrd=0.01812 nrs=0.01812 sa=0 sb=0 sd=0 mult=1 m=1
XMP4 vg n1 VIN VIN sky130_fd_pr__pfet_g5v0d10v5 L=4 W=16 nf=1 ad=4.64 as=4.64 pd=32.58 ps=32.58
+ nrd=0.01812 nrs=0.01812 sa=0 sb=0 sd=0 mult=1 m=1
XMPP VOUT vg VIN VIN sky130_fd_pr__pfet_g5v0d10v5 L=0.5 W=400 nf=40 ad=58 as=60.9 pd=411.6 ps=432.2
+ nrd=0.000725 nrs=0.000725 sa=0 sb=0 sd=0 mult=1 m=1
XMPS na vg VIN VIN sky130_fd_pr__pfet_g5v0d10v5 L=0.5 W=0.84 nf=1 ad=0.2436 as=0.2436 pd=2.26
+ ps=2.26 nrd=0.3452 nrs=0.3452 sa=0 sb=0 sd=0 mult=1 m=1
XMNA na na GND GND sky130_fd_pr__nfet_g5v0d10v5 L=4 W=1 nf=1 ad=0.29 as=0.29 pd=2.58 ps=2.58
+ nrd=0.29 nrs=0.29 sa=0 sb=0 sd=0 mult=1 m=1
XMNA2 tail na GND GND sky130_fd_pr__nfet_g5v0d10v5 L=4 W=1 nf=1 ad=0.29 as=0.29 pd=2.58 ps=2.58
+ nrd=0.29 nrs=0.29 sa=0 sb=0 sd=0 mult=1 m=1
XMNBL VOUT nb GND GND sky130_fd_pr__nfet_g5v0d10v5 L=4 W=2 nf=1 ad=0.58 as=0.58 pd=4.58 ps=4.58
+ nrd=0.145 nrs=0.145 sa=0 sb=0 sd=0 mult=20 m=20
XCc vg VOUT sky130_fd_pr__cap_mim_m3_1 W=30 L=30 MF=1 m=1
XMPB2 pa pa VIN VIN sky130_fd_pr__pfet_g5v0d10v5 L=4 W=4 nf=1 ad=1.16 as=1.16 pd=8.58 ps=8.58
+ nrd=0.0725 nrs=0.0725 sa=0 sb=0 sd=0 mult=1 m=1
XRsh vbp pa GND sky130_fd_pr__res_xhigh_po_0p35 L=205.9 mult=1 m=1
XMNB3 vbp nb GND GND sky130_fd_pr__nfet_g5v0d10v5 L=4 W=2 nf=1 ad=0.58 as=0.58 pd=4.58 ps=4.58
+ nrd=0.145 nrs=0.145 sa=0 sb=0 sd=0 mult=1 m=1
XCbp vbp GND sky130_fd_pr__cap_mim_m3_1 W=22 L=22 MF=1 m=1
XMPT tx pa VIN VIN sky130_fd_pr__pfet_g5v0d10v5 L=4 W=4 nf=1 ad=1.16 as=1.16 pd=8.58 ps=8.58
+ nrd=0.0725 nrs=0.0725 sa=0 sb=0 sd=0 mult=3 m=3
XMPX vg vbp tx VIN sky130_fd_pr__pfet_g5v0d10v5 L=4 W=4 nf=1 ad=1.16 as=1.16 pd=8.58 ps=8.58
+ nrd=0.0725 nrs=0.0725 sa=0 sb=0 sd=0 mult=3 m=3
XMNX vg VREF sx GND sky130_fd_pr__nfet_g5v0d10v5 L=1 W=4 nf=1 ad=1.16 as=1.16 pd=8.58 ps=8.58
+ nrd=0.0725 nrs=0.0725 sa=0 sb=0 sd=0 mult=3 m=3
XMNS sx nb GND GND sky130_fd_pr__nfet_g5v0d10v5 L=4 W=2 nf=1 ad=0.58 as=0.58 pd=4.58 ps=4.58
+ nrd=0.145 nrs=0.145 sa=0 sb=0 sd=0 mult=3 m=3
XCfp VOUT tx sky130_fd_pr__cap_mim_m3_1 W=55 L=55 MF=1 m=1
XCfn VOUT sx sky130_fd_pr__cap_mim_m3_1 W=55 L=55 MF=1 m=1
XCff VIN sx sky130_fd_pr__cap_mim_m3_1 W=32 L=32 MF=1 m=1
XR1 div VIN GND sky130_fd_pr__res_xhigh_po_0p35 L=279.4 mult=1 m=1
XR2 dm div GND sky130_fd_pr__res_xhigh_po_0p35 L=470.5 mult=1 m=1
XR3 GND dm GND sky130_fd_pr__res_xhigh_po_0p35 L=188.2 mult=1 m=1
XMH dm pgb GND GND sky130_fd_pr__nfet_g5v0d10v5 L=0.5 W=1 nf=1 ad=0.29 as=0.29 pd=2.58 ps=2.58
+ nrd=0.29 nrs=0.29 sa=0 sb=0 sd=0 mult=1 m=1
XRpu x VIN GND sky130_fd_pr__res_xhigh_po_0p35 L=588.1 mult=1 m=1
XMD x div GND GND sky130_fd_pr__nfet_g5v0d10v5 L=20 W=0.7 nf=1 ad=0.203 as=0.203 pd=1.98 ps=1.98
+ nrd=0.4143 nrs=0.4143 sa=0 sb=0 sd=0 mult=1 m=1
XMI1P pg x VIN VIN sky130_fd_pr__pfet_g5v0d10v5 L=4 W=0.84 nf=1 ad=0.2436 as=0.2436 pd=2.26 ps=2.26
+ nrd=0.3452 nrs=0.3452 sa=0 sb=0 sd=0 mult=1 m=1
XMI1N pg x GND GND sky130_fd_pr__nfet_g5v0d10v5 L=4 W=0.42 nf=1 ad=0.1218 as=0.1218 pd=1.42 ps=1.42
+ nrd=0.6905 nrs=0.6905 sa=0 sb=0 sd=0 mult=1 m=1
XMI2P pgb pg VIN VIN sky130_fd_pr__pfet_g5v0d10v5 L=0.5 W=0.84 nf=1 ad=0.2436 as=0.2436 pd=2.26
+ ps=2.26 nrd=0.3452 nrs=0.3452 sa=0 sb=0 sd=0 mult=1 m=1
XMI2N pgb pg GND GND sky130_fd_pr__nfet_g5v0d10v5 L=0.5 W=0.42 nf=1 ad=0.1218 as=0.1218 pd=1.42
+ ps=1.42 nrd=0.6905 nrs=0.6905 sa=0 sb=0 sd=0 mult=1 m=1
XMI3P RST_N pgb VOUT VOUT sky130_fd_pr__pfet_g5v0d10v5 L=0.5 W=0.84 nf=1 ad=0.2436 as=0.2436 pd=2.26
+ ps=2.26 nrd=0.3452 nrs=0.3452 sa=0 sb=0 sd=0 mult=1 m=1
XMI3N RST_N pgb GND GND sky130_fd_pr__nfet_g5v0d10v5 L=0.5 W=0.42 nf=1 ad=0.1218 as=0.1218 pd=1.42
+ ps=1.42 nrd=0.6905 nrs=0.6905 sa=0 sb=0 sd=0 mult=1 m=1
**.ends
.end
