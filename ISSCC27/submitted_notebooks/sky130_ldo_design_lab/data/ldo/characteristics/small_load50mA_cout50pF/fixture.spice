Connected physical driver diagnostic
.lib "${SKY130_MODEL}" tt
.option scale=1e-6
.temp 27
Vin vin 0 dc 1.2 ac 0
Vaa vaa 0 dc 1.8 ac 0
Vreference reference 0 dc 1 ac 0
Vloop vfb vout dc 0 ac 0
Iload vout 0 PWL(0 0.05 2u 0.05 2.01u 0.05005 7u 0.05005 7.01u 0.05 12u 0.05)
Rprogram rs 0 33000.0
RshapeL ar ql 100000.0
RshapeR al qr 100000.0
Rce ea ec 1000.0
Rh h bu 1000.0
Rbleed vout 0 100000.0
CshapeL ql vaa 1e-13
CshapeR qr vaa 1e-13
Cea ec 0 1e-10
Cout vout 0 5e-11
Cripple vin h 1.4179510076871385e-12
Cgate gate 0 1e-10
Xn1l al vfb tail 0 sky130_fd_pr__nfet_01v8 w=5.0 l=0.3 nf=1 ad=1.45 as=1.45 pd=10.58 ps=10.58 nrd=0.057999999999999996 nrs=0.057999999999999996 m=1
Xn1r ar reference tail 0 sky130_fd_pr__nfet_01v8 w=5.0 l=0.3 nf=1 ad=1.45 as=1.45 pd=10.58 ps=10.58 nrd=0.057999999999999996 nrs=0.057999999999999996 m=1
Xp3l al al vaa vaa sky130_fd_pr__pfet_01v8 w=5.0 l=0.3 nf=1 ad=1.45 as=1.45 pd=10.58 ps=10.58 nrd=0.057999999999999996 nrs=0.057999999999999996 m=1
Xp3r ar ar vaa vaa sky130_fd_pr__pfet_01v8 w=5.0 l=0.3 nf=1 ad=1.45 as=1.45 pd=10.58 ps=10.58 nrd=0.057999999999999996 nrs=0.057999999999999996 m=1
Xp4l mirror al vaa vaa sky130_fd_pr__pfet_01v8 w=15.0 l=0.3 nf=1 ad=4.35 as=4.35 pd=30.58 ps=30.58 nrd=0.01933333333333333 nrs=0.01933333333333333 m=1
Xp4r ea ar vaa vaa sky130_fd_pr__pfet_01v8 w=15.0 l=0.3 nf=1 ad=4.35 as=4.35 pd=30.58 ps=30.58 nrd=0.01933333333333333 nrs=0.01933333333333333 m=1
Xn5l mirror mirror 0 0 sky130_fd_pr__nfet_01v8 w=5.0 l=1.0 nf=1 ad=1.45 as=1.45 pd=10.58 ps=10.58 nrd=0.057999999999999996 nrs=0.057999999999999996 m=1
Xn5r ea mirror 0 0 sky130_fd_pr__nfet_01v8 w=5.0 l=1.0 nf=1 ad=1.45 as=1.45 pd=10.58 ps=10.58 nrd=0.057999999999999996 nrs=0.057999999999999996 m=1
Xp2l al ql vaa vaa sky130_fd_pr__pfet_01v8 w=4.0 l=0.3 nf=1 ad=1.16 as=1.16 pd=8.58 ps=8.58 nrd=0.0725 nrs=0.0725 m=1
Xp2r ar qr vaa vaa sky130_fd_pr__pfet_01v8 w=4.0 l=0.3 nf=1 ad=1.16 as=1.16 pd=8.58 ps=8.58 nrd=0.0725 nrs=0.0725 m=1
Xnbias bn bn 0 0 sky130_fd_pr__nfet_01v8 w=5.0 l=1.0 nf=1 ad=1.45 as=1.45 pd=10.58 ps=10.58 nrd=0.057999999999999996 nrs=0.057999999999999996 m=1
Xntail tail bn 0 0 sky130_fd_pr__nfet_01v8 w=10.0 l=1.0 nf=1 ad=2.9 as=2.9 pd=20.58 ps=20.58 nrd=0.028999999999999998 nrs=0.028999999999999998 m=1
Xnprogram bp reference rs 0 sky130_fd_pr__nfet_01v8 w=5.0 l=1.0 nf=1 ad=1.45 as=1.45 pd=10.58 ps=10.58 nrd=0.057999999999999996 nrs=0.057999999999999996 m=1
Xpseed bp bp vaa vaa sky130_fd_pr__pfet_01v8 w=20.0 l=1.0 nf=1 ad=5.8 as=5.8 pd=40.58 ps=40.58 nrd=0.014499999999999999 nrs=0.014499999999999999 m=1
Xpcopy bn bp vaa vaa sky130_fd_pr__pfet_01v8 w=20.0 l=1.0 nf=1 ad=5.8 as=5.8 pd=40.58 ps=40.58 nrd=0.014499999999999999 nrs=0.014499999999999999 m=1
Xpup gate h vaa vaa sky130_fd_pr__pfet_01v8 w=20.0 l=0.3 nf=1 ad=5.8 as=5.8 pd=40.58 ps=40.58 nrd=0.014499999999999999 nrs=0.014499999999999999 m=32.0
Xpf h ea gate gate sky130_fd_pr__pfet_01v8 w=5.0 l=0.3 nf=1 ad=1.45 as=1.45 pd=10.58 ps=10.58 nrd=0.057999999999999996 nrs=0.057999999999999996 m=10.0
Xpass vin gate vout vout sky130_fd_pr__nfet_01v8_lvt w=5.0 l=0.15 nf=1 ad=1.45 as=1.45 pd=10.58 ps=10.58 nrd=0.057999999999999996 nrs=0.057999999999999996 m=2400
Xpbr bu bu vaa vaa sky130_fd_pr__pfet_01v8 w=20.0 l=0.3 nf=1 ad=5.8 as=5.8 pd=40.58 ps=40.58 nrd=0.014499999999999999 nrs=0.014499999999999999 m=4
Xnbr bu bn 0 0 sky130_fd_pr__nfet_01v8 w=5.0 l=1.0 nf=1 ad=1.45 as=1.45 pd=10.58 ps=10.58 nrd=0.057999999999999996 nrs=0.057999999999999996 m=1
Xnlim h bn 0 0 sky130_fd_pr__nfet_01v8 w=5.0 l=1.0 nf=1 ad=1.45 as=1.45 pd=10.58 ps=10.58 nrd=0.057999999999999996 nrs=0.057999999999999996 m=6.0
.nodeset v(al)=0.8259326501869402 v(ar)=0.8270349394552392 v(bn)=0.6842767360984375 v(bp)=0.7057512836790827 v(bu)=0.9588158203287293 v(ea)=0.6699155276202191 v(ec)=0.6699155276202191 v(gate)=1.649429604710804 v(h)=0.9588723461092741 v(mirror)=0.7217726998001049 v(ql)=0.8270349394552391 v(qr)=0.8259326501869401 v(reference)=1.0 v(rs)=0.2578889050132331 v(tail)=0.2655942347293561 v(vaa)=1.8 v(vfb)=1.000104949688912 v(vin)=1.2 v(vout)=1.000104949688912
.save v(vout) v(gate) v(ea) v(h)
.control
set numdgt=15
set wr_singlescale
set wr_vecnames
tran .2n 12u 0 .5n
wrdata waveform.tsv v(vout) v(gate) v(ea) v(h)
quit
.endc
.end
