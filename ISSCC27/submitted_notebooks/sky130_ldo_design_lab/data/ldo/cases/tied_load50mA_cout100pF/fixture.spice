Connected physical driver diagnostic
.lib "${SKY130_MODEL}" tt
.option scale=1e-6
.temp 27
Vin vin 0 dc 1.2 ac 0
Vaa vaa 0 dc 1.8 ac 0
Vreference reference 0 dc 1 ac 0
Vloop vfb vout dc 0 ac 0
Iload vout 0 dc 0.05 ac 0
Rprogram rs 0 33000.0
RshapeL ar ql 100000.0
RshapeR al qr 100000.0
Rce ea ec 1000.0
Rh h bu 1000.0
Rbleed vout 0 100000.0
CshapeL ql vaa 1e-13
CshapeR qr vaa 1e-13
Cea ec 0 1e-10
Cout vout 0 1e-10
Cripple vin h 1.4179510076871385e-12
Cgate gate 0 1e-10
Xn1l al vfb tail 0 sky130_fd_pr__nfet_01v8 w=5.0 l=0.3 nf=1 ad=1.45 as=1.45 pd=10.58 ps=10.58 nrd=0.057999999999999996 nrs=0.057999999999999996 m=1
Xn1r ar reference tail 0 sky130_fd_pr__nfet_01v8 w=5.0 l=0.3 nf=1 ad=1.45 as=1.45 pd=10.58 ps=10.58 nrd=0.057999999999999996 nrs=0.057999999999999996 m=1
Xp3l al al vaa vaa sky130_fd_pr__pfet_01v8 w=5.0 l=0.3 nf=1 ad=1.45 as=1.45 pd=10.58 ps=10.58 nrd=0.057999999999999996 nrs=0.057999999999999996 m=1
Xp3r ar ar vaa vaa sky130_fd_pr__pfet_01v8 w=5.0 l=0.3 nf=1 ad=1.45 as=1.45 pd=10.58 ps=10.58 nrd=0.057999999999999996 nrs=0.057999999999999996 m=1
Xp4l mirror al vaa vaa sky130_fd_pr__pfet_01v8 w=15.0 l=0.3 nf=1 ad=4.35 as=4.35 pd=30.58 ps=30.58 nrd=0.01933333333333333 nrs=0.01933333333333333 m=1
Xp4r ea ar vaa vaa sky130_fd_pr__pfet_01v8 w=15.0 l=0.3 nf=1 ad=4.35 as=4.35 pd=30.58 ps=30.58 nrd=0.01933333333333333 nrs=0.01933333333333333 m=1
Xn5l mirror mirror 0 0 sky130_fd_pr__nfet_01v8 w=5.0 l=1.0 nf=1 ad=1.45 as=1.45 pd=10.58 ps=10.58 nrd=0.057999999999999996 nrs=0.057999999999999996 m=1
Xn5r ea mirror 0 0 sky130_fd_pr__nfet_01v8 w=5.0 l=1.0 nf=1 ad=1.45 as=1.45 pd=10.58 ps=10.58 nrd=0.057999999999999996 nrs=0.057999999999999996 m=1
Xp2l al ql vaa vaa sky130_fd_pr__pfet_01v8 w=4.0 l=0.3 nf=1 ad=1.16 as=1.16 pd=8.58 ps=8.58 nrd=0.0725 nrs=0.0725 m=1
Xp2r ar qr vaa vaa sky130_fd_pr__pfet_01v8 w=4.0 l=0.3 nf=1 ad=1.16 as=1.16 pd=8.58 ps=8.58 nrd=0.0725 nrs=0.0725 m=1
Xnbias bn bn 0 0 sky130_fd_pr__nfet_01v8 w=5.0 l=1.0 nf=1 ad=1.45 as=1.45 pd=10.58 ps=10.58 nrd=0.057999999999999996 nrs=0.057999999999999996 m=1
Xntail tail bn 0 0 sky130_fd_pr__nfet_01v8 w=10.0 l=1.0 nf=1 ad=2.9 as=2.9 pd=20.58 ps=20.58 nrd=0.028999999999999998 nrs=0.028999999999999998 m=1
Xnprogram bp reference rs 0 sky130_fd_pr__nfet_01v8 w=5.0 l=1.0 nf=1 ad=1.45 as=1.45 pd=10.58 ps=10.58 nrd=0.057999999999999996 nrs=0.057999999999999996 m=1
Xpseed bp bp vaa vaa sky130_fd_pr__pfet_01v8 w=20.0 l=1.0 nf=1 ad=5.8 as=5.8 pd=40.58 ps=40.58 nrd=0.014499999999999999 nrs=0.014499999999999999 m=1
Xpcopy bn bp vaa vaa sky130_fd_pr__pfet_01v8 w=20.0 l=1.0 nf=1 ad=5.8 as=5.8 pd=40.58 ps=40.58 nrd=0.014499999999999999 nrs=0.014499999999999999 m=1
Xpup gate h vaa vaa sky130_fd_pr__pfet_01v8 w=20.0 l=0.3 nf=1 ad=5.8 as=5.8 pd=40.58 ps=40.58 nrd=0.014499999999999999 nrs=0.014499999999999999 m=32.0
Xpf h ea gate gate sky130_fd_pr__pfet_01v8 w=5.0 l=0.3 nf=1 ad=1.45 as=1.45 pd=10.58 ps=10.58 nrd=0.057999999999999996 nrs=0.057999999999999996 m=10.0
Xpass vin gate vout vout sky130_fd_pr__nfet_01v8_lvt w=5.0 l=0.15 nf=1 ad=1.45 as=1.45 pd=10.58 ps=10.58 nrd=0.057999999999999996 nrs=0.057999999999999996 m=2400
Xpbr bu bu vaa vaa sky130_fd_pr__pfet_01v8 w=20.0 l=0.3 nf=1 ad=5.8 as=5.8 pd=40.58 ps=40.58 nrd=0.014499999999999999 nrs=0.014499999999999999 m=4
Xnbr bu bn 0 0 sky130_fd_pr__nfet_01v8 w=5.0 l=1.0 nf=1 ad=1.45 as=1.45 pd=10.58 ps=10.58 nrd=0.057999999999999996 nrs=0.057999999999999996 m=1
Xnlim h bn 0 0 sky130_fd_pr__nfet_01v8 w=5.0 l=1.0 nf=1 ad=1.45 as=1.45 pd=10.58 ps=10.58 nrd=0.057999999999999996 nrs=0.057999999999999996 m=6.0
.save all @m.xn1l.msky130_fd_pr__nfet_01v8[id] @m.xn1l.msky130_fd_pr__nfet_01v8[gm] @m.xn1l.msky130_fd_pr__nfet_01v8[gds] @m.xn1l.msky130_fd_pr__nfet_01v8[vgs] @m.xn1l.msky130_fd_pr__nfet_01v8[vds] @m.xn1l.msky130_fd_pr__nfet_01v8[vdsat] @m.xn1l.msky130_fd_pr__nfet_01v8[vth] @m.xn1r.msky130_fd_pr__nfet_01v8[id] @m.xn1r.msky130_fd_pr__nfet_01v8[gm] @m.xn1r.msky130_fd_pr__nfet_01v8[gds] @m.xn1r.msky130_fd_pr__nfet_01v8[vgs] @m.xn1r.msky130_fd_pr__nfet_01v8[vds] @m.xn1r.msky130_fd_pr__nfet_01v8[vdsat] @m.xn1r.msky130_fd_pr__nfet_01v8[vth] @m.xp3l.msky130_fd_pr__pfet_01v8[id] @m.xp3l.msky130_fd_pr__pfet_01v8[gm] @m.xp3l.msky130_fd_pr__pfet_01v8[gds] @m.xp3l.msky130_fd_pr__pfet_01v8[vgs] @m.xp3l.msky130_fd_pr__pfet_01v8[vds] @m.xp3l.msky130_fd_pr__pfet_01v8[vdsat] @m.xp3l.msky130_fd_pr__pfet_01v8[vth] @m.xp3r.msky130_fd_pr__pfet_01v8[id] @m.xp3r.msky130_fd_pr__pfet_01v8[gm] @m.xp3r.msky130_fd_pr__pfet_01v8[gds] @m.xp3r.msky130_fd_pr__pfet_01v8[vgs] @m.xp3r.msky130_fd_pr__pfet_01v8[vds] @m.xp3r.msky130_fd_pr__pfet_01v8[vdsat] @m.xp3r.msky130_fd_pr__pfet_01v8[vth] @m.xp4l.msky130_fd_pr__pfet_01v8[id] @m.xp4l.msky130_fd_pr__pfet_01v8[gm] @m.xp4l.msky130_fd_pr__pfet_01v8[gds] @m.xp4l.msky130_fd_pr__pfet_01v8[vgs] @m.xp4l.msky130_fd_pr__pfet_01v8[vds] @m.xp4l.msky130_fd_pr__pfet_01v8[vdsat] @m.xp4l.msky130_fd_pr__pfet_01v8[vth] @m.xp4r.msky130_fd_pr__pfet_01v8[id] @m.xp4r.msky130_fd_pr__pfet_01v8[gm] @m.xp4r.msky130_fd_pr__pfet_01v8[gds] @m.xp4r.msky130_fd_pr__pfet_01v8[vgs] @m.xp4r.msky130_fd_pr__pfet_01v8[vds] @m.xp4r.msky130_fd_pr__pfet_01v8[vdsat] @m.xp4r.msky130_fd_pr__pfet_01v8[vth] @m.xn5l.msky130_fd_pr__nfet_01v8[id] @m.xn5l.msky130_fd_pr__nfet_01v8[gm] @m.xn5l.msky130_fd_pr__nfet_01v8[gds] @m.xn5l.msky130_fd_pr__nfet_01v8[vgs] @m.xn5l.msky130_fd_pr__nfet_01v8[vds] @m.xn5l.msky130_fd_pr__nfet_01v8[vdsat] @m.xn5l.msky130_fd_pr__nfet_01v8[vth] @m.xn5r.msky130_fd_pr__nfet_01v8[id] @m.xn5r.msky130_fd_pr__nfet_01v8[gm] @m.xn5r.msky130_fd_pr__nfet_01v8[gds] @m.xn5r.msky130_fd_pr__nfet_01v8[vgs] @m.xn5r.msky130_fd_pr__nfet_01v8[vds] @m.xn5r.msky130_fd_pr__nfet_01v8[vdsat] @m.xn5r.msky130_fd_pr__nfet_01v8[vth] @m.xp2l.msky130_fd_pr__pfet_01v8[id] @m.xp2l.msky130_fd_pr__pfet_01v8[gm] @m.xp2l.msky130_fd_pr__pfet_01v8[gds] @m.xp2l.msky130_fd_pr__pfet_01v8[vgs] @m.xp2l.msky130_fd_pr__pfet_01v8[vds] @m.xp2l.msky130_fd_pr__pfet_01v8[vdsat] @m.xp2l.msky130_fd_pr__pfet_01v8[vth] @m.xp2r.msky130_fd_pr__pfet_01v8[id] @m.xp2r.msky130_fd_pr__pfet_01v8[gm] @m.xp2r.msky130_fd_pr__pfet_01v8[gds] @m.xp2r.msky130_fd_pr__pfet_01v8[vgs] @m.xp2r.msky130_fd_pr__pfet_01v8[vds] @m.xp2r.msky130_fd_pr__pfet_01v8[vdsat] @m.xp2r.msky130_fd_pr__pfet_01v8[vth] @m.xnbias.msky130_fd_pr__nfet_01v8[id] @m.xnbias.msky130_fd_pr__nfet_01v8[gm] @m.xnbias.msky130_fd_pr__nfet_01v8[gds] @m.xnbias.msky130_fd_pr__nfet_01v8[vgs] @m.xnbias.msky130_fd_pr__nfet_01v8[vds] @m.xnbias.msky130_fd_pr__nfet_01v8[vdsat] @m.xnbias.msky130_fd_pr__nfet_01v8[vth] @m.xntail.msky130_fd_pr__nfet_01v8[id] @m.xntail.msky130_fd_pr__nfet_01v8[gm] @m.xntail.msky130_fd_pr__nfet_01v8[gds] @m.xntail.msky130_fd_pr__nfet_01v8[vgs] @m.xntail.msky130_fd_pr__nfet_01v8[vds] @m.xntail.msky130_fd_pr__nfet_01v8[vdsat] @m.xntail.msky130_fd_pr__nfet_01v8[vth] @m.xnprogram.msky130_fd_pr__nfet_01v8[id] @m.xnprogram.msky130_fd_pr__nfet_01v8[gm] @m.xnprogram.msky130_fd_pr__nfet_01v8[gds] @m.xnprogram.msky130_fd_pr__nfet_01v8[vgs] @m.xnprogram.msky130_fd_pr__nfet_01v8[vds] @m.xnprogram.msky130_fd_pr__nfet_01v8[vdsat] @m.xnprogram.msky130_fd_pr__nfet_01v8[vth] @m.xpseed.msky130_fd_pr__pfet_01v8[id] @m.xpseed.msky130_fd_pr__pfet_01v8[gm] @m.xpseed.msky130_fd_pr__pfet_01v8[gds] @m.xpseed.msky130_fd_pr__pfet_01v8[vgs] @m.xpseed.msky130_fd_pr__pfet_01v8[vds] @m.xpseed.msky130_fd_pr__pfet_01v8[vdsat] @m.xpseed.msky130_fd_pr__pfet_01v8[vth] @m.xpcopy.msky130_fd_pr__pfet_01v8[id] @m.xpcopy.msky130_fd_pr__pfet_01v8[gm] @m.xpcopy.msky130_fd_pr__pfet_01v8[gds] @m.xpcopy.msky130_fd_pr__pfet_01v8[vgs] @m.xpcopy.msky130_fd_pr__pfet_01v8[vds] @m.xpcopy.msky130_fd_pr__pfet_01v8[vdsat] @m.xpcopy.msky130_fd_pr__pfet_01v8[vth] @m.xpup.msky130_fd_pr__pfet_01v8[id] @m.xpup.msky130_fd_pr__pfet_01v8[gm] @m.xpup.msky130_fd_pr__pfet_01v8[gds] @m.xpup.msky130_fd_pr__pfet_01v8[vgs] @m.xpup.msky130_fd_pr__pfet_01v8[vds] @m.xpup.msky130_fd_pr__pfet_01v8[vdsat] @m.xpup.msky130_fd_pr__pfet_01v8[vth] @m.xpf.msky130_fd_pr__pfet_01v8[id] @m.xpf.msky130_fd_pr__pfet_01v8[gm] @m.xpf.msky130_fd_pr__pfet_01v8[gds] @m.xpf.msky130_fd_pr__pfet_01v8[vgs] @m.xpf.msky130_fd_pr__pfet_01v8[vds] @m.xpf.msky130_fd_pr__pfet_01v8[vdsat] @m.xpf.msky130_fd_pr__pfet_01v8[vth] @m.xpass.msky130_fd_pr__nfet_01v8_lvt[id] @m.xpass.msky130_fd_pr__nfet_01v8_lvt[gm] @m.xpass.msky130_fd_pr__nfet_01v8_lvt[gds] @m.xpass.msky130_fd_pr__nfet_01v8_lvt[vgs] @m.xpass.msky130_fd_pr__nfet_01v8_lvt[vds] @m.xpass.msky130_fd_pr__nfet_01v8_lvt[vdsat] @m.xpass.msky130_fd_pr__nfet_01v8_lvt[vth] @m.xpbr.msky130_fd_pr__pfet_01v8[id] @m.xpbr.msky130_fd_pr__pfet_01v8[gm] @m.xpbr.msky130_fd_pr__pfet_01v8[gds] @m.xpbr.msky130_fd_pr__pfet_01v8[vgs] @m.xpbr.msky130_fd_pr__pfet_01v8[vds] @m.xpbr.msky130_fd_pr__pfet_01v8[vdsat] @m.xpbr.msky130_fd_pr__pfet_01v8[vth] @m.xnbr.msky130_fd_pr__nfet_01v8[id] @m.xnbr.msky130_fd_pr__nfet_01v8[gm] @m.xnbr.msky130_fd_pr__nfet_01v8[gds] @m.xnbr.msky130_fd_pr__nfet_01v8[vgs] @m.xnbr.msky130_fd_pr__nfet_01v8[vds] @m.xnbr.msky130_fd_pr__nfet_01v8[vdsat] @m.xnbr.msky130_fd_pr__nfet_01v8[vth] @m.xnlim.msky130_fd_pr__nfet_01v8[id] @m.xnlim.msky130_fd_pr__nfet_01v8[gm] @m.xnlim.msky130_fd_pr__nfet_01v8[gds] @m.xnlim.msky130_fd_pr__nfet_01v8[vgs] @m.xnlim.msky130_fd_pr__nfet_01v8[vds] @m.xnlim.msky130_fd_pr__nfet_01v8[vdsat] @m.xnlim.msky130_fd_pr__nfet_01v8[vth]
.control
set numdgt=15
set wr_singlescale
set wr_vecnames
op
wrdata op.tsv v(al) v(ar) v(bn) v(bp) v(bu) v(ea) v(ec) v(gate) v(h) v(mirror) v(ql) v(qr) v(reference) v(rs) v(tail) v(vaa) v(vfb) v(vin) v(vout) i(Vin) i(Vaa) @m.xn1l.msky130_fd_pr__nfet_01v8[id] @m.xn1l.msky130_fd_pr__nfet_01v8[gm] @m.xn1l.msky130_fd_pr__nfet_01v8[gds] @m.xn1l.msky130_fd_pr__nfet_01v8[vgs] @m.xn1l.msky130_fd_pr__nfet_01v8[vds] @m.xn1l.msky130_fd_pr__nfet_01v8[vdsat] @m.xn1l.msky130_fd_pr__nfet_01v8[vth] @m.xn1r.msky130_fd_pr__nfet_01v8[id] @m.xn1r.msky130_fd_pr__nfet_01v8[gm] @m.xn1r.msky130_fd_pr__nfet_01v8[gds] @m.xn1r.msky130_fd_pr__nfet_01v8[vgs] @m.xn1r.msky130_fd_pr__nfet_01v8[vds] @m.xn1r.msky130_fd_pr__nfet_01v8[vdsat] @m.xn1r.msky130_fd_pr__nfet_01v8[vth] @m.xp3l.msky130_fd_pr__pfet_01v8[id] @m.xp3l.msky130_fd_pr__pfet_01v8[gm] @m.xp3l.msky130_fd_pr__pfet_01v8[gds] @m.xp3l.msky130_fd_pr__pfet_01v8[vgs] @m.xp3l.msky130_fd_pr__pfet_01v8[vds] @m.xp3l.msky130_fd_pr__pfet_01v8[vdsat] @m.xp3l.msky130_fd_pr__pfet_01v8[vth] @m.xp3r.msky130_fd_pr__pfet_01v8[id] @m.xp3r.msky130_fd_pr__pfet_01v8[gm] @m.xp3r.msky130_fd_pr__pfet_01v8[gds] @m.xp3r.msky130_fd_pr__pfet_01v8[vgs] @m.xp3r.msky130_fd_pr__pfet_01v8[vds] @m.xp3r.msky130_fd_pr__pfet_01v8[vdsat] @m.xp3r.msky130_fd_pr__pfet_01v8[vth] @m.xp4l.msky130_fd_pr__pfet_01v8[id] @m.xp4l.msky130_fd_pr__pfet_01v8[gm] @m.xp4l.msky130_fd_pr__pfet_01v8[gds] @m.xp4l.msky130_fd_pr__pfet_01v8[vgs] @m.xp4l.msky130_fd_pr__pfet_01v8[vds] @m.xp4l.msky130_fd_pr__pfet_01v8[vdsat] @m.xp4l.msky130_fd_pr__pfet_01v8[vth] @m.xp4r.msky130_fd_pr__pfet_01v8[id] @m.xp4r.msky130_fd_pr__pfet_01v8[gm] @m.xp4r.msky130_fd_pr__pfet_01v8[gds] @m.xp4r.msky130_fd_pr__pfet_01v8[vgs] @m.xp4r.msky130_fd_pr__pfet_01v8[vds] @m.xp4r.msky130_fd_pr__pfet_01v8[vdsat] @m.xp4r.msky130_fd_pr__pfet_01v8[vth] @m.xn5l.msky130_fd_pr__nfet_01v8[id] @m.xn5l.msky130_fd_pr__nfet_01v8[gm] @m.xn5l.msky130_fd_pr__nfet_01v8[gds] @m.xn5l.msky130_fd_pr__nfet_01v8[vgs] @m.xn5l.msky130_fd_pr__nfet_01v8[vds] @m.xn5l.msky130_fd_pr__nfet_01v8[vdsat] @m.xn5l.msky130_fd_pr__nfet_01v8[vth] @m.xn5r.msky130_fd_pr__nfet_01v8[id] @m.xn5r.msky130_fd_pr__nfet_01v8[gm] @m.xn5r.msky130_fd_pr__nfet_01v8[gds] @m.xn5r.msky130_fd_pr__nfet_01v8[vgs] @m.xn5r.msky130_fd_pr__nfet_01v8[vds] @m.xn5r.msky130_fd_pr__nfet_01v8[vdsat] @m.xn5r.msky130_fd_pr__nfet_01v8[vth] @m.xp2l.msky130_fd_pr__pfet_01v8[id] @m.xp2l.msky130_fd_pr__pfet_01v8[gm] @m.xp2l.msky130_fd_pr__pfet_01v8[gds] @m.xp2l.msky130_fd_pr__pfet_01v8[vgs] @m.xp2l.msky130_fd_pr__pfet_01v8[vds] @m.xp2l.msky130_fd_pr__pfet_01v8[vdsat] @m.xp2l.msky130_fd_pr__pfet_01v8[vth] @m.xp2r.msky130_fd_pr__pfet_01v8[id] @m.xp2r.msky130_fd_pr__pfet_01v8[gm] @m.xp2r.msky130_fd_pr__pfet_01v8[gds] @m.xp2r.msky130_fd_pr__pfet_01v8[vgs] @m.xp2r.msky130_fd_pr__pfet_01v8[vds] @m.xp2r.msky130_fd_pr__pfet_01v8[vdsat] @m.xp2r.msky130_fd_pr__pfet_01v8[vth] @m.xnbias.msky130_fd_pr__nfet_01v8[id] @m.xnbias.msky130_fd_pr__nfet_01v8[gm] @m.xnbias.msky130_fd_pr__nfet_01v8[gds] @m.xnbias.msky130_fd_pr__nfet_01v8[vgs] @m.xnbias.msky130_fd_pr__nfet_01v8[vds] @m.xnbias.msky130_fd_pr__nfet_01v8[vdsat] @m.xnbias.msky130_fd_pr__nfet_01v8[vth] @m.xntail.msky130_fd_pr__nfet_01v8[id] @m.xntail.msky130_fd_pr__nfet_01v8[gm] @m.xntail.msky130_fd_pr__nfet_01v8[gds] @m.xntail.msky130_fd_pr__nfet_01v8[vgs] @m.xntail.msky130_fd_pr__nfet_01v8[vds] @m.xntail.msky130_fd_pr__nfet_01v8[vdsat] @m.xntail.msky130_fd_pr__nfet_01v8[vth] @m.xnprogram.msky130_fd_pr__nfet_01v8[id] @m.xnprogram.msky130_fd_pr__nfet_01v8[gm] @m.xnprogram.msky130_fd_pr__nfet_01v8[gds] @m.xnprogram.msky130_fd_pr__nfet_01v8[vgs] @m.xnprogram.msky130_fd_pr__nfet_01v8[vds] @m.xnprogram.msky130_fd_pr__nfet_01v8[vdsat] @m.xnprogram.msky130_fd_pr__nfet_01v8[vth] @m.xpseed.msky130_fd_pr__pfet_01v8[id] @m.xpseed.msky130_fd_pr__pfet_01v8[gm] @m.xpseed.msky130_fd_pr__pfet_01v8[gds] @m.xpseed.msky130_fd_pr__pfet_01v8[vgs] @m.xpseed.msky130_fd_pr__pfet_01v8[vds] @m.xpseed.msky130_fd_pr__pfet_01v8[vdsat] @m.xpseed.msky130_fd_pr__pfet_01v8[vth] @m.xpcopy.msky130_fd_pr__pfet_01v8[id] @m.xpcopy.msky130_fd_pr__pfet_01v8[gm] @m.xpcopy.msky130_fd_pr__pfet_01v8[gds] @m.xpcopy.msky130_fd_pr__pfet_01v8[vgs] @m.xpcopy.msky130_fd_pr__pfet_01v8[vds] @m.xpcopy.msky130_fd_pr__pfet_01v8[vdsat] @m.xpcopy.msky130_fd_pr__pfet_01v8[vth] @m.xpup.msky130_fd_pr__pfet_01v8[id] @m.xpup.msky130_fd_pr__pfet_01v8[gm] @m.xpup.msky130_fd_pr__pfet_01v8[gds] @m.xpup.msky130_fd_pr__pfet_01v8[vgs] @m.xpup.msky130_fd_pr__pfet_01v8[vds] @m.xpup.msky130_fd_pr__pfet_01v8[vdsat] @m.xpup.msky130_fd_pr__pfet_01v8[vth] @m.xpf.msky130_fd_pr__pfet_01v8[id] @m.xpf.msky130_fd_pr__pfet_01v8[gm] @m.xpf.msky130_fd_pr__pfet_01v8[gds] @m.xpf.msky130_fd_pr__pfet_01v8[vgs] @m.xpf.msky130_fd_pr__pfet_01v8[vds] @m.xpf.msky130_fd_pr__pfet_01v8[vdsat] @m.xpf.msky130_fd_pr__pfet_01v8[vth] @m.xpass.msky130_fd_pr__nfet_01v8_lvt[id] @m.xpass.msky130_fd_pr__nfet_01v8_lvt[gm] @m.xpass.msky130_fd_pr__nfet_01v8_lvt[gds] @m.xpass.msky130_fd_pr__nfet_01v8_lvt[vgs] @m.xpass.msky130_fd_pr__nfet_01v8_lvt[vds] @m.xpass.msky130_fd_pr__nfet_01v8_lvt[vdsat] @m.xpass.msky130_fd_pr__nfet_01v8_lvt[vth] @m.xpbr.msky130_fd_pr__pfet_01v8[id] @m.xpbr.msky130_fd_pr__pfet_01v8[gm] @m.xpbr.msky130_fd_pr__pfet_01v8[gds] @m.xpbr.msky130_fd_pr__pfet_01v8[vgs] @m.xpbr.msky130_fd_pr__pfet_01v8[vds] @m.xpbr.msky130_fd_pr__pfet_01v8[vdsat] @m.xpbr.msky130_fd_pr__pfet_01v8[vth] @m.xnbr.msky130_fd_pr__nfet_01v8[id] @m.xnbr.msky130_fd_pr__nfet_01v8[gm] @m.xnbr.msky130_fd_pr__nfet_01v8[gds] @m.xnbr.msky130_fd_pr__nfet_01v8[vgs] @m.xnbr.msky130_fd_pr__nfet_01v8[vds] @m.xnbr.msky130_fd_pr__nfet_01v8[vdsat] @m.xnbr.msky130_fd_pr__nfet_01v8[vth] @m.xnlim.msky130_fd_pr__nfet_01v8[id] @m.xnlim.msky130_fd_pr__nfet_01v8[gm] @m.xnlim.msky130_fd_pr__nfet_01v8[gds] @m.xnlim.msky130_fd_pr__nfet_01v8[vgs] @m.xnlim.msky130_fd_pr__nfet_01v8[vds] @m.xnlim.msky130_fd_pr__nfet_01v8[vdsat] @m.xnlim.msky130_fd_pr__nfet_01v8[vth]
alter Vin acmag=1
ac dec 100 1 1G
wrdata power.tsv real(v(vout)) imag(v(vout)) real(v(gate)) imag(v(gate)) real(v(h)) imag(v(h)) real(v(ea)) imag(v(ea)) real(v(vfb)) imag(v(vfb)) real(v(reference)) imag(v(reference)) real(v(bn)) imag(v(bn)) real(v(bu)) imag(v(bu)) real(v(tail)) imag(v(tail)) real(v(mirror)) imag(v(mirror)) real(v(al)) imag(v(al)) real(v(ar)) imag(v(ar))
alter Vin acmag=0
alter Vaa acmag=1
ac dec 100 1 1G
wrdata auxiliary.tsv real(v(vout)) imag(v(vout)) real(v(gate)) imag(v(gate)) real(v(h)) imag(v(h)) real(v(ea)) imag(v(ea)) real(v(vfb)) imag(v(vfb)) real(v(reference)) imag(v(reference)) real(v(bn)) imag(v(bn)) real(v(bu)) imag(v(bu)) real(v(tail)) imag(v(tail)) real(v(mirror)) imag(v(mirror)) real(v(al)) imag(v(al)) real(v(ar)) imag(v(ar))
alter Vaa acmag=0
alter Vreference acmag=1
ac dec 100 1 1G
wrdata reference.tsv real(v(vout)) imag(v(vout)) real(v(gate)) imag(v(gate)) real(v(h)) imag(v(h)) real(v(ea)) imag(v(ea)) real(v(vfb)) imag(v(vfb)) real(v(reference)) imag(v(reference)) real(v(bn)) imag(v(bn)) real(v(bu)) imag(v(bu)) real(v(tail)) imag(v(tail)) real(v(mirror)) imag(v(mirror)) real(v(al)) imag(v(al)) real(v(ar)) imag(v(ar))
alter Vreference acmag=0
alter Iload acmag=1
ac dec 100 1 1G
wrdata impedance.tsv real(v(vout)) imag(v(vout)) real(v(gate)) imag(v(gate)) real(v(h)) imag(v(h)) real(v(ea)) imag(v(ea)) real(v(vfb)) imag(v(vfb)) real(v(reference)) imag(v(reference)) real(v(bn)) imag(v(bn)) real(v(bu)) imag(v(bu)) real(v(tail)) imag(v(tail)) real(v(mirror)) imag(v(mirror)) real(v(al)) imag(v(al)) real(v(ar)) imag(v(ar))
alter Iload acmag=0
alter Vloop acmag=1
ac dec 100 1 1G
wrdata loop.tsv real(v(vout)) imag(v(vout)) real(v(gate)) imag(v(gate)) real(v(h)) imag(v(h)) real(v(ea)) imag(v(ea)) real(v(vfb)) imag(v(vfb)) real(v(reference)) imag(v(reference)) real(v(bn)) imag(v(bn)) real(v(bu)) imag(v(bu)) real(v(tail)) imag(v(tail)) real(v(mirror)) imag(v(mirror)) real(v(al)) imag(v(al)) real(v(ar)) imag(v(ar))
alter Vloop acmag=0
quit
.endc
.end
