dropout
.lib "${SKY130_MODEL}" tt
.option scale=1e-6
.temp 27
Vctrl ctrl 0 0
Vs0 s0 0 1.8
Vg0 g0 s0 -0.8
Ed0 d0 s0 ctrl 0 -1
Xq0 d0 g0 s0 s0 sky130_fd_pr__pfet_01v8 w=5.0 l=0.3 nf=1 ad=1.45 as=1.45 pd=10.58 ps=10.58 nrd=0.057999999999999996 nrs=0.057999999999999996
Vs1 s1 0 1.8
Vg1 g1 s1 -1.0
Ed1 d1 s1 ctrl 0 -1
Xq1 d1 g1 s1 s1 sky130_fd_pr__pfet_01v8 w=5.0 l=0.3 nf=1 ad=1.45 as=1.45 pd=10.58 ps=10.58 nrd=0.057999999999999996 nrs=0.057999999999999996
Vs2 s2 0 1.8
Vg2 g2 s2 -1.2
Ed2 d2 s2 ctrl 0 -1
Xq2 d2 g2 s2 s2 sky130_fd_pr__pfet_01v8 w=5.0 l=0.3 nf=1 ad=1.45 as=1.45 pd=10.58 ps=10.58 nrd=0.057999999999999996 nrs=0.057999999999999996
Vs3 s3 0 1.8
Vg3 g3 s3 -1.5
Ed3 d3 s3 ctrl 0 -1
Xq3 d3 g3 s3 s3 sky130_fd_pr__pfet_01v8 w=5.0 l=0.3 nf=1 ad=1.45 as=1.45 pd=10.58 ps=10.58 nrd=0.057999999999999996 nrs=0.057999999999999996
Vs4 s4 0 1.8
Vg4 g4 s4 -1.8
Ed4 d4 s4 ctrl 0 -1
Xq4 d4 g4 s4 s4 sky130_fd_pr__pfet_01v8 w=5.0 l=0.3 nf=1 ad=1.45 as=1.45 pd=10.58 ps=10.58 nrd=0.057999999999999996 nrs=0.057999999999999996
.save v(ctrl) @m.xq0.msky130_fd_pr__pfet_01v8[id] @m.xq0.msky130_fd_pr__pfet_01v8[gm] @m.xq0.msky130_fd_pr__pfet_01v8[gds] @m.xq0.msky130_fd_pr__pfet_01v8[cgg] @m.xq0.msky130_fd_pr__pfet_01v8[vth] @m.xq0.msky130_fd_pr__pfet_01v8[vdsat] @m.xq1.msky130_fd_pr__pfet_01v8[id] @m.xq1.msky130_fd_pr__pfet_01v8[gm] @m.xq1.msky130_fd_pr__pfet_01v8[gds] @m.xq1.msky130_fd_pr__pfet_01v8[cgg] @m.xq1.msky130_fd_pr__pfet_01v8[vth] @m.xq1.msky130_fd_pr__pfet_01v8[vdsat] @m.xq2.msky130_fd_pr__pfet_01v8[id] @m.xq2.msky130_fd_pr__pfet_01v8[gm] @m.xq2.msky130_fd_pr__pfet_01v8[gds] @m.xq2.msky130_fd_pr__pfet_01v8[cgg] @m.xq2.msky130_fd_pr__pfet_01v8[vth] @m.xq2.msky130_fd_pr__pfet_01v8[vdsat] @m.xq3.msky130_fd_pr__pfet_01v8[id] @m.xq3.msky130_fd_pr__pfet_01v8[gm] @m.xq3.msky130_fd_pr__pfet_01v8[gds] @m.xq3.msky130_fd_pr__pfet_01v8[cgg] @m.xq3.msky130_fd_pr__pfet_01v8[vth] @m.xq3.msky130_fd_pr__pfet_01v8[vdsat] @m.xq4.msky130_fd_pr__pfet_01v8[id] @m.xq4.msky130_fd_pr__pfet_01v8[gm] @m.xq4.msky130_fd_pr__pfet_01v8[gds] @m.xq4.msky130_fd_pr__pfet_01v8[cgg] @m.xq4.msky130_fd_pr__pfet_01v8[vth] @m.xq4.msky130_fd_pr__pfet_01v8[vdsat]
.control
set wr_singlescale
set wr_vecnames
set numdgt=15
dc Vctrl 0 0.5 0.005
wrdata table.tsv @m.xq0.msky130_fd_pr__pfet_01v8[id] @m.xq0.msky130_fd_pr__pfet_01v8[gm] @m.xq0.msky130_fd_pr__pfet_01v8[gds] @m.xq0.msky130_fd_pr__pfet_01v8[cgg] @m.xq0.msky130_fd_pr__pfet_01v8[vth] @m.xq0.msky130_fd_pr__pfet_01v8[vdsat] @m.xq1.msky130_fd_pr__pfet_01v8[id] @m.xq1.msky130_fd_pr__pfet_01v8[gm] @m.xq1.msky130_fd_pr__pfet_01v8[gds] @m.xq1.msky130_fd_pr__pfet_01v8[cgg] @m.xq1.msky130_fd_pr__pfet_01v8[vth] @m.xq1.msky130_fd_pr__pfet_01v8[vdsat] @m.xq2.msky130_fd_pr__pfet_01v8[id] @m.xq2.msky130_fd_pr__pfet_01v8[gm] @m.xq2.msky130_fd_pr__pfet_01v8[gds] @m.xq2.msky130_fd_pr__pfet_01v8[cgg] @m.xq2.msky130_fd_pr__pfet_01v8[vth] @m.xq2.msky130_fd_pr__pfet_01v8[vdsat] @m.xq3.msky130_fd_pr__pfet_01v8[id] @m.xq3.msky130_fd_pr__pfet_01v8[gm] @m.xq3.msky130_fd_pr__pfet_01v8[gds] @m.xq3.msky130_fd_pr__pfet_01v8[cgg] @m.xq3.msky130_fd_pr__pfet_01v8[vth] @m.xq3.msky130_fd_pr__pfet_01v8[vdsat] @m.xq4.msky130_fd_pr__pfet_01v8[id] @m.xq4.msky130_fd_pr__pfet_01v8[gm] @m.xq4.msky130_fd_pr__pfet_01v8[gds] @m.xq4.msky130_fd_pr__pfet_01v8[cgg] @m.xq4.msky130_fd_pr__pfet_01v8[vth] @m.xq4.msky130_fd_pr__pfet_01v8[vdsat]
quit
.endc
.end
