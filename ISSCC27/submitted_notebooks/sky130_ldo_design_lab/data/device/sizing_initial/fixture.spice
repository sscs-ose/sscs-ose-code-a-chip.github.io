width_validation
.lib "${SKY130_MODEL}" tt
.option scale=1e-6
.temp 27
Vctrl ctrl 0 0
Vs0 s0 0 0
Eg0 g0 s0 ctrl 0 1
Vd0 d0 s0 0.9
Xq0 d0 g0 s0 s0 sky130_fd_pr__nfet_01v8 w=1.2676648172593348 l=0.3 nf=1 ad=0.36762279700520706 as=0.36762279700520706 pd=3.1153296345186696 ps=3.1153296345186696 nrd=0.22876709683161675 nrs=0.22876709683161675
.save v(ctrl) @m.xq0.msky130_fd_pr__nfet_01v8[id] @m.xq0.msky130_fd_pr__nfet_01v8[gm] @m.xq0.msky130_fd_pr__nfet_01v8[gds] @m.xq0.msky130_fd_pr__nfet_01v8[cgg] @m.xq0.msky130_fd_pr__nfet_01v8[vth] @m.xq0.msky130_fd_pr__nfet_01v8[vdsat]
.control
set wr_singlescale
set wr_vecnames
set numdgt=15
dc Vctrl 0 1.8 0.001
wrdata table.tsv @m.xq0.msky130_fd_pr__nfet_01v8[id] @m.xq0.msky130_fd_pr__nfet_01v8[gm] @m.xq0.msky130_fd_pr__nfet_01v8[gds] @m.xq0.msky130_fd_pr__nfet_01v8[cgg] @m.xq0.msky130_fd_pr__nfet_01v8[vth] @m.xq0.msky130_fd_pr__nfet_01v8[vdsat]
quit
.endc
.end
