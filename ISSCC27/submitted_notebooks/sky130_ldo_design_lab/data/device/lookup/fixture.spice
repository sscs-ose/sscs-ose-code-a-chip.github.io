lookup
.lib "${SKY130_MODEL}" tt
.option scale=1e-6
.temp 27
Vctrl ctrl 0 0
Vs0 s0 0 0
Eg0 g0 s0 ctrl 0 1
Vd0 d0 s0 0.1
Xq0 d0 g0 s0 s0 sky130_fd_pr__nfet_01v8 w=5.0 l=0.15 nf=1 ad=1.45 as=1.45 pd=10.58 ps=10.58 nrd=0.057999999999999996 nrs=0.057999999999999996
Vs1 s1 0 0
Eg1 g1 s1 ctrl 0 1
Vd1 d1 s1 0.3
Xq1 d1 g1 s1 s1 sky130_fd_pr__nfet_01v8 w=5.0 l=0.15 nf=1 ad=1.45 as=1.45 pd=10.58 ps=10.58 nrd=0.057999999999999996 nrs=0.057999999999999996
Vs2 s2 0 0
Eg2 g2 s2 ctrl 0 1
Vd2 d2 s2 0.9
Xq2 d2 g2 s2 s2 sky130_fd_pr__nfet_01v8 w=5.0 l=0.15 nf=1 ad=1.45 as=1.45 pd=10.58 ps=10.58 nrd=0.057999999999999996 nrs=0.057999999999999996
Vs3 s3 0 0
Eg3 g3 s3 ctrl 0 1
Vd3 d3 s3 0.1
Xq3 d3 g3 s3 s3 sky130_fd_pr__nfet_01v8 w=5.0 l=0.3 nf=1 ad=1.45 as=1.45 pd=10.58 ps=10.58 nrd=0.057999999999999996 nrs=0.057999999999999996
Vs4 s4 0 0
Eg4 g4 s4 ctrl 0 1
Vd4 d4 s4 0.3
Xq4 d4 g4 s4 s4 sky130_fd_pr__nfet_01v8 w=5.0 l=0.3 nf=1 ad=1.45 as=1.45 pd=10.58 ps=10.58 nrd=0.057999999999999996 nrs=0.057999999999999996
Vs5 s5 0 0
Eg5 g5 s5 ctrl 0 1
Vd5 d5 s5 0.9
Xq5 d5 g5 s5 s5 sky130_fd_pr__nfet_01v8 w=5.0 l=0.3 nf=1 ad=1.45 as=1.45 pd=10.58 ps=10.58 nrd=0.057999999999999996 nrs=0.057999999999999996
Vs6 s6 0 0
Eg6 g6 s6 ctrl 0 1
Vd6 d6 s6 0.1
Xq6 d6 g6 s6 s6 sky130_fd_pr__nfet_01v8 w=5.0 l=1.0 nf=1 ad=1.45 as=1.45 pd=10.58 ps=10.58 nrd=0.057999999999999996 nrs=0.057999999999999996
Vs7 s7 0 0
Eg7 g7 s7 ctrl 0 1
Vd7 d7 s7 0.3
Xq7 d7 g7 s7 s7 sky130_fd_pr__nfet_01v8 w=5.0 l=1.0 nf=1 ad=1.45 as=1.45 pd=10.58 ps=10.58 nrd=0.057999999999999996 nrs=0.057999999999999996
Vs8 s8 0 0
Eg8 g8 s8 ctrl 0 1
Vd8 d8 s8 0.9
Xq8 d8 g8 s8 s8 sky130_fd_pr__nfet_01v8 w=5.0 l=1.0 nf=1 ad=1.45 as=1.45 pd=10.58 ps=10.58 nrd=0.057999999999999996 nrs=0.057999999999999996
Vs9 s9 0 1.8
Eg9 g9 s9 ctrl 0 -1
Vd9 d9 s9 -0.1
Xq9 d9 g9 s9 s9 sky130_fd_pr__pfet_01v8 w=5.0 l=0.15 nf=1 ad=1.45 as=1.45 pd=10.58 ps=10.58 nrd=0.057999999999999996 nrs=0.057999999999999996
Vs10 s10 0 1.8
Eg10 g10 s10 ctrl 0 -1
Vd10 d10 s10 -0.3
Xq10 d10 g10 s10 s10 sky130_fd_pr__pfet_01v8 w=5.0 l=0.15 nf=1 ad=1.45 as=1.45 pd=10.58 ps=10.58 nrd=0.057999999999999996 nrs=0.057999999999999996
Vs11 s11 0 1.8
Eg11 g11 s11 ctrl 0 -1
Vd11 d11 s11 -0.9
Xq11 d11 g11 s11 s11 sky130_fd_pr__pfet_01v8 w=5.0 l=0.15 nf=1 ad=1.45 as=1.45 pd=10.58 ps=10.58 nrd=0.057999999999999996 nrs=0.057999999999999996
Vs12 s12 0 1.8
Eg12 g12 s12 ctrl 0 -1
Vd12 d12 s12 -0.1
Xq12 d12 g12 s12 s12 sky130_fd_pr__pfet_01v8 w=5.0 l=0.3 nf=1 ad=1.45 as=1.45 pd=10.58 ps=10.58 nrd=0.057999999999999996 nrs=0.057999999999999996
Vs13 s13 0 1.8
Eg13 g13 s13 ctrl 0 -1
Vd13 d13 s13 -0.3
Xq13 d13 g13 s13 s13 sky130_fd_pr__pfet_01v8 w=5.0 l=0.3 nf=1 ad=1.45 as=1.45 pd=10.58 ps=10.58 nrd=0.057999999999999996 nrs=0.057999999999999996
Vs14 s14 0 1.8
Eg14 g14 s14 ctrl 0 -1
Vd14 d14 s14 -0.9
Xq14 d14 g14 s14 s14 sky130_fd_pr__pfet_01v8 w=5.0 l=0.3 nf=1 ad=1.45 as=1.45 pd=10.58 ps=10.58 nrd=0.057999999999999996 nrs=0.057999999999999996
Vs15 s15 0 1.8
Eg15 g15 s15 ctrl 0 -1
Vd15 d15 s15 -0.1
Xq15 d15 g15 s15 s15 sky130_fd_pr__pfet_01v8 w=5.0 l=1.0 nf=1 ad=1.45 as=1.45 pd=10.58 ps=10.58 nrd=0.057999999999999996 nrs=0.057999999999999996
Vs16 s16 0 1.8
Eg16 g16 s16 ctrl 0 -1
Vd16 d16 s16 -0.3
Xq16 d16 g16 s16 s16 sky130_fd_pr__pfet_01v8 w=5.0 l=1.0 nf=1 ad=1.45 as=1.45 pd=10.58 ps=10.58 nrd=0.057999999999999996 nrs=0.057999999999999996
Vs17 s17 0 1.8
Eg17 g17 s17 ctrl 0 -1
Vd17 d17 s17 -0.9
Xq17 d17 g17 s17 s17 sky130_fd_pr__pfet_01v8 w=5.0 l=1.0 nf=1 ad=1.45 as=1.45 pd=10.58 ps=10.58 nrd=0.057999999999999996 nrs=0.057999999999999996
.save v(ctrl) @m.xq0.msky130_fd_pr__nfet_01v8[id] @m.xq0.msky130_fd_pr__nfet_01v8[gm] @m.xq0.msky130_fd_pr__nfet_01v8[gds] @m.xq0.msky130_fd_pr__nfet_01v8[cgg] @m.xq0.msky130_fd_pr__nfet_01v8[vth] @m.xq0.msky130_fd_pr__nfet_01v8[vdsat] @m.xq1.msky130_fd_pr__nfet_01v8[id] @m.xq1.msky130_fd_pr__nfet_01v8[gm] @m.xq1.msky130_fd_pr__nfet_01v8[gds] @m.xq1.msky130_fd_pr__nfet_01v8[cgg] @m.xq1.msky130_fd_pr__nfet_01v8[vth] @m.xq1.msky130_fd_pr__nfet_01v8[vdsat] @m.xq2.msky130_fd_pr__nfet_01v8[id] @m.xq2.msky130_fd_pr__nfet_01v8[gm] @m.xq2.msky130_fd_pr__nfet_01v8[gds] @m.xq2.msky130_fd_pr__nfet_01v8[cgg] @m.xq2.msky130_fd_pr__nfet_01v8[vth] @m.xq2.msky130_fd_pr__nfet_01v8[vdsat] @m.xq3.msky130_fd_pr__nfet_01v8[id] @m.xq3.msky130_fd_pr__nfet_01v8[gm] @m.xq3.msky130_fd_pr__nfet_01v8[gds] @m.xq3.msky130_fd_pr__nfet_01v8[cgg] @m.xq3.msky130_fd_pr__nfet_01v8[vth] @m.xq3.msky130_fd_pr__nfet_01v8[vdsat] @m.xq4.msky130_fd_pr__nfet_01v8[id] @m.xq4.msky130_fd_pr__nfet_01v8[gm] @m.xq4.msky130_fd_pr__nfet_01v8[gds] @m.xq4.msky130_fd_pr__nfet_01v8[cgg] @m.xq4.msky130_fd_pr__nfet_01v8[vth] @m.xq4.msky130_fd_pr__nfet_01v8[vdsat] @m.xq5.msky130_fd_pr__nfet_01v8[id] @m.xq5.msky130_fd_pr__nfet_01v8[gm] @m.xq5.msky130_fd_pr__nfet_01v8[gds] @m.xq5.msky130_fd_pr__nfet_01v8[cgg] @m.xq5.msky130_fd_pr__nfet_01v8[vth] @m.xq5.msky130_fd_pr__nfet_01v8[vdsat] @m.xq6.msky130_fd_pr__nfet_01v8[id] @m.xq6.msky130_fd_pr__nfet_01v8[gm] @m.xq6.msky130_fd_pr__nfet_01v8[gds] @m.xq6.msky130_fd_pr__nfet_01v8[cgg] @m.xq6.msky130_fd_pr__nfet_01v8[vth] @m.xq6.msky130_fd_pr__nfet_01v8[vdsat] @m.xq7.msky130_fd_pr__nfet_01v8[id] @m.xq7.msky130_fd_pr__nfet_01v8[gm] @m.xq7.msky130_fd_pr__nfet_01v8[gds] @m.xq7.msky130_fd_pr__nfet_01v8[cgg] @m.xq7.msky130_fd_pr__nfet_01v8[vth] @m.xq7.msky130_fd_pr__nfet_01v8[vdsat] @m.xq8.msky130_fd_pr__nfet_01v8[id] @m.xq8.msky130_fd_pr__nfet_01v8[gm] @m.xq8.msky130_fd_pr__nfet_01v8[gds] @m.xq8.msky130_fd_pr__nfet_01v8[cgg] @m.xq8.msky130_fd_pr__nfet_01v8[vth] @m.xq8.msky130_fd_pr__nfet_01v8[vdsat] @m.xq9.msky130_fd_pr__pfet_01v8[id] @m.xq9.msky130_fd_pr__pfet_01v8[gm] @m.xq9.msky130_fd_pr__pfet_01v8[gds] @m.xq9.msky130_fd_pr__pfet_01v8[cgg] @m.xq9.msky130_fd_pr__pfet_01v8[vth] @m.xq9.msky130_fd_pr__pfet_01v8[vdsat] @m.xq10.msky130_fd_pr__pfet_01v8[id] @m.xq10.msky130_fd_pr__pfet_01v8[gm] @m.xq10.msky130_fd_pr__pfet_01v8[gds] @m.xq10.msky130_fd_pr__pfet_01v8[cgg] @m.xq10.msky130_fd_pr__pfet_01v8[vth] @m.xq10.msky130_fd_pr__pfet_01v8[vdsat] @m.xq11.msky130_fd_pr__pfet_01v8[id] @m.xq11.msky130_fd_pr__pfet_01v8[gm] @m.xq11.msky130_fd_pr__pfet_01v8[gds] @m.xq11.msky130_fd_pr__pfet_01v8[cgg] @m.xq11.msky130_fd_pr__pfet_01v8[vth] @m.xq11.msky130_fd_pr__pfet_01v8[vdsat] @m.xq12.msky130_fd_pr__pfet_01v8[id] @m.xq12.msky130_fd_pr__pfet_01v8[gm] @m.xq12.msky130_fd_pr__pfet_01v8[gds] @m.xq12.msky130_fd_pr__pfet_01v8[cgg] @m.xq12.msky130_fd_pr__pfet_01v8[vth] @m.xq12.msky130_fd_pr__pfet_01v8[vdsat] @m.xq13.msky130_fd_pr__pfet_01v8[id] @m.xq13.msky130_fd_pr__pfet_01v8[gm] @m.xq13.msky130_fd_pr__pfet_01v8[gds] @m.xq13.msky130_fd_pr__pfet_01v8[cgg] @m.xq13.msky130_fd_pr__pfet_01v8[vth] @m.xq13.msky130_fd_pr__pfet_01v8[vdsat] @m.xq14.msky130_fd_pr__pfet_01v8[id] @m.xq14.msky130_fd_pr__pfet_01v8[gm] @m.xq14.msky130_fd_pr__pfet_01v8[gds] @m.xq14.msky130_fd_pr__pfet_01v8[cgg] @m.xq14.msky130_fd_pr__pfet_01v8[vth] @m.xq14.msky130_fd_pr__pfet_01v8[vdsat] @m.xq15.msky130_fd_pr__pfet_01v8[id] @m.xq15.msky130_fd_pr__pfet_01v8[gm] @m.xq15.msky130_fd_pr__pfet_01v8[gds] @m.xq15.msky130_fd_pr__pfet_01v8[cgg] @m.xq15.msky130_fd_pr__pfet_01v8[vth] @m.xq15.msky130_fd_pr__pfet_01v8[vdsat] @m.xq16.msky130_fd_pr__pfet_01v8[id] @m.xq16.msky130_fd_pr__pfet_01v8[gm] @m.xq16.msky130_fd_pr__pfet_01v8[gds] @m.xq16.msky130_fd_pr__pfet_01v8[cgg] @m.xq16.msky130_fd_pr__pfet_01v8[vth] @m.xq16.msky130_fd_pr__pfet_01v8[vdsat] @m.xq17.msky130_fd_pr__pfet_01v8[id] @m.xq17.msky130_fd_pr__pfet_01v8[gm] @m.xq17.msky130_fd_pr__pfet_01v8[gds] @m.xq17.msky130_fd_pr__pfet_01v8[cgg] @m.xq17.msky130_fd_pr__pfet_01v8[vth] @m.xq17.msky130_fd_pr__pfet_01v8[vdsat]
.control
set wr_singlescale
set wr_vecnames
set numdgt=15
dc Vctrl 0 1.8 0.005
wrdata table.tsv @m.xq0.msky130_fd_pr__nfet_01v8[id] @m.xq0.msky130_fd_pr__nfet_01v8[gm] @m.xq0.msky130_fd_pr__nfet_01v8[gds] @m.xq0.msky130_fd_pr__nfet_01v8[cgg] @m.xq0.msky130_fd_pr__nfet_01v8[vth] @m.xq0.msky130_fd_pr__nfet_01v8[vdsat] @m.xq1.msky130_fd_pr__nfet_01v8[id] @m.xq1.msky130_fd_pr__nfet_01v8[gm] @m.xq1.msky130_fd_pr__nfet_01v8[gds] @m.xq1.msky130_fd_pr__nfet_01v8[cgg] @m.xq1.msky130_fd_pr__nfet_01v8[vth] @m.xq1.msky130_fd_pr__nfet_01v8[vdsat] @m.xq2.msky130_fd_pr__nfet_01v8[id] @m.xq2.msky130_fd_pr__nfet_01v8[gm] @m.xq2.msky130_fd_pr__nfet_01v8[gds] @m.xq2.msky130_fd_pr__nfet_01v8[cgg] @m.xq2.msky130_fd_pr__nfet_01v8[vth] @m.xq2.msky130_fd_pr__nfet_01v8[vdsat] @m.xq3.msky130_fd_pr__nfet_01v8[id] @m.xq3.msky130_fd_pr__nfet_01v8[gm] @m.xq3.msky130_fd_pr__nfet_01v8[gds] @m.xq3.msky130_fd_pr__nfet_01v8[cgg] @m.xq3.msky130_fd_pr__nfet_01v8[vth] @m.xq3.msky130_fd_pr__nfet_01v8[vdsat] @m.xq4.msky130_fd_pr__nfet_01v8[id] @m.xq4.msky130_fd_pr__nfet_01v8[gm] @m.xq4.msky130_fd_pr__nfet_01v8[gds] @m.xq4.msky130_fd_pr__nfet_01v8[cgg] @m.xq4.msky130_fd_pr__nfet_01v8[vth] @m.xq4.msky130_fd_pr__nfet_01v8[vdsat] @m.xq5.msky130_fd_pr__nfet_01v8[id] @m.xq5.msky130_fd_pr__nfet_01v8[gm] @m.xq5.msky130_fd_pr__nfet_01v8[gds] @m.xq5.msky130_fd_pr__nfet_01v8[cgg] @m.xq5.msky130_fd_pr__nfet_01v8[vth] @m.xq5.msky130_fd_pr__nfet_01v8[vdsat] @m.xq6.msky130_fd_pr__nfet_01v8[id] @m.xq6.msky130_fd_pr__nfet_01v8[gm] @m.xq6.msky130_fd_pr__nfet_01v8[gds] @m.xq6.msky130_fd_pr__nfet_01v8[cgg] @m.xq6.msky130_fd_pr__nfet_01v8[vth] @m.xq6.msky130_fd_pr__nfet_01v8[vdsat] @m.xq7.msky130_fd_pr__nfet_01v8[id] @m.xq7.msky130_fd_pr__nfet_01v8[gm] @m.xq7.msky130_fd_pr__nfet_01v8[gds] @m.xq7.msky130_fd_pr__nfet_01v8[cgg] @m.xq7.msky130_fd_pr__nfet_01v8[vth] @m.xq7.msky130_fd_pr__nfet_01v8[vdsat] @m.xq8.msky130_fd_pr__nfet_01v8[id] @m.xq8.msky130_fd_pr__nfet_01v8[gm] @m.xq8.msky130_fd_pr__nfet_01v8[gds] @m.xq8.msky130_fd_pr__nfet_01v8[cgg] @m.xq8.msky130_fd_pr__nfet_01v8[vth] @m.xq8.msky130_fd_pr__nfet_01v8[vdsat] @m.xq9.msky130_fd_pr__pfet_01v8[id] @m.xq9.msky130_fd_pr__pfet_01v8[gm] @m.xq9.msky130_fd_pr__pfet_01v8[gds] @m.xq9.msky130_fd_pr__pfet_01v8[cgg] @m.xq9.msky130_fd_pr__pfet_01v8[vth] @m.xq9.msky130_fd_pr__pfet_01v8[vdsat] @m.xq10.msky130_fd_pr__pfet_01v8[id] @m.xq10.msky130_fd_pr__pfet_01v8[gm] @m.xq10.msky130_fd_pr__pfet_01v8[gds] @m.xq10.msky130_fd_pr__pfet_01v8[cgg] @m.xq10.msky130_fd_pr__pfet_01v8[vth] @m.xq10.msky130_fd_pr__pfet_01v8[vdsat] @m.xq11.msky130_fd_pr__pfet_01v8[id] @m.xq11.msky130_fd_pr__pfet_01v8[gm] @m.xq11.msky130_fd_pr__pfet_01v8[gds] @m.xq11.msky130_fd_pr__pfet_01v8[cgg] @m.xq11.msky130_fd_pr__pfet_01v8[vth] @m.xq11.msky130_fd_pr__pfet_01v8[vdsat] @m.xq12.msky130_fd_pr__pfet_01v8[id] @m.xq12.msky130_fd_pr__pfet_01v8[gm] @m.xq12.msky130_fd_pr__pfet_01v8[gds] @m.xq12.msky130_fd_pr__pfet_01v8[cgg] @m.xq12.msky130_fd_pr__pfet_01v8[vth] @m.xq12.msky130_fd_pr__pfet_01v8[vdsat] @m.xq13.msky130_fd_pr__pfet_01v8[id] @m.xq13.msky130_fd_pr__pfet_01v8[gm] @m.xq13.msky130_fd_pr__pfet_01v8[gds] @m.xq13.msky130_fd_pr__pfet_01v8[cgg] @m.xq13.msky130_fd_pr__pfet_01v8[vth] @m.xq13.msky130_fd_pr__pfet_01v8[vdsat] @m.xq14.msky130_fd_pr__pfet_01v8[id] @m.xq14.msky130_fd_pr__pfet_01v8[gm] @m.xq14.msky130_fd_pr__pfet_01v8[gds] @m.xq14.msky130_fd_pr__pfet_01v8[cgg] @m.xq14.msky130_fd_pr__pfet_01v8[vth] @m.xq14.msky130_fd_pr__pfet_01v8[vdsat] @m.xq15.msky130_fd_pr__pfet_01v8[id] @m.xq15.msky130_fd_pr__pfet_01v8[gm] @m.xq15.msky130_fd_pr__pfet_01v8[gds] @m.xq15.msky130_fd_pr__pfet_01v8[cgg] @m.xq15.msky130_fd_pr__pfet_01v8[vth] @m.xq15.msky130_fd_pr__pfet_01v8[vdsat] @m.xq16.msky130_fd_pr__pfet_01v8[id] @m.xq16.msky130_fd_pr__pfet_01v8[gm] @m.xq16.msky130_fd_pr__pfet_01v8[gds] @m.xq16.msky130_fd_pr__pfet_01v8[cgg] @m.xq16.msky130_fd_pr__pfet_01v8[vth] @m.xq16.msky130_fd_pr__pfet_01v8[vdsat] @m.xq17.msky130_fd_pr__pfet_01v8[id] @m.xq17.msky130_fd_pr__pfet_01v8[gm] @m.xq17.msky130_fd_pr__pfet_01v8[gds] @m.xq17.msky130_fd_pr__pfet_01v8[cgg] @m.xq17.msky130_fd_pr__pfet_01v8[vth] @m.xq17.msky130_fd_pr__pfet_01v8[vdsat]
quit
.endc
.end
