* P0-1R write grid pw=10ns rdrv=0
.option post=0 ingold=2 numdgt=10 measdgt=10 method=gear
.hdl "/home/grads/s/seokjindaveoh/work/ep_demo/char/va/sky130_fd_pr_reram__reram_cell.va"
.lib "/home/grads/s/seokjindaveoh/work/ep_demo/char/models/sky130_5v_tt.lib.spice" tt
.temp 27
.param tstep=1e-11
Vh th 0 0.1
Xrh th 0 sky130_fd_pr_reram__reram_cell Tfilament_0=3.3e-9 t_step=tstep
Vl tl 0 0.1
Xrl tl 0 sky130_fd_pr_reram__reram_cell Tfilament_0=4.9e-9 t_step=tstep
.measure tran ih find i(vh) at=0.5n
.measure tran il find i(vl) at=0.5n
.param tf0=3.3e-9 vte=0 vbe=0
Vte tes 0 PWL(0 0 5.0000e-09 0 6.0000e-09 vte 1.6000e-08 vte 1.7000e-08 0 2.7000e-08 0 2.8000e-08 0.1)
Vbe bes 0 PWL(0 0 5.0000e-09 0 6.0000e-09 vbe 1.6000e-08 vbe 1.7000e-08 0)
Rd1 tes te1 0.001
Vsns te1 te 0
Xr te be sky130_fd_pr_reram__reram_cell Tfilament_0=tf0 t_step=tstep
Rd2 be bes 0.001
.measure tran ird find i(vsns) at=4.6000e-08
.measure tran vrd find v(te,be) at=4.6000e-08
.measure tran iwmax max par('abs(i(vsns))') from=5.0000e-09 to=1.7000e-08
.measure tran vwmax max par('abs(v(te,be))') from=5.0000e-09 to=1.7000e-08
.data dw
+ tf0 vte vbe
+ 3.934877e-09 5.000000e-01 0.000000e+00
+ 3.934877e-09 0.000000e+00 5.000000e-01
+ 3.934877e-09 6.000000e-01 0.000000e+00
+ 3.934877e-09 0.000000e+00 6.000000e-01
+ 3.934877e-09 7.000000e-01 0.000000e+00
+ 3.934877e-09 0.000000e+00 7.000000e-01
+ 3.934877e-09 8.000000e-01 0.000000e+00
+ 3.934877e-09 0.000000e+00 8.000000e-01
+ 3.934877e-09 9.000000e-01 0.000000e+00
+ 3.934877e-09 0.000000e+00 9.000000e-01
+ 3.934877e-09 1.000000e+00 0.000000e+00
+ 3.934877e-09 0.000000e+00 1.000000e+00
+ 3.934877e-09 1.100000e+00 0.000000e+00
+ 3.934877e-09 0.000000e+00 1.100000e+00
+ 3.934877e-09 1.200000e+00 0.000000e+00
+ 3.934877e-09 0.000000e+00 1.200000e+00
+ 3.934877e-09 1.300000e+00 0.000000e+00
+ 3.934877e-09 0.000000e+00 1.300000e+00
+ 3.934877e-09 1.400000e+00 0.000000e+00
+ 3.934877e-09 0.000000e+00 1.400000e+00
+ 3.934877e-09 1.500000e+00 0.000000e+00
+ 3.934877e-09 0.000000e+00 1.500000e+00
+ 3.934877e-09 1.600000e+00 0.000000e+00
+ 3.934877e-09 0.000000e+00 1.600000e+00
+ 3.934877e-09 1.700000e+00 0.000000e+00
+ 3.934877e-09 0.000000e+00 1.700000e+00
+ 3.934877e-09 1.800000e+00 0.000000e+00
+ 3.934877e-09 0.000000e+00 1.800000e+00
+ 4.075405e-09 5.000000e-01 0.000000e+00
+ 4.075405e-09 0.000000e+00 5.000000e-01
+ 4.075405e-09 6.000000e-01 0.000000e+00
+ 4.075405e-09 0.000000e+00 6.000000e-01
+ 4.075405e-09 7.000000e-01 0.000000e+00
+ 4.075405e-09 0.000000e+00 7.000000e-01
+ 4.075405e-09 8.000000e-01 0.000000e+00
+ 4.075405e-09 0.000000e+00 8.000000e-01
+ 4.075405e-09 9.000000e-01 0.000000e+00
+ 4.075405e-09 0.000000e+00 9.000000e-01
+ 4.075405e-09 1.000000e+00 0.000000e+00
+ 4.075405e-09 0.000000e+00 1.000000e+00
+ 4.075405e-09 1.100000e+00 0.000000e+00
+ 4.075405e-09 0.000000e+00 1.100000e+00
+ 4.075405e-09 1.200000e+00 0.000000e+00
+ 4.075405e-09 0.000000e+00 1.200000e+00
+ 4.075405e-09 1.300000e+00 0.000000e+00
+ 4.075405e-09 0.000000e+00 1.300000e+00
+ 4.075405e-09 1.400000e+00 0.000000e+00
+ 4.075405e-09 0.000000e+00 1.400000e+00
+ 4.075405e-09 1.500000e+00 0.000000e+00
+ 4.075405e-09 0.000000e+00 1.500000e+00
+ 4.075405e-09 1.600000e+00 0.000000e+00
+ 4.075405e-09 0.000000e+00 1.600000e+00
+ 4.075405e-09 1.700000e+00 0.000000e+00
+ 4.075405e-09 0.000000e+00 1.700000e+00
+ 4.075405e-09 1.800000e+00 0.000000e+00
+ 4.075405e-09 0.000000e+00 1.800000e+00
+ 4.186949e-09 5.000000e-01 0.000000e+00
+ 4.186949e-09 0.000000e+00 5.000000e-01
+ 4.186949e-09 6.000000e-01 0.000000e+00
+ 4.186949e-09 0.000000e+00 6.000000e-01
+ 4.186949e-09 7.000000e-01 0.000000e+00
+ 4.186949e-09 0.000000e+00 7.000000e-01
+ 4.186949e-09 8.000000e-01 0.000000e+00
+ 4.186949e-09 0.000000e+00 8.000000e-01
+ 4.186949e-09 9.000000e-01 0.000000e+00
+ 4.186949e-09 0.000000e+00 9.000000e-01
+ 4.186949e-09 1.000000e+00 0.000000e+00
+ 4.186949e-09 0.000000e+00 1.000000e+00
+ 4.186949e-09 1.100000e+00 0.000000e+00
+ 4.186949e-09 0.000000e+00 1.100000e+00
+ 4.186949e-09 1.200000e+00 0.000000e+00
+ 4.186949e-09 0.000000e+00 1.200000e+00
+ 4.186949e-09 1.300000e+00 0.000000e+00
+ 4.186949e-09 0.000000e+00 1.300000e+00
+ 4.186949e-09 1.400000e+00 0.000000e+00
+ 4.186949e-09 0.000000e+00 1.400000e+00
+ 4.186949e-09 1.500000e+00 0.000000e+00
+ 4.186949e-09 0.000000e+00 1.500000e+00
+ 4.186949e-09 1.600000e+00 0.000000e+00
+ 4.186949e-09 0.000000e+00 1.600000e+00
+ 4.186949e-09 1.700000e+00 0.000000e+00
+ 4.186949e-09 0.000000e+00 1.700000e+00
+ 4.186949e-09 1.800000e+00 0.000000e+00
+ 4.186949e-09 0.000000e+00 1.800000e+00
+ 4.266090e-09 5.000000e-01 0.000000e+00
+ 4.266090e-09 0.000000e+00 5.000000e-01
+ 4.266090e-09 6.000000e-01 0.000000e+00
+ 4.266090e-09 0.000000e+00 6.000000e-01
+ 4.266090e-09 7.000000e-01 0.000000e+00
+ 4.266090e-09 0.000000e+00 7.000000e-01
+ 4.266090e-09 8.000000e-01 0.000000e+00
+ 4.266090e-09 0.000000e+00 8.000000e-01
+ 4.266090e-09 9.000000e-01 0.000000e+00
+ 4.266090e-09 0.000000e+00 9.000000e-01
+ 4.266090e-09 1.000000e+00 0.000000e+00
+ 4.266090e-09 0.000000e+00 1.000000e+00
+ 4.266090e-09 1.100000e+00 0.000000e+00
+ 4.266090e-09 0.000000e+00 1.100000e+00
+ 4.266090e-09 1.200000e+00 0.000000e+00
+ 4.266090e-09 0.000000e+00 1.200000e+00
+ 4.266090e-09 1.300000e+00 0.000000e+00
+ 4.266090e-09 0.000000e+00 1.300000e+00
+ 4.266090e-09 1.400000e+00 0.000000e+00
+ 4.266090e-09 0.000000e+00 1.400000e+00
+ 4.266090e-09 1.500000e+00 0.000000e+00
+ 4.266090e-09 0.000000e+00 1.500000e+00
+ 4.266090e-09 1.600000e+00 0.000000e+00
+ 4.266090e-09 0.000000e+00 1.600000e+00
+ 4.266090e-09 1.700000e+00 0.000000e+00
+ 4.266090e-09 0.000000e+00 1.700000e+00
+ 4.266090e-09 1.800000e+00 0.000000e+00
+ 4.266090e-09 0.000000e+00 1.800000e+00
+ 4.377634e-09 5.000000e-01 0.000000e+00
+ 4.377634e-09 0.000000e+00 5.000000e-01
+ 4.377634e-09 6.000000e-01 0.000000e+00
+ 4.377634e-09 0.000000e+00 6.000000e-01
+ 4.377634e-09 7.000000e-01 0.000000e+00
+ 4.377634e-09 0.000000e+00 7.000000e-01
+ 4.377634e-09 8.000000e-01 0.000000e+00
+ 4.377634e-09 0.000000e+00 8.000000e-01
+ 4.377634e-09 9.000000e-01 0.000000e+00
+ 4.377634e-09 0.000000e+00 9.000000e-01
+ 4.377634e-09 1.000000e+00 0.000000e+00
+ 4.377634e-09 0.000000e+00 1.000000e+00
+ 4.377634e-09 1.100000e+00 0.000000e+00
+ 4.377634e-09 0.000000e+00 1.100000e+00
+ 4.377634e-09 1.200000e+00 0.000000e+00
+ 4.377634e-09 0.000000e+00 1.200000e+00
+ 4.377634e-09 1.300000e+00 0.000000e+00
+ 4.377634e-09 0.000000e+00 1.300000e+00
+ 4.377634e-09 1.400000e+00 0.000000e+00
+ 4.377634e-09 0.000000e+00 1.400000e+00
+ 4.377634e-09 1.500000e+00 0.000000e+00
+ 4.377634e-09 0.000000e+00 1.500000e+00
+ 4.377634e-09 1.600000e+00 0.000000e+00
+ 4.377634e-09 0.000000e+00 1.600000e+00
+ 4.377634e-09 1.700000e+00 0.000000e+00
+ 4.377634e-09 0.000000e+00 1.700000e+00
+ 4.377634e-09 1.800000e+00 0.000000e+00
+ 4.377634e-09 0.000000e+00 1.800000e+00
+ 4.456775e-09 5.000000e-01 0.000000e+00
+ 4.456775e-09 0.000000e+00 5.000000e-01
+ 4.456775e-09 6.000000e-01 0.000000e+00
+ 4.456775e-09 0.000000e+00 6.000000e-01
+ 4.456775e-09 7.000000e-01 0.000000e+00
+ 4.456775e-09 0.000000e+00 7.000000e-01
+ 4.456775e-09 8.000000e-01 0.000000e+00
+ 4.456775e-09 0.000000e+00 8.000000e-01
+ 4.456775e-09 9.000000e-01 0.000000e+00
+ 4.456775e-09 0.000000e+00 9.000000e-01
+ 4.456775e-09 1.000000e+00 0.000000e+00
+ 4.456775e-09 0.000000e+00 1.000000e+00
+ 4.456775e-09 1.100000e+00 0.000000e+00
+ 4.456775e-09 0.000000e+00 1.100000e+00
+ 4.456775e-09 1.200000e+00 0.000000e+00
+ 4.456775e-09 0.000000e+00 1.200000e+00
+ 4.456775e-09 1.300000e+00 0.000000e+00
+ 4.456775e-09 0.000000e+00 1.300000e+00
+ 4.456775e-09 1.400000e+00 0.000000e+00
+ 4.456775e-09 0.000000e+00 1.400000e+00
+ 4.456775e-09 1.500000e+00 0.000000e+00
+ 4.456775e-09 0.000000e+00 1.500000e+00
+ 4.456775e-09 1.600000e+00 0.000000e+00
+ 4.456775e-09 0.000000e+00 1.600000e+00
+ 4.456775e-09 1.700000e+00 0.000000e+00
+ 4.456775e-09 0.000000e+00 1.700000e+00
+ 4.456775e-09 1.800000e+00 0.000000e+00
+ 4.456775e-09 0.000000e+00 1.800000e+00
+ 4.568319e-09 5.000000e-01 0.000000e+00
+ 4.568319e-09 0.000000e+00 5.000000e-01
+ 4.568319e-09 6.000000e-01 0.000000e+00
+ 4.568319e-09 0.000000e+00 6.000000e-01
+ 4.568319e-09 7.000000e-01 0.000000e+00
+ 4.568319e-09 0.000000e+00 7.000000e-01
+ 4.568319e-09 8.000000e-01 0.000000e+00
+ 4.568319e-09 0.000000e+00 8.000000e-01
+ 4.568319e-09 9.000000e-01 0.000000e+00
+ 4.568319e-09 0.000000e+00 9.000000e-01
+ 4.568319e-09 1.000000e+00 0.000000e+00
+ 4.568319e-09 0.000000e+00 1.000000e+00
+ 4.568319e-09 1.100000e+00 0.000000e+00
+ 4.568319e-09 0.000000e+00 1.100000e+00
+ 4.568319e-09 1.200000e+00 0.000000e+00
+ 4.568319e-09 0.000000e+00 1.200000e+00
+ 4.568319e-09 1.300000e+00 0.000000e+00
+ 4.568319e-09 0.000000e+00 1.300000e+00
+ 4.568319e-09 1.400000e+00 0.000000e+00
+ 4.568319e-09 0.000000e+00 1.400000e+00
+ 4.568319e-09 1.500000e+00 0.000000e+00
+ 4.568319e-09 0.000000e+00 1.500000e+00
+ 4.568319e-09 1.600000e+00 0.000000e+00
+ 4.568319e-09 0.000000e+00 1.600000e+00
+ 4.568319e-09 1.700000e+00 0.000000e+00
+ 4.568319e-09 0.000000e+00 1.700000e+00
+ 4.568319e-09 1.800000e+00 0.000000e+00
+ 4.568319e-09 0.000000e+00 1.800000e+00
+ 4.647460e-09 5.000000e-01 0.000000e+00
+ 4.647460e-09 0.000000e+00 5.000000e-01
+ 4.647460e-09 6.000000e-01 0.000000e+00
+ 4.647460e-09 0.000000e+00 6.000000e-01
+ 4.647460e-09 7.000000e-01 0.000000e+00
+ 4.647460e-09 0.000000e+00 7.000000e-01
+ 4.647460e-09 8.000000e-01 0.000000e+00
+ 4.647460e-09 0.000000e+00 8.000000e-01
+ 4.647460e-09 9.000000e-01 0.000000e+00
+ 4.647460e-09 0.000000e+00 9.000000e-01
+ 4.647460e-09 1.000000e+00 0.000000e+00
+ 4.647460e-09 0.000000e+00 1.000000e+00
+ 4.647460e-09 1.100000e+00 0.000000e+00
+ 4.647460e-09 0.000000e+00 1.100000e+00
+ 4.647460e-09 1.200000e+00 0.000000e+00
+ 4.647460e-09 0.000000e+00 1.200000e+00
+ 4.647460e-09 1.300000e+00 0.000000e+00
+ 4.647460e-09 0.000000e+00 1.300000e+00
+ 4.647460e-09 1.400000e+00 0.000000e+00
+ 4.647460e-09 0.000000e+00 1.400000e+00
+ 4.647460e-09 1.500000e+00 0.000000e+00
+ 4.647460e-09 0.000000e+00 1.500000e+00
+ 4.647460e-09 1.600000e+00 0.000000e+00
+ 4.647460e-09 0.000000e+00 1.600000e+00
+ 4.647460e-09 1.700000e+00 0.000000e+00
+ 4.647460e-09 0.000000e+00 1.700000e+00
+ 4.647460e-09 1.800000e+00 0.000000e+00
+ 4.647460e-09 0.000000e+00 1.800000e+00
+ 4.708847e-09 5.000000e-01 0.000000e+00
+ 4.708847e-09 0.000000e+00 5.000000e-01
+ 4.708847e-09 6.000000e-01 0.000000e+00
+ 4.708847e-09 0.000000e+00 6.000000e-01
+ 4.708847e-09 7.000000e-01 0.000000e+00
+ 4.708847e-09 0.000000e+00 7.000000e-01
+ 4.708847e-09 8.000000e-01 0.000000e+00
+ 4.708847e-09 0.000000e+00 8.000000e-01
+ 4.708847e-09 9.000000e-01 0.000000e+00
+ 4.708847e-09 0.000000e+00 9.000000e-01
+ 4.708847e-09 1.000000e+00 0.000000e+00
+ 4.708847e-09 0.000000e+00 1.000000e+00
+ 4.708847e-09 1.100000e+00 0.000000e+00
+ 4.708847e-09 0.000000e+00 1.100000e+00
+ 4.708847e-09 1.200000e+00 0.000000e+00
+ 4.708847e-09 0.000000e+00 1.200000e+00
+ 4.708847e-09 1.300000e+00 0.000000e+00
+ 4.708847e-09 0.000000e+00 1.300000e+00
+ 4.708847e-09 1.400000e+00 0.000000e+00
+ 4.708847e-09 0.000000e+00 1.400000e+00
+ 4.708847e-09 1.500000e+00 0.000000e+00
+ 4.708847e-09 0.000000e+00 1.500000e+00
+ 4.708847e-09 1.600000e+00 0.000000e+00
+ 4.708847e-09 0.000000e+00 1.600000e+00
+ 4.708847e-09 1.700000e+00 0.000000e+00
+ 4.708847e-09 0.000000e+00 1.700000e+00
+ 4.708847e-09 1.800000e+00 0.000000e+00
+ 4.708847e-09 0.000000e+00 1.800000e+00
+ 4.759003e-09 5.000000e-01 0.000000e+00
+ 4.759003e-09 0.000000e+00 5.000000e-01
+ 4.759003e-09 6.000000e-01 0.000000e+00
+ 4.759003e-09 0.000000e+00 6.000000e-01
+ 4.759003e-09 7.000000e-01 0.000000e+00
+ 4.759003e-09 0.000000e+00 7.000000e-01
+ 4.759003e-09 8.000000e-01 0.000000e+00
+ 4.759003e-09 0.000000e+00 8.000000e-01
+ 4.759003e-09 9.000000e-01 0.000000e+00
+ 4.759003e-09 0.000000e+00 9.000000e-01
+ 4.759003e-09 1.000000e+00 0.000000e+00
+ 4.759003e-09 0.000000e+00 1.000000e+00
+ 4.759003e-09 1.100000e+00 0.000000e+00
+ 4.759003e-09 0.000000e+00 1.100000e+00
+ 4.759003e-09 1.200000e+00 0.000000e+00
+ 4.759003e-09 0.000000e+00 1.200000e+00
+ 4.759003e-09 1.300000e+00 0.000000e+00
+ 4.759003e-09 0.000000e+00 1.300000e+00
+ 4.759003e-09 1.400000e+00 0.000000e+00
+ 4.759003e-09 0.000000e+00 1.400000e+00
+ 4.759003e-09 1.500000e+00 0.000000e+00
+ 4.759003e-09 0.000000e+00 1.500000e+00
+ 4.759003e-09 1.600000e+00 0.000000e+00
+ 4.759003e-09 0.000000e+00 1.600000e+00
+ 4.759003e-09 1.700000e+00 0.000000e+00
+ 4.759003e-09 0.000000e+00 1.700000e+00
+ 4.759003e-09 1.800000e+00 0.000000e+00
+ 4.759003e-09 0.000000e+00 1.800000e+00
+ 4.801410e-09 5.000000e-01 0.000000e+00
+ 4.801410e-09 0.000000e+00 5.000000e-01
+ 4.801410e-09 6.000000e-01 0.000000e+00
+ 4.801410e-09 0.000000e+00 6.000000e-01
+ 4.801410e-09 7.000000e-01 0.000000e+00
+ 4.801410e-09 0.000000e+00 7.000000e-01
+ 4.801410e-09 8.000000e-01 0.000000e+00
+ 4.801410e-09 0.000000e+00 8.000000e-01
+ 4.801410e-09 9.000000e-01 0.000000e+00
+ 4.801410e-09 0.000000e+00 9.000000e-01
+ 4.801410e-09 1.000000e+00 0.000000e+00
+ 4.801410e-09 0.000000e+00 1.000000e+00
+ 4.801410e-09 1.100000e+00 0.000000e+00
+ 4.801410e-09 0.000000e+00 1.100000e+00
+ 4.801410e-09 1.200000e+00 0.000000e+00
+ 4.801410e-09 0.000000e+00 1.200000e+00
+ 4.801410e-09 1.300000e+00 0.000000e+00
+ 4.801410e-09 0.000000e+00 1.300000e+00
+ 4.801410e-09 1.400000e+00 0.000000e+00
+ 4.801410e-09 0.000000e+00 1.400000e+00
+ 4.801410e-09 1.500000e+00 0.000000e+00
+ 4.801410e-09 0.000000e+00 1.500000e+00
+ 4.801410e-09 1.600000e+00 0.000000e+00
+ 4.801410e-09 0.000000e+00 1.600000e+00
+ 4.801410e-09 1.700000e+00 0.000000e+00
+ 4.801410e-09 0.000000e+00 1.700000e+00
+ 4.801410e-09 1.800000e+00 0.000000e+00
+ 4.801410e-09 0.000000e+00 1.800000e+00
+ 4.838145e-09 5.000000e-01 0.000000e+00
+ 4.838145e-09 0.000000e+00 5.000000e-01
+ 4.838145e-09 6.000000e-01 0.000000e+00
+ 4.838145e-09 0.000000e+00 6.000000e-01
+ 4.838145e-09 7.000000e-01 0.000000e+00
+ 4.838145e-09 0.000000e+00 7.000000e-01
+ 4.838145e-09 8.000000e-01 0.000000e+00
+ 4.838145e-09 0.000000e+00 8.000000e-01
+ 4.838145e-09 9.000000e-01 0.000000e+00
+ 4.838145e-09 0.000000e+00 9.000000e-01
+ 4.838145e-09 1.000000e+00 0.000000e+00
+ 4.838145e-09 0.000000e+00 1.000000e+00
+ 4.838145e-09 1.100000e+00 0.000000e+00
+ 4.838145e-09 0.000000e+00 1.100000e+00
+ 4.838145e-09 1.200000e+00 0.000000e+00
+ 4.838145e-09 0.000000e+00 1.200000e+00
+ 4.838145e-09 1.300000e+00 0.000000e+00
+ 4.838145e-09 0.000000e+00 1.300000e+00
+ 4.838145e-09 1.400000e+00 0.000000e+00
+ 4.838145e-09 0.000000e+00 1.400000e+00
+ 4.838145e-09 1.500000e+00 0.000000e+00
+ 4.838145e-09 0.000000e+00 1.500000e+00
+ 4.838145e-09 1.600000e+00 0.000000e+00
+ 4.838145e-09 0.000000e+00 1.600000e+00
+ 4.838145e-09 1.700000e+00 0.000000e+00
+ 4.838145e-09 0.000000e+00 1.700000e+00
+ 4.838145e-09 1.800000e+00 0.000000e+00
+ 4.838145e-09 0.000000e+00 1.800000e+00
+ 4.870547e-09 5.000000e-01 0.000000e+00
+ 4.870547e-09 0.000000e+00 5.000000e-01
+ 4.870547e-09 6.000000e-01 0.000000e+00
+ 4.870547e-09 0.000000e+00 6.000000e-01
+ 4.870547e-09 7.000000e-01 0.000000e+00
+ 4.870547e-09 0.000000e+00 7.000000e-01
+ 4.870547e-09 8.000000e-01 0.000000e+00
+ 4.870547e-09 0.000000e+00 8.000000e-01
+ 4.870547e-09 9.000000e-01 0.000000e+00
+ 4.870547e-09 0.000000e+00 9.000000e-01
+ 4.870547e-09 1.000000e+00 0.000000e+00
+ 4.870547e-09 0.000000e+00 1.000000e+00
+ 4.870547e-09 1.100000e+00 0.000000e+00
+ 4.870547e-09 0.000000e+00 1.100000e+00
+ 4.870547e-09 1.200000e+00 0.000000e+00
+ 4.870547e-09 0.000000e+00 1.200000e+00
+ 4.870547e-09 1.300000e+00 0.000000e+00
+ 4.870547e-09 0.000000e+00 1.300000e+00
+ 4.870547e-09 1.400000e+00 0.000000e+00
+ 4.870547e-09 0.000000e+00 1.400000e+00
+ 4.870547e-09 1.500000e+00 0.000000e+00
+ 4.870547e-09 0.000000e+00 1.500000e+00
+ 4.870547e-09 1.600000e+00 0.000000e+00
+ 4.870547e-09 0.000000e+00 1.600000e+00
+ 4.870547e-09 1.700000e+00 0.000000e+00
+ 4.870547e-09 0.000000e+00 1.700000e+00
+ 4.870547e-09 1.800000e+00 0.000000e+00
+ 4.870547e-09 0.000000e+00 1.800000e+00
+ 4.899531e-09 5.000000e-01 0.000000e+00
+ 4.899531e-09 0.000000e+00 5.000000e-01
+ 4.899531e-09 6.000000e-01 0.000000e+00
+ 4.899531e-09 0.000000e+00 6.000000e-01
+ 4.899531e-09 7.000000e-01 0.000000e+00
+ 4.899531e-09 0.000000e+00 7.000000e-01
+ 4.899531e-09 8.000000e-01 0.000000e+00
+ 4.899531e-09 0.000000e+00 8.000000e-01
+ 4.899531e-09 9.000000e-01 0.000000e+00
+ 4.899531e-09 0.000000e+00 9.000000e-01
+ 4.899531e-09 1.000000e+00 0.000000e+00
+ 4.899531e-09 0.000000e+00 1.000000e+00
+ 4.899531e-09 1.100000e+00 0.000000e+00
+ 4.899531e-09 0.000000e+00 1.100000e+00
+ 4.899531e-09 1.200000e+00 0.000000e+00
+ 4.899531e-09 0.000000e+00 1.200000e+00
+ 4.899531e-09 1.300000e+00 0.000000e+00
+ 4.899531e-09 0.000000e+00 1.300000e+00
+ 4.899531e-09 1.400000e+00 0.000000e+00
+ 4.899531e-09 0.000000e+00 1.400000e+00
+ 4.899531e-09 1.500000e+00 0.000000e+00
+ 4.899531e-09 0.000000e+00 1.500000e+00
+ 4.899531e-09 1.600000e+00 0.000000e+00
+ 4.899531e-09 0.000000e+00 1.600000e+00
+ 4.899531e-09 1.700000e+00 0.000000e+00
+ 4.899531e-09 0.000000e+00 1.700000e+00
+ 4.899531e-09 1.800000e+00 0.000000e+00
+ 4.899531e-09 0.000000e+00 1.800000e+00
.enddata
.tran 10p 4.7000e-08 sweep data=dw
.end
