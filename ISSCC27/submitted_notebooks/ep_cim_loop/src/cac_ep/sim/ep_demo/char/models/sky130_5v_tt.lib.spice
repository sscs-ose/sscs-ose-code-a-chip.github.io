* SKY130 g5v0d10v5 (5 V) tt library wrapper. The included files are the public SkyWater sky130_fd_pr models (Apache-2.0).
* The notebook (tools/fix_paths.py) rewrites the paths below to this folder.
.lib tt
.option scale = 1.0u
.param mc_mm_switch = 0
.param mc_skew = 0
.include "/home/grads/s/seokjindaveoh/work/rram_see_spice/models/invariant.spice"
.include "/home/grads/s/seokjindaveoh/work/rram_see_spice/models/typical.spice"
.include "/home/grads/s/seokjindaveoh/work/rram_see_spice/models/lod.spice"
.include "/home/grads/s/seokjindaveoh/work/rram_see_spice/models/sky130_fd_pr__nfet_g5v0d10v5__mismatch.corner.spice"
.include "/home/grads/s/seokjindaveoh/work/rram_see_spice/models/sky130_fd_pr__pfet_g5v0d10v5__mismatch.corner.spice"
.include "/home/grads/s/seokjindaveoh/work/rram_see_spice/models/sky130_fd_pr__nfet_g5v0d10v5__tt.corner.spice"
.include "/home/grads/s/seokjindaveoh/work/rram_see_spice/models/sky130_fd_pr__pfet_g5v0d10v5__tt.corner.spice"
.endl tt
