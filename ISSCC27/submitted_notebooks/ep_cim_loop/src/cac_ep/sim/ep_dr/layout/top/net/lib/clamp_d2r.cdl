* clamp_d2r.cdl — 사본 (include 를 한 번만), 원본 digital/col_blk/macros/clamp_d2r.cdl, mk_top.py 2026-10-28 07:35
.SUBCKT clamp_d2r col vrailp vrailm VSS
* δ clamp: col -R1- da -D_a-> vrailm ; vrailp -D_b-> db -R2- col  (VSS = 기판 tap, 소자 연결 없음)
R1 col da 100 $[RES_GENERIC_ND] $W=1u $L=0.82u
DDa da vrailm diode_pd2nw_11v0 2.548 7.97 m=1
DDb vrailp db diode_pd2nw_11v0 2.548 7.97 m=1
R2 db col 100 $[RES_GENERIC_ND] $W=1u $L=0.82u
.ENDS clamp_d2r
