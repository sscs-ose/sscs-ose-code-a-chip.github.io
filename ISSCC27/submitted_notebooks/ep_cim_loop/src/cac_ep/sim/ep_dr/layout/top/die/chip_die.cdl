* die LVS source: r6 chip core 를 그대로 넣고, die 핀 = core 핀 (패드는 black box — 레이아웃에서 패드 셀 대신 LEF 핀 도형 + 이름표)
.INCLUDE /home/grads/s/seokjindaveoh/work/ep_dr/layout/top/net/chip_core.cdl
.SUBCKT chip_die SCK SDI SLD RST SEL_EN WP CK CK3 LAT LQ1 LQ2 VRAILP VRAILM VWH VWLO VWL VBUS_F VBUS_N IBIAS VBNC VBPC IBIASP VDD VSS VCM
Xcore SCK SDI SLD RST SEL_EN WP CK CK3 LAT LQ1 LQ2 VRAILP VRAILM VWH VWLO VWL VBUS_F VBUS_N IBIAS VBNC VBPC IBIASP VDD VSS VCM chip_core
.ENDS
