.subckt wu_rbank akx akp vcm aky akm ako vss
R0 akx r0 $SUB=vss $[res_xhigh_po_0p35] w=0.350u l=58.230u
R1 r0 r1 $SUB=vss $[res_xhigh_po_0p35] w=0.350u l=58.230u
R2 r1 akp $SUB=vss $[res_xhigh_po_0p35] w=0.350u l=58.230u
R3 akp r3 $SUB=vss $[res_xhigh_po_0p35] w=0.350u l=58.230u
R4 r3 r4 $SUB=vss $[res_xhigh_po_0p35] w=0.350u l=58.230u
R5 r4 r5 $SUB=vss $[res_xhigh_po_0p35] w=0.350u l=58.230u
R6 r5 r6 $SUB=vss $[res_xhigh_po_0p35] w=0.350u l=58.230u
R7 r6 r7 $SUB=vss $[res_xhigh_po_0p35] w=0.350u l=58.230u
R8 r7 vcm $SUB=vss $[res_xhigh_po_0p35] w=0.350u l=58.230u
R9 aky r9 $SUB=vss $[res_xhigh_po_0p35] w=0.350u l=58.230u
R10 r9 r10 $SUB=vss $[res_xhigh_po_0p35] w=0.350u l=58.230u
R11 r10 akm $SUB=vss $[res_xhigh_po_0p35] w=0.350u l=58.230u
R12 akm r12 $SUB=vss $[res_xhigh_po_0p35] w=0.350u l=58.230u
R13 r12 r13 $SUB=vss $[res_xhigh_po_0p35] w=0.350u l=58.230u
R14 r13 r14 $SUB=vss $[res_xhigh_po_0p35] w=0.350u l=58.230u
R15 r14 r15 $SUB=vss $[res_xhigh_po_0p35] w=0.350u l=58.230u
R16 r15 r16 $SUB=vss $[res_xhigh_po_0p35] w=0.350u l=58.230u
R17 r16 ako $SUB=vss $[res_xhigh_po_0p35] w=0.350u l=58.230u
.ends wu_rbank
