* tp_br — test pattern 블록 (testpat/gen_tp.py, 10/28). 패드 연결 없음, 핀 = 블록 변 met3.
.SUBCKT sky130_fd_sc_hvl__inv_1 A VGND VNB VPB VPWR Y
*.PININFO A:I VGND:I VNB:I VPB:I VPWR:I Y:O
MMIP1 Y A VPWR VPB pfet_g5v0d10v5 m=1 w=1.5u l=0.5u mult=1 sa=0.265
+ sb=0.265 sd=0.28 topography=normal area=0.063 perim=1.14
MMIN1 Y A VGND VNB nfet_g5v0d10v5 m=1 w=0.75u l=0.5u mult=1 sa=0.265
+ sb=0.265 sd=0.28 topography=normal area=0.063 perim=1.14
.ENDS sky130_fd_sc_hvl__inv_1

.SUBCKT sky130_fd_sc_hvl__nand2_1 A B VGND VNB VPB VPWR Y
*.PININFO A:I B:I VGND:I VNB:I VPB:I VPWR:I Y:O
MMP0 Y A VPWR VPB pfet_g5v0d10v5 m=1 w=1.5u l=0.5u mult=1 sa=0.265
+ sb=0.265 sd=0.28 topography=normal area=0.063 perim=1.14
MMP1 Y B VPWR VPB pfet_g5v0d10v5 m=1 w=1.5u l=0.5u mult=1 sa=0.265
+ sb=0.265 sd=0.28 topography=normal area=0.063 perim=1.14
MMN0 Y A sndA VNB nfet_g5v0d10v5 m=1 w=0.75u l=0.5u mult=1 sa=0.265
+ sb=0.265 sd=0.28 topography=normal area=0.063 perim=1.14
MMN1 sndA B VGND VNB nfet_g5v0d10v5 m=1 w=0.75u l=0.5u mult=1 sa=0.265
+ sb=0.265 sd=0.28 topography=normal area=0.063 perim=1.14
.ENDS sky130_fd_sc_hvl__nand2_1

.SUBCKT sky130_fd_sc_hvl__dfrtp_1 CLK D RESET_B VGND VNB VPB VPWR Q
*.PININFO CLK:I D:I RESET_B:I VGND:I VNB:I VPB:I VPWR:I Q:O
MI46 clkpos clkneg VGND VNB nfet_g5v0d10v5 m=1 w=0.42u l=0.5u mult=1
+ sa=0.265 sb=0.265 sd=0.28 topography=normal area=0.063 perim=1.14
MI42 db clkneg M0 VNB nfet_g5v0d10v5 m=1 w=0.42u l=0.5u mult=1 sa=0.265
+ sb=0.265 sd=0.28 topography=normal area=0.063 perim=1.14
MI656 net062 s0 net052 VNB nfet_g5v0d10v5 m=1 w=0.42u l=0.5u mult=1
+ sa=0.265 sb=0.265 sd=0.28 topography=normal area=0.063 perim=1.14
MI657 net052 RESET_B VGND VNB nfet_g5v0d10v5 m=1 w=0.42u l=0.5u mult=1
+ sa=0.265 sb=0.265 sd=0.28 topography=normal area=0.063 perim=1.14
MI33 net51 RESET_B VGND VNB nfet_g5v0d10v5 m=1 w=0.42u l=0.5u mult=1
+ sa=0.265 sb=0.265 sd=0.28 topography=normal area=0.063 perim=1.14
MI4 M0 clkpos net43 VNB nfet_g5v0d10v5 m=1 w=0.42u l=0.5u mult=1
+ sa=0.265 sb=0.265 sd=0.28 topography=normal area=0.063 perim=1.14
MI34 net43 M1 net51 VNB nfet_g5v0d10v5 m=1 w=0.42u l=0.5u mult=1
+ sa=0.265 sb=0.265 sd=0.28 topography=normal area=0.063 perim=1.14
MI655 s0 clkneg net061 VNB nfet_g5v0d10v5 m=1 w=0.42u l=0.5u mult=1
+ sa=0.265 sb=0.265 sd=0.28 topography=normal area=0.063 perim=1.14
MI652 net069 s0 VGND VNB nfet_g5v0d10v5 m=1 w=0.42u l=0.5u mult=1
+ sa=0.265 sb=0.265 sd=0.28 topography=normal area=0.063 perim=1.14
MI653 Q net069 VGND VNB nfet_g5v0d10v5 m=1 w=0.75u l=0.5u mult=1
+ sa=0.265 sb=0.265 sd=0.28 topography=normal area=0.063 perim=1.14
MI654 net061 net062 VGND VNB nfet_g5v0d10v5 m=1 w=0.42u l=0.5u mult=1
+ sa=0.265 sb=0.265 sd=0.28 topography=normal area=0.063 perim=1.14
MI44 clkneg CLK VGND VNB nfet_g5v0d10v5 m=1 w=0.42u l=0.5u mult=1
+ sa=0.265 sb=0.265 sd=0.28 topography=normal area=0.063 perim=1.14
MI647 M1 M0 VGND VNB nfet_g5v0d10v5 m=1 w=0.75u l=0.5u mult=1 sa=0.265
+ sb=0.265 sd=0.28 topography=normal area=0.063 perim=1.14
MI39 db D net098 VNB nfet_g5v0d10v5 m=1 w=0.42u l=0.5u mult=1 sa=0.265
+ sb=0.265 sd=0.28 topography=normal area=0.063 perim=1.14
MI38 net098 RESET_B VGND VNB nfet_g5v0d10v5 m=1 w=0.42u l=0.5u mult=1
+ sa=0.265 sb=0.265 sd=0.28 topography=normal area=0.063 perim=1.14
MI649 M1 clkpos s0 VNB nfet_g5v0d10v5 m=1 w=0.75u l=0.5u mult=1 sa=0.265
+ sb=0.265 sd=0.28 topography=normal area=0.063 perim=1.14
MI47 clkpos clkneg VPWR VPB pfet_g5v0d10v5 m=1 w=0.75u l=0.5u mult=1
+ sa=0.265 sb=0.265 sd=0.28 topography=normal area=0.063 perim=1.14
MI43 db clkpos M0 VPB pfet_g5v0d10v5 m=1 w=0.42u l=0.5u mult=1 sa=0.265
+ sb=0.265 sd=0.28 topography=normal area=0.063 perim=1.14
MI662 net089 net062 VPWR VPB pfet_g5v0d10v5 m=1 w=0.42u l=0.5u mult=1
+ sa=0.265 sb=0.265 sd=0.28 topography=normal area=0.063 perim=1.14
MI659 net062 RESET_B VPWR VPB pfet_g5v0d10v5 m=1 w=0.42u l=0.5u mult=1
+ sa=0.265 sb=0.265 sd=0.28 topography=normal area=0.063 perim=1.14
MI664 s0 clkpos net089 VPB pfet_g5v0d10v5 m=1 w=0.42u l=0.5u mult=1
+ sa=0.265 sb=0.265 sd=0.28 topography=normal area=0.063 perim=1.14
MI658 net062 s0 VPWR VPB pfet_g5v0d10v5 m=1 w=0.42u l=0.5u mult=1
+ sa=0.265 sb=0.265 sd=0.28 topography=normal area=0.063 perim=1.14
MI30 net54 M1 VPWR VPB pfet_g5v0d10v5 m=1 w=0.42u l=0.5u mult=1 sa=0.265
+ sb=0.265 sd=0.28 topography=normal area=0.063 perim=1.14
MI31 M0 clkneg net54 VPB pfet_g5v0d10v5 m=1 w=0.42u l=0.5u mult=1
+ sa=0.265 sb=0.265 sd=0.28 topography=normal area=0.063 perim=1.14
MI32 M0 RESET_B VPWR VPB pfet_g5v0d10v5 m=1 w=0.42u l=0.5u mult=1
+ sa=0.265 sb=0.265 sd=0.28 topography=normal area=0.063 perim=1.14
MI663 net069 s0 VPWR VPB pfet_g5v0d10v5 m=1 w=0.75u l=0.5u mult=1
+ sa=0.265 sb=0.265 sd=0.28 topography=normal area=0.063 perim=1.14
MI660 Q net069 VPWR VPB pfet_g5v0d10v5 m=1 w=1.5u l=0.5u mult=1 sa=0.265
+ sb=0.265 sd=0.28 topography=normal area=0.063 perim=1.14
MI45 clkneg CLK VPWR VPB pfet_g5v0d10v5 m=1 w=0.75u l=0.5u mult=1
+ sa=0.265 sb=0.265 sd=0.28 topography=normal area=0.063 perim=1.14
MI648 M1 M0 VPWR VPB pfet_g5v0d10v5 m=1 w=1.0u l=0.5u mult=1 sa=0.265
+ sb=0.265 sd=0.28 topography=normal area=0.063 perim=1.14
MI41 db RESET_B VPWR VPB pfet_g5v0d10v5 m=1 w=0.42u l=0.5u mult=1
+ sa=0.265 sb=0.265 sd=0.28 topography=normal area=0.063 perim=1.14
MI40 db D VPWR VPB pfet_g5v0d10v5 m=1 w=0.42u l=0.5u mult=1 sa=0.265
+ sb=0.265 sd=0.28 topography=normal area=0.063 perim=1.14
MI650 M1 clkneg s0 VPB pfet_g5v0d10v5 m=1 w=1.0u l=0.5u mult=1 sa=0.265
+ sb=0.265 sd=0.28 topography=normal area=0.063 perim=1.14
.ENDS sky130_fd_sc_hvl__dfrtp_1

.SUBCKT sky130_fd_sc_hvl__buf_4 A VGND VNB VPB VPWR X
*.PININFO A:I VGND:I VNB:I VPB:I VPWR:I X:O
MMIN1 Ab A VGND VNB nfet_g5v0d10v5 m=1 w=0.75u l=0.5u mult=1 sa=0.265
+ sb=0.265 sd=0.28 topography=normal area=0.063 perim=1.14
MMIN2 X Ab VGND VNB nfet_g5v0d10v5 m=4 w=0.75u l=0.5u mult=1 sa=0.265
+ sb=0.265 sd=0.28 topography=normal area=0.063 perim=1.14
MMIP1 Ab A VPWR VPB pfet_g5v0d10v5 m=1 w=1.5u l=0.5u mult=1 sa=0.265
+ sb=0.265 sd=0.28 topography=normal area=0.063 perim=1.14
MMIP2 X Ab VPWR VPB pfet_g5v0d10v5 m=4 w=1.5u l=0.5u mult=1 sa=0.265
+ sb=0.265 sd=0.28 topography=normal area=0.063 perim=1.14
.ENDS sky130_fd_sc_hvl__buf_4

.subckt tp_ro en rstb out VSS VDD
X0 fb en VSS VSS VDD VDD n0 sky130_fd_sc_hvl__nand2_1
X1 n0 VSS VSS VDD VDD n1 sky130_fd_sc_hvl__inv_1
X2 n1 VSS VSS VDD VDD n2 sky130_fd_sc_hvl__inv_1
X3 n2 VSS VSS VDD VDD n3 sky130_fd_sc_hvl__inv_1
X4 n3 VSS VSS VDD VDD n4 sky130_fd_sc_hvl__inv_1
X5 n4 VSS VSS VDD VDD n5 sky130_fd_sc_hvl__inv_1
X6 n5 VSS VSS VDD VDD n6 sky130_fd_sc_hvl__inv_1
X7 n6 VSS VSS VDD VDD n7 sky130_fd_sc_hvl__inv_1
X8 n7 VSS VSS VDD VDD n8 sky130_fd_sc_hvl__inv_1
X9 n8 VSS VSS VDD VDD n9 sky130_fd_sc_hvl__inv_1
X10 n9 VSS VSS VDD VDD n10 sky130_fd_sc_hvl__inv_1
X11 n10 VSS VSS VDD VDD n11 sky130_fd_sc_hvl__inv_1
X12 n11 VSS VSS VDD VDD n12 sky130_fd_sc_hvl__inv_1
X13 n12 VSS VSS VDD VDD n13 sky130_fd_sc_hvl__inv_1
X14 n13 VSS VSS VDD VDD n14 sky130_fd_sc_hvl__inv_1
X15 n14 VSS VSS VDD VDD n15 sky130_fd_sc_hvl__inv_1
X16 n15 VSS VSS VDD VDD n16 sky130_fd_sc_hvl__inv_1
X17 n16 VSS VSS VDD VDD n17 sky130_fd_sc_hvl__inv_1
X18 n17 VSS VSS VDD VDD n18 sky130_fd_sc_hvl__inv_1
X19 n18 VSS VSS VDD VDD n19 sky130_fd_sc_hvl__inv_1
X20 n19 VSS VSS VDD VDD n20 sky130_fd_sc_hvl__inv_1
X21 n20 VSS VSS VDD VDD n21 sky130_fd_sc_hvl__inv_1
X22 n21 VSS VSS VDD VDD n22 sky130_fd_sc_hvl__inv_1
X23 n22 VSS VSS VDD VDD n23 sky130_fd_sc_hvl__inv_1
X24 n23 VSS VSS VDD VDD n24 sky130_fd_sc_hvl__inv_1
X25 n24 VSS VSS VDD VDD n25 sky130_fd_sc_hvl__inv_1
X26 n25 VSS VSS VDD VDD n26 sky130_fd_sc_hvl__inv_1
X27 n26 VSS VSS VDD VDD n27 sky130_fd_sc_hvl__inv_1
X28 n27 VSS VSS VDD VDD n28 sky130_fd_sc_hvl__inv_1
X29 n28 VSS VSS VDD VDD n29 sky130_fd_sc_hvl__inv_1
X30 n29 VSS VSS VDD VDD n30 sky130_fd_sc_hvl__inv_1
X31 n30 VSS VSS VDD VDD n31 sky130_fd_sc_hvl__inv_1
X32 n31 VSS VSS VDD VDD n32 sky130_fd_sc_hvl__inv_1
X33 n32 VSS VSS VDD VDD n33 sky130_fd_sc_hvl__inv_1
X34 n33 VSS VSS VDD VDD n34 sky130_fd_sc_hvl__inv_1
X35 n34 VSS VSS VDD VDD n35 sky130_fd_sc_hvl__inv_1
X36 n35 VSS VSS VDD VDD n36 sky130_fd_sc_hvl__inv_1
X37 n36 VSS VSS VDD VDD n37 sky130_fd_sc_hvl__inv_1
X38 n37 VSS VSS VDD VDD n38 sky130_fd_sc_hvl__inv_1
X39 n38 VSS VSS VDD VDD n39 sky130_fd_sc_hvl__inv_1
X40 n39 VSS VSS VDD VDD n40 sky130_fd_sc_hvl__inv_1
X41 n40 VSS VSS VDD VDD n41 sky130_fd_sc_hvl__inv_1
X42 n41 VSS VSS VDD VDD n42 sky130_fd_sc_hvl__inv_1
X43 n42 VSS VSS VDD VDD n43 sky130_fd_sc_hvl__inv_1
X44 n43 VSS VSS VDD VDD n44 sky130_fd_sc_hvl__inv_1
X45 n44 VSS VSS VDD VDD n45 sky130_fd_sc_hvl__inv_1
X46 n45 VSS VSS VDD VDD n46 sky130_fd_sc_hvl__inv_1
X47 n46 VSS VSS VDD VDD n47 sky130_fd_sc_hvl__inv_1
X48 n47 VSS VSS VDD VDD n48 sky130_fd_sc_hvl__inv_1
X49 n48 VSS VSS VDD VDD n49 sky130_fd_sc_hvl__inv_1
X50 n49 VSS VSS VDD VDD n50 sky130_fd_sc_hvl__inv_1
X51 n50 VSS VSS VDD VDD n51 sky130_fd_sc_hvl__inv_1
X52 n51 VSS VSS VDD VDD n52 sky130_fd_sc_hvl__inv_1
X53 n52 VSS VSS VDD VDD n53 sky130_fd_sc_hvl__inv_1
X54 n53 VSS VSS VDD VDD n54 sky130_fd_sc_hvl__inv_1
X55 n54 VSS VSS VDD VDD n55 sky130_fd_sc_hvl__inv_1
X56 n55 VSS VSS VDD VDD n56 sky130_fd_sc_hvl__inv_1
X57 n56 VSS VSS VDD VDD n57 sky130_fd_sc_hvl__inv_1
X58 n57 VSS VSS VDD VDD n58 sky130_fd_sc_hvl__inv_1
X59 n58 VSS VSS VDD VDD n59 sky130_fd_sc_hvl__inv_1
X60 n59 VSS VSS VDD VDD n60 sky130_fd_sc_hvl__inv_1
X61 n60 VSS VSS VDD VDD n61 sky130_fd_sc_hvl__inv_1
X62 n61 VSS VSS VDD VDD n62 sky130_fd_sc_hvl__inv_1
X63 n62 VSS VSS VDD VDD n63 sky130_fd_sc_hvl__inv_1
X64 n63 VSS VSS VDD VDD n64 sky130_fd_sc_hvl__inv_1
X65 n64 VSS VSS VDD VDD n65 sky130_fd_sc_hvl__inv_1
X66 n65 VSS VSS VDD VDD n66 sky130_fd_sc_hvl__inv_1
X67 n66 VSS VSS VDD VDD n67 sky130_fd_sc_hvl__inv_1
X68 n67 VSS VSS VDD VDD n68 sky130_fd_sc_hvl__inv_1
X69 n68 VSS VSS VDD VDD n69 sky130_fd_sc_hvl__inv_1
X70 n69 VSS VSS VDD VDD n70 sky130_fd_sc_hvl__inv_1
X71 n70 VSS VSS VDD VDD n71 sky130_fd_sc_hvl__inv_1
X72 n71 VSS VSS VDD VDD n72 sky130_fd_sc_hvl__inv_1
X73 n72 VSS VSS VDD VDD n73 sky130_fd_sc_hvl__inv_1
X74 n73 VSS VSS VDD VDD n74 sky130_fd_sc_hvl__inv_1
X75 n74 VSS VSS VDD VDD n75 sky130_fd_sc_hvl__inv_1
X76 n75 VSS VSS VDD VDD n76 sky130_fd_sc_hvl__inv_1
X77 n76 VSS VSS VDD VDD n77 sky130_fd_sc_hvl__inv_1
X78 n77 VSS VSS VDD VDD n78 sky130_fd_sc_hvl__inv_1
X79 n78 VSS VSS VDD VDD n79 sky130_fd_sc_hvl__inv_1
X80 n79 VSS VSS VDD VDD n80 sky130_fd_sc_hvl__inv_1
X81 n80 VSS VSS VDD VDD n81 sky130_fd_sc_hvl__inv_1
X82 n81 VSS VSS VDD VDD n82 sky130_fd_sc_hvl__inv_1
X83 n82 VSS VSS VDD VDD n83 sky130_fd_sc_hvl__inv_1
X84 n83 VSS VSS VDD VDD n84 sky130_fd_sc_hvl__inv_1
X85 n84 VSS VSS VDD VDD n85 sky130_fd_sc_hvl__inv_1
X86 n85 VSS VSS VDD VDD fb sky130_fd_sc_hvl__inv_1
X87 fb VSS VSS VDD VDD ck0 sky130_fd_sc_hvl__inv_1
X88 ck0 qb1 rstb VSS VSS VDD VDD q1 sky130_fd_sc_hvl__dfrtp_1
X89 q1 VSS VSS VDD VDD qb1 sky130_fd_sc_hvl__inv_1
X90 q2 VSS VSS VDD VDD qb2 sky130_fd_sc_hvl__inv_1
X91 q1 qb2 rstb VSS VSS VDD VDD q2 sky130_fd_sc_hvl__dfrtp_1
X92 q2 qb3 rstb VSS VSS VDD VDD q3 sky130_fd_sc_hvl__dfrtp_1
X93 q3 VSS VSS VDD VDD qb3 sky130_fd_sc_hvl__inv_1
X94 q4 VSS VSS VDD VDD qb4 sky130_fd_sc_hvl__inv_1
X95 q3 qb4 rstb VSS VSS VDD VDD q4 sky130_fd_sc_hvl__dfrtp_1
X96 q4 qb5 rstb VSS VSS VDD VDD q5 sky130_fd_sc_hvl__dfrtp_1
X97 q5 VSS VSS VDD VDD qb5 sky130_fd_sc_hvl__inv_1
X98 q6 VSS VSS VDD VDD qb6 sky130_fd_sc_hvl__inv_1
X99 q5 qb6 rstb VSS VSS VDD VDD q6 sky130_fd_sc_hvl__dfrtp_1
X100 q6 qb7 rstb VSS VSS VDD VDD q7 sky130_fd_sc_hvl__dfrtp_1
X101 q7 VSS VSS VDD VDD qb7 sky130_fd_sc_hvl__inv_1
X102 q8 VSS VSS VDD VDD qb8 sky130_fd_sc_hvl__inv_1
X103 q7 qb8 rstb VSS VSS VDD VDD q8 sky130_fd_sc_hvl__dfrtp_1
X104 q8 VSS VSS VDD VDD out sky130_fd_sc_hvl__buf_4
.ends tp_ro
.subckt tp_kv_hpo0p35_s f1 s1 s2 f2 VSS
R0 f1 s1 $SUB=VSS $[res_high_po_0p35] w=0.350u l=2.000u
R1 s1 s2 $SUB=VSS $[res_high_po_0p35] w=0.350u l=10.000u
R2 s2 f2 $SUB=VSS $[res_high_po_0p35] w=0.350u l=2.000u
.ends tp_kv_hpo0p35_s
.subckt tp_kv_hpo1p41_s f1 s1 s2 f2 VSS
R0 f1 s1 $SUB=VSS $[res_high_po_1p41] w=1.410u l=2.000u
R1 s1 s2 $SUB=VSS $[res_high_po_1p41] w=1.410u l=10.000u
R2 s2 f2 $SUB=VSS $[res_high_po_1p41] w=1.410u l=2.000u
.ends tp_kv_hpo1p41_s
.subckt tp_kv_xpo0p35_s f1 s1 s2 f2 VSS
R0 f1 s1 $SUB=VSS $[res_xhigh_po_0p35] w=0.350u l=2.000u
R1 s1 s2 $SUB=VSS $[res_xhigh_po_0p35] w=0.350u l=10.000u
R2 s2 f2 $SUB=VSS $[res_xhigh_po_0p35] w=0.350u l=2.000u
.ends tp_kv_xpo0p35_s
.subckt tp_kv_xpo1p41_s f1 s1 s2 f2 VSS
R0 f1 s1 $SUB=VSS $[res_xhigh_po_1p41] w=1.410u l=2.000u
R1 s1 s2 $SUB=VSS $[res_xhigh_po_1p41] w=1.410u l=10.000u
R2 s2 f2 $SUB=VSS $[res_xhigh_po_1p41] w=1.410u l=2.000u
.ends tp_kv_xpo1p41_s
.subckt tp_kv_nd_s f1 s1 s2 f2 VSS
R0 f1 s1 240 $[RES_GENERIC_ND] $W=1u $L=2u
R1 s1 s2 1200 $[RES_GENERIC_ND] $W=1u $L=10u
R2 s2 f2 240 $[RES_GENERIC_ND] $W=1u $L=2u
.ends tp_kv_nd_s
.subckt tp_kv_pd_s f1 s1 s2 f2 VSS VDD
R0 f1 s1 394 $[RES_GENERIC_PD] $W=1u $L=2u
R1 s1 s2 1970 $[RES_GENERIC_PD] $W=1u $L=10u
R2 s2 f2 394 $[RES_GENERIC_PD] $W=1u $L=2u
.ends tp_kv_pd_s
.subckt tp_kv_m1_s f1 s1 s2 f2 VSS
R0 f1 s1 $[res_generic_m1] $W=0.4u $L=2u
R1 s1 s2 $[res_generic_m1] $W=0.4u $L=117.2u
R2 s2 f2 $[res_generic_m1] $W=0.4u $L=2u
.ends tp_kv_m1_s
.subckt tp_kv_m2_s f1 s1 s2 f2 VSS
R0 f1 s1 $[res_generic_m2] $W=0.4u $L=2u
R1 s1 s2 $[res_generic_m2] $W=0.4u $L=117.2u
R2 s2 f2 $[res_generic_m2] $W=0.4u $L=2u
.ends tp_kv_m2_s
.subckt tp_kv_m3_s f1 s1 s2 f2 VSS
R0 f1 s1 $[res_generic_m3] $W=0.4u $L=2u
R1 s1 s2 $[res_generic_m3] $W=0.4u $L=117.2u
R2 s2 f2 $[res_generic_m3] $W=0.4u $L=2u
.ends tp_kv_m3_s
.subckt tp_kv_hpo0p35_l f1 s1 s2 f2 VSS
R0 f1 s1 $SUB=VSS $[res_high_po_0p35] w=0.350u l=2.000u
R1 s1 s2 $SUB=VSS $[res_high_po_0p35] w=0.350u l=20.000u
R2 s2 f2 $SUB=VSS $[res_high_po_0p35] w=0.350u l=2.000u
.ends tp_kv_hpo0p35_l
.subckt tp_kv_hpo1p41_l f1 s1 s2 f2 VSS
R0 f1 s1 $SUB=VSS $[res_high_po_1p41] w=1.410u l=2.000u
R1 s1 s2 $SUB=VSS $[res_high_po_1p41] w=1.410u l=20.000u
R2 s2 f2 $SUB=VSS $[res_high_po_1p41] w=1.410u l=2.000u
.ends tp_kv_hpo1p41_l
.subckt tp_kv_xpo0p35_l f1 s1 s2 f2 VSS
R0 f1 s1 $SUB=VSS $[res_xhigh_po_0p35] w=0.350u l=2.000u
R1 s1 s2 $SUB=VSS $[res_xhigh_po_0p35] w=0.350u l=20.000u
R2 s2 f2 $SUB=VSS $[res_xhigh_po_0p35] w=0.350u l=2.000u
.ends tp_kv_xpo0p35_l
.subckt tp_kv_xpo1p41_l f1 s1 s2 f2 VSS
R0 f1 s1 $SUB=VSS $[res_xhigh_po_1p41] w=1.410u l=2.000u
R1 s1 s2 $SUB=VSS $[res_xhigh_po_1p41] w=1.410u l=20.000u
R2 s2 f2 $SUB=VSS $[res_xhigh_po_1p41] w=1.410u l=2.000u
.ends tp_kv_xpo1p41_l
.subckt tp_kv_nd_l f1 s1 s2 f2 VSS
R0 f1 s1 240 $[RES_GENERIC_ND] $W=1u $L=2u
R1 s1 s2 2400 $[RES_GENERIC_ND] $W=1u $L=20u
R2 s2 f2 240 $[RES_GENERIC_ND] $W=1u $L=2u
.ends tp_kv_nd_l
.subckt tp_kv_pd_l f1 s1 s2 f2 VSS VDD
R0 f1 s1 394 $[RES_GENERIC_PD] $W=1u $L=2u
R1 s1 s2 3940 $[RES_GENERIC_PD] $W=1u $L=20u
R2 s2 f2 394 $[RES_GENERIC_PD] $W=1u $L=2u
.ends tp_kv_pd_l
.subckt tp_kv_m1_l f1 s1 s2 f2 VSS
R0 f1 s1 $[res_generic_m1] $W=0.4u $L=2u
R1 s1 s2 $[res_generic_m1] $W=0.4u $L=234.8u
R2 s2 f2 $[res_generic_m1] $W=0.4u $L=2u
.ends tp_kv_m1_l
.subckt tp_kv_m2_l f1 s1 s2 f2 VSS
R0 f1 s1 $[res_generic_m2] $W=0.4u $L=2u
R1 s1 s2 $[res_generic_m2] $W=0.4u $L=234.8u
R2 s2 f2 $[res_generic_m2] $W=0.4u $L=2u
.ends tp_kv_m2_l
.subckt tp_kv_m3_l f1 s1 s2 f2 VSS
R0 f1 s1 $[res_generic_m3] $W=0.4u $L=2u
R1 s1 s2 $[res_generic_m3] $W=0.4u $L=234.8u
R2 s2 f2 $[res_generic_m3] $W=0.4u $L=2u
.ends tp_kv_m3_l
.subckt tp_ch_poly a b VSS
* R0 = LVS 용 met3_res 표지 (사슬 자체가 아님): a·b 가 사슬로 한 넷이 되는 것을 나눔
R0 a b $[res_generic_m3] $W=0.5u $L=1u
.ends tp_ch_poly
.subckt tp_ch_ndiff a b VSS
* R0 = LVS 용 met3_res 표지 (사슬 자체가 아님): a·b 가 사슬로 한 넷이 되는 것을 나눔
R0 a b $[res_generic_m3] $W=0.5u $L=1u
.ends tp_ch_ndiff
.subckt tp_ch_pdiff a b VDD VSS
* R0 = LVS 용 met3_res 표지 (사슬 자체가 아님): a·b 가 사슬로 한 넷이 되는 것을 나눔
R0 a b $[res_generic_m3] $W=0.5u $L=1u
.ends tp_ch_pdiff
.subckt tp_ch_mcon a b VSS
* R0 = LVS 용 met3_res 표지 (사슬 자체가 아님): a·b 가 사슬로 한 넷이 되는 것을 나눔
R0 a b $[res_generic_m3] $W=0.5u $L=1u
.ends tp_ch_mcon
.subckt tp_ch_via1 a b VSS
* R0 = LVS 용 met3_res 표지 (사슬 자체가 아님): a·b 가 사슬로 한 넷이 되는 것을 나눔
R0 a b $[res_generic_m3] $W=0.5u $L=1u
.ends tp_ch_via1
.subckt tp_ch_via2 a b VSS
* R0 = LVS 용 met3_res 표지 (사슬 자체가 아님): a·b 가 사슬로 한 넷이 되는 것을 나눔
R0 a b $[res_generic_m3] $W=0.5u $L=1u
.ends tp_ch_via2
.subckt tp_1t1r s te wl VSS
R0 te dn $[reram]
M1 dn wl s VSS nfet_g5v0d10v5 w=1.5u l=0.5u
M2 dn wl s VSS nfet_g5v0d10v5 w=1.5u l=0.5u
.ends tp_1t1r
.subckt tp_nacc s d g VSS
M1 d g s VSS nfet_g5v0d10v5 w=1.5u l=0.5u
M2 d g s VSS nfet_g5v0d10v5 w=1.5u l=0.5u
.ends tp_nacc
.subckt tp_pair ns ng2 nd2 ng1 nd1 pg2 ps pd2 pd1 pg1 VSS VDD
MN1 nd1 ng1 ns VSS nfet_g5v0d10v5 w=4u l=1u
MN2 nd2 ng2 ns VSS nfet_g5v0d10v5 w=4u l=1u
MP1 pd1 pg1 ps VDD pfet_g5v0d10v5 w=4u l=1u
MP2 pd2 pg2 ps VDD pfet_g5v0d10v5 w=4u l=1u
.ends tp_pair

.subckt tp_br ro_1_en ro_1_rstb ro_1_out kv_hpo0p35_s_1_f1 kv_hpo0p35_s_1_s1 kv_hpo0p35_s_1_s2 kv_hpo0p35_s_1_f2 kv_hpo1p41_s_1_f1 kv_hpo1p41_s_1_s1 kv_hpo1p41_s_1_s2 kv_hpo1p41_s_1_f2 kv_xpo0p35_s_1_f1 kv_xpo0p35_s_1_s1 kv_xpo0p35_s_1_s2 kv_xpo0p35_s_1_f2 kv_xpo1p41_s_1_f1 kv_xpo1p41_s_1_s1 kv_xpo1p41_s_1_s2 kv_xpo1p41_s_1_f2 kv_nd_s_1_f1 kv_nd_s_1_s1 kv_nd_s_1_s2 kv_nd_s_1_f2 kv_pd_s_1_f1 kv_pd_s_1_s1 kv_pd_s_1_s2 kv_pd_s_1_f2 kv_m1_s_1_f1 kv_m1_s_1_s1 kv_m1_s_1_s2 kv_m1_s_1_f2 kv_m2_s_1_f1 kv_m2_s_1_s1 kv_m2_s_1_s2 kv_m2_s_1_f2 kv_m3_s_1_f1 kv_m3_s_1_s1 kv_m3_s_1_s2 kv_m3_s_1_f2 kv_hpo0p35_l_1_f1 kv_hpo0p35_l_1_s1 kv_hpo0p35_l_1_s2 kv_hpo0p35_l_1_f2 kv_hpo1p41_l_1_f1 kv_hpo1p41_l_1_s1 kv_hpo1p41_l_1_s2 kv_hpo1p41_l_1_f2 kv_xpo0p35_l_1_f1 kv_xpo0p35_l_1_s1 kv_xpo0p35_l_1_s2 kv_xpo0p35_l_1_f2 kv_xpo1p41_l_1_f1 kv_xpo1p41_l_1_s1 kv_xpo1p41_l_1_s2 kv_xpo1p41_l_1_f2 kv_nd_l_1_f1 kv_nd_l_1_s1 kv_nd_l_1_s2 kv_nd_l_1_f2 kv_pd_l_1_f1 kv_pd_l_1_s1 kv_pd_l_1_s2 kv_pd_l_1_f2 kv_m1_l_1_f1 kv_m1_l_1_s1 kv_m1_l_1_s2 kv_m1_l_1_f2 kv_m2_l_1_f1 kv_m2_l_1_s1 kv_m2_l_1_s2 kv_m2_l_1_f2 kv_m3_l_1_f1 kv_m3_l_1_s1 kv_m3_l_1_s2 kv_m3_l_1_f2 ch_poly_1_a ch_poly_1_b ch_ndiff_1_a ch_ndiff_1_b ch_pdiff_1_a ch_pdiff_1_b ch_mcon_1_a ch_mcon_1_b ch_via1_1_a ch_via1_1_b ch_via2_1_a ch_via2_1_b ch_poly_2_a ch_poly_2_b ch_ndiff_2_a ch_ndiff_2_b ch_pdiff_2_a ch_pdiff_2_b ch_mcon_2_a ch_mcon_2_b ch_via1_2_a ch_via1_2_b ch_via2_2_a ch_via2_2_b ch_poly_3_a ch_poly_3_b ch_ndiff_3_a ch_ndiff_3_b ch_pdiff_3_a ch_pdiff_3_b ch_mcon_3_a ch_mcon_3_b rr_1_s rr_1_te rr_1_wl rr_2_s rr_2_te rr_2_wl rr_3_s rr_3_te rr_3_wl rr_4_s rr_4_te rr_4_wl nacc_1_s nacc_1_d nacc_1_g nacc_2_s nacc_2_d nacc_2_g pair_1_ns pair_1_ng2 pair_1_nd2 pair_1_ng1 pair_1_nd1 pair_1_pg2 pair_1_ps pair_1_pd2 pair_1_pd1 pair_1_pg1 pair_2_ns pair_2_ng2 pair_2_nd2 pair_2_ng1 pair_2_nd1 pair_2_pg2 pair_2_ps pair_2_pd2 pair_2_pd1 pair_2_pg1 ch_poly_4_a ch_poly_4_b ch_ndiff_4_a ch_ndiff_4_b ch_pdiff_4_a ch_pdiff_4_b ch_mcon_4_a ch_mcon_4_b ch_via1_3_a ch_via1_3_b ch_via2_3_a ch_via2_3_b rr_5_s rr_5_te rr_5_wl nacc_3_s nacc_3_d nacc_3_g pair_3_ns pair_3_ng2 pair_3_nd2 pair_3_ng1 pair_3_nd1 pair_3_pg2 pair_3_ps pair_3_pd2 pair_3_pd1 pair_3_pg1 rr_6_s rr_6_te rr_6_wl nacc_4_s nacc_4_d nacc_4_g pair_4_ns pair_4_ng2 pair_4_nd2 pair_4_ng1 pair_4_nd1 pair_4_pg2 pair_4_ps pair_4_pd2 pair_4_pd1 pair_4_pg1 rr_7_s rr_7_te rr_7_wl nacc_5_s nacc_5_d nacc_5_g pair_5_ns pair_5_ng2 pair_5_nd2 pair_5_ng1 pair_5_nd1 pair_5_pg2 pair_5_ps pair_5_pd2 pair_5_pd1 pair_5_pg1 rr_8_s rr_8_te rr_8_wl nacc_6_s nacc_6_d nacc_6_g pair_6_ns pair_6_ng2 pair_6_nd2 pair_6_ng1 pair_6_nd1 pair_6_pg2 pair_6_ps pair_6_pd2 pair_6_pd1 pair_6_pg1 VDD VSS
Xro_1 ro_1_en ro_1_rstb ro_1_out VSS VDD tp_ro
Xkv_hpo0p35_s_1 kv_hpo0p35_s_1_f1 kv_hpo0p35_s_1_s1 kv_hpo0p35_s_1_s2 kv_hpo0p35_s_1_f2 VSS tp_kv_hpo0p35_s
Xkv_hpo1p41_s_1 kv_hpo1p41_s_1_f1 kv_hpo1p41_s_1_s1 kv_hpo1p41_s_1_s2 kv_hpo1p41_s_1_f2 VSS tp_kv_hpo1p41_s
Xkv_xpo0p35_s_1 kv_xpo0p35_s_1_f1 kv_xpo0p35_s_1_s1 kv_xpo0p35_s_1_s2 kv_xpo0p35_s_1_f2 VSS tp_kv_xpo0p35_s
Xkv_xpo1p41_s_1 kv_xpo1p41_s_1_f1 kv_xpo1p41_s_1_s1 kv_xpo1p41_s_1_s2 kv_xpo1p41_s_1_f2 VSS tp_kv_xpo1p41_s
Xkv_nd_s_1 kv_nd_s_1_f1 kv_nd_s_1_s1 kv_nd_s_1_s2 kv_nd_s_1_f2 VSS tp_kv_nd_s
Xkv_pd_s_1 kv_pd_s_1_f1 kv_pd_s_1_s1 kv_pd_s_1_s2 kv_pd_s_1_f2 VSS VDD tp_kv_pd_s
Xkv_m1_s_1 kv_m1_s_1_f1 kv_m1_s_1_s1 kv_m1_s_1_s2 kv_m1_s_1_f2 VSS tp_kv_m1_s
Xkv_m2_s_1 kv_m2_s_1_f1 kv_m2_s_1_s1 kv_m2_s_1_s2 kv_m2_s_1_f2 VSS tp_kv_m2_s
Xkv_m3_s_1 kv_m3_s_1_f1 kv_m3_s_1_s1 kv_m3_s_1_s2 kv_m3_s_1_f2 VSS tp_kv_m3_s
Xkv_hpo0p35_l_1 kv_hpo0p35_l_1_f1 kv_hpo0p35_l_1_s1 kv_hpo0p35_l_1_s2 kv_hpo0p35_l_1_f2 VSS tp_kv_hpo0p35_l
Xkv_hpo1p41_l_1 kv_hpo1p41_l_1_f1 kv_hpo1p41_l_1_s1 kv_hpo1p41_l_1_s2 kv_hpo1p41_l_1_f2 VSS tp_kv_hpo1p41_l
Xkv_xpo0p35_l_1 kv_xpo0p35_l_1_f1 kv_xpo0p35_l_1_s1 kv_xpo0p35_l_1_s2 kv_xpo0p35_l_1_f2 VSS tp_kv_xpo0p35_l
Xkv_xpo1p41_l_1 kv_xpo1p41_l_1_f1 kv_xpo1p41_l_1_s1 kv_xpo1p41_l_1_s2 kv_xpo1p41_l_1_f2 VSS tp_kv_xpo1p41_l
Xkv_nd_l_1 kv_nd_l_1_f1 kv_nd_l_1_s1 kv_nd_l_1_s2 kv_nd_l_1_f2 VSS tp_kv_nd_l
Xkv_pd_l_1 kv_pd_l_1_f1 kv_pd_l_1_s1 kv_pd_l_1_s2 kv_pd_l_1_f2 VSS VDD tp_kv_pd_l
Xkv_m1_l_1 kv_m1_l_1_f1 kv_m1_l_1_s1 kv_m1_l_1_s2 kv_m1_l_1_f2 VSS tp_kv_m1_l
Xkv_m2_l_1 kv_m2_l_1_f1 kv_m2_l_1_s1 kv_m2_l_1_s2 kv_m2_l_1_f2 VSS tp_kv_m2_l
Xkv_m3_l_1 kv_m3_l_1_f1 kv_m3_l_1_s1 kv_m3_l_1_s2 kv_m3_l_1_f2 VSS tp_kv_m3_l
Xch_poly_1 ch_poly_1_a ch_poly_1_b VSS tp_ch_poly
Xch_ndiff_1 ch_ndiff_1_a ch_ndiff_1_b VSS tp_ch_ndiff
Xch_pdiff_1 ch_pdiff_1_a ch_pdiff_1_b VDD VSS tp_ch_pdiff
Xch_mcon_1 ch_mcon_1_a ch_mcon_1_b VSS tp_ch_mcon
Xch_via1_1 ch_via1_1_a ch_via1_1_b VSS tp_ch_via1
Xch_via2_1 ch_via2_1_a ch_via2_1_b VSS tp_ch_via2
Xch_poly_2 ch_poly_2_a ch_poly_2_b VSS tp_ch_poly
Xch_ndiff_2 ch_ndiff_2_a ch_ndiff_2_b VSS tp_ch_ndiff
Xch_pdiff_2 ch_pdiff_2_a ch_pdiff_2_b VDD VSS tp_ch_pdiff
Xch_mcon_2 ch_mcon_2_a ch_mcon_2_b VSS tp_ch_mcon
Xch_via1_2 ch_via1_2_a ch_via1_2_b VSS tp_ch_via1
Xch_via2_2 ch_via2_2_a ch_via2_2_b VSS tp_ch_via2
Xch_poly_3 ch_poly_3_a ch_poly_3_b VSS tp_ch_poly
Xch_ndiff_3 ch_ndiff_3_a ch_ndiff_3_b VSS tp_ch_ndiff
Xch_pdiff_3 ch_pdiff_3_a ch_pdiff_3_b VDD VSS tp_ch_pdiff
Xch_mcon_3 ch_mcon_3_a ch_mcon_3_b VSS tp_ch_mcon
Xrr_1 rr_1_s rr_1_te rr_1_wl VSS tp_1t1r
Xrr_2 rr_2_s rr_2_te rr_2_wl VSS tp_1t1r
Xrr_3 rr_3_s rr_3_te rr_3_wl VSS tp_1t1r
Xrr_4 rr_4_s rr_4_te rr_4_wl VSS tp_1t1r
Xnacc_1 nacc_1_s nacc_1_d nacc_1_g VSS tp_nacc
Xnacc_2 nacc_2_s nacc_2_d nacc_2_g VSS tp_nacc
Xpair_1 pair_1_ns pair_1_ng2 pair_1_nd2 pair_1_ng1 pair_1_nd1 pair_1_pg2 pair_1_ps pair_1_pd2 pair_1_pd1 pair_1_pg1 VSS VDD tp_pair
Xpair_2 pair_2_ns pair_2_ng2 pair_2_nd2 pair_2_ng1 pair_2_nd1 pair_2_pg2 pair_2_ps pair_2_pd2 pair_2_pd1 pair_2_pg1 VSS VDD tp_pair
Xch_poly_4 ch_poly_4_a ch_poly_4_b VSS tp_ch_poly
Xch_ndiff_4 ch_ndiff_4_a ch_ndiff_4_b VSS tp_ch_ndiff
Xch_pdiff_4 ch_pdiff_4_a ch_pdiff_4_b VDD VSS tp_ch_pdiff
Xch_mcon_4 ch_mcon_4_a ch_mcon_4_b VSS tp_ch_mcon
Xch_via1_3 ch_via1_3_a ch_via1_3_b VSS tp_ch_via1
Xch_via2_3 ch_via2_3_a ch_via2_3_b VSS tp_ch_via2
Xrr_5 rr_5_s rr_5_te rr_5_wl VSS tp_1t1r
Xnacc_3 nacc_3_s nacc_3_d nacc_3_g VSS tp_nacc
Xpair_3 pair_3_ns pair_3_ng2 pair_3_nd2 pair_3_ng1 pair_3_nd1 pair_3_pg2 pair_3_ps pair_3_pd2 pair_3_pd1 pair_3_pg1 VSS VDD tp_pair
Xrr_6 rr_6_s rr_6_te rr_6_wl VSS tp_1t1r
Xnacc_4 nacc_4_s nacc_4_d nacc_4_g VSS tp_nacc
Xpair_4 pair_4_ns pair_4_ng2 pair_4_nd2 pair_4_ng1 pair_4_nd1 pair_4_pg2 pair_4_ps pair_4_pd2 pair_4_pd1 pair_4_pg1 VSS VDD tp_pair
Xrr_7 rr_7_s rr_7_te rr_7_wl VSS tp_1t1r
Xnacc_5 nacc_5_s nacc_5_d nacc_5_g VSS tp_nacc
Xpair_5 pair_5_ns pair_5_ng2 pair_5_nd2 pair_5_ng1 pair_5_nd1 pair_5_pg2 pair_5_ps pair_5_pd2 pair_5_pd1 pair_5_pg1 VSS VDD tp_pair
Xrr_8 rr_8_s rr_8_te rr_8_wl VSS tp_1t1r
Xnacc_6 nacc_6_s nacc_6_d nacc_6_g VSS tp_nacc
Xpair_6 pair_6_ns pair_6_ng2 pair_6_nd2 pair_6_ng1 pair_6_nd1 pair_6_pg2 pair_6_ps pair_6_pd2 pair_6_pd1 pair_6_pg1 VSS VDD tp_pair
.ends tp_br
