.subckt wu_tg3 vp vm akx aky ako abs ctl ctlb vdd vss
MT0n akx ctl vp vss nfet_g5v0d10v5 w=2u l=0.5u
MT0p akx ctlb vp vdd pfet_g5v0d10v5 w=4u l=0.5u
MT1n aky ctl vm vss nfet_g5v0d10v5 w=2u l=0.5u
MT1p aky ctlb vm vdd pfet_g5v0d10v5 w=4u l=0.5u
MT2n abs ctl ako vss nfet_g5v0d10v5 w=2u l=0.5u
MT2p abs ctlb ako vdd pfet_g5v0d10v5 w=4u l=0.5u
.ends wu_tg3
