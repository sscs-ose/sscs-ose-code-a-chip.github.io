.subckt input_drive row_0 row_1 row_2 row_3 row_4 row_5 row_6 row_7 row_8 row_9 row_10 row_11 row_12 row_13 row_14 row_15 row_16 row_17 row_18 row_19 row_20 row_21 row_22 row_23 row_24 row_25 row_26 row_27 row_28 row_29 row_30 row_31 row_32 row_33 row_34 row_35 row_36 row_37 row_38 row_39 row_40 row_41 row_42 row_43 row_44 row_45 row_46 row_47 row_48 row_49 row_50 row_51 row_52 row_53 row_54 row_55 row_56 row_57 row_58 row_59 row_60 row_61 row_62 row_63 row_64 row_65 row_66 row_67 row_68 row_69 row_70 row_71 row_72 row_73 row_74 row_75 row_76 row_77 row_78 row_79 row_80 row_81 row_82 row_83 row_84 row_85 row_86 row_87 row_88 row_89 row_90 row_91 row_92 row_93 row_94 row_95 row_96 row_97 row_98 row_99 ga0 ga1 ga2 ga3 ga4 ga5 ga6 ga7 ga8 ga9 ga10 ga11 ga12 ga13 ga14 ga15 ga16 ga17 ga18 ga19 ga20 ga21 ga22 ga23 ga24 ga25 ga26 ga27 ga28 ga29 ga30 ga31 ga32 ga33 ga34 ga35 ga36 ga37 ga38 ga39 ga40 ga41 ga42 ga43 ga44 ga45 ga46 ga47 ga48 gb0 gb1 gb2 gb3 gb4 gb5 gb6 gb7 gb8 gb9 gb10 gb11 gb12 gb13 gb14 gb15 gb16 gb17 gb18 gb19 gb20 gb21 gb22 gb23 gb24 gb25 gb26 gb27 gb28 gb29 gb30 gb31 gb32 gb33 gb34 gb35 gb36 gb37 gb38 gb39 gb40 gb41 gb42 gb43 gb44 gb45 gb46 gb47 gb48 READ vrailp vrailm vss
MDm0 row_0 gb0 vrailm vss nfet_g5v0d10v5 w=1000u l=0.5u
MDp0 row_0 ga0 vrailp vss nfet_g5v0d10v5 w=1000u l=0.5u
MDm1 row_1 ga0 vrailm vss nfet_g5v0d10v5 w=1000u l=0.5u
MDp1 row_1 gb0 vrailp vss nfet_g5v0d10v5 w=1000u l=0.5u
MDm2 row_2 gb1 vrailm vss nfet_g5v0d10v5 w=1000u l=0.5u
MDp2 row_2 ga1 vrailp vss nfet_g5v0d10v5 w=1000u l=0.5u
MDm3 row_3 ga1 vrailm vss nfet_g5v0d10v5 w=1000u l=0.5u
MDp3 row_3 gb1 vrailp vss nfet_g5v0d10v5 w=1000u l=0.5u
MDm4 row_4 gb2 vrailm vss nfet_g5v0d10v5 w=1000u l=0.5u
MDp4 row_4 ga2 vrailp vss nfet_g5v0d10v5 w=1000u l=0.5u
MDm5 row_5 ga2 vrailm vss nfet_g5v0d10v5 w=1000u l=0.5u
MDp5 row_5 gb2 vrailp vss nfet_g5v0d10v5 w=1000u l=0.5u
MDm6 row_6 gb3 vrailm vss nfet_g5v0d10v5 w=1000u l=0.5u
MDp6 row_6 ga3 vrailp vss nfet_g5v0d10v5 w=1000u l=0.5u
MDm7 row_7 ga3 vrailm vss nfet_g5v0d10v5 w=1000u l=0.5u
MDp7 row_7 gb3 vrailp vss nfet_g5v0d10v5 w=1000u l=0.5u
MDm8 row_8 gb4 vrailm vss nfet_g5v0d10v5 w=1000u l=0.5u
MDp8 row_8 ga4 vrailp vss nfet_g5v0d10v5 w=1000u l=0.5u
MDm9 row_9 ga4 vrailm vss nfet_g5v0d10v5 w=1000u l=0.5u
MDp9 row_9 gb4 vrailp vss nfet_g5v0d10v5 w=1000u l=0.5u
MDm10 row_10 gb5 vrailm vss nfet_g5v0d10v5 w=1000u l=0.5u
MDp10 row_10 ga5 vrailp vss nfet_g5v0d10v5 w=1000u l=0.5u
MDm11 row_11 ga5 vrailm vss nfet_g5v0d10v5 w=1000u l=0.5u
MDp11 row_11 gb5 vrailp vss nfet_g5v0d10v5 w=1000u l=0.5u
MDm12 row_12 gb6 vrailm vss nfet_g5v0d10v5 w=1000u l=0.5u
MDp12 row_12 ga6 vrailp vss nfet_g5v0d10v5 w=1000u l=0.5u
MDm13 row_13 ga6 vrailm vss nfet_g5v0d10v5 w=1000u l=0.5u
MDp13 row_13 gb6 vrailp vss nfet_g5v0d10v5 w=1000u l=0.5u
MDm14 row_14 gb7 vrailm vss nfet_g5v0d10v5 w=1000u l=0.5u
MDp14 row_14 ga7 vrailp vss nfet_g5v0d10v5 w=1000u l=0.5u
MDm15 row_15 ga7 vrailm vss nfet_g5v0d10v5 w=1000u l=0.5u
MDp15 row_15 gb7 vrailp vss nfet_g5v0d10v5 w=1000u l=0.5u
MDm16 row_16 gb8 vrailm vss nfet_g5v0d10v5 w=1000u l=0.5u
MDp16 row_16 ga8 vrailp vss nfet_g5v0d10v5 w=1000u l=0.5u
MDm17 row_17 ga8 vrailm vss nfet_g5v0d10v5 w=1000u l=0.5u
MDp17 row_17 gb8 vrailp vss nfet_g5v0d10v5 w=1000u l=0.5u
MDm18 row_18 gb9 vrailm vss nfet_g5v0d10v5 w=1000u l=0.5u
MDp18 row_18 ga9 vrailp vss nfet_g5v0d10v5 w=1000u l=0.5u
MDm19 row_19 ga9 vrailm vss nfet_g5v0d10v5 w=1000u l=0.5u
MDp19 row_19 gb9 vrailp vss nfet_g5v0d10v5 w=1000u l=0.5u
MDm20 row_20 gb10 vrailm vss nfet_g5v0d10v5 w=1000u l=0.5u
MDp20 row_20 ga10 vrailp vss nfet_g5v0d10v5 w=1000u l=0.5u
MDm21 row_21 ga10 vrailm vss nfet_g5v0d10v5 w=1000u l=0.5u
MDp21 row_21 gb10 vrailp vss nfet_g5v0d10v5 w=1000u l=0.5u
MDm22 row_22 gb11 vrailm vss nfet_g5v0d10v5 w=1000u l=0.5u
MDp22 row_22 ga11 vrailp vss nfet_g5v0d10v5 w=1000u l=0.5u
MDm23 row_23 ga11 vrailm vss nfet_g5v0d10v5 w=1000u l=0.5u
MDp23 row_23 gb11 vrailp vss nfet_g5v0d10v5 w=1000u l=0.5u
MDm24 row_24 gb12 vrailm vss nfet_g5v0d10v5 w=1000u l=0.5u
MDp24 row_24 ga12 vrailp vss nfet_g5v0d10v5 w=1000u l=0.5u
MDm25 row_25 ga12 vrailm vss nfet_g5v0d10v5 w=1000u l=0.5u
MDp25 row_25 gb12 vrailp vss nfet_g5v0d10v5 w=1000u l=0.5u
MDm26 row_26 gb13 vrailm vss nfet_g5v0d10v5 w=1000u l=0.5u
MDp26 row_26 ga13 vrailp vss nfet_g5v0d10v5 w=1000u l=0.5u
MDm27 row_27 ga13 vrailm vss nfet_g5v0d10v5 w=1000u l=0.5u
MDp27 row_27 gb13 vrailp vss nfet_g5v0d10v5 w=1000u l=0.5u
MDm28 row_28 gb14 vrailm vss nfet_g5v0d10v5 w=1000u l=0.5u
MDp28 row_28 ga14 vrailp vss nfet_g5v0d10v5 w=1000u l=0.5u
MDm29 row_29 ga14 vrailm vss nfet_g5v0d10v5 w=1000u l=0.5u
MDp29 row_29 gb14 vrailp vss nfet_g5v0d10v5 w=1000u l=0.5u
MDm30 row_30 gb15 vrailm vss nfet_g5v0d10v5 w=1000u l=0.5u
MDp30 row_30 ga15 vrailp vss nfet_g5v0d10v5 w=1000u l=0.5u
MDm31 row_31 ga15 vrailm vss nfet_g5v0d10v5 w=1000u l=0.5u
MDp31 row_31 gb15 vrailp vss nfet_g5v0d10v5 w=1000u l=0.5u
MDm32 row_32 gb16 vrailm vss nfet_g5v0d10v5 w=1000u l=0.5u
MDp32 row_32 ga16 vrailp vss nfet_g5v0d10v5 w=1000u l=0.5u
MDm33 row_33 ga16 vrailm vss nfet_g5v0d10v5 w=1000u l=0.5u
MDp33 row_33 gb16 vrailp vss nfet_g5v0d10v5 w=1000u l=0.5u
MDm34 row_34 gb17 vrailm vss nfet_g5v0d10v5 w=1000u l=0.5u
MDp34 row_34 ga17 vrailp vss nfet_g5v0d10v5 w=1000u l=0.5u
MDm35 row_35 ga17 vrailm vss nfet_g5v0d10v5 w=1000u l=0.5u
MDp35 row_35 gb17 vrailp vss nfet_g5v0d10v5 w=1000u l=0.5u
MDm36 row_36 gb18 vrailm vss nfet_g5v0d10v5 w=1000u l=0.5u
MDp36 row_36 ga18 vrailp vss nfet_g5v0d10v5 w=1000u l=0.5u
MDm37 row_37 ga18 vrailm vss nfet_g5v0d10v5 w=1000u l=0.5u
MDp37 row_37 gb18 vrailp vss nfet_g5v0d10v5 w=1000u l=0.5u
MDm38 row_38 gb19 vrailm vss nfet_g5v0d10v5 w=1000u l=0.5u
MDp38 row_38 ga19 vrailp vss nfet_g5v0d10v5 w=1000u l=0.5u
MDm39 row_39 ga19 vrailm vss nfet_g5v0d10v5 w=1000u l=0.5u
MDp39 row_39 gb19 vrailp vss nfet_g5v0d10v5 w=1000u l=0.5u
MDm40 row_40 gb20 vrailm vss nfet_g5v0d10v5 w=1000u l=0.5u
MDp40 row_40 ga20 vrailp vss nfet_g5v0d10v5 w=1000u l=0.5u
MDm41 row_41 ga20 vrailm vss nfet_g5v0d10v5 w=1000u l=0.5u
MDp41 row_41 gb20 vrailp vss nfet_g5v0d10v5 w=1000u l=0.5u
MDm42 row_42 gb21 vrailm vss nfet_g5v0d10v5 w=1000u l=0.5u
MDp42 row_42 ga21 vrailp vss nfet_g5v0d10v5 w=1000u l=0.5u
MDm43 row_43 ga21 vrailm vss nfet_g5v0d10v5 w=1000u l=0.5u
MDp43 row_43 gb21 vrailp vss nfet_g5v0d10v5 w=1000u l=0.5u
MDm44 row_44 gb22 vrailm vss nfet_g5v0d10v5 w=1000u l=0.5u
MDp44 row_44 ga22 vrailp vss nfet_g5v0d10v5 w=1000u l=0.5u
MDm45 row_45 ga22 vrailm vss nfet_g5v0d10v5 w=1000u l=0.5u
MDp45 row_45 gb22 vrailp vss nfet_g5v0d10v5 w=1000u l=0.5u
MDm46 row_46 gb23 vrailm vss nfet_g5v0d10v5 w=1000u l=0.5u
MDp46 row_46 ga23 vrailp vss nfet_g5v0d10v5 w=1000u l=0.5u
MDm47 row_47 ga23 vrailm vss nfet_g5v0d10v5 w=1000u l=0.5u
MDp47 row_47 gb23 vrailp vss nfet_g5v0d10v5 w=1000u l=0.5u
MDm48 row_48 gb24 vrailm vss nfet_g5v0d10v5 w=1000u l=0.5u
MDp48 row_48 ga24 vrailp vss nfet_g5v0d10v5 w=1000u l=0.5u
MDm49 row_49 ga24 vrailm vss nfet_g5v0d10v5 w=1000u l=0.5u
MDp49 row_49 gb24 vrailp vss nfet_g5v0d10v5 w=1000u l=0.5u
MDm50 row_50 gb25 vrailm vss nfet_g5v0d10v5 w=1000u l=0.5u
MDp50 row_50 ga25 vrailp vss nfet_g5v0d10v5 w=1000u l=0.5u
MDm51 row_51 ga25 vrailm vss nfet_g5v0d10v5 w=1000u l=0.5u
MDp51 row_51 gb25 vrailp vss nfet_g5v0d10v5 w=1000u l=0.5u
MDm52 row_52 gb26 vrailm vss nfet_g5v0d10v5 w=1000u l=0.5u
MDp52 row_52 ga26 vrailp vss nfet_g5v0d10v5 w=1000u l=0.5u
MDm53 row_53 ga26 vrailm vss nfet_g5v0d10v5 w=1000u l=0.5u
MDp53 row_53 gb26 vrailp vss nfet_g5v0d10v5 w=1000u l=0.5u
MDm54 row_54 gb27 vrailm vss nfet_g5v0d10v5 w=1000u l=0.5u
MDp54 row_54 ga27 vrailp vss nfet_g5v0d10v5 w=1000u l=0.5u
MDm55 row_55 ga27 vrailm vss nfet_g5v0d10v5 w=1000u l=0.5u
MDp55 row_55 gb27 vrailp vss nfet_g5v0d10v5 w=1000u l=0.5u
MDm56 row_56 gb28 vrailm vss nfet_g5v0d10v5 w=1000u l=0.5u
MDp56 row_56 ga28 vrailp vss nfet_g5v0d10v5 w=1000u l=0.5u
MDm57 row_57 ga28 vrailm vss nfet_g5v0d10v5 w=1000u l=0.5u
MDp57 row_57 gb28 vrailp vss nfet_g5v0d10v5 w=1000u l=0.5u
MDm58 row_58 gb29 vrailm vss nfet_g5v0d10v5 w=1000u l=0.5u
MDp58 row_58 ga29 vrailp vss nfet_g5v0d10v5 w=1000u l=0.5u
MDm59 row_59 ga29 vrailm vss nfet_g5v0d10v5 w=1000u l=0.5u
MDp59 row_59 gb29 vrailp vss nfet_g5v0d10v5 w=1000u l=0.5u
MDm60 row_60 gb30 vrailm vss nfet_g5v0d10v5 w=1000u l=0.5u
MDp60 row_60 ga30 vrailp vss nfet_g5v0d10v5 w=1000u l=0.5u
MDm61 row_61 ga30 vrailm vss nfet_g5v0d10v5 w=1000u l=0.5u
MDp61 row_61 gb30 vrailp vss nfet_g5v0d10v5 w=1000u l=0.5u
MDm62 row_62 gb31 vrailm vss nfet_g5v0d10v5 w=1000u l=0.5u
MDp62 row_62 ga31 vrailp vss nfet_g5v0d10v5 w=1000u l=0.5u
MDm63 row_63 ga31 vrailm vss nfet_g5v0d10v5 w=1000u l=0.5u
MDp63 row_63 gb31 vrailp vss nfet_g5v0d10v5 w=1000u l=0.5u
MDm64 row_64 gb32 vrailm vss nfet_g5v0d10v5 w=1000u l=0.5u
MDp64 row_64 ga32 vrailp vss nfet_g5v0d10v5 w=1000u l=0.5u
MDm65 row_65 ga32 vrailm vss nfet_g5v0d10v5 w=1000u l=0.5u
MDp65 row_65 gb32 vrailp vss nfet_g5v0d10v5 w=1000u l=0.5u
MDm66 row_66 gb33 vrailm vss nfet_g5v0d10v5 w=1000u l=0.5u
MDp66 row_66 ga33 vrailp vss nfet_g5v0d10v5 w=1000u l=0.5u
MDm67 row_67 ga33 vrailm vss nfet_g5v0d10v5 w=1000u l=0.5u
MDp67 row_67 gb33 vrailp vss nfet_g5v0d10v5 w=1000u l=0.5u
MDm68 row_68 gb34 vrailm vss nfet_g5v0d10v5 w=1000u l=0.5u
MDp68 row_68 ga34 vrailp vss nfet_g5v0d10v5 w=1000u l=0.5u
MDm69 row_69 ga34 vrailm vss nfet_g5v0d10v5 w=1000u l=0.5u
MDp69 row_69 gb34 vrailp vss nfet_g5v0d10v5 w=1000u l=0.5u
MDm70 row_70 gb35 vrailm vss nfet_g5v0d10v5 w=1000u l=0.5u
MDp70 row_70 ga35 vrailp vss nfet_g5v0d10v5 w=1000u l=0.5u
MDm71 row_71 ga35 vrailm vss nfet_g5v0d10v5 w=1000u l=0.5u
MDp71 row_71 gb35 vrailp vss nfet_g5v0d10v5 w=1000u l=0.5u
MDm72 row_72 gb36 vrailm vss nfet_g5v0d10v5 w=1000u l=0.5u
MDp72 row_72 ga36 vrailp vss nfet_g5v0d10v5 w=1000u l=0.5u
MDm73 row_73 ga36 vrailm vss nfet_g5v0d10v5 w=1000u l=0.5u
MDp73 row_73 gb36 vrailp vss nfet_g5v0d10v5 w=1000u l=0.5u
MDm74 row_74 gb37 vrailm vss nfet_g5v0d10v5 w=1000u l=0.5u
MDp74 row_74 ga37 vrailp vss nfet_g5v0d10v5 w=1000u l=0.5u
MDm75 row_75 ga37 vrailm vss nfet_g5v0d10v5 w=1000u l=0.5u
MDp75 row_75 gb37 vrailp vss nfet_g5v0d10v5 w=1000u l=0.5u
MDm76 row_76 gb38 vrailm vss nfet_g5v0d10v5 w=1000u l=0.5u
MDp76 row_76 ga38 vrailp vss nfet_g5v0d10v5 w=1000u l=0.5u
MDm77 row_77 ga38 vrailm vss nfet_g5v0d10v5 w=1000u l=0.5u
MDp77 row_77 gb38 vrailp vss nfet_g5v0d10v5 w=1000u l=0.5u
MDm78 row_78 gb39 vrailm vss nfet_g5v0d10v5 w=1000u l=0.5u
MDp78 row_78 ga39 vrailp vss nfet_g5v0d10v5 w=1000u l=0.5u
MDm79 row_79 ga39 vrailm vss nfet_g5v0d10v5 w=1000u l=0.5u
MDp79 row_79 gb39 vrailp vss nfet_g5v0d10v5 w=1000u l=0.5u
MDm80 row_80 gb40 vrailm vss nfet_g5v0d10v5 w=1000u l=0.5u
MDp80 row_80 ga40 vrailp vss nfet_g5v0d10v5 w=1000u l=0.5u
MDm81 row_81 ga40 vrailm vss nfet_g5v0d10v5 w=1000u l=0.5u
MDp81 row_81 gb40 vrailp vss nfet_g5v0d10v5 w=1000u l=0.5u
MDm82 row_82 gb41 vrailm vss nfet_g5v0d10v5 w=1000u l=0.5u
MDp82 row_82 ga41 vrailp vss nfet_g5v0d10v5 w=1000u l=0.5u
MDm83 row_83 ga41 vrailm vss nfet_g5v0d10v5 w=1000u l=0.5u
MDp83 row_83 gb41 vrailp vss nfet_g5v0d10v5 w=1000u l=0.5u
MDm84 row_84 gb42 vrailm vss nfet_g5v0d10v5 w=1000u l=0.5u
MDp84 row_84 ga42 vrailp vss nfet_g5v0d10v5 w=1000u l=0.5u
MDm85 row_85 ga42 vrailm vss nfet_g5v0d10v5 w=1000u l=0.5u
MDp85 row_85 gb42 vrailp vss nfet_g5v0d10v5 w=1000u l=0.5u
MDm86 row_86 gb43 vrailm vss nfet_g5v0d10v5 w=1000u l=0.5u
MDp86 row_86 ga43 vrailp vss nfet_g5v0d10v5 w=1000u l=0.5u
MDm87 row_87 ga43 vrailm vss nfet_g5v0d10v5 w=1000u l=0.5u
MDp87 row_87 gb43 vrailp vss nfet_g5v0d10v5 w=1000u l=0.5u
MDm88 row_88 gb44 vrailm vss nfet_g5v0d10v5 w=1000u l=0.5u
MDp88 row_88 ga44 vrailp vss nfet_g5v0d10v5 w=1000u l=0.5u
MDm89 row_89 ga44 vrailm vss nfet_g5v0d10v5 w=1000u l=0.5u
MDp89 row_89 gb44 vrailp vss nfet_g5v0d10v5 w=1000u l=0.5u
MDm90 row_90 gb45 vrailm vss nfet_g5v0d10v5 w=1000u l=0.5u
MDp90 row_90 ga45 vrailp vss nfet_g5v0d10v5 w=1000u l=0.5u
MDm91 row_91 ga45 vrailm vss nfet_g5v0d10v5 w=1000u l=0.5u
MDp91 row_91 gb45 vrailp vss nfet_g5v0d10v5 w=1000u l=0.5u
MDm92 row_92 gb46 vrailm vss nfet_g5v0d10v5 w=1000u l=0.5u
MDp92 row_92 ga46 vrailp vss nfet_g5v0d10v5 w=1000u l=0.5u
MDm93 row_93 ga46 vrailm vss nfet_g5v0d10v5 w=1000u l=0.5u
MDp93 row_93 gb46 vrailp vss nfet_g5v0d10v5 w=1000u l=0.5u
MDm94 row_94 gb47 vrailm vss nfet_g5v0d10v5 w=1000u l=0.5u
MDp94 row_94 ga47 vrailp vss nfet_g5v0d10v5 w=1000u l=0.5u
MDm95 row_95 ga47 vrailm vss nfet_g5v0d10v5 w=1000u l=0.5u
MDp95 row_95 gb47 vrailp vss nfet_g5v0d10v5 w=1000u l=0.5u
MDm96 row_96 gb48 vrailm vss nfet_g5v0d10v5 w=1000u l=0.5u
MDp96 row_96 ga48 vrailp vss nfet_g5v0d10v5 w=1000u l=0.5u
MDm97 row_97 ga48 vrailm vss nfet_g5v0d10v5 w=1000u l=0.5u
MDp97 row_97 gb48 vrailp vss nfet_g5v0d10v5 w=1000u l=0.5u
MDb98 row_98 READ vrailp vss nfet_g5v0d10v5 w=1000u l=0.5u
MDb99 row_99 READ vrailm vss nfet_g5v0d10v5 w=1000u l=0.5u
.ends input_drive
