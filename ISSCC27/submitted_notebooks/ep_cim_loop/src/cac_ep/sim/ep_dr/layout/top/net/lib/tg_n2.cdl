* tg_n2.cdl — 사본 (그대로), 원본 layout/blocks/tg_n2.cdl, mk_top.py 2026-10-28 07:35
.subckt tg_n2 a b ctl ctlb VDD VSS
Mn_0 b ctl a VSS nfet_g5v0d10v5 w=1.000u l=0.500u
Mn_1 b ctl a VSS nfet_g5v0d10v5 w=1.000u l=0.500u
Mp_0 b ctlb a VDD pfet_g5v0d10v5 w=2.000u l=0.500u
Mp_1 b ctlb a VDD pfet_g5v0d10v5 w=2.000u l=0.500u
.ends tg_n2
