* row_blk.cdl — 사본 (.INCLUDE 주석), 원본 digital/row_blk/out/row_blk/row_blk.cdl, mk_top.py 2026-10-28 07:35
* row_blk.cdl -- GENERATED by v2cdl.py from row_blk_pnr.v

*(chip_core.cdl 이 한 번만 include) .INCLUDE /home/grads/s/seokjindaveoh/work/ep_dr/digital/pdk/sky130_fd_sc_hvl_u.cdl
*(chip_core.cdl 이 한 번만 include) .INCLUDE /home/grads/s/seokjindaveoh/work/ep_dr/digital/row_blk/macros/rb_macros.cdl

.SUBCKT row_blk sdi row1_clk row2_clk rstb sel_en PROG VER SENSE READb WRANY vw vwl vzero R1 R2 row[105] row[104] row[103] row[102] row[101] row[100] row[99] row[98] row[97] row[96] row[95] row[94] row[93] row[92] row[91] row[90] row[89] row[88] row[87] row[86] row[85] row[84] row[83] row[82] row[81] row[80] row[79] row[78] row[77] row[76] row[75] row[74] row[73] row[72] row[71] row[70] row[69] row[68] row[67] row[66] row[65] row[64] row[63] row[62] row[61] row[60] row[59] row[58] row[57] row[56] row[55] row[54] row[53] row[52] row[51] row[50] row[49] row[48] row[47] row[46] row[45] row[44] row[43] row[42] row[41] row[40] row[39] row[38] row[37] row[36] row[35] row[34] row[33] row[32] row[31] row[30] row[29] row[28] row[27] row[26] row[25] row[24] row[23] row[22] row[21] row[20] row[19] row[18] row[17] row[16] row[15] row[14] row[13] row[12] row[11] row[10] row[9] row[8] row[7] row[6] row[5] row[4] row[3] row[2] row[1] row[0] wl[105] wl[104] wl[103] wl[102] wl[101] wl[100] wl[99] wl[98] wl[97] wl[96] wl[95] wl[94] wl[93] wl[92] wl[91] wl[90] wl[89] wl[88] wl[87] wl[86] wl[85] wl[84] wl[83] wl[82] wl[81] wl[80] wl[79] wl[78] wl[77] wl[76] wl[75] wl[74] wl[73] wl[72] wl[71] wl[70] wl[69] wl[68] wl[67] wl[66] wl[65] wl[64] wl[63] wl[62] wl[61] wl[60] wl[59] wl[58] wl[57] wl[56] wl[55] wl[54] wl[53] wl[52] wl[51] wl[50] wl[49] wl[48] wl[47] wl[46] wl[45] wl[44] wl[43] wl[42] wl[41] wl[40] wl[39] wl[38] wl[37] wl[36] wl[35] wl[34] wl[33] wl[32] wl[31] wl[30] wl[29] wl[28] wl[27] wl[26] wl[25] wl[24] wl[23] wl[22] wl[21] wl[20] wl[19] wl[18] wl[17] wl[16] wl[15] wl[14] wl[13] wl[12] wl[11] wl[10] wl[9] wl[8] wl[7] wl[6] wl[5] wl[4] wl[3] wl[2] wl[1] wl[0] VDD VSS
XFE_OFC9_FE_DBTN0_READb FE_DBTN0_READb VSS VSS VDD VDD FE_OFN10_FE_DBTN0_READb sky130_fd_sc_hvl__buf_2
XFE_OFC8_WRANY FE_OFN7_WRANY VSS VSS VDD VDD FE_OFN9_n sky130_fd_sc_hvl__buf_1
XFE_OFC6_WRANY WRANY VSS VSS VDD VDD FE_OFN7_WRANY sky130_fd_sc_hvl__buf_1
XFE_OFC5_SENSE SENSE VSS VSS VDD VDD FE_OFN6_SENSE sky130_fd_sc_hvl__buf_1
XFE_OFC4_VER VER VSS VSS VDD VDD FE_OFN5_VER sky130_fd_sc_hvl__buf_1
XFE_OFC3_PROG PROG VSS VSS VDD VDD FE_OFN4_PROG sky130_fd_sc_hvl__buf_1
XFE_OFC2_sel_en sel_en VSS VSS VDD VDD FE_OFN3_sel_en sky130_fd_sc_hvl__buf_1
XFE_OFC1_rstb rstb VSS VSS VDD VDD FE_OFN2_rstb sky130_fd_sc_hvl__buf_2
XFE_DBTC0_READb READb VSS VSS VDD VDD FE_DBTN0_READb sky130_fd_sc_hvl__inv_1
Xg1237 wsel[0] VSS VSS VDD VDD wselb[0] sky130_fd_sc_hvl__inv_1
Xg1183 wz[0] VSS VSS VDD VDD wzb[0] sky130_fd_sc_hvl__inv_1
Xg971 wlvb[0] VSS VSS VDD VDD wlv[0] sky130_fd_sc_hvl__inv_1
Xg1184 wz[1] VSS VSS VDD VDD wzb[1] sky130_fd_sc_hvl__inv_1
Xg973 wlvb[2] VSS VSS VDD VDD wlv[2] sky130_fd_sc_hvl__inv_1
Xg1188 wz[5] VSS VSS VDD VDD wzb[5] sky130_fd_sc_hvl__inv_1
Xg981 wlvb[10] VSS VSS VDD VDD wlv[10] sky130_fd_sc_hvl__inv_1
Xg1204 wz[21] VSS VSS VDD VDD wzb[21] sky130_fd_sc_hvl__inv_1
Xg1013 wlvb[42] VSS VSS VDD VDD wlv[42] sky130_fd_sc_hvl__inv_1
Xg1268 wz[85] VSS VSS VDD VDD wzb[85] sky130_fd_sc_hvl__inv_1
Xg1162 sns[85] VSS VSS VDD VDD snsb[85] sky130_fd_sc_hvl__inv_1
Xg1056 wlvb[85] VSS VSS VDD VDD wlv[85] sky130_fd_sc_hvl__inv_1
Xg853 sns[21] VSS VSS VDD VDD snsb[21] sky130_fd_sc_hvl__inv_1
Xg801 wl0b[42] VSS VSS VDD VDD wl0[42] sky130_fd_sc_hvl__inv_1
Xg724 wl0b[85] VSS VSS VDD VDD wl0[85] sky130_fd_sc_hvl__inv_1
Xg1089 wsel[86] VSS VSS VDD VDD wselb[86] sky130_fd_sc_hvl__inv_1
Xg1276 wsel[43] VSS VSS VDD VDD wselb[43] sky130_fd_sc_hvl__inv_1
Xg1269 wz[86] VSS VSS VDD VDD wzb[86] sky130_fd_sc_hvl__inv_1
Xg1163 sns[86] VSS VSS VDD VDD snsb[86] sky130_fd_sc_hvl__inv_1
Xg992 wlvb[21] VSS VSS VDD VDD wlv[21] sky130_fd_sc_hvl__inv_1
Xg1108 wz[43] VSS VSS VDD VDD wzb[43] sky130_fd_sc_hvl__inv_1
Xg1057 wlvb[86] VSS VSS VDD VDD wlv[86] sky130_fd_sc_hvl__inv_1
Xg722 sns[43] VSS VSS VDD VDD snsb[43] sky130_fd_sc_hvl__inv_1
Xg723 wl0b[86] VSS VSS VDD VDD wl0[86] sky130_fd_sc_hvl__inv_1
Xg864 wsel[87] VSS VSS VDD VDD wselb[87] sky130_fd_sc_hvl__inv_1
Xg1014 wlvb[43] VSS VSS VDD VDD wlv[43] sky130_fd_sc_hvl__inv_1
Xg1270 wz[87] VSS VSS VDD VDD wzb[87] sky130_fd_sc_hvl__inv_1
Xg1164 sns[87] VSS VSS VDD VDD snsb[87] sky130_fd_sc_hvl__inv_1
Xg1058 wlvb[87] VSS VSS VDD VDD wlv[87] sky130_fd_sc_hvl__inv_1
Xg1079 sns[5] VSS VSS VDD VDD snsb[5] sky130_fd_sc_hvl__inv_1
Xg769 wl0b[10] VSS VSS VDD VDD wl0[10] sky130_fd_sc_hvl__inv_1
Xg780 wl0b[21] VSS VSS VDD VDD wl0[21] sky130_fd_sc_hvl__inv_1
Xg802 wl0b[43] VSS VSS VDD VDD wl0[43] sky130_fd_sc_hvl__inv_1
Xg721 wl0b[87] VSS VSS VDD VDD wl0[87] sky130_fd_sc_hvl__inv_1
Xg833 wsel[88] VSS VSS VDD VDD wselb[88] sky130_fd_sc_hvl__inv_1
Xg1274 wsel[44] VSS VSS VDD VDD wselb[44] sky130_fd_sc_hvl__inv_1
Xg1275 wz[88] VSS VSS VDD VDD wzb[88] sky130_fd_sc_hvl__inv_1
Xg1165 sns[88] VSS VSS VDD VDD snsb[88] sky130_fd_sc_hvl__inv_1
Xg1106 wsel[22] VSS VSS VDD VDD wselb[22] sky130_fd_sc_hvl__inv_1
Xg1107 wz[44] VSS VSS VDD VDD wzb[44] sky130_fd_sc_hvl__inv_1
Xg1059 wlvb[88] VSS VSS VDD VDD wlv[88] sky130_fd_sc_hvl__inv_1
Xg719 sns[44] VSS VSS VDD VDD snsb[44] sky130_fd_sc_hvl__inv_1
Xg720 wl0b[88] VSS VSS VDD VDD wl0[88] sky130_fd_sc_hvl__inv_1
Xg708 wsel[89] VSS VSS VDD VDD wselb[89] sky130_fd_sc_hvl__inv_1
Xg1213 wsel[11] VSS VSS VDD VDD wselb[11] sky130_fd_sc_hvl__inv_1
Xg1205 wz[22] VSS VSS VDD VDD wzb[22] sky130_fd_sc_hvl__inv_1
Xg1015 wlvb[44] VSS VSS VDD VDD wlv[44] sky130_fd_sc_hvl__inv_1
Xg1272 wz[89] VSS VSS VDD VDD wzb[89] sky130_fd_sc_hvl__inv_1
Xg1166 sns[89] VSS VSS VDD VDD snsb[89] sky130_fd_sc_hvl__inv_1
Xg1060 wlvb[89] VSS VSS VDD VDD wlv[89] sky130_fd_sc_hvl__inv_1
Xg852 sns[22] VSS VSS VDD VDD snsb[22] sky130_fd_sc_hvl__inv_1
Xg803 wl0b[44] VSS VSS VDD VDD wl0[44] sky130_fd_sc_hvl__inv_1
Xg717 wl0b[89] VSS VSS VDD VDD wl0[89] sky130_fd_sc_hvl__inv_1
Xg645 wsel[90] VSS VSS VDD VDD wselb[90] sky130_fd_sc_hvl__inv_1
Xg1267 wsel[45] VSS VSS VDD VDD wselb[45] sky130_fd_sc_hvl__inv_1
Xg1271 wz[90] VSS VSS VDD VDD wzb[90] sky130_fd_sc_hvl__inv_1
Xg1167 sns[90] VSS VSS VDD VDD snsb[90] sky130_fd_sc_hvl__inv_1
Xg976 wlvb[5] VSS VSS VDD VDD wlv[5] sky130_fd_sc_hvl__inv_1
Xg1194 wz[11] VSS VSS VDD VDD wzb[11] sky130_fd_sc_hvl__inv_1
Xg993 wlvb[22] VSS VSS VDD VDD wlv[22] sky130_fd_sc_hvl__inv_1
Xg1103 wz[45] VSS VSS VDD VDD wzb[45] sky130_fd_sc_hvl__inv_1
Xg1061 wlvb[90] VSS VSS VDD VDD wlv[90] sky130_fd_sc_hvl__inv_1
Xg715 sns[45] VSS VSS VDD VDD snsb[45] sky130_fd_sc_hvl__inv_1
Xg716 wl0b[90] VSS VSS VDD VDD wl0[90] sky130_fd_sc_hvl__inv_1
Xg1262 wsel[91] VSS VSS VDD VDD wselb[91] sky130_fd_sc_hvl__inv_1
Xg1016 wlvb[45] VSS VSS VDD VDD wlv[45] sky130_fd_sc_hvl__inv_1
Xg1266 wz[91] VSS VSS VDD VDD wzb[91] sky130_fd_sc_hvl__inv_1
Xg1168 sns[91] VSS VSS VDD VDD snsb[91] sky130_fd_sc_hvl__inv_1
Xg1062 wlvb[91] VSS VSS VDD VDD wlv[91] sky130_fd_sc_hvl__inv_1
Xg872 sns[11] VSS VSS VDD VDD snsb[11] sky130_fd_sc_hvl__inv_1
Xg781 wl0b[22] VSS VSS VDD VDD wl0[22] sky130_fd_sc_hvl__inv_1
Xg804 wl0b[45] VSS VSS VDD VDD wl0[45] sky130_fd_sc_hvl__inv_1
Xg714 wl0b[91] VSS VSS VDD VDD wl0[91] sky130_fd_sc_hvl__inv_1
Xg1247 wsel[92] VSS VSS VDD VDD wselb[92] sky130_fd_sc_hvl__inv_1
Xg1264 wsel[46] VSS VSS VDD VDD wselb[46] sky130_fd_sc_hvl__inv_1
Xg1265 wz[92] VSS VSS VDD VDD wzb[92] sky130_fd_sc_hvl__inv_1
Xg1169 sns[92] VSS VSS VDD VDD snsb[92] sky130_fd_sc_hvl__inv_1
Xg1101 wsel[23] VSS VSS VDD VDD wselb[23] sky130_fd_sc_hvl__inv_1
Xg1102 wz[46] VSS VSS VDD VDD wzb[46] sky130_fd_sc_hvl__inv_1
Xg1063 wlvb[92] VSS VSS VDD VDD wlv[92] sky130_fd_sc_hvl__inv_1
Xg712 sns[46] VSS VSS VDD VDD snsb[46] sky130_fd_sc_hvl__inv_1
Xg713 wl0b[92] VSS VSS VDD VDD wl0[92] sky130_fd_sc_hvl__inv_1
Xg1231 wsel[93] VSS VSS VDD VDD wselb[93] sky130_fd_sc_hvl__inv_1
Xg982 wlvb[11] VSS VSS VDD VDD wlv[11] sky130_fd_sc_hvl__inv_1
Xg1206 wz[23] VSS VSS VDD VDD wzb[23] sky130_fd_sc_hvl__inv_1
Xg1017 wlvb[46] VSS VSS VDD VDD wlv[46] sky130_fd_sc_hvl__inv_1
Xg1261 wz[93] VSS VSS VDD VDD wzb[93] sky130_fd_sc_hvl__inv_1
Xg1170 sns[93] VSS VSS VDD VDD snsb[93] sky130_fd_sc_hvl__inv_1
Xg1064 wlvb[93] VSS VSS VDD VDD wlv[93] sky130_fd_sc_hvl__inv_1
Xg848 sns[23] VSS VSS VDD VDD snsb[23] sky130_fd_sc_hvl__inv_1
Xg805 wl0b[46] VSS VSS VDD VDD wl0[46] sky130_fd_sc_hvl__inv_1
Xg707 wl0b[93] VSS VSS VDD VDD wl0[93] sky130_fd_sc_hvl__inv_1
Xg1216 wsel[94] VSS VSS VDD VDD wselb[94] sky130_fd_sc_hvl__inv_1
Xg1259 wsel[47] VSS VSS VDD VDD wselb[47] sky130_fd_sc_hvl__inv_1
Xg1260 wz[94] VSS VSS VDD VDD wzb[94] sky130_fd_sc_hvl__inv_1
Xg1171 sns[94] VSS VSS VDD VDD snsb[94] sky130_fd_sc_hvl__inv_1
Xg994 wlvb[23] VSS VSS VDD VDD wlv[23] sky130_fd_sc_hvl__inv_1
Xg1100 wz[47] VSS VSS VDD VDD wzb[47] sky130_fd_sc_hvl__inv_1
Xg1065 wlvb[94] VSS VSS VDD VDD wlv[94] sky130_fd_sc_hvl__inv_1
Xg705 sns[47] VSS VSS VDD VDD snsb[47] sky130_fd_sc_hvl__inv_1
Xg706 wl0b[94] VSS VSS VDD VDD wl0[94] sky130_fd_sc_hvl__inv_1
Xg1119 wsel[95] VSS VSS VDD VDD wselb[95] sky130_fd_sc_hvl__inv_1
Xg1018 wlvb[47] VSS VSS VDD VDD wlv[47] sky130_fd_sc_hvl__inv_1
Xg1258 wz[95] VSS VSS VDD VDD wzb[95] sky130_fd_sc_hvl__inv_1
Xg1172 sns[95] VSS VSS VDD VDD snsb[95] sky130_fd_sc_hvl__inv_1
Xg1066 wlvb[95] VSS VSS VDD VDD wlv[95] sky130_fd_sc_hvl__inv_1
Xg1078 sns[1] VSS VSS VDD VDD snsb[1] sky130_fd_sc_hvl__inv_1
Xg761 wl0b[2] VSS VSS VDD VDD wl0[2] sky130_fd_sc_hvl__inv_1
Xg764 wl0b[5] VSS VSS VDD VDD wl0[5] sky130_fd_sc_hvl__inv_1
Xg770 wl0b[11] VSS VSS VDD VDD wl0[11] sky130_fd_sc_hvl__inv_1
Xg782 wl0b[23] VSS VSS VDD VDD wl0[23] sky130_fd_sc_hvl__inv_1
Xg806 wl0b[47] VSS VSS VDD VDD wl0[47] sky130_fd_sc_hvl__inv_1
Xg704 wl0b[95] VSS VSS VDD VDD wl0[95] sky130_fd_sc_hvl__inv_1
Xg1088 wsel[96] VSS VSS VDD VDD wselb[96] sky130_fd_sc_hvl__inv_1
Xg1256 wsel[48] VSS VSS VDD VDD wselb[48] sky130_fd_sc_hvl__inv_1
Xg1257 wz[96] VSS VSS VDD VDD wzb[96] sky130_fd_sc_hvl__inv_1
Xg1173 sns[96] VSS VSS VDD VDD snsb[96] sky130_fd_sc_hvl__inv_1
Xg1098 wsel[24] VSS VSS VDD VDD wselb[24] sky130_fd_sc_hvl__inv_1
Xg1099 wz[48] VSS VSS VDD VDD wzb[48] sky130_fd_sc_hvl__inv_1
Xg1067 wlvb[96] VSS VSS VDD VDD wlv[96] sky130_fd_sc_hvl__inv_1
Xg702 sns[48] VSS VSS VDD VDD snsb[48] sky130_fd_sc_hvl__inv_1
Xg703 wl0b[96] VSS VSS VDD VDD wl0[96] sky130_fd_sc_hvl__inv_1
Xg832 wsel[97] VSS VSS VDD VDD wselb[97] sky130_fd_sc_hvl__inv_1
Xg1211 wsel[12] VSS VSS VDD VDD wselb[12] sky130_fd_sc_hvl__inv_1
Xg1212 wz[24] VSS VSS VDD VDD wzb[24] sky130_fd_sc_hvl__inv_1
Xg1019 wlvb[48] VSS VSS VDD VDD wlv[48] sky130_fd_sc_hvl__inv_1
Xg1254 wz[97] VSS VSS VDD VDD wzb[97] sky130_fd_sc_hvl__inv_1
Xg1174 sns[97] VSS VSS VDD VDD snsb[97] sky130_fd_sc_hvl__inv_1
Xg1068 wlvb[97] VSS VSS VDD VDD wlv[97] sky130_fd_sc_hvl__inv_1
Xg847 sns[24] VSS VSS VDD VDD snsb[24] sky130_fd_sc_hvl__inv_1
Xg807 wl0b[48] VSS VSS VDD VDD wl0[48] sky130_fd_sc_hvl__inv_1
Xg700 wl0b[97] VSS VSS VDD VDD wl0[97] sky130_fd_sc_hvl__inv_1
Xg644 wsel[98] VSS VSS VDD VDD wselb[98] sky130_fd_sc_hvl__inv_1
Xg1252 wsel[49] VSS VSS VDD VDD wselb[49] sky130_fd_sc_hvl__inv_1
Xg1253 wz[98] VSS VSS VDD VDD wzb[98] sky130_fd_sc_hvl__inv_1
Xg1175 sns[98] VSS VSS VDD VDD snsb[98] sky130_fd_sc_hvl__inv_1
Xg1226 wsel[6] VSS VSS VDD VDD wselb[6] sky130_fd_sc_hvl__inv_1
Xg1195 wz[12] VSS VSS VDD VDD wzb[12] sky130_fd_sc_hvl__inv_1
Xg995 wlvb[24] VSS VSS VDD VDD wlv[24] sky130_fd_sc_hvl__inv_1
Xg1096 wz[49] VSS VSS VDD VDD wzb[49] sky130_fd_sc_hvl__inv_1
Xg1069 wlvb[98] VSS VSS VDD VDD wlv[98] sky130_fd_sc_hvl__inv_1
Xg698 sns[49] VSS VSS VDD VDD snsb[49] sky130_fd_sc_hvl__inv_1
Xg699 wl0b[98] VSS VSS VDD VDD wl0[98] sky130_fd_sc_hvl__inv_1
Xg1246 wsel[99] VSS VSS VDD VDD wselb[99] sky130_fd_sc_hvl__inv_1
Xg1020 wlvb[49] VSS VSS VDD VDD wlv[49] sky130_fd_sc_hvl__inv_1
Xg1251 wz[99] VSS VSS VDD VDD wzb[99] sky130_fd_sc_hvl__inv_1
Xg1176 sns[99] VSS VSS VDD VDD snsb[99] sky130_fd_sc_hvl__inv_1
Xg1070 wlvb[99] VSS VSS VDD VDD wlv[99] sky130_fd_sc_hvl__inv_1
Xg871 sns[12] VSS VSS VDD VDD snsb[12] sky130_fd_sc_hvl__inv_1
Xg783 wl0b[24] VSS VSS VDD VDD wl0[24] sky130_fd_sc_hvl__inv_1
Xg808 wl0b[49] VSS VSS VDD VDD wl0[49] sky130_fd_sc_hvl__inv_1
Xg697 wl0b[99] VSS VSS VDD VDD wl0[99] sky130_fd_sc_hvl__inv_1
Xg1249 wsel[50] VSS VSS VDD VDD wselb[50] sky130_fd_sc_hvl__inv_1
Xg1094 wsel[25] VSS VSS VDD VDD wselb[25] sky130_fd_sc_hvl__inv_1
Xg1095 wz[50] VSS VSS VDD VDD wzb[50] sky130_fd_sc_hvl__inv_1
Xg695 sns[50] VSS VSS VDD VDD snsb[50] sky130_fd_sc_hvl__inv_1
Xg1230 wsel[3] VSS VSS VDD VDD wselb[3] sky130_fd_sc_hvl__inv_1
Xg1189 wz[6] VSS VSS VDD VDD wzb[6] sky130_fd_sc_hvl__inv_1
Xg983 wlvb[12] VSS VSS VDD VDD wlv[12] sky130_fd_sc_hvl__inv_1
Xg1209 wz[25] VSS VSS VDD VDD wzb[25] sky130_fd_sc_hvl__inv_1
Xg1021 wlvb[50] VSS VSS VDD VDD wlv[50] sky130_fd_sc_hvl__inv_1
Xg845 sns[25] VSS VSS VDD VDD snsb[25] sky130_fd_sc_hvl__inv_1
Xg809 wl0b[50] VSS VSS VDD VDD wl0[50] sky130_fd_sc_hvl__inv_1
Xg1243 wsel[51] VSS VSS VDD VDD wselb[51] sky130_fd_sc_hvl__inv_1
Xg996 wlvb[25] VSS VSS VDD VDD wlv[25] sky130_fd_sc_hvl__inv_1
Xg1093 wz[51] VSS VSS VDD VDD wzb[51] sky130_fd_sc_hvl__inv_1
Xg690 sns[51] VSS VSS VDD VDD snsb[51] sky130_fd_sc_hvl__inv_1
Xg1022 wlvb[51] VSS VSS VDD VDD wlv[51] sky130_fd_sc_hvl__inv_1
Xg883 sns[6] VSS VSS VDD VDD snsb[6] sky130_fd_sc_hvl__inv_1
Xg771 wl0b[12] VSS VSS VDD VDD wl0[12] sky130_fd_sc_hvl__inv_1
Xg784 wl0b[25] VSS VSS VDD VDD wl0[25] sky130_fd_sc_hvl__inv_1
Xg810 wl0b[51] VSS VSS VDD VDD wl0[51] sky130_fd_sc_hvl__inv_1
Xg1240 wsel[52] VSS VSS VDD VDD wselb[52] sky130_fd_sc_hvl__inv_1
Xg1091 wsel[26] VSS VSS VDD VDD wselb[26] sky130_fd_sc_hvl__inv_1
Xg1092 wz[52] VSS VSS VDD VDD wzb[52] sky130_fd_sc_hvl__inv_1
Xg687 sns[52] VSS VSS VDD VDD snsb[52] sky130_fd_sc_hvl__inv_1
Xg1207 wsel[13] VSS VSS VDD VDD wselb[13] sky130_fd_sc_hvl__inv_1
Xg1208 wz[26] VSS VSS VDD VDD wzb[26] sky130_fd_sc_hvl__inv_1
Xg1023 wlvb[52] VSS VSS VDD VDD wlv[52] sky130_fd_sc_hvl__inv_1
Xg844 sns[26] VSS VSS VDD VDD snsb[26] sky130_fd_sc_hvl__inv_1
Xg811 wl0b[52] VSS VSS VDD VDD wl0[52] sky130_fd_sc_hvl__inv_1
Xg1236 wsel[53] VSS VSS VDD VDD wselb[53] sky130_fd_sc_hvl__inv_1
Xg972 wlvb[1] VSS VSS VDD VDD wlv[1] sky130_fd_sc_hvl__inv_1
Xg1186 wz[3] VSS VSS VDD VDD wzb[3] sky130_fd_sc_hvl__inv_1
Xg977 wlvb[6] VSS VSS VDD VDD wlv[6] sky130_fd_sc_hvl__inv_1
Xg1196 wz[13] VSS VSS VDD VDD wzb[13] sky130_fd_sc_hvl__inv_1
Xg997 wlvb[26] VSS VSS VDD VDD wlv[26] sky130_fd_sc_hvl__inv_1
Xg1086 wz[53] VSS VSS VDD VDD wzb[53] sky130_fd_sc_hvl__inv_1
Xg683 sns[53] VSS VSS VDD VDD snsb[53] sky130_fd_sc_hvl__inv_1
Xg1024 wlvb[53] VSS VSS VDD VDD wlv[53] sky130_fd_sc_hvl__inv_1
Xg869 sns[13] VSS VSS VDD VDD snsb[13] sky130_fd_sc_hvl__inv_1
Xg785 wl0b[26] VSS VSS VDD VDD wl0[26] sky130_fd_sc_hvl__inv_1
Xg812 wl0b[53] VSS VSS VDD VDD wl0[53] sky130_fd_sc_hvl__inv_1
Xg1233 wsel[54] VSS VSS VDD VDD wselb[54] sky130_fd_sc_hvl__inv_1
Xg1083 wsel[27] VSS VSS VDD VDD wselb[27] sky130_fd_sc_hvl__inv_1
Xg1084 wz[54] VSS VSS VDD VDD wzb[54] sky130_fd_sc_hvl__inv_1
Xg680 sns[54] VSS VSS VDD VDD snsb[54] sky130_fd_sc_hvl__inv_1
Xg984 wlvb[13] VSS VSS VDD VDD wlv[13] sky130_fd_sc_hvl__inv_1
Xg1139 wz[27] VSS VSS VDD VDD wzb[27] sky130_fd_sc_hvl__inv_1
Xg1025 wlvb[54] VSS VSS VDD VDD wlv[54] sky130_fd_sc_hvl__inv_1
Xg841 sns[27] VSS VSS VDD VDD snsb[27] sky130_fd_sc_hvl__inv_1
Xg813 wl0b[54] VSS VSS VDD VDD wl0[54] sky130_fd_sc_hvl__inv_1
Xg1228 wsel[55] VSS VSS VDD VDD wselb[55] sky130_fd_sc_hvl__inv_1
Xg998 wlvb[27] VSS VSS VDD VDD wlv[27] sky130_fd_sc_hvl__inv_1
Xg1080 wz[55] VSS VSS VDD VDD wzb[55] sky130_fd_sc_hvl__inv_1
Xg674 sns[55] VSS VSS VDD VDD snsb[55] sky130_fd_sc_hvl__inv_1
Xg1026 wlvb[55] VSS VSS VDD VDD wlv[55] sky130_fd_sc_hvl__inv_1
Xg1082 sns[3] VSS VSS VDD VDD snsb[3] sky130_fd_sc_hvl__inv_1
Xg765 wl0b[6] VSS VSS VDD VDD wl0[6] sky130_fd_sc_hvl__inv_1
Xg772 wl0b[13] VSS VSS VDD VDD wl0[13] sky130_fd_sc_hvl__inv_1
Xg786 wl0b[27] VSS VSS VDD VDD wl0[27] sky130_fd_sc_hvl__inv_1
Xg814 wl0b[55] VSS VSS VDD VDD wl0[55] sky130_fd_sc_hvl__inv_1
Xg1225 wsel[56] VSS VSS VDD VDD wselb[56] sky130_fd_sc_hvl__inv_1
Xg881 wsel[28] VSS VSS VDD VDD wselb[28] sky130_fd_sc_hvl__inv_1
Xg882 wz[56] VSS VSS VDD VDD wzb[56] sky130_fd_sc_hvl__inv_1
Xg671 sns[56] VSS VSS VDD VDD snsb[56] sky130_fd_sc_hvl__inv_1
Xg1137 wsel[14] VSS VSS VDD VDD wselb[14] sky130_fd_sc_hvl__inv_1
Xg1138 wz[28] VSS VSS VDD VDD wzb[28] sky130_fd_sc_hvl__inv_1
Xg1027 wlvb[56] VSS VSS VDD VDD wlv[56] sky130_fd_sc_hvl__inv_1
Xg840 sns[28] VSS VSS VDD VDD snsb[28] sky130_fd_sc_hvl__inv_1
Xg815 wl0b[56] VSS VSS VDD VDD wl0[56] sky130_fd_sc_hvl__inv_1
Xg1221 wsel[57] VSS VSS VDD VDD wselb[57] sky130_fd_sc_hvl__inv_1
Xg1223 wsel[7] VSS VSS VDD VDD wselb[7] sky130_fd_sc_hvl__inv_1
Xg1197 wz[14] VSS VSS VDD VDD wzb[14] sky130_fd_sc_hvl__inv_1
Xg999 wlvb[28] VSS VSS VDD VDD wlv[28] sky130_fd_sc_hvl__inv_1
Xg877 wz[57] VSS VSS VDD VDD wzb[57] sky130_fd_sc_hvl__inv_1
Xg667 sns[57] VSS VSS VDD VDD snsb[57] sky130_fd_sc_hvl__inv_1
Xg1028 wlvb[57] VSS VSS VDD VDD wlv[57] sky130_fd_sc_hvl__inv_1
Xg868 sns[14] VSS VSS VDD VDD snsb[14] sky130_fd_sc_hvl__inv_1
Xg787 wl0b[28] VSS VSS VDD VDD wl0[28] sky130_fd_sc_hvl__inv_1
Xg816 wl0b[57] VSS VSS VDD VDD wl0[57] sky130_fd_sc_hvl__inv_1
Xg1218 wsel[58] VSS VSS VDD VDD wselb[58] sky130_fd_sc_hvl__inv_1
Xg873 wsel[29] VSS VSS VDD VDD wselb[29] sky130_fd_sc_hvl__inv_1
Xg874 wz[58] VSS VSS VDD VDD wzb[58] sky130_fd_sc_hvl__inv_1
Xg664 sns[58] VSS VSS VDD VDD snsb[58] sky130_fd_sc_hvl__inv_1
Xg974 wlvb[3] VSS VSS VDD VDD wlv[3] sky130_fd_sc_hvl__inv_1
Xg1190 wz[7] VSS VSS VDD VDD wzb[7] sky130_fd_sc_hvl__inv_1
Xg985 wlvb[14] VSS VSS VDD VDD wlv[14] sky130_fd_sc_hvl__inv_1
Xg1134 wz[29] VSS VSS VDD VDD wzb[29] sky130_fd_sc_hvl__inv_1
Xg1029 wlvb[58] VSS VSS VDD VDD wlv[58] sky130_fd_sc_hvl__inv_1
Xg838 sns[29] VSS VSS VDD VDD snsb[29] sky130_fd_sc_hvl__inv_1
Xg817 wl0b[58] VSS VSS VDD VDD wl0[58] sky130_fd_sc_hvl__inv_1
Xg1210 wsel[59] VSS VSS VDD VDD wselb[59] sky130_fd_sc_hvl__inv_1
Xg1000 wlvb[29] VSS VSS VDD VDD wlv[29] sky130_fd_sc_hvl__inv_1
Xg870 wz[59] VSS VSS VDD VDD wzb[59] sky130_fd_sc_hvl__inv_1
Xg659 sns[59] VSS VSS VDD VDD snsb[59] sky130_fd_sc_hvl__inv_1
Xg1030 wlvb[59] VSS VSS VDD VDD wlv[59] sky130_fd_sc_hvl__inv_1
Xg879 sns[7] VSS VSS VDD VDD snsb[7] sky130_fd_sc_hvl__inv_1
Xg773 wl0b[14] VSS VSS VDD VDD wl0[14] sky130_fd_sc_hvl__inv_1
Xg788 wl0b[29] VSS VSS VDD VDD wl0[29] sky130_fd_sc_hvl__inv_1
Xg818 wl0b[59] VSS VSS VDD VDD wl0[59] sky130_fd_sc_hvl__inv_1
Xg1136 wsel[60] VSS VSS VDD VDD wselb[60] sky130_fd_sc_hvl__inv_1
Xg866 wsel[30] VSS VSS VDD VDD wselb[30] sky130_fd_sc_hvl__inv_1
Xg867 wz[60] VSS VSS VDD VDD wzb[60] sky130_fd_sc_hvl__inv_1
Xg656 sns[60] VSS VSS VDD VDD snsb[60] sky130_fd_sc_hvl__inv_1
Xg1132 wsel[15] VSS VSS VDD VDD wselb[15] sky130_fd_sc_hvl__inv_1
Xg1133 wz[30] VSS VSS VDD VDD wzb[30] sky130_fd_sc_hvl__inv_1
Xg1031 wlvb[60] VSS VSS VDD VDD wlv[60] sky130_fd_sc_hvl__inv_1
Xg837 sns[30] VSS VSS VDD VDD snsb[30] sky130_fd_sc_hvl__inv_1
Xg819 wl0b[60] VSS VSS VDD VDD wl0[60] sky130_fd_sc_hvl__inv_1
Xg1128 wsel[61] VSS VSS VDD VDD wselb[61] sky130_fd_sc_hvl__inv_1
Xg978 wlvb[7] VSS VSS VDD VDD wlv[7] sky130_fd_sc_hvl__inv_1
Xg1198 wz[15] VSS VSS VDD VDD wzb[15] sky130_fd_sc_hvl__inv_1
Xg1001 wlvb[30] VSS VSS VDD VDD wlv[30] sky130_fd_sc_hvl__inv_1
Xg861 wz[61] VSS VSS VDD VDD wzb[61] sky130_fd_sc_hvl__inv_1
Xg652 sns[61] VSS VSS VDD VDD snsb[61] sky130_fd_sc_hvl__inv_1
Xg1032 wlvb[61] VSS VSS VDD VDD wlv[61] sky130_fd_sc_hvl__inv_1
Xg863 sns[15] VSS VSS VDD VDD snsb[15] sky130_fd_sc_hvl__inv_1
Xg789 wl0b[30] VSS VSS VDD VDD wl0[30] sky130_fd_sc_hvl__inv_1
Xg820 wl0b[61] VSS VSS VDD VDD wl0[61] sky130_fd_sc_hvl__inv_1
Xg1121 wsel[62] VSS VSS VDD VDD wselb[62] sky130_fd_sc_hvl__inv_1
Xg857 wsel[31] VSS VSS VDD VDD wselb[31] sky130_fd_sc_hvl__inv_1
Xg858 wz[62] VSS VSS VDD VDD wzb[62] sky130_fd_sc_hvl__inv_1
Xg649 sns[62] VSS VSS VDD VDD snsb[62] sky130_fd_sc_hvl__inv_1
Xg986 wlvb[15] VSS VSS VDD VDD wlv[15] sky130_fd_sc_hvl__inv_1
Xg1131 wz[31] VSS VSS VDD VDD wzb[31] sky130_fd_sc_hvl__inv_1
Xg1033 wlvb[62] VSS VSS VDD VDD wlv[62] sky130_fd_sc_hvl__inv_1
Xg831 sns[31] VSS VSS VDD VDD snsb[31] sky130_fd_sc_hvl__inv_1
Xg821 wl0b[62] VSS VSS VDD VDD wl0[62] sky130_fd_sc_hvl__inv_1
Xg1112 wsel[63] VSS VSS VDD VDD wselb[63] sky130_fd_sc_hvl__inv_1
Xg1002 wlvb[31] VSS VSS VDD VDD wlv[31] sky130_fd_sc_hvl__inv_1
Xg854 wz[63] VSS VSS VDD VDD wzb[63] sky130_fd_sc_hvl__inv_1
Xg1140 sns[63] VSS VSS VDD VDD snsb[63] sky130_fd_sc_hvl__inv_1
Xg1034 wlvb[63] VSS VSS VDD VDD wlv[63] sky130_fd_sc_hvl__inv_1
Xg1077 sns[0] VSS VSS VDD VDD snsb[0] sky130_fd_sc_hvl__inv_1
Xg759 wl0b[0] VSS VSS VDD VDD wl0[0] sky130_fd_sc_hvl__inv_1
Xg760 wl0b[1] VSS VSS VDD VDD wl0[1] sky130_fd_sc_hvl__inv_1
Xg762 wl0b[3] VSS VSS VDD VDD wl0[3] sky130_fd_sc_hvl__inv_1
Xg766 wl0b[7] VSS VSS VDD VDD wl0[7] sky130_fd_sc_hvl__inv_1
Xg774 wl0b[15] VSS VSS VDD VDD wl0[15] sky130_fd_sc_hvl__inv_1
Xg790 wl0b[31] VSS VSS VDD VDD wl0[31] sky130_fd_sc_hvl__inv_1
Xg822 wl0b[63] VSS VSS VDD VDD wl0[63] sky130_fd_sc_hvl__inv_1
Xg1105 wsel[64] VSS VSS VDD VDD wselb[64] sky130_fd_sc_hvl__inv_1
Xg850 wsel[32] VSS VSS VDD VDD wselb[32] sky130_fd_sc_hvl__inv_1
Xg851 wz[64] VSS VSS VDD VDD wzb[64] sky130_fd_sc_hvl__inv_1
Xg1141 sns[64] VSS VSS VDD VDD snsb[64] sky130_fd_sc_hvl__inv_1
Xg1129 wsel[16] VSS VSS VDD VDD wselb[16] sky130_fd_sc_hvl__inv_1
Xg1130 wz[32] VSS VSS VDD VDD wzb[32] sky130_fd_sc_hvl__inv_1
Xg1035 wlvb[64] VSS VSS VDD VDD wlv[64] sky130_fd_sc_hvl__inv_1
Xg829 sns[32] VSS VSS VDD VDD snsb[32] sky130_fd_sc_hvl__inv_1
Xg830 wl0b[64] VSS VSS VDD VDD wl0[64] sky130_fd_sc_hvl__inv_1
Xg1097 wsel[65] VSS VSS VDD VDD wselb[65] sky130_fd_sc_hvl__inv_1
Xg1222 wsel[8] VSS VSS VDD VDD wselb[8] sky130_fd_sc_hvl__inv_1
Xg1199 wz[16] VSS VSS VDD VDD wzb[16] sky130_fd_sc_hvl__inv_1
Xg1003 wlvb[32] VSS VSS VDD VDD wlv[32] sky130_fd_sc_hvl__inv_1
Xg846 wz[65] VSS VSS VDD VDD wzb[65] sky130_fd_sc_hvl__inv_1
Xg1142 sns[65] VSS VSS VDD VDD snsb[65] sky130_fd_sc_hvl__inv_1
Xg1036 wlvb[65] VSS VSS VDD VDD wlv[65] sky130_fd_sc_hvl__inv_1
Xg862 sns[16] VSS VSS VDD VDD snsb[16] sky130_fd_sc_hvl__inv_1
Xg791 wl0b[32] VSS VSS VDD VDD wl0[32] sky130_fd_sc_hvl__inv_1
Xg827 wl0b[65] VSS VSS VDD VDD wl0[65] sky130_fd_sc_hvl__inv_1
Xg1090 wsel[66] VSS VSS VDD VDD wselb[66] sky130_fd_sc_hvl__inv_1
Xg842 wsel[33] VSS VSS VDD VDD wselb[33] sky130_fd_sc_hvl__inv_1
Xg843 wz[66] VSS VSS VDD VDD wzb[66] sky130_fd_sc_hvl__inv_1
Xg1143 sns[66] VSS VSS VDD VDD snsb[66] sky130_fd_sc_hvl__inv_1
Xg1229 wsel[4] VSS VSS VDD VDD wselb[4] sky130_fd_sc_hvl__inv_1
Xg1191 wz[8] VSS VSS VDD VDD wzb[8] sky130_fd_sc_hvl__inv_1
Xg987 wlvb[16] VSS VSS VDD VDD wlv[16] sky130_fd_sc_hvl__inv_1
Xg1127 wz[33] VSS VSS VDD VDD wzb[33] sky130_fd_sc_hvl__inv_1
Xg1037 wlvb[66] VSS VSS VDD VDD wlv[66] sky130_fd_sc_hvl__inv_1
Xg825 sns[33] VSS VSS VDD VDD snsb[33] sky130_fd_sc_hvl__inv_1
Xg826 wl0b[66] VSS VSS VDD VDD wl0[66] sky130_fd_sc_hvl__inv_1
Xg880 wsel[67] VSS VSS VDD VDD wselb[67] sky130_fd_sc_hvl__inv_1
Xg1004 wlvb[33] VSS VSS VDD VDD wlv[33] sky130_fd_sc_hvl__inv_1
Xg839 wz[67] VSS VSS VDD VDD wzb[67] sky130_fd_sc_hvl__inv_1
Xg1144 sns[67] VSS VSS VDD VDD snsb[67] sky130_fd_sc_hvl__inv_1
Xg1038 wlvb[67] VSS VSS VDD VDD wlv[67] sky130_fd_sc_hvl__inv_1
Xg878 sns[8] VSS VSS VDD VDD snsb[8] sky130_fd_sc_hvl__inv_1
Xg775 wl0b[16] VSS VSS VDD VDD wl0[16] sky130_fd_sc_hvl__inv_1
Xg792 wl0b[33] VSS VSS VDD VDD wl0[33] sky130_fd_sc_hvl__inv_1
Xg824 wl0b[67] VSS VSS VDD VDD wl0[67] sky130_fd_sc_hvl__inv_1
Xg865 wsel[68] VSS VSS VDD VDD wselb[68] sky130_fd_sc_hvl__inv_1
Xg835 wsel[34] VSS VSS VDD VDD wselb[34] sky130_fd_sc_hvl__inv_1
Xg836 wz[68] VSS VSS VDD VDD wzb[68] sky130_fd_sc_hvl__inv_1
Xg1145 sns[68] VSS VSS VDD VDD snsb[68] sky130_fd_sc_hvl__inv_1
Xg1125 wsel[17] VSS VSS VDD VDD wselb[17] sky130_fd_sc_hvl__inv_1
Xg1126 wz[34] VSS VSS VDD VDD wzb[34] sky130_fd_sc_hvl__inv_1
Xg1039 wlvb[68] VSS VSS VDD VDD wlv[68] sky130_fd_sc_hvl__inv_1
Xg758 sns[34] VSS VSS VDD VDD snsb[34] sky130_fd_sc_hvl__inv_1
Xg823 wl0b[68] VSS VSS VDD VDD wl0[68] sky130_fd_sc_hvl__inv_1
Xg849 wsel[69] VSS VSS VDD VDD wselb[69] sky130_fd_sc_hvl__inv_1
Xg1234 wsel[2] VSS VSS VDD VDD wselb[2] sky130_fd_sc_hvl__inv_1
Xg1187 wz[4] VSS VSS VDD VDD wzb[4] sky130_fd_sc_hvl__inv_1
Xg979 wlvb[8] VSS VSS VDD VDD wlv[8] sky130_fd_sc_hvl__inv_1
Xg1200 wz[17] VSS VSS VDD VDD wzb[17] sky130_fd_sc_hvl__inv_1
Xg1005 wlvb[34] VSS VSS VDD VDD wlv[34] sky130_fd_sc_hvl__inv_1
Xg828 wz[69] VSS VSS VDD VDD wzb[69] sky130_fd_sc_hvl__inv_1
Xg1146 sns[69] VSS VSS VDD VDD snsb[69] sky130_fd_sc_hvl__inv_1
Xg1040 wlvb[69] VSS VSS VDD VDD wlv[69] sky130_fd_sc_hvl__inv_1
Xg860 sns[17] VSS VSS VDD VDD snsb[17] sky130_fd_sc_hvl__inv_1
Xg793 wl0b[34] VSS VSS VDD VDD wl0[34] sky130_fd_sc_hvl__inv_1
Xg755 wl0b[69] VSS VSS VDD VDD wl0[69] sky130_fd_sc_hvl__inv_1
Xg834 wsel[70] VSS VSS VDD VDD wselb[70] sky130_fd_sc_hvl__inv_1
Xg756 wsel[35] VSS VSS VDD VDD wselb[35] sky130_fd_sc_hvl__inv_1
Xg757 wz[70] VSS VSS VDD VDD wzb[70] sky130_fd_sc_hvl__inv_1
Xg1147 sns[70] VSS VSS VDD VDD snsb[70] sky130_fd_sc_hvl__inv_1
Xg988 wlvb[17] VSS VSS VDD VDD wlv[17] sky130_fd_sc_hvl__inv_1
Xg1124 wz[35] VSS VSS VDD VDD wzb[35] sky130_fd_sc_hvl__inv_1
Xg1041 wlvb[70] VSS VSS VDD VDD wlv[70] sky130_fd_sc_hvl__inv_1
Xg753 sns[35] VSS VSS VDD VDD snsb[35] sky130_fd_sc_hvl__inv_1
Xg754 wl0b[70] VSS VSS VDD VDD wl0[70] sky130_fd_sc_hvl__inv_1
Xg740 wsel[71] VSS VSS VDD VDD wselb[71] sky130_fd_sc_hvl__inv_1
Xg1006 wlvb[35] VSS VSS VDD VDD wlv[35] sky130_fd_sc_hvl__inv_1
Xg749 wz[71] VSS VSS VDD VDD wzb[71] sky130_fd_sc_hvl__inv_1
Xg1148 sns[71] VSS VSS VDD VDD snsb[71] sky130_fd_sc_hvl__inv_1
Xg1042 wlvb[71] VSS VSS VDD VDD wlv[71] sky130_fd_sc_hvl__inv_1
Xg1081 sns[4] VSS VSS VDD VDD snsb[4] sky130_fd_sc_hvl__inv_1
Xg767 wl0b[8] VSS VSS VDD VDD wl0[8] sky130_fd_sc_hvl__inv_1
Xg776 wl0b[17] VSS VSS VDD VDD wl0[17] sky130_fd_sc_hvl__inv_1
Xg794 wl0b[35] VSS VSS VDD VDD wl0[35] sky130_fd_sc_hvl__inv_1
Xg752 wl0b[71] VSS VSS VDD VDD wl0[71] sky130_fd_sc_hvl__inv_1
Xg709 wsel[72] VSS VSS VDD VDD wselb[72] sky130_fd_sc_hvl__inv_1
Xg741 wsel[36] VSS VSS VDD VDD wselb[36] sky130_fd_sc_hvl__inv_1
Xg742 wz[72] VSS VSS VDD VDD wzb[72] sky130_fd_sc_hvl__inv_1
Xg1149 sns[72] VSS VSS VDD VDD snsb[72] sky130_fd_sc_hvl__inv_1
Xg1122 wsel[18] VSS VSS VDD VDD wselb[18] sky130_fd_sc_hvl__inv_1
Xg1123 wz[36] VSS VSS VDD VDD wzb[36] sky130_fd_sc_hvl__inv_1
Xg1043 wlvb[72] VSS VSS VDD VDD wlv[72] sky130_fd_sc_hvl__inv_1
Xg750 sns[36] VSS VSS VDD VDD snsb[36] sky130_fd_sc_hvl__inv_1
Xg751 wl0b[72] VSS VSS VDD VDD wl0[72] sky130_fd_sc_hvl__inv_1
Xg677 wsel[73] VSS VSS VDD VDD wselb[73] sky130_fd_sc_hvl__inv_1
Xg1220 wsel[9] VSS VSS VDD VDD wselb[9] sky130_fd_sc_hvl__inv_1
Xg1201 wz[18] VSS VSS VDD VDD wzb[18] sky130_fd_sc_hvl__inv_1
Xg1007 wlvb[36] VSS VSS VDD VDD wlv[36] sky130_fd_sc_hvl__inv_1
Xg733 wz[73] VSS VSS VDD VDD wzb[73] sky130_fd_sc_hvl__inv_1
Xg1150 sns[73] VSS VSS VDD VDD snsb[73] sky130_fd_sc_hvl__inv_1
Xg1044 wlvb[73] VSS VSS VDD VDD wlv[73] sky130_fd_sc_hvl__inv_1
Xg859 sns[18] VSS VSS VDD VDD snsb[18] sky130_fd_sc_hvl__inv_1
Xg795 wl0b[36] VSS VSS VDD VDD wl0[36] sky130_fd_sc_hvl__inv_1
Xg748 wl0b[73] VSS VSS VDD VDD wl0[73] sky130_fd_sc_hvl__inv_1
Xg646 wsel[74] VSS VSS VDD VDD wselb[74] sky130_fd_sc_hvl__inv_1
Xg725 wsel[37] VSS VSS VDD VDD wselb[37] sky130_fd_sc_hvl__inv_1
Xg726 wz[74] VSS VSS VDD VDD wzb[74] sky130_fd_sc_hvl__inv_1
Xg1151 sns[74] VSS VSS VDD VDD snsb[74] sky130_fd_sc_hvl__inv_1
Xg1235 wsel[1] VSS VSS VDD VDD wselb[1] sky130_fd_sc_hvl__inv_1
Xg1185 wz[2] VSS VSS VDD VDD wzb[2] sky130_fd_sc_hvl__inv_1
Xg975 wlvb[4] VSS VSS VDD VDD wlv[4] sky130_fd_sc_hvl__inv_1
Xg1192 wz[9] VSS VSS VDD VDD wzb[9] sky130_fd_sc_hvl__inv_1
Xg989 wlvb[18] VSS VSS VDD VDD wlv[18] sky130_fd_sc_hvl__inv_1
Xg1118 wz[37] VSS VSS VDD VDD wzb[37] sky130_fd_sc_hvl__inv_1
Xg1045 wlvb[74] VSS VSS VDD VDD wlv[74] sky130_fd_sc_hvl__inv_1
Xg746 sns[37] VSS VSS VDD VDD snsb[37] sky130_fd_sc_hvl__inv_1
Xg747 wl0b[74] VSS VSS VDD VDD wl0[74] sky130_fd_sc_hvl__inv_1
Xg1273 wsel[75] VSS VSS VDD VDD wselb[75] sky130_fd_sc_hvl__inv_1
Xg1008 wlvb[37] VSS VSS VDD VDD wlv[37] sky130_fd_sc_hvl__inv_1
Xg718 wz[75] VSS VSS VDD VDD wzb[75] sky130_fd_sc_hvl__inv_1
Xg1152 sns[75] VSS VSS VDD VDD snsb[75] sky130_fd_sc_hvl__inv_1
Xg1046 wlvb[75] VSS VSS VDD VDD wlv[75] sky130_fd_sc_hvl__inv_1
Xg876 sns[9] VSS VSS VDD VDD snsb[9] sky130_fd_sc_hvl__inv_1
Xg777 wl0b[18] VSS VSS VDD VDD wl0[18] sky130_fd_sc_hvl__inv_1
Xg796 wl0b[37] VSS VSS VDD VDD wl0[37] sky130_fd_sc_hvl__inv_1
Xg745 wl0b[75] VSS VSS VDD VDD wl0[75] sky130_fd_sc_hvl__inv_1
Xg1263 wsel[76] VSS VSS VDD VDD wselb[76] sky130_fd_sc_hvl__inv_1
Xg710 wsel[38] VSS VSS VDD VDD wselb[38] sky130_fd_sc_hvl__inv_1
Xg711 wz[76] VSS VSS VDD VDD wzb[76] sky130_fd_sc_hvl__inv_1
Xg1153 sns[76] VSS VSS VDD VDD snsb[76] sky130_fd_sc_hvl__inv_1
Xg1116 wsel[19] VSS VSS VDD VDD wselb[19] sky130_fd_sc_hvl__inv_1
Xg1117 wz[38] VSS VSS VDD VDD wzb[38] sky130_fd_sc_hvl__inv_1
Xg1047 wlvb[76] VSS VSS VDD VDD wlv[76] sky130_fd_sc_hvl__inv_1
Xg743 sns[38] VSS VSS VDD VDD snsb[38] sky130_fd_sc_hvl__inv_1
Xg744 wl0b[76] VSS VSS VDD VDD wl0[76] sky130_fd_sc_hvl__inv_1
Xg1255 wsel[77] VSS VSS VDD VDD wselb[77] sky130_fd_sc_hvl__inv_1
Xg980 wlvb[9] VSS VSS VDD VDD wlv[9] sky130_fd_sc_hvl__inv_1
Xg1202 wz[19] VSS VSS VDD VDD wzb[19] sky130_fd_sc_hvl__inv_1
Xg1009 wlvb[38] VSS VSS VDD VDD wlv[38] sky130_fd_sc_hvl__inv_1
Xg701 wz[77] VSS VSS VDD VDD wzb[77] sky130_fd_sc_hvl__inv_1
Xg1154 sns[77] VSS VSS VDD VDD snsb[77] sky130_fd_sc_hvl__inv_1
Xg1048 wlvb[77] VSS VSS VDD VDD wlv[77] sky130_fd_sc_hvl__inv_1
Xg856 sns[19] VSS VSS VDD VDD snsb[19] sky130_fd_sc_hvl__inv_1
Xg797 wl0b[38] VSS VSS VDD VDD wl0[38] sky130_fd_sc_hvl__inv_1
Xg739 wl0b[77] VSS VSS VDD VDD wl0[77] sky130_fd_sc_hvl__inv_1
Xg1248 wsel[78] VSS VSS VDD VDD wselb[78] sky130_fd_sc_hvl__inv_1
Xg693 wsel[39] VSS VSS VDD VDD wselb[39] sky130_fd_sc_hvl__inv_1
Xg694 wz[78] VSS VSS VDD VDD wzb[78] sky130_fd_sc_hvl__inv_1
Xg1155 sns[78] VSS VSS VDD VDD snsb[78] sky130_fd_sc_hvl__inv_1
Xg990 wlvb[19] VSS VSS VDD VDD wlv[19] sky130_fd_sc_hvl__inv_1
Xg1115 wz[39] VSS VSS VDD VDD wzb[39] sky130_fd_sc_hvl__inv_1
Xg1049 wlvb[78] VSS VSS VDD VDD wlv[78] sky130_fd_sc_hvl__inv_1
Xg737 sns[39] VSS VSS VDD VDD snsb[39] sky130_fd_sc_hvl__inv_1
Xg738 wl0b[78] VSS VSS VDD VDD wl0[78] sky130_fd_sc_hvl__inv_1
Xg1239 wsel[79] VSS VSS VDD VDD wselb[79] sky130_fd_sc_hvl__inv_1
Xg1010 wlvb[39] VSS VSS VDD VDD wlv[39] sky130_fd_sc_hvl__inv_1
Xg686 wz[79] VSS VSS VDD VDD wzb[79] sky130_fd_sc_hvl__inv_1
Xg1156 sns[79] VSS VSS VDD VDD snsb[79] sky130_fd_sc_hvl__inv_1
Xg1050 wlvb[79] VSS VSS VDD VDD wlv[79] sky130_fd_sc_hvl__inv_1
Xg1085 sns[2] VSS VSS VDD VDD snsb[2] sky130_fd_sc_hvl__inv_1
Xg763 wl0b[4] VSS VSS VDD VDD wl0[4] sky130_fd_sc_hvl__inv_1
Xg768 wl0b[9] VSS VSS VDD VDD wl0[9] sky130_fd_sc_hvl__inv_1
Xg778 wl0b[19] VSS VSS VDD VDD wl0[19] sky130_fd_sc_hvl__inv_1
Xg798 wl0b[39] VSS VSS VDD VDD wl0[39] sky130_fd_sc_hvl__inv_1
Xg736 wl0b[79] VSS VSS VDD VDD wl0[79] sky130_fd_sc_hvl__inv_1
Xg1232 wsel[80] VSS VSS VDD VDD wselb[80] sky130_fd_sc_hvl__inv_1
Xg678 wsel[40] VSS VSS VDD VDD wselb[40] sky130_fd_sc_hvl__inv_1
Xg679 wz[80] VSS VSS VDD VDD wzb[80] sky130_fd_sc_hvl__inv_1
Xg1157 sns[80] VSS VSS VDD VDD snsb[80] sky130_fd_sc_hvl__inv_1
Xg1113 wsel[20] VSS VSS VDD VDD wselb[20] sky130_fd_sc_hvl__inv_1
Xg1114 wz[40] VSS VSS VDD VDD wzb[40] sky130_fd_sc_hvl__inv_1
Xg1051 wlvb[80] VSS VSS VDD VDD wlv[80] sky130_fd_sc_hvl__inv_1
Xg734 sns[40] VSS VSS VDD VDD snsb[40] sky130_fd_sc_hvl__inv_1
Xg735 wl0b[80] VSS VSS VDD VDD wl0[80] sky130_fd_sc_hvl__inv_1
Xg1224 wsel[81] VSS VSS VDD VDD wselb[81] sky130_fd_sc_hvl__inv_1
Xg1219 wsel[10] VSS VSS VDD VDD wselb[10] sky130_fd_sc_hvl__inv_1
Xg1203 wz[20] VSS VSS VDD VDD wzb[20] sky130_fd_sc_hvl__inv_1
Xg1011 wlvb[40] VSS VSS VDD VDD wlv[40] sky130_fd_sc_hvl__inv_1
Xg670 wz[81] VSS VSS VDD VDD wzb[81] sky130_fd_sc_hvl__inv_1
Xg1158 sns[81] VSS VSS VDD VDD snsb[81] sky130_fd_sc_hvl__inv_1
Xg1052 wlvb[81] VSS VSS VDD VDD wlv[81] sky130_fd_sc_hvl__inv_1
Xg855 sns[20] VSS VSS VDD VDD snsb[20] sky130_fd_sc_hvl__inv_1
Xg799 wl0b[40] VSS VSS VDD VDD wl0[40] sky130_fd_sc_hvl__inv_1
Xg732 wl0b[81] VSS VSS VDD VDD wl0[81] sky130_fd_sc_hvl__inv_1
Xg1217 wsel[82] VSS VSS VDD VDD wselb[82] sky130_fd_sc_hvl__inv_1
Xg662 wsel[41] VSS VSS VDD VDD wselb[41] sky130_fd_sc_hvl__inv_1
Xg663 wz[82] VSS VSS VDD VDD wzb[82] sky130_fd_sc_hvl__inv_1
Xg1159 sns[82] VSS VSS VDD VDD snsb[82] sky130_fd_sc_hvl__inv_1
Xg1227 wsel[5] VSS VSS VDD VDD wselb[5] sky130_fd_sc_hvl__inv_1
Xg1193 wz[10] VSS VSS VDD VDD wzb[10] sky130_fd_sc_hvl__inv_1
Xg991 wlvb[20] VSS VSS VDD VDD wlv[20] sky130_fd_sc_hvl__inv_1
Xg1111 wz[41] VSS VSS VDD VDD wzb[41] sky130_fd_sc_hvl__inv_1
Xg1053 wlvb[82] VSS VSS VDD VDD wlv[82] sky130_fd_sc_hvl__inv_1
Xg730 sns[41] VSS VSS VDD VDD snsb[41] sky130_fd_sc_hvl__inv_1
Xg731 wl0b[82] VSS VSS VDD VDD wl0[82] sky130_fd_sc_hvl__inv_1
Xg1135 wsel[83] VSS VSS VDD VDD wselb[83] sky130_fd_sc_hvl__inv_1
Xg1012 wlvb[41] VSS VSS VDD VDD wlv[41] sky130_fd_sc_hvl__inv_1
Xg655 wz[83] VSS VSS VDD VDD wzb[83] sky130_fd_sc_hvl__inv_1
Xg1160 sns[83] VSS VSS VDD VDD snsb[83] sky130_fd_sc_hvl__inv_1
Xg1054 wlvb[83] VSS VSS VDD VDD wlv[83] sky130_fd_sc_hvl__inv_1
Xg875 sns[10] VSS VSS VDD VDD snsb[10] sky130_fd_sc_hvl__inv_1
Xg779 wl0b[20] VSS VSS VDD VDD wl0[20] sky130_fd_sc_hvl__inv_1
Xg800 wl0b[41] VSS VSS VDD VDD wl0[41] sky130_fd_sc_hvl__inv_1
Xg729 wl0b[83] VSS VSS VDD VDD wl0[83] sky130_fd_sc_hvl__inv_1
Xg1120 wsel[84] VSS VSS VDD VDD wselb[84] sky130_fd_sc_hvl__inv_1
Xg647 wsel[42] VSS VSS VDD VDD wselb[42] sky130_fd_sc_hvl__inv_1
Xg648 wz[84] VSS VSS VDD VDD wzb[84] sky130_fd_sc_hvl__inv_1
Xg1161 sns[84] VSS VSS VDD VDD snsb[84] sky130_fd_sc_hvl__inv_1
Xg1109 wsel[21] VSS VSS VDD VDD wselb[21] sky130_fd_sc_hvl__inv_1
Xg1110 wz[42] VSS VSS VDD VDD wzb[42] sky130_fd_sc_hvl__inv_1
Xg1055 wlvb[84] VSS VSS VDD VDD wlv[84] sky130_fd_sc_hvl__inv_1
Xg727 sns[42] VSS VSS VDD VDD snsb[42] sky130_fd_sc_hvl__inv_1
Xg728 wl0b[84] VSS VSS VDD VDD wl0[84] sky130_fd_sc_hvl__inv_1
Xg1104 wsel[85] VSS VSS VDD VDD wselb[85] sky130_fd_sc_hvl__inv_1
Xrow1q_reg_99 row1_clk row1q[98] FE_OFN2_rstb VSS VSS VDD VDD row1q[99] sky130_fd_sc_hvl__dfrtp_1
Xrow1q_reg_98 row1_clk row1q[97] FE_OFN2_rstb VSS VSS VDD VDD row1q[98] sky130_fd_sc_hvl__dfrtp_1
Xrow1q_reg_97 row1_clk row1q[96] FE_OFN2_rstb VSS VSS VDD VDD row1q[97] sky130_fd_sc_hvl__dfrtp_1
Xrow1q_reg_96 row1_clk row1q[95] FE_OFN2_rstb VSS VSS VDD VDD row1q[96] sky130_fd_sc_hvl__dfrtp_1
Xrow1q_reg_95 row1_clk row1q[94] rstb VSS VSS VDD VDD row1q[95] sky130_fd_sc_hvl__dfrtp_1
Xrow1q_reg_94 row1_clk row1q[93] FE_OFN2_rstb VSS VSS VDD VDD row1q[94] sky130_fd_sc_hvl__dfrtp_1
Xrow1q_reg_93 row1_clk row1q[92] FE_OFN2_rstb VSS VSS VDD VDD row1q[93] sky130_fd_sc_hvl__dfrtp_1
Xrow1q_reg_92 row1_clk row1q[91] FE_OFN2_rstb VSS VSS VDD VDD row1q[92] sky130_fd_sc_hvl__dfrtp_1
Xrow1q_reg_91 row1_clk row1q[90] FE_OFN2_rstb VSS VSS VDD VDD row1q[91] sky130_fd_sc_hvl__dfrtp_1
Xrow1q_reg_90 row1_clk row1q[89] rstb VSS VSS VDD VDD row1q[90] sky130_fd_sc_hvl__dfrtp_1
Xrow1q_reg_89 row1_clk row1q[88] rstb VSS VSS VDD VDD row1q[89] sky130_fd_sc_hvl__dfrtp_1
Xrow1q_reg_88 row1_clk row1q[87] FE_OFN2_rstb VSS VSS VDD VDD row1q[88] sky130_fd_sc_hvl__dfrtp_1
Xrow1q_reg_87 row1_clk row1q[86] FE_OFN2_rstb VSS VSS VDD VDD row1q[87] sky130_fd_sc_hvl__dfrtp_1
Xrow1q_reg_86 row1_clk row1q[85] FE_OFN2_rstb VSS VSS VDD VDD row1q[86] sky130_fd_sc_hvl__dfrtp_1
Xrow1q_reg_85 row1_clk row1q[84] FE_OFN2_rstb VSS VSS VDD VDD row1q[85] sky130_fd_sc_hvl__dfrtp_1
Xrow1q_reg_84 row1_clk row1q[83] rstb VSS VSS VDD VDD row1q[84] sky130_fd_sc_hvl__dfrtp_1
Xrow1q_reg_83 row1_clk row1q[82] rstb VSS VSS VDD VDD row1q[83] sky130_fd_sc_hvl__dfrtp_1
Xrow1q_reg_82 row1_clk row1q[81] FE_OFN2_rstb VSS VSS VDD VDD row1q[82] sky130_fd_sc_hvl__dfrtp_1
Xrow1q_reg_81 row1_clk row1q[80] FE_OFN2_rstb VSS VSS VDD VDD row1q[81] sky130_fd_sc_hvl__dfrtp_1
Xrow1q_reg_80 row1_clk row1q[79] FE_OFN2_rstb VSS VSS VDD VDD row1q[80] sky130_fd_sc_hvl__dfrtp_1
Xrow1q_reg_79 row1_clk row1q[78] FE_OFN2_rstb VSS VSS VDD VDD row1q[79] sky130_fd_sc_hvl__dfrtp_1
Xrow1q_reg_78 row1_clk row1q[77] rstb VSS VSS VDD VDD row1q[78] sky130_fd_sc_hvl__dfrtp_1
Xrow1q_reg_77 row1_clk row1q[76] rstb VSS VSS VDD VDD row1q[77] sky130_fd_sc_hvl__dfrtp_1
Xrow1q_reg_76 row1_clk row1q[75] FE_OFN2_rstb VSS VSS VDD VDD row1q[76] sky130_fd_sc_hvl__dfrtp_1
Xrow1q_reg_75 row1_clk row1q[74] FE_OFN2_rstb VSS VSS VDD VDD row1q[75] sky130_fd_sc_hvl__dfrtp_1
Xrow1q_reg_74 row1_clk row1q[73] FE_OFN2_rstb VSS VSS VDD VDD row1q[74] sky130_fd_sc_hvl__dfrtp_1
Xrow1q_reg_73 row1_clk row1q[72] FE_OFN2_rstb VSS VSS VDD VDD row1q[73] sky130_fd_sc_hvl__dfrtp_1
Xrow1q_reg_72 row1_clk row1q[71] rstb VSS VSS VDD VDD row1q[72] sky130_fd_sc_hvl__dfrtp_1
Xrow1q_reg_71 row1_clk row1q[70] rstb VSS VSS VDD VDD row1q[71] sky130_fd_sc_hvl__dfrtp_1
Xrow1q_reg_70 row1_clk row1q[69] rstb VSS VSS VDD VDD row1q[70] sky130_fd_sc_hvl__dfrtp_1
Xrow1q_reg_69 row1_clk row1q[68] FE_OFN2_rstb VSS VSS VDD VDD row1q[69] sky130_fd_sc_hvl__dfrtp_1
Xrow1q_reg_68 row1_clk row1q[67] FE_OFN2_rstb VSS VSS VDD VDD row1q[68] sky130_fd_sc_hvl__dfrtp_1
Xrow1q_reg_67 row1_clk row1q[66] FE_OFN2_rstb VSS VSS VDD VDD row1q[67] sky130_fd_sc_hvl__dfrtp_1
Xrow1q_reg_66 row1_clk row1q[65] rstb VSS VSS VDD VDD row1q[66] sky130_fd_sc_hvl__dfrtp_1
Xrow1q_reg_65 row1_clk row1q[64] rstb VSS VSS VDD VDD row1q[65] sky130_fd_sc_hvl__dfrtp_1
Xrow1q_reg_64 row1_clk row1q[63] rstb VSS VSS VDD VDD row1q[64] sky130_fd_sc_hvl__dfrtp_1
Xrow1q_reg_63 row1_clk row1q[62] FE_OFN2_rstb VSS VSS VDD VDD row1q[63] sky130_fd_sc_hvl__dfrtp_1
Xrow1q_reg_62 row1_clk row1q[61] FE_OFN2_rstb VSS VSS VDD VDD row1q[62] sky130_fd_sc_hvl__dfrtp_1
Xrow1q_reg_61 row1_clk row1q[60] FE_OFN2_rstb VSS VSS VDD VDD row1q[61] sky130_fd_sc_hvl__dfrtp_1
Xrow1q_reg_60 row1_clk row1q[59] rstb VSS VSS VDD VDD row1q[60] sky130_fd_sc_hvl__dfrtp_1
Xrow1q_reg_59 row1_clk row1q[58] rstb VSS VSS VDD VDD row1q[59] sky130_fd_sc_hvl__dfrtp_1
Xrow1q_reg_58 row1_clk row1q[57] rstb VSS VSS VDD VDD row1q[58] sky130_fd_sc_hvl__dfrtp_1
Xrow1q_reg_57 row1_clk row1q[56] FE_OFN2_rstb VSS VSS VDD VDD row1q[57] sky130_fd_sc_hvl__dfrtp_1
Xrow1q_reg_56 row1_clk row1q[55] FE_OFN2_rstb VSS VSS VDD VDD row1q[56] sky130_fd_sc_hvl__dfrtp_1
Xrow1q_reg_55 row1_clk row1q[54] FE_OFN2_rstb VSS VSS VDD VDD row1q[55] sky130_fd_sc_hvl__dfrtp_1
Xrow1q_reg_54 row1_clk row1q[53] rstb VSS VSS VDD VDD row1q[54] sky130_fd_sc_hvl__dfrtp_1
Xrow1q_reg_53 row1_clk row1q[52] rstb VSS VSS VDD VDD row1q[53] sky130_fd_sc_hvl__dfrtp_1
Xrow1q_reg_52 row1_clk row1q[51] rstb VSS VSS VDD VDD row1q[52] sky130_fd_sc_hvl__dfrtp_1
Xrow1q_reg_51 row1_clk row1q[50] FE_OFN2_rstb VSS VSS VDD VDD row1q[51] sky130_fd_sc_hvl__dfrtp_1
Xrow1q_reg_50 row1_clk row1q[49] FE_OFN2_rstb VSS VSS VDD VDD row1q[50] sky130_fd_sc_hvl__dfrtp_1
Xrow1q_reg_49 row1_clk row1q[48] FE_OFN2_rstb VSS VSS VDD VDD row1q[49] sky130_fd_sc_hvl__dfrtp_1
Xrow1q_reg_48 row1_clk row1q[47] rstb VSS VSS VDD VDD row1q[48] sky130_fd_sc_hvl__dfrtp_1
Xrow1q_reg_47 row1_clk row1q[46] rstb VSS VSS VDD VDD row1q[47] sky130_fd_sc_hvl__dfrtp_1
Xrow1q_reg_46 row1_clk row1q[45] rstb VSS VSS VDD VDD row1q[46] sky130_fd_sc_hvl__dfrtp_1
Xrow1q_reg_45 row1_clk row1q[44] FE_OFN2_rstb VSS VSS VDD VDD row1q[45] sky130_fd_sc_hvl__dfrtp_1
Xrow1q_reg_44 row1_clk row1q[43] FE_OFN2_rstb VSS VSS VDD VDD row1q[44] sky130_fd_sc_hvl__dfrtp_1
Xrow1q_reg_43 row1_clk row1q[42] FE_OFN2_rstb VSS VSS VDD VDD row1q[43] sky130_fd_sc_hvl__dfrtp_1
Xrow1q_reg_42 row1_clk row1q[41] rstb VSS VSS VDD VDD row1q[42] sky130_fd_sc_hvl__dfrtp_1
Xrow1q_reg_41 row1_clk row1q[40] rstb VSS VSS VDD VDD row1q[41] sky130_fd_sc_hvl__dfrtp_1
Xrow1q_reg_40 row1_clk row1q[39] rstb VSS VSS VDD VDD row1q[40] sky130_fd_sc_hvl__dfrtp_1
Xrow1q_reg_39 row1_clk row1q[38] FE_OFN2_rstb VSS VSS VDD VDD row1q[39] sky130_fd_sc_hvl__dfrtp_1
Xrow1q_reg_38 row1_clk row1q[37] FE_OFN2_rstb VSS VSS VDD VDD row1q[38] sky130_fd_sc_hvl__dfrtp_1
Xrow1q_reg_37 row1_clk row1q[36] FE_OFN2_rstb VSS VSS VDD VDD row1q[37] sky130_fd_sc_hvl__dfrtp_1
Xrow1q_reg_36 row1_clk row1q[35] rstb VSS VSS VDD VDD row1q[36] sky130_fd_sc_hvl__dfrtp_1
Xrow1q_reg_35 row1_clk row1q[34] rstb VSS VSS VDD VDD row1q[35] sky130_fd_sc_hvl__dfrtp_1
Xrow1q_reg_34 row1_clk row1q[33] rstb VSS VSS VDD VDD row1q[34] sky130_fd_sc_hvl__dfrtp_1
Xrow1q_reg_33 row1_clk row1q[32] FE_OFN2_rstb VSS VSS VDD VDD row1q[33] sky130_fd_sc_hvl__dfrtp_1
Xrow1q_reg_32 row1_clk row1q[31] FE_OFN2_rstb VSS VSS VDD VDD row1q[32] sky130_fd_sc_hvl__dfrtp_1
Xrow1q_reg_31 row1_clk row1q[30] FE_OFN2_rstb VSS VSS VDD VDD row1q[31] sky130_fd_sc_hvl__dfrtp_1
Xrow1q_reg_30 row1_clk row1q[29] rstb VSS VSS VDD VDD row1q[30] sky130_fd_sc_hvl__dfrtp_1
Xrow1q_reg_29 row1_clk row1q[28] rstb VSS VSS VDD VDD row1q[29] sky130_fd_sc_hvl__dfrtp_1
Xrow1q_reg_28 row1_clk row1q[27] rstb VSS VSS VDD VDD row1q[28] sky130_fd_sc_hvl__dfrtp_1
Xrow1q_reg_27 row1_clk row1q[26] FE_OFN2_rstb VSS VSS VDD VDD row1q[27] sky130_fd_sc_hvl__dfrtp_1
Xrow1q_reg_26 row1_clk row1q[25] FE_OFN2_rstb VSS VSS VDD VDD row1q[26] sky130_fd_sc_hvl__dfrtp_1
Xrow1q_reg_25 row1_clk row1q[24] FE_OFN2_rstb VSS VSS VDD VDD row1q[25] sky130_fd_sc_hvl__dfrtp_1
Xrow1q_reg_24 row1_clk row1q[23] rstb VSS VSS VDD VDD row1q[24] sky130_fd_sc_hvl__dfrtp_1
Xrow1q_reg_23 row1_clk row1q[22] rstb VSS VSS VDD VDD row1q[23] sky130_fd_sc_hvl__dfrtp_1
Xrow1q_reg_22 row1_clk row1q[21] rstb VSS VSS VDD VDD row1q[22] sky130_fd_sc_hvl__dfrtp_1
Xrow1q_reg_21 row1_clk row1q[20] FE_OFN2_rstb VSS VSS VDD VDD row1q[21] sky130_fd_sc_hvl__dfrtp_1
Xrow1q_reg_20 row1_clk row1q[19] FE_OFN2_rstb VSS VSS VDD VDD row1q[20] sky130_fd_sc_hvl__dfrtp_1
Xrow1q_reg_19 row1_clk row1q[18] FE_OFN2_rstb VSS VSS VDD VDD row1q[19] sky130_fd_sc_hvl__dfrtp_1
Xrow1q_reg_18 row1_clk row1q[17] rstb VSS VSS VDD VDD row1q[18] sky130_fd_sc_hvl__dfrtp_1
Xrow1q_reg_17 row1_clk row1q[16] rstb VSS VSS VDD VDD row1q[17] sky130_fd_sc_hvl__dfrtp_1
Xrow1q_reg_16 row1_clk row1q[15] rstb VSS VSS VDD VDD row1q[16] sky130_fd_sc_hvl__dfrtp_1
Xrow1q_reg_15 row1_clk row1q[14] FE_OFN2_rstb VSS VSS VDD VDD row1q[15] sky130_fd_sc_hvl__dfrtp_1
Xrow1q_reg_14 row1_clk row1q[13] FE_OFN2_rstb VSS VSS VDD VDD row1q[14] sky130_fd_sc_hvl__dfrtp_1
Xrow1q_reg_13 row1_clk row1q[12] FE_OFN2_rstb VSS VSS VDD VDD row1q[13] sky130_fd_sc_hvl__dfrtp_1
Xrow1q_reg_12 row1_clk row1q[11] rstb VSS VSS VDD VDD row1q[12] sky130_fd_sc_hvl__dfrtp_1
Xrow1q_reg_11 row1_clk row1q[10] rstb VSS VSS VDD VDD row1q[11] sky130_fd_sc_hvl__dfrtp_1
Xrow1q_reg_10 row1_clk row1q[9] rstb VSS VSS VDD VDD row1q[10] sky130_fd_sc_hvl__dfrtp_1
Xrow1q_reg_9 row1_clk row1q[8] FE_OFN2_rstb VSS VSS VDD VDD row1q[9] sky130_fd_sc_hvl__dfrtp_1
Xrow1q_reg_8 row1_clk row1q[7] FE_OFN2_rstb VSS VSS VDD VDD row1q[8] sky130_fd_sc_hvl__dfrtp_1
Xg1250 wz[100] VSS VSS VDD VDD wzb[100] sky130_fd_sc_hvl__inv_1
Xg1071 wlvb[100] VSS VSS VDD VDD wlv[100] sky130_fd_sc_hvl__inv_1
Xg696 wl0b[100] VSS VSS VDD VDD wl0[100] sky130_fd_sc_hvl__inv_1
Xg1245 wz[101] VSS VSS VDD VDD wzb[101] sky130_fd_sc_hvl__inv_1
Xg1178 sns[101] VSS VSS VDD VDD snsb[101] sky130_fd_sc_hvl__inv_1
Xg1076 wlvb[105] VSS VSS VDD VDD wlv[105] sky130_fd_sc_hvl__inv_1
Xg1072 wlvb[101] VSS VSS VDD VDD wlv[101] sky130_fd_sc_hvl__inv_1
Xg1215 wsel[100] VSS VSS VDD VDD wselb[100] sky130_fd_sc_hvl__inv_1
Xg1181 sns[104] VSS VSS VDD VDD snsb[104] sky130_fd_sc_hvl__inv_1
Xg1074 wlvb[103] VSS VSS VDD VDD wlv[103] sky130_fd_sc_hvl__inv_1
Xg1180 sns[103] VSS VSS VDD VDD snsb[103] sky130_fd_sc_hvl__inv_1
Xg692 wl0b[101] VSS VSS VDD VDD wl0[101] sky130_fd_sc_hvl__inv_1
Xg643 wsel[102] VSS VSS VDD VDD wselb[102] sky130_fd_sc_hvl__inv_1
Xg1244 wz[102] VSS VSS VDD VDD wzb[102] sky130_fd_sc_hvl__inv_1
Xg1182 sns[105] VSS VSS VDD VDD snsb[105] sky130_fd_sc_hvl__inv_1
Xg691 wl0b[102] VSS VSS VDD VDD wl0[102] sky130_fd_sc_hvl__inv_1
Xg1242 wz[103] VSS VSS VDD VDD wzb[103] sky130_fd_sc_hvl__inv_1
Xg689 wl0b[103] VSS VSS VDD VDD wl0[103] sky130_fd_sc_hvl__inv_1
Xg642 wsel[104] VSS VSS VDD VDD wselb[104] sky130_fd_sc_hvl__inv_1
Xg1241 wz[104] VSS VSS VDD VDD wzb[104] sky130_fd_sc_hvl__inv_1
Xg1075 wlvb[104] VSS VSS VDD VDD wlv[104] sky130_fd_sc_hvl__inv_1
Xg1238 wz[105] VSS VSS VDD VDD wzb[105] sky130_fd_sc_hvl__inv_1
Xg1073 wlvb[102] VSS VSS VDD VDD wlv[102] sky130_fd_sc_hvl__inv_1
Xg685 wl0b[105] VSS VSS VDD VDD wl0[105] sky130_fd_sc_hvl__inv_1
Xg1087 wsel[101] VSS VSS VDD VDD wselb[101] sky130_fd_sc_hvl__inv_1
Xg1214 wsel[103] VSS VSS VDD VDD wselb[103] sky130_fd_sc_hvl__inv_1
Xg641 wsel[105] VSS VSS VDD VDD wselb[105] sky130_fd_sc_hvl__inv_1
Xg688 wl0b[104] VSS VSS VDD VDD wl0[104] sky130_fd_sc_hvl__inv_1
Xg1179 sns[102] VSS VSS VDD VDD snsb[102] sky130_fd_sc_hvl__inv_1
Xg1177 sns[100] VSS VSS VDD VDD snsb[100] sky130_fd_sc_hvl__inv_1
Xrow1q_reg_7 row1_clk row1q[6] FE_OFN2_rstb VSS VSS VDD VDD row1q[7] sky130_fd_sc_hvl__dfrtp_1
Xrow1q_reg_6 row1_clk row1q[5] rstb VSS VSS VDD VDD row1q[6] sky130_fd_sc_hvl__dfrtp_1
Xrow2q_reg_5 row2_clk row2q[4] rstb VSS VSS VDD VDD row2q[5] sky130_fd_sc_hvl__dfrtp_1
Xrow1q_reg_5 row1_clk row1q[4] rstb VSS VSS VDD VDD row1q[5] sky130_fd_sc_hvl__dfrtp_1
Xrow2q_reg_4 row2_clk row2q[3] rstb VSS VSS VDD VDD row2q[4] sky130_fd_sc_hvl__dfrtp_1
Xrow1q_reg_4 row1_clk row1q[3] rstb VSS VSS VDD VDD row1q[4] sky130_fd_sc_hvl__dfrtp_1
Xrow1q_reg_3 row1_clk row1q[2] FE_OFN2_rstb VSS VSS VDD VDD row1q[3] sky130_fd_sc_hvl__dfrtp_1
Xrow2q_reg_3 row2_clk row2q[2] rstb VSS VSS VDD VDD row2q[3] sky130_fd_sc_hvl__dfrtp_1
Xrow2q_reg_2 row2_clk row2q[1] rstb VSS VSS VDD VDD row2q[2] sky130_fd_sc_hvl__dfrtp_1
Xrow1q_reg_2 row1_clk row1q[1] FE_OFN2_rstb VSS VSS VDD VDD row1q[2] sky130_fd_sc_hvl__dfrtp_1
Xrow1q_reg_1 row1_clk row1q[0] FE_OFN2_rstb VSS VSS VDD VDD row1q[1] sky130_fd_sc_hvl__dfrtp_1
Xrow2q_reg_1 row2_clk row2q[0] rstb VSS VSS VDD VDD row2q[1] sky130_fd_sc_hvl__dfrtp_1
Xrow2q_reg_0 row2_clk sdi rstb VSS VSS VDD VDD row2q[0] sky130_fd_sc_hvl__dfrtp_1
Xrow1q_reg_0 row1_clk sdi rstb VSS VSS VDD VDD row1q[0] sky130_fd_sc_hvl__dfrtp_1
Xg_row_0.u_rowl_g81__2398 wlvb[0] g_row[0].u_rowl_n_5 VSS VSS VDD VDD wl0b[0] sky130_fd_sc_hvl__nand2_1
Xg_row_0.u_rowl_g82__5107 g_row[0].u_rowl_n_3 FE_OFN5_VER FE_OFN10_FE_DBTN0_READb VSS VSS VDD VDD wlvb[0] sky130_fd_sc_hvl__a21oi_1
Xg_row_0.u_rowl_g83__6260 g_row[0].u_rowl_n_3 FE_OFN9_n VSS VSS VDD VDD wsel[0] sky130_fd_sc_hvl__and2_1
Xg_row_0.u_rowl_g84__4319 g_row[0].u_rowl_n_3 FE_OFN6_SENSE VSS VSS VDD VDD sns[0] sky130_fd_sc_hvl__and2_1
Xg_row_0.u_rowl_g85 g_row[0].u_rowl_n_5 VSS VSS VDD VDD wlw[0] sky130_fd_sc_hvl__inv_1
Xg_row_0.u_rowl_g86__8428 g_row[0].u_rowl_n_2 FE_OFN9_n VSS VSS VDD VDD wz[0] sky130_fd_sc_hvl__and2_1
Xg_row_0.u_rowl_g87__5526 g_row[0].u_rowl_n_3 FE_OFN4_PROG VSS VSS VDD VDD g_row[0].u_rowl_n_5 sky130_fd_sc_hvl__nand2_1
Xg_row_0.u_rowl_g88 g_row[0].u_rowl_n_2 VSS VSS VDD VDD g_row[0].u_rowl_n_3 sky130_fd_sc_hvl__inv_1
Xg_row_0.u_rowl_g89__6783 FE_OFN3_sel_en row1q[0] VSS VSS VDD VDD g_row[0].u_rowl_n_2 sky130_fd_sc_hvl__nand2_1
Xg_row_1.u_rowl_g81__3680 wlvb[1] g_row[1].u_rowl_n_5 VSS VSS VDD VDD wl0b[1] sky130_fd_sc_hvl__nand2_1
Xg_row_1.u_rowl_g82__1617 g_row[1].u_rowl_n_3 FE_OFN5_VER FE_OFN10_FE_DBTN0_READb VSS VSS VDD VDD wlvb[1] sky130_fd_sc_hvl__a21oi_1
Xg_row_1.u_rowl_g83__2802 g_row[1].u_rowl_n_3 FE_OFN9_n VSS VSS VDD VDD wsel[1] sky130_fd_sc_hvl__and2_1
Xg_row_1.u_rowl_g84__1705 g_row[1].u_rowl_n_3 FE_OFN6_SENSE VSS VSS VDD VDD sns[1] sky130_fd_sc_hvl__and2_1
Xg_row_1.u_rowl_g85 g_row[1].u_rowl_n_5 VSS VSS VDD VDD wlw[1] sky130_fd_sc_hvl__inv_1
Xg_row_1.u_rowl_g86__5122 g_row[1].u_rowl_n_2 FE_OFN9_n VSS VSS VDD VDD wz[1] sky130_fd_sc_hvl__and2_1
Xg_row_1.u_rowl_g87__8246 g_row[1].u_rowl_n_3 FE_OFN4_PROG VSS VSS VDD VDD g_row[1].u_rowl_n_5 sky130_fd_sc_hvl__nand2_1
Xg_row_1.u_rowl_g88 g_row[1].u_rowl_n_2 VSS VSS VDD VDD g_row[1].u_rowl_n_3 sky130_fd_sc_hvl__inv_1
Xg_row_1.u_rowl_g89__7098 FE_OFN3_sel_en row1q[1] VSS VSS VDD VDD g_row[1].u_rowl_n_2 sky130_fd_sc_hvl__nand2_1
Xg_row_2.u_rowl_g81__6131 wlvb[2] g_row[2].u_rowl_n_5 VSS VSS VDD VDD wl0b[2] sky130_fd_sc_hvl__nand2_1
Xg_row_2.u_rowl_g82__1881 g_row[2].u_rowl_n_3 FE_OFN5_VER FE_OFN10_FE_DBTN0_READb VSS VSS VDD VDD wlvb[2] sky130_fd_sc_hvl__a21oi_1
Xg_row_2.u_rowl_g83__5115 g_row[2].u_rowl_n_3 FE_OFN9_n VSS VSS VDD VDD wsel[2] sky130_fd_sc_hvl__and2_1
Xg_row_2.u_rowl_g84__7482 g_row[2].u_rowl_n_3 FE_OFN6_SENSE VSS VSS VDD VDD sns[2] sky130_fd_sc_hvl__and2_1
Xg_row_2.u_rowl_g85 g_row[2].u_rowl_n_5 VSS VSS VDD VDD wlw[2] sky130_fd_sc_hvl__inv_1
Xg_row_2.u_rowl_g86__4733 g_row[2].u_rowl_n_2 FE_OFN7_WRANY VSS VSS VDD VDD wz[2] sky130_fd_sc_hvl__and2_1
Xg_row_2.u_rowl_g87__6161 g_row[2].u_rowl_n_3 PROG VSS VSS VDD VDD g_row[2].u_rowl_n_5 sky130_fd_sc_hvl__nand2_1
Xg_row_2.u_rowl_g88 g_row[2].u_rowl_n_2 VSS VSS VDD VDD g_row[2].u_rowl_n_3 sky130_fd_sc_hvl__inv_1
Xg_row_2.u_rowl_g89__9315 FE_OFN3_sel_en row1q[2] VSS VSS VDD VDD g_row[2].u_rowl_n_2 sky130_fd_sc_hvl__nand2_1
Xg_row_3.u_rowl_g81__9945 wlvb[3] g_row[3].u_rowl_n_5 VSS VSS VDD VDD wl0b[3] sky130_fd_sc_hvl__nand2_1
Xg_row_3.u_rowl_g82__2883 g_row[3].u_rowl_n_3 VER FE_OFN10_FE_DBTN0_READb VSS VSS VDD VDD wlvb[3] sky130_fd_sc_hvl__a21oi_1
Xg_row_3.u_rowl_g83__2346 g_row[3].u_rowl_n_3 FE_OFN7_WRANY VSS VSS VDD VDD wsel[3] sky130_fd_sc_hvl__and2_1
Xg_row_3.u_rowl_g84__1666 g_row[3].u_rowl_n_3 FE_OFN6_SENSE VSS VSS VDD VDD sns[3] sky130_fd_sc_hvl__and2_1
Xg_row_3.u_rowl_g85 g_row[3].u_rowl_n_5 VSS VSS VDD VDD wlw[3] sky130_fd_sc_hvl__inv_1
Xg_row_3.u_rowl_g86__7410 g_row[3].u_rowl_n_2 FE_OFN7_WRANY VSS VSS VDD VDD wz[3] sky130_fd_sc_hvl__and2_1
Xg_row_3.u_rowl_g87__6417 g_row[3].u_rowl_n_3 PROG VSS VSS VDD VDD g_row[3].u_rowl_n_5 sky130_fd_sc_hvl__nand2_1
Xg_row_3.u_rowl_g88 g_row[3].u_rowl_n_2 VSS VSS VDD VDD g_row[3].u_rowl_n_3 sky130_fd_sc_hvl__inv_1
Xg_row_3.u_rowl_g89__5477 sel_en row1q[3] VSS VSS VDD VDD g_row[3].u_rowl_n_2 sky130_fd_sc_hvl__nand2_1
Xg_row_4.u_rowl_g81__2398 wlvb[4] g_row[4].u_rowl_n_5 VSS VSS VDD VDD wl0b[4] sky130_fd_sc_hvl__nand2_1
Xg_row_4.u_rowl_g82__5107 g_row[4].u_rowl_n_3 VER FE_DBTN0_READb VSS VSS VDD VDD wlvb[4] sky130_fd_sc_hvl__a21oi_1
Xg_row_4.u_rowl_g83__6260 g_row[4].u_rowl_n_3 FE_OFN7_WRANY VSS VSS VDD VDD wsel[4] sky130_fd_sc_hvl__and2_1
Xg_row_4.u_rowl_g84__4319 g_row[4].u_rowl_n_3 SENSE VSS VSS VDD VDD sns[4] sky130_fd_sc_hvl__and2_1
Xg_row_4.u_rowl_g85 g_row[4].u_rowl_n_5 VSS VSS VDD VDD wlw[4] sky130_fd_sc_hvl__inv_1
Xg_row_4.u_rowl_g86__8428 g_row[4].u_rowl_n_2 WRANY VSS VSS VDD VDD wz[4] sky130_fd_sc_hvl__and2_1
Xg_row_4.u_rowl_g87__5526 g_row[4].u_rowl_n_3 PROG VSS VSS VDD VDD g_row[4].u_rowl_n_5 sky130_fd_sc_hvl__nand2_1
Xg_row_4.u_rowl_g88 g_row[4].u_rowl_n_2 VSS VSS VDD VDD g_row[4].u_rowl_n_3 sky130_fd_sc_hvl__inv_1
Xg_row_4.u_rowl_g89__6783 sel_en row1q[4] VSS VSS VDD VDD g_row[4].u_rowl_n_2 sky130_fd_sc_hvl__nand2_1
Xg_row_5.u_rowl_g81__3680 wlvb[5] g_row[5].u_rowl_n_5 VSS VSS VDD VDD wl0b[5] sky130_fd_sc_hvl__nand2_1
Xg_row_5.u_rowl_g82__1617 g_row[5].u_rowl_n_3 VER FE_DBTN0_READb VSS VSS VDD VDD wlvb[5] sky130_fd_sc_hvl__a21oi_1
Xg_row_5.u_rowl_g83__2802 g_row[5].u_rowl_n_3 WRANY VSS VSS VDD VDD wsel[5] sky130_fd_sc_hvl__and2_1
Xg_row_5.u_rowl_g84__1705 g_row[5].u_rowl_n_3 SENSE VSS VSS VDD VDD sns[5] sky130_fd_sc_hvl__and2_1
Xg_row_5.u_rowl_g85 g_row[5].u_rowl_n_5 VSS VSS VDD VDD wlw[5] sky130_fd_sc_hvl__inv_1
Xg_row_5.u_rowl_g86__5122 g_row[5].u_rowl_n_2 WRANY VSS VSS VDD VDD wz[5] sky130_fd_sc_hvl__and2_1
Xg_row_5.u_rowl_g87__8246 g_row[5].u_rowl_n_3 PROG VSS VSS VDD VDD g_row[5].u_rowl_n_5 sky130_fd_sc_hvl__nand2_1
Xg_row_5.u_rowl_g88 g_row[5].u_rowl_n_2 VSS VSS VDD VDD g_row[5].u_rowl_n_3 sky130_fd_sc_hvl__inv_1
Xg_row_5.u_rowl_g89__7098 sel_en row1q[5] VSS VSS VDD VDD g_row[5].u_rowl_n_2 sky130_fd_sc_hvl__nand2_1
Xg_row_6.u_rowl_g81__6131 wlvb[6] g_row[6].u_rowl_n_5 VSS VSS VDD VDD wl0b[6] sky130_fd_sc_hvl__nand2_1
Xg_row_6.u_rowl_g82__1881 g_row[6].u_rowl_n_3 FE_OFN5_VER FE_OFN10_FE_DBTN0_READb VSS VSS VDD VDD wlvb[6] sky130_fd_sc_hvl__a21oi_1
Xg_row_6.u_rowl_g83__5115 g_row[6].u_rowl_n_3 FE_OFN9_n VSS VSS VDD VDD wsel[6] sky130_fd_sc_hvl__and2_1
Xg_row_6.u_rowl_g84__7482 g_row[6].u_rowl_n_3 FE_OFN6_SENSE VSS VSS VDD VDD sns[6] sky130_fd_sc_hvl__and2_1
Xg_row_6.u_rowl_g85 g_row[6].u_rowl_n_5 VSS VSS VDD VDD wlw[6] sky130_fd_sc_hvl__inv_1
Xg_row_6.u_rowl_g86__4733 g_row[6].u_rowl_n_2 FE_OFN9_n VSS VSS VDD VDD wz[6] sky130_fd_sc_hvl__and2_1
Xg_row_6.u_rowl_g87__6161 g_row[6].u_rowl_n_3 FE_OFN4_PROG VSS VSS VDD VDD g_row[6].u_rowl_n_5 sky130_fd_sc_hvl__nand2_1
Xg_row_6.u_rowl_g88 g_row[6].u_rowl_n_2 VSS VSS VDD VDD g_row[6].u_rowl_n_3 sky130_fd_sc_hvl__inv_1
Xg_row_6.u_rowl_g89__9315 FE_OFN3_sel_en row1q[6] VSS VSS VDD VDD g_row[6].u_rowl_n_2 sky130_fd_sc_hvl__nand2_1
Xg_row_7.u_rowl_g81__9945 wlvb[7] g_row[7].u_rowl_n_5 VSS VSS VDD VDD wl0b[7] sky130_fd_sc_hvl__nand2_1
Xg_row_7.u_rowl_g82__2883 g_row[7].u_rowl_n_3 FE_OFN5_VER FE_OFN10_FE_DBTN0_READb VSS VSS VDD VDD wlvb[7] sky130_fd_sc_hvl__a21oi_1
Xg_row_7.u_rowl_g83__2346 g_row[7].u_rowl_n_3 FE_OFN9_n VSS VSS VDD VDD wsel[7] sky130_fd_sc_hvl__and2_1
Xg_row_7.u_rowl_g84__1666 g_row[7].u_rowl_n_3 FE_OFN6_SENSE VSS VSS VDD VDD sns[7] sky130_fd_sc_hvl__and2_1
Xg_row_7.u_rowl_g85 g_row[7].u_rowl_n_5 VSS VSS VDD VDD wlw[7] sky130_fd_sc_hvl__inv_1
Xg_row_7.u_rowl_g86__7410 g_row[7].u_rowl_n_2 FE_OFN9_n VSS VSS VDD VDD wz[7] sky130_fd_sc_hvl__and2_1
Xg_row_7.u_rowl_g87__6417 g_row[7].u_rowl_n_3 FE_OFN4_PROG VSS VSS VDD VDD g_row[7].u_rowl_n_5 sky130_fd_sc_hvl__nand2_1
Xg_row_7.u_rowl_g88 g_row[7].u_rowl_n_2 VSS VSS VDD VDD g_row[7].u_rowl_n_3 sky130_fd_sc_hvl__inv_1
Xg_row_7.u_rowl_g89__5477 FE_OFN3_sel_en row1q[7] VSS VSS VDD VDD g_row[7].u_rowl_n_2 sky130_fd_sc_hvl__nand2_1
Xg_row_8.u_rowl_g81__2398 wlvb[8] g_row[8].u_rowl_n_5 VSS VSS VDD VDD wl0b[8] sky130_fd_sc_hvl__nand2_1
Xg_row_8.u_rowl_g82__5107 g_row[8].u_rowl_n_3 FE_OFN5_VER FE_OFN10_FE_DBTN0_READb VSS VSS VDD VDD wlvb[8] sky130_fd_sc_hvl__a21oi_1
Xg_row_8.u_rowl_g83__6260 g_row[8].u_rowl_n_3 FE_OFN9_n VSS VSS VDD VDD wsel[8] sky130_fd_sc_hvl__and2_1
Xg_row_8.u_rowl_g84__4319 g_row[8].u_rowl_n_3 FE_OFN6_SENSE VSS VSS VDD VDD sns[8] sky130_fd_sc_hvl__and2_1
Xg_row_8.u_rowl_g85 g_row[8].u_rowl_n_5 VSS VSS VDD VDD wlw[8] sky130_fd_sc_hvl__inv_1
Xg_row_8.u_rowl_g86__8428 g_row[8].u_rowl_n_2 FE_OFN7_WRANY VSS VSS VDD VDD wz[8] sky130_fd_sc_hvl__and2_1
Xg_row_8.u_rowl_g87__5526 g_row[8].u_rowl_n_3 PROG VSS VSS VDD VDD g_row[8].u_rowl_n_5 sky130_fd_sc_hvl__nand2_1
Xg_row_8.u_rowl_g88 g_row[8].u_rowl_n_2 VSS VSS VDD VDD g_row[8].u_rowl_n_3 sky130_fd_sc_hvl__inv_1
Xg_row_8.u_rowl_g89__6783 FE_OFN3_sel_en row1q[8] VSS VSS VDD VDD g_row[8].u_rowl_n_2 sky130_fd_sc_hvl__nand2_1
Xg_row_9.u_rowl_g81__3680 wlvb[9] g_row[9].u_rowl_n_5 VSS VSS VDD VDD wl0b[9] sky130_fd_sc_hvl__nand2_1
Xg_row_9.u_rowl_g82__1617 g_row[9].u_rowl_n_3 VER FE_OFN10_FE_DBTN0_READb VSS VSS VDD VDD wlvb[9] sky130_fd_sc_hvl__a21oi_1
Xg_row_9.u_rowl_g83__2802 g_row[9].u_rowl_n_3 FE_OFN7_WRANY VSS VSS VDD VDD wsel[9] sky130_fd_sc_hvl__and2_1
Xg_row_9.u_rowl_g84__1705 g_row[9].u_rowl_n_3 FE_OFN6_SENSE VSS VSS VDD VDD sns[9] sky130_fd_sc_hvl__and2_1
Xg_row_9.u_rowl_g85 g_row[9].u_rowl_n_5 VSS VSS VDD VDD wlw[9] sky130_fd_sc_hvl__inv_1
Xg_row_9.u_rowl_g86__5122 g_row[9].u_rowl_n_2 FE_OFN7_WRANY VSS VSS VDD VDD wz[9] sky130_fd_sc_hvl__and2_1
Xg_row_9.u_rowl_g87__8246 g_row[9].u_rowl_n_3 PROG VSS VSS VDD VDD g_row[9].u_rowl_n_5 sky130_fd_sc_hvl__nand2_1
Xg_row_9.u_rowl_g88 g_row[9].u_rowl_n_2 VSS VSS VDD VDD g_row[9].u_rowl_n_3 sky130_fd_sc_hvl__inv_1
Xg_row_9.u_rowl_g89__7098 sel_en row1q[9] VSS VSS VDD VDD g_row[9].u_rowl_n_2 sky130_fd_sc_hvl__nand2_1
Xg_row_10.u_rowl_g81__6131 wlvb[10] g_row[10].u_rowl_n_5 VSS VSS VDD VDD wl0b[10] sky130_fd_sc_hvl__nand2_1
Xg_row_10.u_rowl_g82__1881 g_row[10].u_rowl_n_3 VER FE_DBTN0_READb VSS VSS VDD VDD wlvb[10] sky130_fd_sc_hvl__a21oi_1
Xg_row_10.u_rowl_g83__5115 g_row[10].u_rowl_n_3 FE_OFN7_WRANY VSS VSS VDD VDD wsel[10] sky130_fd_sc_hvl__and2_1
Xg_row_10.u_rowl_g84__7482 g_row[10].u_rowl_n_3 SENSE VSS VSS VDD VDD sns[10] sky130_fd_sc_hvl__and2_1
Xg_row_10.u_rowl_g85 g_row[10].u_rowl_n_5 VSS VSS VDD VDD wlw[10] sky130_fd_sc_hvl__inv_1
Xg_row_10.u_rowl_g86__4733 g_row[10].u_rowl_n_2 WRANY VSS VSS VDD VDD wz[10] sky130_fd_sc_hvl__and2_1
Xg_row_10.u_rowl_g87__6161 g_row[10].u_rowl_n_3 PROG VSS VSS VDD VDD g_row[10].u_rowl_n_5 sky130_fd_sc_hvl__nand2_1
Xg_row_10.u_rowl_g88 g_row[10].u_rowl_n_2 VSS VSS VDD VDD g_row[10].u_rowl_n_3 sky130_fd_sc_hvl__inv_1
Xg_row_10.u_rowl_g89__9315 sel_en row1q[10] VSS VSS VDD VDD g_row[10].u_rowl_n_2 sky130_fd_sc_hvl__nand2_1
Xg_row_11.u_rowl_g81__9945 wlvb[11] g_row[11].u_rowl_n_5 VSS VSS VDD VDD wl0b[11] sky130_fd_sc_hvl__nand2_1
Xg_row_11.u_rowl_g82__2883 g_row[11].u_rowl_n_3 VER FE_DBTN0_READb VSS VSS VDD VDD wlvb[11] sky130_fd_sc_hvl__a21oi_1
Xg_row_11.u_rowl_g83__2346 g_row[11].u_rowl_n_3 WRANY VSS VSS VDD VDD wsel[11] sky130_fd_sc_hvl__and2_1
Xg_row_11.u_rowl_g84__1666 g_row[11].u_rowl_n_3 SENSE VSS VSS VDD VDD sns[11] sky130_fd_sc_hvl__and2_1
Xg_row_11.u_rowl_g85 g_row[11].u_rowl_n_5 VSS VSS VDD VDD wlw[11] sky130_fd_sc_hvl__inv_1
Xg_row_11.u_rowl_g86__7410 g_row[11].u_rowl_n_2 WRANY VSS VSS VDD VDD wz[11] sky130_fd_sc_hvl__and2_1
Xg_row_11.u_rowl_g87__6417 g_row[11].u_rowl_n_3 PROG VSS VSS VDD VDD g_row[11].u_rowl_n_5 sky130_fd_sc_hvl__nand2_1
Xg_row_11.u_rowl_g88 g_row[11].u_rowl_n_2 VSS VSS VDD VDD g_row[11].u_rowl_n_3 sky130_fd_sc_hvl__inv_1
Xg_row_11.u_rowl_g89__5477 sel_en row1q[11] VSS VSS VDD VDD g_row[11].u_rowl_n_2 sky130_fd_sc_hvl__nand2_1
Xg_row_12.u_rowl_g81__2398 wlvb[12] g_row[12].u_rowl_n_5 VSS VSS VDD VDD wl0b[12] sky130_fd_sc_hvl__nand2_1
Xg_row_12.u_rowl_g82__5107 g_row[12].u_rowl_n_3 FE_OFN5_VER FE_OFN10_FE_DBTN0_READb VSS VSS VDD VDD wlvb[12] sky130_fd_sc_hvl__a21oi_1
Xg_row_12.u_rowl_g83__6260 g_row[12].u_rowl_n_3 FE_OFN9_n VSS VSS VDD VDD wsel[12] sky130_fd_sc_hvl__and2_1
Xg_row_12.u_rowl_g84__4319 g_row[12].u_rowl_n_3 FE_OFN6_SENSE VSS VSS VDD VDD sns[12] sky130_fd_sc_hvl__and2_1
Xg_row_12.u_rowl_g85 g_row[12].u_rowl_n_5 VSS VSS VDD VDD wlw[12] sky130_fd_sc_hvl__inv_1
Xg_row_12.u_rowl_g86__8428 g_row[12].u_rowl_n_2 FE_OFN9_n VSS VSS VDD VDD wz[12] sky130_fd_sc_hvl__and2_1
Xg_row_12.u_rowl_g87__5526 g_row[12].u_rowl_n_3 FE_OFN4_PROG VSS VSS VDD VDD g_row[12].u_rowl_n_5 sky130_fd_sc_hvl__nand2_1
Xg_row_12.u_rowl_g88 g_row[12].u_rowl_n_2 VSS VSS VDD VDD g_row[12].u_rowl_n_3 sky130_fd_sc_hvl__inv_1
Xg_row_12.u_rowl_g89__6783 FE_OFN3_sel_en row1q[12] VSS VSS VDD VDD g_row[12].u_rowl_n_2 sky130_fd_sc_hvl__nand2_1
Xg_row_13.u_rowl_g81__3680 wlvb[13] g_row[13].u_rowl_n_5 VSS VSS VDD VDD wl0b[13] sky130_fd_sc_hvl__nand2_1
Xg_row_13.u_rowl_g82__1617 g_row[13].u_rowl_n_3 FE_OFN5_VER FE_OFN10_FE_DBTN0_READb VSS VSS VDD VDD wlvb[13] sky130_fd_sc_hvl__a21oi_1
Xg_row_13.u_rowl_g83__2802 g_row[13].u_rowl_n_3 FE_OFN9_n VSS VSS VDD VDD wsel[13] sky130_fd_sc_hvl__and2_1
Xg_row_13.u_rowl_g84__1705 g_row[13].u_rowl_n_3 FE_OFN6_SENSE VSS VSS VDD VDD sns[13] sky130_fd_sc_hvl__and2_1
Xg_row_13.u_rowl_g85 g_row[13].u_rowl_n_5 VSS VSS VDD VDD wlw[13] sky130_fd_sc_hvl__inv_1
Xg_row_13.u_rowl_g86__5122 g_row[13].u_rowl_n_2 FE_OFN9_n VSS VSS VDD VDD wz[13] sky130_fd_sc_hvl__and2_1
Xg_row_13.u_rowl_g87__8246 g_row[13].u_rowl_n_3 FE_OFN4_PROG VSS VSS VDD VDD g_row[13].u_rowl_n_5 sky130_fd_sc_hvl__nand2_1
Xg_row_13.u_rowl_g88 g_row[13].u_rowl_n_2 VSS VSS VDD VDD g_row[13].u_rowl_n_3 sky130_fd_sc_hvl__inv_1
Xg_row_13.u_rowl_g89__7098 FE_OFN3_sel_en row1q[13] VSS VSS VDD VDD g_row[13].u_rowl_n_2 sky130_fd_sc_hvl__nand2_1
Xg_row_14.u_rowl_g81__6131 wlvb[14] g_row[14].u_rowl_n_5 VSS VSS VDD VDD wl0b[14] sky130_fd_sc_hvl__nand2_1
Xg_row_14.u_rowl_g82__1881 g_row[14].u_rowl_n_3 FE_OFN5_VER FE_OFN10_FE_DBTN0_READb VSS VSS VDD VDD wlvb[14] sky130_fd_sc_hvl__a21oi_1
Xg_row_14.u_rowl_g83__5115 g_row[14].u_rowl_n_3 FE_OFN9_n VSS VSS VDD VDD wsel[14] sky130_fd_sc_hvl__and2_1
Xg_row_14.u_rowl_g84__7482 g_row[14].u_rowl_n_3 FE_OFN6_SENSE VSS VSS VDD VDD sns[14] sky130_fd_sc_hvl__and2_1
Xg_row_14.u_rowl_g85 g_row[14].u_rowl_n_5 VSS VSS VDD VDD wlw[14] sky130_fd_sc_hvl__inv_1
Xg_row_14.u_rowl_g86__4733 g_row[14].u_rowl_n_2 FE_OFN7_WRANY VSS VSS VDD VDD wz[14] sky130_fd_sc_hvl__and2_1
Xg_row_14.u_rowl_g87__6161 g_row[14].u_rowl_n_3 PROG VSS VSS VDD VDD g_row[14].u_rowl_n_5 sky130_fd_sc_hvl__nand2_1
Xg_row_14.u_rowl_g88 g_row[14].u_rowl_n_2 VSS VSS VDD VDD g_row[14].u_rowl_n_3 sky130_fd_sc_hvl__inv_1
Xg_row_14.u_rowl_g89__9315 FE_OFN3_sel_en row1q[14] VSS VSS VDD VDD g_row[14].u_rowl_n_2 sky130_fd_sc_hvl__nand2_1
Xg_row_15.u_rowl_g81__9945 wlvb[15] g_row[15].u_rowl_n_5 VSS VSS VDD VDD wl0b[15] sky130_fd_sc_hvl__nand2_1
Xg_row_15.u_rowl_g82__2883 g_row[15].u_rowl_n_3 VER FE_OFN10_FE_DBTN0_READb VSS VSS VDD VDD wlvb[15] sky130_fd_sc_hvl__a21oi_1
Xg_row_15.u_rowl_g83__2346 g_row[15].u_rowl_n_3 FE_OFN7_WRANY VSS VSS VDD VDD wsel[15] sky130_fd_sc_hvl__and2_1
Xg_row_15.u_rowl_g84__1666 g_row[15].u_rowl_n_3 FE_OFN6_SENSE VSS VSS VDD VDD sns[15] sky130_fd_sc_hvl__and2_1
Xg_row_15.u_rowl_g85 g_row[15].u_rowl_n_5 VSS VSS VDD VDD wlw[15] sky130_fd_sc_hvl__inv_1
Xg_row_15.u_rowl_g86__7410 g_row[15].u_rowl_n_2 FE_OFN7_WRANY VSS VSS VDD VDD wz[15] sky130_fd_sc_hvl__and2_1
Xg_row_15.u_rowl_g87__6417 g_row[15].u_rowl_n_3 PROG VSS VSS VDD VDD g_row[15].u_rowl_n_5 sky130_fd_sc_hvl__nand2_1
Xg_row_15.u_rowl_g88 g_row[15].u_rowl_n_2 VSS VSS VDD VDD g_row[15].u_rowl_n_3 sky130_fd_sc_hvl__inv_1
Xg_row_15.u_rowl_g89__5477 sel_en row1q[15] VSS VSS VDD VDD g_row[15].u_rowl_n_2 sky130_fd_sc_hvl__nand2_1
Xg_row_16.u_rowl_g81__2398 wlvb[16] g_row[16].u_rowl_n_5 VSS VSS VDD VDD wl0b[16] sky130_fd_sc_hvl__nand2_1
Xg_row_16.u_rowl_g82__5107 g_row[16].u_rowl_n_3 VER FE_DBTN0_READb VSS VSS VDD VDD wlvb[16] sky130_fd_sc_hvl__a21oi_1
Xg_row_16.u_rowl_g83__6260 g_row[16].u_rowl_n_3 FE_OFN7_WRANY VSS VSS VDD VDD wsel[16] sky130_fd_sc_hvl__and2_1
Xg_row_16.u_rowl_g84__4319 g_row[16].u_rowl_n_3 SENSE VSS VSS VDD VDD sns[16] sky130_fd_sc_hvl__and2_1
Xg_row_16.u_rowl_g85 g_row[16].u_rowl_n_5 VSS VSS VDD VDD wlw[16] sky130_fd_sc_hvl__inv_1
Xg_row_16.u_rowl_g86__8428 g_row[16].u_rowl_n_2 WRANY VSS VSS VDD VDD wz[16] sky130_fd_sc_hvl__and2_1
Xg_row_16.u_rowl_g87__5526 g_row[16].u_rowl_n_3 PROG VSS VSS VDD VDD g_row[16].u_rowl_n_5 sky130_fd_sc_hvl__nand2_1
Xg_row_16.u_rowl_g88 g_row[16].u_rowl_n_2 VSS VSS VDD VDD g_row[16].u_rowl_n_3 sky130_fd_sc_hvl__inv_1
Xg_row_16.u_rowl_g89__6783 sel_en row1q[16] VSS VSS VDD VDD g_row[16].u_rowl_n_2 sky130_fd_sc_hvl__nand2_1
Xg_row_17.u_rowl_g81__3680 wlvb[17] g_row[17].u_rowl_n_5 VSS VSS VDD VDD wl0b[17] sky130_fd_sc_hvl__nand2_1
Xg_row_17.u_rowl_g82__1617 g_row[17].u_rowl_n_3 VER FE_DBTN0_READb VSS VSS VDD VDD wlvb[17] sky130_fd_sc_hvl__a21oi_1
Xg_row_17.u_rowl_g83__2802 g_row[17].u_rowl_n_3 WRANY VSS VSS VDD VDD wsel[17] sky130_fd_sc_hvl__and2_1
Xg_row_17.u_rowl_g84__1705 g_row[17].u_rowl_n_3 SENSE VSS VSS VDD VDD sns[17] sky130_fd_sc_hvl__and2_1
Xg_row_17.u_rowl_g85 g_row[17].u_rowl_n_5 VSS VSS VDD VDD wlw[17] sky130_fd_sc_hvl__inv_1
Xg_row_17.u_rowl_g86__5122 g_row[17].u_rowl_n_2 WRANY VSS VSS VDD VDD wz[17] sky130_fd_sc_hvl__and2_1
Xg_row_17.u_rowl_g87__8246 g_row[17].u_rowl_n_3 PROG VSS VSS VDD VDD g_row[17].u_rowl_n_5 sky130_fd_sc_hvl__nand2_1
Xg_row_17.u_rowl_g88 g_row[17].u_rowl_n_2 VSS VSS VDD VDD g_row[17].u_rowl_n_3 sky130_fd_sc_hvl__inv_1
Xg_row_17.u_rowl_g89__7098 sel_en row1q[17] VSS VSS VDD VDD g_row[17].u_rowl_n_2 sky130_fd_sc_hvl__nand2_1
Xg_row_18.u_rowl_g81__6131 wlvb[18] g_row[18].u_rowl_n_5 VSS VSS VDD VDD wl0b[18] sky130_fd_sc_hvl__nand2_1
Xg_row_18.u_rowl_g82__1881 g_row[18].u_rowl_n_3 FE_OFN5_VER FE_OFN10_FE_DBTN0_READb VSS VSS VDD VDD wlvb[18] sky130_fd_sc_hvl__a21oi_1
Xg_row_18.u_rowl_g83__5115 g_row[18].u_rowl_n_3 FE_OFN9_n VSS VSS VDD VDD wsel[18] sky130_fd_sc_hvl__and2_1
Xg_row_18.u_rowl_g84__7482 g_row[18].u_rowl_n_3 FE_OFN6_SENSE VSS VSS VDD VDD sns[18] sky130_fd_sc_hvl__and2_1
Xg_row_18.u_rowl_g85 g_row[18].u_rowl_n_5 VSS VSS VDD VDD wlw[18] sky130_fd_sc_hvl__inv_1
Xg_row_18.u_rowl_g86__4733 g_row[18].u_rowl_n_2 FE_OFN9_n VSS VSS VDD VDD wz[18] sky130_fd_sc_hvl__and2_1
Xg_row_18.u_rowl_g87__6161 g_row[18].u_rowl_n_3 FE_OFN4_PROG VSS VSS VDD VDD g_row[18].u_rowl_n_5 sky130_fd_sc_hvl__nand2_1
Xg_row_18.u_rowl_g88 g_row[18].u_rowl_n_2 VSS VSS VDD VDD g_row[18].u_rowl_n_3 sky130_fd_sc_hvl__inv_1
Xg_row_18.u_rowl_g89__9315 FE_OFN3_sel_en row1q[18] VSS VSS VDD VDD g_row[18].u_rowl_n_2 sky130_fd_sc_hvl__nand2_1
Xg_row_19.u_rowl_g81__9945 wlvb[19] g_row[19].u_rowl_n_5 VSS VSS VDD VDD wl0b[19] sky130_fd_sc_hvl__nand2_1
Xg_row_19.u_rowl_g82__2883 g_row[19].u_rowl_n_3 FE_OFN5_VER FE_OFN10_FE_DBTN0_READb VSS VSS VDD VDD wlvb[19] sky130_fd_sc_hvl__a21oi_1
Xg_row_19.u_rowl_g83__2346 g_row[19].u_rowl_n_3 FE_OFN9_n VSS VSS VDD VDD wsel[19] sky130_fd_sc_hvl__and2_1
Xg_row_19.u_rowl_g84__1666 g_row[19].u_rowl_n_3 FE_OFN6_SENSE VSS VSS VDD VDD sns[19] sky130_fd_sc_hvl__and2_1
Xg_row_19.u_rowl_g85 g_row[19].u_rowl_n_5 VSS VSS VDD VDD wlw[19] sky130_fd_sc_hvl__inv_1
Xg_row_19.u_rowl_g86__7410 g_row[19].u_rowl_n_2 FE_OFN9_n VSS VSS VDD VDD wz[19] sky130_fd_sc_hvl__and2_1
Xg_row_19.u_rowl_g87__6417 g_row[19].u_rowl_n_3 FE_OFN4_PROG VSS VSS VDD VDD g_row[19].u_rowl_n_5 sky130_fd_sc_hvl__nand2_1
Xg_row_19.u_rowl_g88 g_row[19].u_rowl_n_2 VSS VSS VDD VDD g_row[19].u_rowl_n_3 sky130_fd_sc_hvl__inv_1
Xg_row_19.u_rowl_g89__5477 FE_OFN3_sel_en row1q[19] VSS VSS VDD VDD g_row[19].u_rowl_n_2 sky130_fd_sc_hvl__nand2_1
Xg_row_20.u_rowl_g81__2398 wlvb[20] g_row[20].u_rowl_n_5 VSS VSS VDD VDD wl0b[20] sky130_fd_sc_hvl__nand2_1
Xg_row_20.u_rowl_g82__5107 g_row[20].u_rowl_n_3 FE_OFN5_VER FE_OFN10_FE_DBTN0_READb VSS VSS VDD VDD wlvb[20] sky130_fd_sc_hvl__a21oi_1
Xg_row_20.u_rowl_g83__6260 g_row[20].u_rowl_n_3 FE_OFN9_n VSS VSS VDD VDD wsel[20] sky130_fd_sc_hvl__and2_1
Xg_row_20.u_rowl_g84__4319 g_row[20].u_rowl_n_3 FE_OFN6_SENSE VSS VSS VDD VDD sns[20] sky130_fd_sc_hvl__and2_1
Xg_row_20.u_rowl_g85 g_row[20].u_rowl_n_5 VSS VSS VDD VDD wlw[20] sky130_fd_sc_hvl__inv_1
Xg_row_20.u_rowl_g86__8428 g_row[20].u_rowl_n_2 FE_OFN7_WRANY VSS VSS VDD VDD wz[20] sky130_fd_sc_hvl__and2_1
Xg_row_20.u_rowl_g87__5526 g_row[20].u_rowl_n_3 PROG VSS VSS VDD VDD g_row[20].u_rowl_n_5 sky130_fd_sc_hvl__nand2_1
Xg_row_20.u_rowl_g88 g_row[20].u_rowl_n_2 VSS VSS VDD VDD g_row[20].u_rowl_n_3 sky130_fd_sc_hvl__inv_1
Xg_row_20.u_rowl_g89__6783 FE_OFN3_sel_en row1q[20] VSS VSS VDD VDD g_row[20].u_rowl_n_2 sky130_fd_sc_hvl__nand2_1
Xg_row_21.u_rowl_g81__3680 wlvb[21] g_row[21].u_rowl_n_5 VSS VSS VDD VDD wl0b[21] sky130_fd_sc_hvl__nand2_1
Xg_row_21.u_rowl_g82__1617 g_row[21].u_rowl_n_3 VER FE_OFN10_FE_DBTN0_READb VSS VSS VDD VDD wlvb[21] sky130_fd_sc_hvl__a21oi_1
Xg_row_21.u_rowl_g83__2802 g_row[21].u_rowl_n_3 FE_OFN7_WRANY VSS VSS VDD VDD wsel[21] sky130_fd_sc_hvl__and2_1
Xg_row_21.u_rowl_g84__1705 g_row[21].u_rowl_n_3 FE_OFN6_SENSE VSS VSS VDD VDD sns[21] sky130_fd_sc_hvl__and2_1
Xg_row_21.u_rowl_g85 g_row[21].u_rowl_n_5 VSS VSS VDD VDD wlw[21] sky130_fd_sc_hvl__inv_1
Xg_row_21.u_rowl_g86__5122 g_row[21].u_rowl_n_2 FE_OFN7_WRANY VSS VSS VDD VDD wz[21] sky130_fd_sc_hvl__and2_1
Xg_row_21.u_rowl_g87__8246 g_row[21].u_rowl_n_3 PROG VSS VSS VDD VDD g_row[21].u_rowl_n_5 sky130_fd_sc_hvl__nand2_1
Xg_row_21.u_rowl_g88 g_row[21].u_rowl_n_2 VSS VSS VDD VDD g_row[21].u_rowl_n_3 sky130_fd_sc_hvl__inv_1
Xg_row_21.u_rowl_g89__7098 sel_en row1q[21] VSS VSS VDD VDD g_row[21].u_rowl_n_2 sky130_fd_sc_hvl__nand2_1
Xg_row_22.u_rowl_g81__6131 wlvb[22] g_row[22].u_rowl_n_5 VSS VSS VDD VDD wl0b[22] sky130_fd_sc_hvl__nand2_1
Xg_row_22.u_rowl_g82__1881 g_row[22].u_rowl_n_3 VER FE_DBTN0_READb VSS VSS VDD VDD wlvb[22] sky130_fd_sc_hvl__a21oi_1
Xg_row_22.u_rowl_g83__5115 g_row[22].u_rowl_n_3 FE_OFN7_WRANY VSS VSS VDD VDD wsel[22] sky130_fd_sc_hvl__and2_1
Xg_row_22.u_rowl_g84__7482 g_row[22].u_rowl_n_3 SENSE VSS VSS VDD VDD sns[22] sky130_fd_sc_hvl__and2_1
Xg_row_22.u_rowl_g85 g_row[22].u_rowl_n_5 VSS VSS VDD VDD wlw[22] sky130_fd_sc_hvl__inv_1
Xg_row_22.u_rowl_g86__4733 g_row[22].u_rowl_n_2 WRANY VSS VSS VDD VDD wz[22] sky130_fd_sc_hvl__and2_1
Xg_row_22.u_rowl_g87__6161 g_row[22].u_rowl_n_3 PROG VSS VSS VDD VDD g_row[22].u_rowl_n_5 sky130_fd_sc_hvl__nand2_1
Xg_row_22.u_rowl_g88 g_row[22].u_rowl_n_2 VSS VSS VDD VDD g_row[22].u_rowl_n_3 sky130_fd_sc_hvl__inv_1
Xg_row_22.u_rowl_g89__9315 sel_en row1q[22] VSS VSS VDD VDD g_row[22].u_rowl_n_2 sky130_fd_sc_hvl__nand2_1
Xg_row_23.u_rowl_g81__9945 wlvb[23] g_row[23].u_rowl_n_5 VSS VSS VDD VDD wl0b[23] sky130_fd_sc_hvl__nand2_1
Xg_row_23.u_rowl_g82__2883 g_row[23].u_rowl_n_3 VER FE_DBTN0_READb VSS VSS VDD VDD wlvb[23] sky130_fd_sc_hvl__a21oi_1
Xg_row_23.u_rowl_g83__2346 g_row[23].u_rowl_n_3 WRANY VSS VSS VDD VDD wsel[23] sky130_fd_sc_hvl__and2_1
Xg_row_23.u_rowl_g84__1666 g_row[23].u_rowl_n_3 SENSE VSS VSS VDD VDD sns[23] sky130_fd_sc_hvl__and2_1
Xg_row_23.u_rowl_g85 g_row[23].u_rowl_n_5 VSS VSS VDD VDD wlw[23] sky130_fd_sc_hvl__inv_1
Xg_row_23.u_rowl_g86__7410 g_row[23].u_rowl_n_2 WRANY VSS VSS VDD VDD wz[23] sky130_fd_sc_hvl__and2_1
Xg_row_23.u_rowl_g87__6417 g_row[23].u_rowl_n_3 PROG VSS VSS VDD VDD g_row[23].u_rowl_n_5 sky130_fd_sc_hvl__nand2_1
Xg_row_23.u_rowl_g88 g_row[23].u_rowl_n_2 VSS VSS VDD VDD g_row[23].u_rowl_n_3 sky130_fd_sc_hvl__inv_1
Xg_row_23.u_rowl_g89__5477 sel_en row1q[23] VSS VSS VDD VDD g_row[23].u_rowl_n_2 sky130_fd_sc_hvl__nand2_1
Xg_row_24.u_rowl_g81__2398 wlvb[24] g_row[24].u_rowl_n_5 VSS VSS VDD VDD wl0b[24] sky130_fd_sc_hvl__nand2_1
Xg_row_24.u_rowl_g82__5107 g_row[24].u_rowl_n_3 FE_OFN5_VER FE_OFN10_FE_DBTN0_READb VSS VSS VDD VDD wlvb[24] sky130_fd_sc_hvl__a21oi_1
Xg_row_24.u_rowl_g83__6260 g_row[24].u_rowl_n_3 FE_OFN9_n VSS VSS VDD VDD wsel[24] sky130_fd_sc_hvl__and2_1
Xg_row_24.u_rowl_g84__4319 g_row[24].u_rowl_n_3 FE_OFN6_SENSE VSS VSS VDD VDD sns[24] sky130_fd_sc_hvl__and2_1
Xg_row_24.u_rowl_g85 g_row[24].u_rowl_n_5 VSS VSS VDD VDD wlw[24] sky130_fd_sc_hvl__inv_1
Xg_row_24.u_rowl_g86__8428 g_row[24].u_rowl_n_2 FE_OFN9_n VSS VSS VDD VDD wz[24] sky130_fd_sc_hvl__and2_1
Xg_row_24.u_rowl_g87__5526 g_row[24].u_rowl_n_3 FE_OFN4_PROG VSS VSS VDD VDD g_row[24].u_rowl_n_5 sky130_fd_sc_hvl__nand2_1
Xg_row_24.u_rowl_g88 g_row[24].u_rowl_n_2 VSS VSS VDD VDD g_row[24].u_rowl_n_3 sky130_fd_sc_hvl__inv_1
Xg_row_24.u_rowl_g89__6783 FE_OFN3_sel_en row1q[24] VSS VSS VDD VDD g_row[24].u_rowl_n_2 sky130_fd_sc_hvl__nand2_1
Xg_row_25.u_rowl_g81__3680 wlvb[25] g_row[25].u_rowl_n_5 VSS VSS VDD VDD wl0b[25] sky130_fd_sc_hvl__nand2_1
Xg_row_25.u_rowl_g82__1617 g_row[25].u_rowl_n_3 FE_OFN5_VER FE_OFN10_FE_DBTN0_READb VSS VSS VDD VDD wlvb[25] sky130_fd_sc_hvl__a21oi_1
Xg_row_25.u_rowl_g83__2802 g_row[25].u_rowl_n_3 FE_OFN9_n VSS VSS VDD VDD wsel[25] sky130_fd_sc_hvl__and2_1
Xg_row_25.u_rowl_g84__1705 g_row[25].u_rowl_n_3 FE_OFN6_SENSE VSS VSS VDD VDD sns[25] sky130_fd_sc_hvl__and2_1
Xg_row_25.u_rowl_g85 g_row[25].u_rowl_n_5 VSS VSS VDD VDD wlw[25] sky130_fd_sc_hvl__inv_1
Xg_row_25.u_rowl_g86__5122 g_row[25].u_rowl_n_2 FE_OFN9_n VSS VSS VDD VDD wz[25] sky130_fd_sc_hvl__and2_1
Xg_row_25.u_rowl_g87__8246 g_row[25].u_rowl_n_3 FE_OFN4_PROG VSS VSS VDD VDD g_row[25].u_rowl_n_5 sky130_fd_sc_hvl__nand2_1
Xg_row_25.u_rowl_g88 g_row[25].u_rowl_n_2 VSS VSS VDD VDD g_row[25].u_rowl_n_3 sky130_fd_sc_hvl__inv_1
Xg_row_25.u_rowl_g89__7098 FE_OFN3_sel_en row1q[25] VSS VSS VDD VDD g_row[25].u_rowl_n_2 sky130_fd_sc_hvl__nand2_1
Xg_row_26.u_rowl_g81__6131 wlvb[26] g_row[26].u_rowl_n_5 VSS VSS VDD VDD wl0b[26] sky130_fd_sc_hvl__nand2_1
Xg_row_26.u_rowl_g82__1881 g_row[26].u_rowl_n_3 FE_OFN5_VER FE_OFN10_FE_DBTN0_READb VSS VSS VDD VDD wlvb[26] sky130_fd_sc_hvl__a21oi_1
Xg_row_26.u_rowl_g83__5115 g_row[26].u_rowl_n_3 FE_OFN9_n VSS VSS VDD VDD wsel[26] sky130_fd_sc_hvl__and2_1
Xg_row_26.u_rowl_g84__7482 g_row[26].u_rowl_n_3 FE_OFN6_SENSE VSS VSS VDD VDD sns[26] sky130_fd_sc_hvl__and2_1
Xg_row_26.u_rowl_g85 g_row[26].u_rowl_n_5 VSS VSS VDD VDD wlw[26] sky130_fd_sc_hvl__inv_1
Xg_row_26.u_rowl_g86__4733 g_row[26].u_rowl_n_2 FE_OFN7_WRANY VSS VSS VDD VDD wz[26] sky130_fd_sc_hvl__and2_1
Xg_row_26.u_rowl_g87__6161 g_row[26].u_rowl_n_3 PROG VSS VSS VDD VDD g_row[26].u_rowl_n_5 sky130_fd_sc_hvl__nand2_1
Xg_row_26.u_rowl_g88 g_row[26].u_rowl_n_2 VSS VSS VDD VDD g_row[26].u_rowl_n_3 sky130_fd_sc_hvl__inv_1
Xg_row_26.u_rowl_g89__9315 FE_OFN3_sel_en row1q[26] VSS VSS VDD VDD g_row[26].u_rowl_n_2 sky130_fd_sc_hvl__nand2_1
Xg_row_27.u_rowl_g81__9945 wlvb[27] g_row[27].u_rowl_n_5 VSS VSS VDD VDD wl0b[27] sky130_fd_sc_hvl__nand2_1
Xg_row_27.u_rowl_g82__2883 g_row[27].u_rowl_n_3 VER FE_OFN10_FE_DBTN0_READb VSS VSS VDD VDD wlvb[27] sky130_fd_sc_hvl__a21oi_1
Xg_row_27.u_rowl_g83__2346 g_row[27].u_rowl_n_3 FE_OFN7_WRANY VSS VSS VDD VDD wsel[27] sky130_fd_sc_hvl__and2_1
Xg_row_27.u_rowl_g84__1666 g_row[27].u_rowl_n_3 FE_OFN6_SENSE VSS VSS VDD VDD sns[27] sky130_fd_sc_hvl__and2_1
Xg_row_27.u_rowl_g85 g_row[27].u_rowl_n_5 VSS VSS VDD VDD wlw[27] sky130_fd_sc_hvl__inv_1
Xg_row_27.u_rowl_g86__7410 g_row[27].u_rowl_n_2 FE_OFN7_WRANY VSS VSS VDD VDD wz[27] sky130_fd_sc_hvl__and2_1
Xg_row_27.u_rowl_g87__6417 g_row[27].u_rowl_n_3 PROG VSS VSS VDD VDD g_row[27].u_rowl_n_5 sky130_fd_sc_hvl__nand2_1
Xg_row_27.u_rowl_g88 g_row[27].u_rowl_n_2 VSS VSS VDD VDD g_row[27].u_rowl_n_3 sky130_fd_sc_hvl__inv_1
Xg_row_27.u_rowl_g89__5477 sel_en row1q[27] VSS VSS VDD VDD g_row[27].u_rowl_n_2 sky130_fd_sc_hvl__nand2_1
Xg_row_28.u_rowl_g81__2398 wlvb[28] g_row[28].u_rowl_n_5 VSS VSS VDD VDD wl0b[28] sky130_fd_sc_hvl__nand2_1
Xg_row_28.u_rowl_g82__5107 g_row[28].u_rowl_n_3 VER FE_DBTN0_READb VSS VSS VDD VDD wlvb[28] sky130_fd_sc_hvl__a21oi_1
Xg_row_28.u_rowl_g83__6260 g_row[28].u_rowl_n_3 FE_OFN7_WRANY VSS VSS VDD VDD wsel[28] sky130_fd_sc_hvl__and2_1
Xg_row_28.u_rowl_g84__4319 g_row[28].u_rowl_n_3 SENSE VSS VSS VDD VDD sns[28] sky130_fd_sc_hvl__and2_1
Xg_row_28.u_rowl_g85 g_row[28].u_rowl_n_5 VSS VSS VDD VDD wlw[28] sky130_fd_sc_hvl__inv_1
Xg_row_28.u_rowl_g86__8428 g_row[28].u_rowl_n_2 WRANY VSS VSS VDD VDD wz[28] sky130_fd_sc_hvl__and2_1
Xg_row_28.u_rowl_g87__5526 g_row[28].u_rowl_n_3 PROG VSS VSS VDD VDD g_row[28].u_rowl_n_5 sky130_fd_sc_hvl__nand2_1
Xg_row_28.u_rowl_g88 g_row[28].u_rowl_n_2 VSS VSS VDD VDD g_row[28].u_rowl_n_3 sky130_fd_sc_hvl__inv_1
Xg_row_28.u_rowl_g89__6783 sel_en row1q[28] VSS VSS VDD VDD g_row[28].u_rowl_n_2 sky130_fd_sc_hvl__nand2_1
Xg_row_29.u_rowl_g81__3680 wlvb[29] g_row[29].u_rowl_n_5 VSS VSS VDD VDD wl0b[29] sky130_fd_sc_hvl__nand2_1
Xg_row_29.u_rowl_g82__1617 g_row[29].u_rowl_n_3 VER FE_DBTN0_READb VSS VSS VDD VDD wlvb[29] sky130_fd_sc_hvl__a21oi_1
Xg_row_29.u_rowl_g83__2802 g_row[29].u_rowl_n_3 WRANY VSS VSS VDD VDD wsel[29] sky130_fd_sc_hvl__and2_1
Xg_row_29.u_rowl_g84__1705 g_row[29].u_rowl_n_3 SENSE VSS VSS VDD VDD sns[29] sky130_fd_sc_hvl__and2_1
Xg_row_29.u_rowl_g85 g_row[29].u_rowl_n_5 VSS VSS VDD VDD wlw[29] sky130_fd_sc_hvl__inv_1
Xg_row_29.u_rowl_g86__5122 g_row[29].u_rowl_n_2 WRANY VSS VSS VDD VDD wz[29] sky130_fd_sc_hvl__and2_1
Xg_row_29.u_rowl_g87__8246 g_row[29].u_rowl_n_3 PROG VSS VSS VDD VDD g_row[29].u_rowl_n_5 sky130_fd_sc_hvl__nand2_1
Xg_row_29.u_rowl_g88 g_row[29].u_rowl_n_2 VSS VSS VDD VDD g_row[29].u_rowl_n_3 sky130_fd_sc_hvl__inv_1
Xg_row_29.u_rowl_g89__7098 sel_en row1q[29] VSS VSS VDD VDD g_row[29].u_rowl_n_2 sky130_fd_sc_hvl__nand2_1
Xg_row_30.u_rowl_g81__6131 wlvb[30] g_row[30].u_rowl_n_5 VSS VSS VDD VDD wl0b[30] sky130_fd_sc_hvl__nand2_1
Xg_row_30.u_rowl_g82__1881 g_row[30].u_rowl_n_3 FE_OFN5_VER FE_OFN10_FE_DBTN0_READb VSS VSS VDD VDD wlvb[30] sky130_fd_sc_hvl__a21oi_1
Xg_row_30.u_rowl_g83__5115 g_row[30].u_rowl_n_3 FE_OFN9_n VSS VSS VDD VDD wsel[30] sky130_fd_sc_hvl__and2_1
Xg_row_30.u_rowl_g84__7482 g_row[30].u_rowl_n_3 FE_OFN6_SENSE VSS VSS VDD VDD sns[30] sky130_fd_sc_hvl__and2_1
Xg_row_30.u_rowl_g85 g_row[30].u_rowl_n_5 VSS VSS VDD VDD wlw[30] sky130_fd_sc_hvl__inv_1
Xg_row_30.u_rowl_g86__4733 g_row[30].u_rowl_n_2 FE_OFN9_n VSS VSS VDD VDD wz[30] sky130_fd_sc_hvl__and2_1
Xg_row_30.u_rowl_g87__6161 g_row[30].u_rowl_n_3 FE_OFN4_PROG VSS VSS VDD VDD g_row[30].u_rowl_n_5 sky130_fd_sc_hvl__nand2_1
Xg_row_30.u_rowl_g88 g_row[30].u_rowl_n_2 VSS VSS VDD VDD g_row[30].u_rowl_n_3 sky130_fd_sc_hvl__inv_1
Xg_row_30.u_rowl_g89__9315 FE_OFN3_sel_en row1q[30] VSS VSS VDD VDD g_row[30].u_rowl_n_2 sky130_fd_sc_hvl__nand2_1
Xg_row_31.u_rowl_g81__9945 wlvb[31] g_row[31].u_rowl_n_5 VSS VSS VDD VDD wl0b[31] sky130_fd_sc_hvl__nand2_1
Xg_row_31.u_rowl_g82__2883 g_row[31].u_rowl_n_3 FE_OFN5_VER FE_OFN10_FE_DBTN0_READb VSS VSS VDD VDD wlvb[31] sky130_fd_sc_hvl__a21oi_1
Xg_row_31.u_rowl_g83__2346 g_row[31].u_rowl_n_3 FE_OFN9_n VSS VSS VDD VDD wsel[31] sky130_fd_sc_hvl__and2_1
Xg_row_31.u_rowl_g84__1666 g_row[31].u_rowl_n_3 FE_OFN6_SENSE VSS VSS VDD VDD sns[31] sky130_fd_sc_hvl__and2_1
Xg_row_31.u_rowl_g85 g_row[31].u_rowl_n_5 VSS VSS VDD VDD wlw[31] sky130_fd_sc_hvl__inv_1
Xg_row_31.u_rowl_g86__7410 g_row[31].u_rowl_n_2 FE_OFN9_n VSS VSS VDD VDD wz[31] sky130_fd_sc_hvl__and2_1
Xg_row_31.u_rowl_g87__6417 g_row[31].u_rowl_n_3 FE_OFN4_PROG VSS VSS VDD VDD g_row[31].u_rowl_n_5 sky130_fd_sc_hvl__nand2_1
Xg_row_31.u_rowl_g88 g_row[31].u_rowl_n_2 VSS VSS VDD VDD g_row[31].u_rowl_n_3 sky130_fd_sc_hvl__inv_1
Xg_row_31.u_rowl_g89__5477 FE_OFN3_sel_en row1q[31] VSS VSS VDD VDD g_row[31].u_rowl_n_2 sky130_fd_sc_hvl__nand2_1
Xg_row_32.u_rowl_g81__2398 wlvb[32] g_row[32].u_rowl_n_5 VSS VSS VDD VDD wl0b[32] sky130_fd_sc_hvl__nand2_1
Xg_row_32.u_rowl_g82__5107 g_row[32].u_rowl_n_3 FE_OFN5_VER FE_OFN10_FE_DBTN0_READb VSS VSS VDD VDD wlvb[32] sky130_fd_sc_hvl__a21oi_1
Xg_row_32.u_rowl_g83__6260 g_row[32].u_rowl_n_3 FE_OFN9_n VSS VSS VDD VDD wsel[32] sky130_fd_sc_hvl__and2_1
Xg_row_32.u_rowl_g84__4319 g_row[32].u_rowl_n_3 FE_OFN6_SENSE VSS VSS VDD VDD sns[32] sky130_fd_sc_hvl__and2_1
Xg_row_32.u_rowl_g85 g_row[32].u_rowl_n_5 VSS VSS VDD VDD wlw[32] sky130_fd_sc_hvl__inv_1
Xg_row_32.u_rowl_g86__8428 g_row[32].u_rowl_n_2 FE_OFN7_WRANY VSS VSS VDD VDD wz[32] sky130_fd_sc_hvl__and2_1
Xg_row_32.u_rowl_g87__5526 g_row[32].u_rowl_n_3 PROG VSS VSS VDD VDD g_row[32].u_rowl_n_5 sky130_fd_sc_hvl__nand2_1
Xg_row_32.u_rowl_g88 g_row[32].u_rowl_n_2 VSS VSS VDD VDD g_row[32].u_rowl_n_3 sky130_fd_sc_hvl__inv_1
Xg_row_32.u_rowl_g89__6783 FE_OFN3_sel_en row1q[32] VSS VSS VDD VDD g_row[32].u_rowl_n_2 sky130_fd_sc_hvl__nand2_1
Xg_row_33.u_rowl_g81__3680 wlvb[33] g_row[33].u_rowl_n_5 VSS VSS VDD VDD wl0b[33] sky130_fd_sc_hvl__nand2_1
Xg_row_33.u_rowl_g82__1617 g_row[33].u_rowl_n_3 VER FE_OFN10_FE_DBTN0_READb VSS VSS VDD VDD wlvb[33] sky130_fd_sc_hvl__a21oi_1
Xg_row_33.u_rowl_g83__2802 g_row[33].u_rowl_n_3 FE_OFN7_WRANY VSS VSS VDD VDD wsel[33] sky130_fd_sc_hvl__and2_1
Xg_row_33.u_rowl_g84__1705 g_row[33].u_rowl_n_3 FE_OFN6_SENSE VSS VSS VDD VDD sns[33] sky130_fd_sc_hvl__and2_1
Xg_row_33.u_rowl_g85 g_row[33].u_rowl_n_5 VSS VSS VDD VDD wlw[33] sky130_fd_sc_hvl__inv_1
Xg_row_33.u_rowl_g86__5122 g_row[33].u_rowl_n_2 FE_OFN7_WRANY VSS VSS VDD VDD wz[33] sky130_fd_sc_hvl__and2_1
Xg_row_33.u_rowl_g87__8246 g_row[33].u_rowl_n_3 PROG VSS VSS VDD VDD g_row[33].u_rowl_n_5 sky130_fd_sc_hvl__nand2_1
Xg_row_33.u_rowl_g88 g_row[33].u_rowl_n_2 VSS VSS VDD VDD g_row[33].u_rowl_n_3 sky130_fd_sc_hvl__inv_1
Xg_row_33.u_rowl_g89__7098 sel_en row1q[33] VSS VSS VDD VDD g_row[33].u_rowl_n_2 sky130_fd_sc_hvl__nand2_1
Xg_row_34.u_rowl_g81__6131 wlvb[34] g_row[34].u_rowl_n_5 VSS VSS VDD VDD wl0b[34] sky130_fd_sc_hvl__nand2_1
Xg_row_34.u_rowl_g82__1881 g_row[34].u_rowl_n_3 VER FE_DBTN0_READb VSS VSS VDD VDD wlvb[34] sky130_fd_sc_hvl__a21oi_1
Xg_row_34.u_rowl_g83__5115 g_row[34].u_rowl_n_3 FE_OFN7_WRANY VSS VSS VDD VDD wsel[34] sky130_fd_sc_hvl__and2_1
Xg_row_34.u_rowl_g84__7482 g_row[34].u_rowl_n_3 SENSE VSS VSS VDD VDD sns[34] sky130_fd_sc_hvl__and2_1
Xg_row_34.u_rowl_g85 g_row[34].u_rowl_n_5 VSS VSS VDD VDD wlw[34] sky130_fd_sc_hvl__inv_1
Xg_row_34.u_rowl_g86__4733 g_row[34].u_rowl_n_2 WRANY VSS VSS VDD VDD wz[34] sky130_fd_sc_hvl__and2_1
Xg_row_34.u_rowl_g87__6161 g_row[34].u_rowl_n_3 PROG VSS VSS VDD VDD g_row[34].u_rowl_n_5 sky130_fd_sc_hvl__nand2_1
Xg_row_34.u_rowl_g88 g_row[34].u_rowl_n_2 VSS VSS VDD VDD g_row[34].u_rowl_n_3 sky130_fd_sc_hvl__inv_1
Xg_row_34.u_rowl_g89__9315 sel_en row1q[34] VSS VSS VDD VDD g_row[34].u_rowl_n_2 sky130_fd_sc_hvl__nand2_1
Xg_row_35.u_rowl_g81__9945 wlvb[35] g_row[35].u_rowl_n_5 VSS VSS VDD VDD wl0b[35] sky130_fd_sc_hvl__nand2_1
Xg_row_35.u_rowl_g82__2883 g_row[35].u_rowl_n_3 VER FE_DBTN0_READb VSS VSS VDD VDD wlvb[35] sky130_fd_sc_hvl__a21oi_1
Xg_row_35.u_rowl_g83__2346 g_row[35].u_rowl_n_3 WRANY VSS VSS VDD VDD wsel[35] sky130_fd_sc_hvl__and2_1
Xg_row_35.u_rowl_g84__1666 g_row[35].u_rowl_n_3 SENSE VSS VSS VDD VDD sns[35] sky130_fd_sc_hvl__and2_1
Xg_row_35.u_rowl_g85 g_row[35].u_rowl_n_5 VSS VSS VDD VDD wlw[35] sky130_fd_sc_hvl__inv_1
Xg_row_35.u_rowl_g86__7410 g_row[35].u_rowl_n_2 WRANY VSS VSS VDD VDD wz[35] sky130_fd_sc_hvl__and2_1
Xg_row_35.u_rowl_g87__6417 g_row[35].u_rowl_n_3 PROG VSS VSS VDD VDD g_row[35].u_rowl_n_5 sky130_fd_sc_hvl__nand2_1
Xg_row_35.u_rowl_g88 g_row[35].u_rowl_n_2 VSS VSS VDD VDD g_row[35].u_rowl_n_3 sky130_fd_sc_hvl__inv_1
Xg_row_35.u_rowl_g89__5477 sel_en row1q[35] VSS VSS VDD VDD g_row[35].u_rowl_n_2 sky130_fd_sc_hvl__nand2_1
Xg_row_36.u_rowl_g81__2398 wlvb[36] g_row[36].u_rowl_n_5 VSS VSS VDD VDD wl0b[36] sky130_fd_sc_hvl__nand2_1
Xg_row_36.u_rowl_g82__5107 g_row[36].u_rowl_n_3 FE_OFN5_VER FE_OFN10_FE_DBTN0_READb VSS VSS VDD VDD wlvb[36] sky130_fd_sc_hvl__a21oi_1
Xg_row_36.u_rowl_g83__6260 g_row[36].u_rowl_n_3 FE_OFN9_n VSS VSS VDD VDD wsel[36] sky130_fd_sc_hvl__and2_1
Xg_row_36.u_rowl_g84__4319 g_row[36].u_rowl_n_3 FE_OFN6_SENSE VSS VSS VDD VDD sns[36] sky130_fd_sc_hvl__and2_1
Xg_row_36.u_rowl_g85 g_row[36].u_rowl_n_5 VSS VSS VDD VDD wlw[36] sky130_fd_sc_hvl__inv_1
Xg_row_36.u_rowl_g86__8428 g_row[36].u_rowl_n_2 FE_OFN9_n VSS VSS VDD VDD wz[36] sky130_fd_sc_hvl__and2_1
Xg_row_36.u_rowl_g87__5526 g_row[36].u_rowl_n_3 FE_OFN4_PROG VSS VSS VDD VDD g_row[36].u_rowl_n_5 sky130_fd_sc_hvl__nand2_1
Xg_row_36.u_rowl_g88 g_row[36].u_rowl_n_2 VSS VSS VDD VDD g_row[36].u_rowl_n_3 sky130_fd_sc_hvl__inv_1
Xg_row_36.u_rowl_g89__6783 FE_OFN3_sel_en row1q[36] VSS VSS VDD VDD g_row[36].u_rowl_n_2 sky130_fd_sc_hvl__nand2_1
Xg_row_37.u_rowl_g81__3680 wlvb[37] g_row[37].u_rowl_n_5 VSS VSS VDD VDD wl0b[37] sky130_fd_sc_hvl__nand2_1
Xg_row_37.u_rowl_g82__1617 g_row[37].u_rowl_n_3 FE_OFN5_VER FE_OFN10_FE_DBTN0_READb VSS VSS VDD VDD wlvb[37] sky130_fd_sc_hvl__a21oi_1
Xg_row_37.u_rowl_g83__2802 g_row[37].u_rowl_n_3 FE_OFN9_n VSS VSS VDD VDD wsel[37] sky130_fd_sc_hvl__and2_1
Xg_row_37.u_rowl_g84__1705 g_row[37].u_rowl_n_3 FE_OFN6_SENSE VSS VSS VDD VDD sns[37] sky130_fd_sc_hvl__and2_1
Xg_row_37.u_rowl_g85 g_row[37].u_rowl_n_5 VSS VSS VDD VDD wlw[37] sky130_fd_sc_hvl__inv_1
Xg_row_37.u_rowl_g86__5122 g_row[37].u_rowl_n_2 FE_OFN9_n VSS VSS VDD VDD wz[37] sky130_fd_sc_hvl__and2_1
Xg_row_37.u_rowl_g87__8246 g_row[37].u_rowl_n_3 FE_OFN4_PROG VSS VSS VDD VDD g_row[37].u_rowl_n_5 sky130_fd_sc_hvl__nand2_1
Xg_row_37.u_rowl_g88 g_row[37].u_rowl_n_2 VSS VSS VDD VDD g_row[37].u_rowl_n_3 sky130_fd_sc_hvl__inv_1
Xg_row_37.u_rowl_g89__7098 FE_OFN3_sel_en row1q[37] VSS VSS VDD VDD g_row[37].u_rowl_n_2 sky130_fd_sc_hvl__nand2_1
Xg_row_38.u_rowl_g81__6131 wlvb[38] g_row[38].u_rowl_n_5 VSS VSS VDD VDD wl0b[38] sky130_fd_sc_hvl__nand2_1
Xg_row_38.u_rowl_g82__1881 g_row[38].u_rowl_n_3 FE_OFN5_VER FE_OFN10_FE_DBTN0_READb VSS VSS VDD VDD wlvb[38] sky130_fd_sc_hvl__a21oi_1
Xg_row_38.u_rowl_g83__5115 g_row[38].u_rowl_n_3 FE_OFN9_n VSS VSS VDD VDD wsel[38] sky130_fd_sc_hvl__and2_1
Xg_row_38.u_rowl_g84__7482 g_row[38].u_rowl_n_3 FE_OFN6_SENSE VSS VSS VDD VDD sns[38] sky130_fd_sc_hvl__and2_1
Xg_row_38.u_rowl_g85 g_row[38].u_rowl_n_5 VSS VSS VDD VDD wlw[38] sky130_fd_sc_hvl__inv_1
Xg_row_38.u_rowl_g86__4733 g_row[38].u_rowl_n_2 FE_OFN7_WRANY VSS VSS VDD VDD wz[38] sky130_fd_sc_hvl__and2_1
Xg_row_38.u_rowl_g87__6161 g_row[38].u_rowl_n_3 PROG VSS VSS VDD VDD g_row[38].u_rowl_n_5 sky130_fd_sc_hvl__nand2_1
Xg_row_38.u_rowl_g88 g_row[38].u_rowl_n_2 VSS VSS VDD VDD g_row[38].u_rowl_n_3 sky130_fd_sc_hvl__inv_1
Xg_row_38.u_rowl_g89__9315 FE_OFN3_sel_en row1q[38] VSS VSS VDD VDD g_row[38].u_rowl_n_2 sky130_fd_sc_hvl__nand2_1
Xg_row_39.u_rowl_g81__9945 wlvb[39] g_row[39].u_rowl_n_5 VSS VSS VDD VDD wl0b[39] sky130_fd_sc_hvl__nand2_1
Xg_row_39.u_rowl_g82__2883 g_row[39].u_rowl_n_3 VER FE_OFN10_FE_DBTN0_READb VSS VSS VDD VDD wlvb[39] sky130_fd_sc_hvl__a21oi_1
Xg_row_39.u_rowl_g83__2346 g_row[39].u_rowl_n_3 FE_OFN7_WRANY VSS VSS VDD VDD wsel[39] sky130_fd_sc_hvl__and2_1
Xg_row_39.u_rowl_g84__1666 g_row[39].u_rowl_n_3 FE_OFN6_SENSE VSS VSS VDD VDD sns[39] sky130_fd_sc_hvl__and2_1
Xg_row_39.u_rowl_g85 g_row[39].u_rowl_n_5 VSS VSS VDD VDD wlw[39] sky130_fd_sc_hvl__inv_1
Xg_row_39.u_rowl_g86__7410 g_row[39].u_rowl_n_2 FE_OFN7_WRANY VSS VSS VDD VDD wz[39] sky130_fd_sc_hvl__and2_1
Xg_row_39.u_rowl_g87__6417 g_row[39].u_rowl_n_3 PROG VSS VSS VDD VDD g_row[39].u_rowl_n_5 sky130_fd_sc_hvl__nand2_1
Xg_row_39.u_rowl_g88 g_row[39].u_rowl_n_2 VSS VSS VDD VDD g_row[39].u_rowl_n_3 sky130_fd_sc_hvl__inv_1
Xg_row_39.u_rowl_g89__5477 sel_en row1q[39] VSS VSS VDD VDD g_row[39].u_rowl_n_2 sky130_fd_sc_hvl__nand2_1
Xg_row_40.u_rowl_g81__2398 wlvb[40] g_row[40].u_rowl_n_5 VSS VSS VDD VDD wl0b[40] sky130_fd_sc_hvl__nand2_1
Xg_row_40.u_rowl_g82__5107 g_row[40].u_rowl_n_3 VER FE_DBTN0_READb VSS VSS VDD VDD wlvb[40] sky130_fd_sc_hvl__a21oi_1
Xg_row_40.u_rowl_g83__6260 g_row[40].u_rowl_n_3 FE_OFN7_WRANY VSS VSS VDD VDD wsel[40] sky130_fd_sc_hvl__and2_1
Xg_row_40.u_rowl_g84__4319 g_row[40].u_rowl_n_3 SENSE VSS VSS VDD VDD sns[40] sky130_fd_sc_hvl__and2_1
Xg_row_40.u_rowl_g85 g_row[40].u_rowl_n_5 VSS VSS VDD VDD wlw[40] sky130_fd_sc_hvl__inv_1
Xg_row_40.u_rowl_g86__8428 g_row[40].u_rowl_n_2 WRANY VSS VSS VDD VDD wz[40] sky130_fd_sc_hvl__and2_1
Xg_row_40.u_rowl_g87__5526 g_row[40].u_rowl_n_3 PROG VSS VSS VDD VDD g_row[40].u_rowl_n_5 sky130_fd_sc_hvl__nand2_1
Xg_row_40.u_rowl_g88 g_row[40].u_rowl_n_2 VSS VSS VDD VDD g_row[40].u_rowl_n_3 sky130_fd_sc_hvl__inv_1
Xg_row_40.u_rowl_g89__6783 sel_en row1q[40] VSS VSS VDD VDD g_row[40].u_rowl_n_2 sky130_fd_sc_hvl__nand2_1
Xg_row_41.u_rowl_g81__3680 wlvb[41] g_row[41].u_rowl_n_5 VSS VSS VDD VDD wl0b[41] sky130_fd_sc_hvl__nand2_1
Xg_row_41.u_rowl_g82__1617 g_row[41].u_rowl_n_3 VER FE_DBTN0_READb VSS VSS VDD VDD wlvb[41] sky130_fd_sc_hvl__a21oi_1
Xg_row_41.u_rowl_g83__2802 g_row[41].u_rowl_n_3 WRANY VSS VSS VDD VDD wsel[41] sky130_fd_sc_hvl__and2_1
Xg_row_41.u_rowl_g84__1705 g_row[41].u_rowl_n_3 SENSE VSS VSS VDD VDD sns[41] sky130_fd_sc_hvl__and2_1
Xg_row_41.u_rowl_g85 g_row[41].u_rowl_n_5 VSS VSS VDD VDD wlw[41] sky130_fd_sc_hvl__inv_1
Xg_row_41.u_rowl_g86__5122 g_row[41].u_rowl_n_2 WRANY VSS VSS VDD VDD wz[41] sky130_fd_sc_hvl__and2_1
Xg_row_41.u_rowl_g87__8246 g_row[41].u_rowl_n_3 PROG VSS VSS VDD VDD g_row[41].u_rowl_n_5 sky130_fd_sc_hvl__nand2_1
Xg_row_41.u_rowl_g88 g_row[41].u_rowl_n_2 VSS VSS VDD VDD g_row[41].u_rowl_n_3 sky130_fd_sc_hvl__inv_1
Xg_row_41.u_rowl_g89__7098 sel_en row1q[41] VSS VSS VDD VDD g_row[41].u_rowl_n_2 sky130_fd_sc_hvl__nand2_1
Xg_row_42.u_rowl_g81__6131 wlvb[42] g_row[42].u_rowl_n_5 VSS VSS VDD VDD wl0b[42] sky130_fd_sc_hvl__nand2_1
Xg_row_42.u_rowl_g82__1881 g_row[42].u_rowl_n_3 FE_OFN5_VER FE_OFN10_FE_DBTN0_READb VSS VSS VDD VDD wlvb[42] sky130_fd_sc_hvl__a21oi_1
Xg_row_42.u_rowl_g83__5115 g_row[42].u_rowl_n_3 FE_OFN9_n VSS VSS VDD VDD wsel[42] sky130_fd_sc_hvl__and2_1
Xg_row_42.u_rowl_g84__7482 g_row[42].u_rowl_n_3 FE_OFN6_SENSE VSS VSS VDD VDD sns[42] sky130_fd_sc_hvl__and2_1
Xg_row_42.u_rowl_g85 g_row[42].u_rowl_n_5 VSS VSS VDD VDD wlw[42] sky130_fd_sc_hvl__inv_1
Xg_row_42.u_rowl_g86__4733 g_row[42].u_rowl_n_2 FE_OFN9_n VSS VSS VDD VDD wz[42] sky130_fd_sc_hvl__and2_1
Xg_row_42.u_rowl_g87__6161 g_row[42].u_rowl_n_3 FE_OFN4_PROG VSS VSS VDD VDD g_row[42].u_rowl_n_5 sky130_fd_sc_hvl__nand2_1
Xg_row_42.u_rowl_g88 g_row[42].u_rowl_n_2 VSS VSS VDD VDD g_row[42].u_rowl_n_3 sky130_fd_sc_hvl__inv_1
Xg_row_42.u_rowl_g89__9315 FE_OFN3_sel_en row1q[42] VSS VSS VDD VDD g_row[42].u_rowl_n_2 sky130_fd_sc_hvl__nand2_1
Xg_row_43.u_rowl_g81__9945 wlvb[43] g_row[43].u_rowl_n_5 VSS VSS VDD VDD wl0b[43] sky130_fd_sc_hvl__nand2_1
Xg_row_43.u_rowl_g82__2883 g_row[43].u_rowl_n_3 FE_OFN5_VER FE_OFN10_FE_DBTN0_READb VSS VSS VDD VDD wlvb[43] sky130_fd_sc_hvl__a21oi_1
Xg_row_43.u_rowl_g83__2346 g_row[43].u_rowl_n_3 FE_OFN9_n VSS VSS VDD VDD wsel[43] sky130_fd_sc_hvl__and2_1
Xg_row_43.u_rowl_g84__1666 g_row[43].u_rowl_n_3 FE_OFN6_SENSE VSS VSS VDD VDD sns[43] sky130_fd_sc_hvl__and2_1
Xg_row_43.u_rowl_g85 g_row[43].u_rowl_n_5 VSS VSS VDD VDD wlw[43] sky130_fd_sc_hvl__inv_1
Xg_row_43.u_rowl_g86__7410 g_row[43].u_rowl_n_2 FE_OFN9_n VSS VSS VDD VDD wz[43] sky130_fd_sc_hvl__and2_1
Xg_row_43.u_rowl_g87__6417 g_row[43].u_rowl_n_3 FE_OFN4_PROG VSS VSS VDD VDD g_row[43].u_rowl_n_5 sky130_fd_sc_hvl__nand2_1
Xg_row_43.u_rowl_g88 g_row[43].u_rowl_n_2 VSS VSS VDD VDD g_row[43].u_rowl_n_3 sky130_fd_sc_hvl__inv_1
Xg_row_43.u_rowl_g89__5477 FE_OFN3_sel_en row1q[43] VSS VSS VDD VDD g_row[43].u_rowl_n_2 sky130_fd_sc_hvl__nand2_1
Xg_row_44.u_rowl_g81__2398 wlvb[44] g_row[44].u_rowl_n_5 VSS VSS VDD VDD wl0b[44] sky130_fd_sc_hvl__nand2_1
Xg_row_44.u_rowl_g82__5107 g_row[44].u_rowl_n_3 FE_OFN5_VER FE_OFN10_FE_DBTN0_READb VSS VSS VDD VDD wlvb[44] sky130_fd_sc_hvl__a21oi_1
Xg_row_44.u_rowl_g83__6260 g_row[44].u_rowl_n_3 FE_OFN9_n VSS VSS VDD VDD wsel[44] sky130_fd_sc_hvl__and2_1
Xg_row_44.u_rowl_g84__4319 g_row[44].u_rowl_n_3 FE_OFN6_SENSE VSS VSS VDD VDD sns[44] sky130_fd_sc_hvl__and2_1
Xg_row_44.u_rowl_g85 g_row[44].u_rowl_n_5 VSS VSS VDD VDD wlw[44] sky130_fd_sc_hvl__inv_1
Xg_row_44.u_rowl_g86__8428 g_row[44].u_rowl_n_2 FE_OFN7_WRANY VSS VSS VDD VDD wz[44] sky130_fd_sc_hvl__and2_1
Xg_row_44.u_rowl_g87__5526 g_row[44].u_rowl_n_3 PROG VSS VSS VDD VDD g_row[44].u_rowl_n_5 sky130_fd_sc_hvl__nand2_1
Xg_row_44.u_rowl_g88 g_row[44].u_rowl_n_2 VSS VSS VDD VDD g_row[44].u_rowl_n_3 sky130_fd_sc_hvl__inv_1
Xg_row_44.u_rowl_g89__6783 FE_OFN3_sel_en row1q[44] VSS VSS VDD VDD g_row[44].u_rowl_n_2 sky130_fd_sc_hvl__nand2_1
Xg_row_45.u_rowl_g81__3680 wlvb[45] g_row[45].u_rowl_n_5 VSS VSS VDD VDD wl0b[45] sky130_fd_sc_hvl__nand2_1
Xg_row_45.u_rowl_g82__1617 g_row[45].u_rowl_n_3 VER FE_OFN10_FE_DBTN0_READb VSS VSS VDD VDD wlvb[45] sky130_fd_sc_hvl__a21oi_1
Xg_row_45.u_rowl_g83__2802 g_row[45].u_rowl_n_3 FE_OFN7_WRANY VSS VSS VDD VDD wsel[45] sky130_fd_sc_hvl__and2_1
Xg_row_45.u_rowl_g84__1705 g_row[45].u_rowl_n_3 FE_OFN6_SENSE VSS VSS VDD VDD sns[45] sky130_fd_sc_hvl__and2_1
Xg_row_45.u_rowl_g85 g_row[45].u_rowl_n_5 VSS VSS VDD VDD wlw[45] sky130_fd_sc_hvl__inv_1
Xg_row_45.u_rowl_g86__5122 g_row[45].u_rowl_n_2 FE_OFN7_WRANY VSS VSS VDD VDD wz[45] sky130_fd_sc_hvl__and2_1
Xg_row_45.u_rowl_g87__8246 g_row[45].u_rowl_n_3 PROG VSS VSS VDD VDD g_row[45].u_rowl_n_5 sky130_fd_sc_hvl__nand2_1
Xg_row_45.u_rowl_g88 g_row[45].u_rowl_n_2 VSS VSS VDD VDD g_row[45].u_rowl_n_3 sky130_fd_sc_hvl__inv_1
Xg_row_45.u_rowl_g89__7098 sel_en row1q[45] VSS VSS VDD VDD g_row[45].u_rowl_n_2 sky130_fd_sc_hvl__nand2_1
Xg_row_46.u_rowl_g81__6131 wlvb[46] g_row[46].u_rowl_n_5 VSS VSS VDD VDD wl0b[46] sky130_fd_sc_hvl__nand2_1
Xg_row_46.u_rowl_g82__1881 g_row[46].u_rowl_n_3 VER FE_DBTN0_READb VSS VSS VDD VDD wlvb[46] sky130_fd_sc_hvl__a21oi_1
Xg_row_46.u_rowl_g83__5115 g_row[46].u_rowl_n_3 FE_OFN7_WRANY VSS VSS VDD VDD wsel[46] sky130_fd_sc_hvl__and2_1
Xg_row_46.u_rowl_g84__7482 g_row[46].u_rowl_n_3 SENSE VSS VSS VDD VDD sns[46] sky130_fd_sc_hvl__and2_1
Xg_row_46.u_rowl_g85 g_row[46].u_rowl_n_5 VSS VSS VDD VDD wlw[46] sky130_fd_sc_hvl__inv_1
Xg_row_46.u_rowl_g86__4733 g_row[46].u_rowl_n_2 WRANY VSS VSS VDD VDD wz[46] sky130_fd_sc_hvl__and2_1
Xg_row_46.u_rowl_g87__6161 g_row[46].u_rowl_n_3 PROG VSS VSS VDD VDD g_row[46].u_rowl_n_5 sky130_fd_sc_hvl__nand2_1
Xg_row_46.u_rowl_g88 g_row[46].u_rowl_n_2 VSS VSS VDD VDD g_row[46].u_rowl_n_3 sky130_fd_sc_hvl__inv_1
Xg_row_46.u_rowl_g89__9315 sel_en row1q[46] VSS VSS VDD VDD g_row[46].u_rowl_n_2 sky130_fd_sc_hvl__nand2_1
Xg_row_47.u_rowl_g81__9945 wlvb[47] g_row[47].u_rowl_n_5 VSS VSS VDD VDD wl0b[47] sky130_fd_sc_hvl__nand2_1
Xg_row_47.u_rowl_g82__2883 g_row[47].u_rowl_n_3 VER FE_DBTN0_READb VSS VSS VDD VDD wlvb[47] sky130_fd_sc_hvl__a21oi_1
Xg_row_47.u_rowl_g83__2346 g_row[47].u_rowl_n_3 WRANY VSS VSS VDD VDD wsel[47] sky130_fd_sc_hvl__and2_1
Xg_row_47.u_rowl_g84__1666 g_row[47].u_rowl_n_3 SENSE VSS VSS VDD VDD sns[47] sky130_fd_sc_hvl__and2_1
Xg_row_47.u_rowl_g85 g_row[47].u_rowl_n_5 VSS VSS VDD VDD wlw[47] sky130_fd_sc_hvl__inv_1
Xg_row_47.u_rowl_g86__7410 g_row[47].u_rowl_n_2 WRANY VSS VSS VDD VDD wz[47] sky130_fd_sc_hvl__and2_1
Xg_row_47.u_rowl_g87__6417 g_row[47].u_rowl_n_3 PROG VSS VSS VDD VDD g_row[47].u_rowl_n_5 sky130_fd_sc_hvl__nand2_1
Xg_row_47.u_rowl_g88 g_row[47].u_rowl_n_2 VSS VSS VDD VDD g_row[47].u_rowl_n_3 sky130_fd_sc_hvl__inv_1
Xg_row_47.u_rowl_g89__5477 sel_en row1q[47] VSS VSS VDD VDD g_row[47].u_rowl_n_2 sky130_fd_sc_hvl__nand2_1
Xg_row_48.u_rowl_g81__2398 wlvb[48] g_row[48].u_rowl_n_5 VSS VSS VDD VDD wl0b[48] sky130_fd_sc_hvl__nand2_1
Xg_row_48.u_rowl_g82__5107 g_row[48].u_rowl_n_3 FE_OFN5_VER FE_OFN10_FE_DBTN0_READb VSS VSS VDD VDD wlvb[48] sky130_fd_sc_hvl__a21oi_1
Xg_row_48.u_rowl_g83__6260 g_row[48].u_rowl_n_3 FE_OFN9_n VSS VSS VDD VDD wsel[48] sky130_fd_sc_hvl__and2_1
Xg_row_48.u_rowl_g84__4319 g_row[48].u_rowl_n_3 FE_OFN6_SENSE VSS VSS VDD VDD sns[48] sky130_fd_sc_hvl__and2_1
Xg_row_48.u_rowl_g85 g_row[48].u_rowl_n_5 VSS VSS VDD VDD wlw[48] sky130_fd_sc_hvl__inv_1
Xg_row_48.u_rowl_g86__8428 g_row[48].u_rowl_n_2 FE_OFN9_n VSS VSS VDD VDD wz[48] sky130_fd_sc_hvl__and2_1
Xg_row_48.u_rowl_g87__5526 g_row[48].u_rowl_n_3 FE_OFN4_PROG VSS VSS VDD VDD g_row[48].u_rowl_n_5 sky130_fd_sc_hvl__nand2_1
Xg_row_48.u_rowl_g88 g_row[48].u_rowl_n_2 VSS VSS VDD VDD g_row[48].u_rowl_n_3 sky130_fd_sc_hvl__inv_1
Xg_row_48.u_rowl_g89__6783 FE_OFN3_sel_en row1q[48] VSS VSS VDD VDD g_row[48].u_rowl_n_2 sky130_fd_sc_hvl__nand2_1
Xg_row_49.u_rowl_g81__3680 wlvb[49] g_row[49].u_rowl_n_5 VSS VSS VDD VDD wl0b[49] sky130_fd_sc_hvl__nand2_1
Xg_row_49.u_rowl_g82__1617 g_row[49].u_rowl_n_3 FE_OFN5_VER FE_OFN10_FE_DBTN0_READb VSS VSS VDD VDD wlvb[49] sky130_fd_sc_hvl__a21oi_1
Xg_row_49.u_rowl_g83__2802 g_row[49].u_rowl_n_3 FE_OFN9_n VSS VSS VDD VDD wsel[49] sky130_fd_sc_hvl__and2_1
Xg_row_49.u_rowl_g84__1705 g_row[49].u_rowl_n_3 FE_OFN6_SENSE VSS VSS VDD VDD sns[49] sky130_fd_sc_hvl__and2_1
Xg_row_49.u_rowl_g85 g_row[49].u_rowl_n_5 VSS VSS VDD VDD wlw[49] sky130_fd_sc_hvl__inv_1
Xg_row_49.u_rowl_g86__5122 g_row[49].u_rowl_n_2 FE_OFN9_n VSS VSS VDD VDD wz[49] sky130_fd_sc_hvl__and2_1
Xg_row_49.u_rowl_g87__8246 g_row[49].u_rowl_n_3 FE_OFN4_PROG VSS VSS VDD VDD g_row[49].u_rowl_n_5 sky130_fd_sc_hvl__nand2_1
Xg_row_49.u_rowl_g88 g_row[49].u_rowl_n_2 VSS VSS VDD VDD g_row[49].u_rowl_n_3 sky130_fd_sc_hvl__inv_1
Xg_row_49.u_rowl_g89__7098 FE_OFN3_sel_en row1q[49] VSS VSS VDD VDD g_row[49].u_rowl_n_2 sky130_fd_sc_hvl__nand2_1
Xg_row_50.u_rowl_g81__6131 wlvb[50] g_row[50].u_rowl_n_5 VSS VSS VDD VDD wl0b[50] sky130_fd_sc_hvl__nand2_1
Xg_row_50.u_rowl_g82__1881 g_row[50].u_rowl_n_3 FE_OFN5_VER FE_OFN10_FE_DBTN0_READb VSS VSS VDD VDD wlvb[50] sky130_fd_sc_hvl__a21oi_1
Xg_row_50.u_rowl_g83__5115 g_row[50].u_rowl_n_3 FE_OFN9_n VSS VSS VDD VDD wsel[50] sky130_fd_sc_hvl__and2_1
Xg_row_50.u_rowl_g84__7482 g_row[50].u_rowl_n_3 FE_OFN6_SENSE VSS VSS VDD VDD sns[50] sky130_fd_sc_hvl__and2_1
Xg_row_50.u_rowl_g85 g_row[50].u_rowl_n_5 VSS VSS VDD VDD wlw[50] sky130_fd_sc_hvl__inv_1
Xg_row_50.u_rowl_g86__4733 g_row[50].u_rowl_n_2 FE_OFN7_WRANY VSS VSS VDD VDD wz[50] sky130_fd_sc_hvl__and2_1
Xg_row_50.u_rowl_g87__6161 g_row[50].u_rowl_n_3 PROG VSS VSS VDD VDD g_row[50].u_rowl_n_5 sky130_fd_sc_hvl__nand2_1
Xg_row_50.u_rowl_g88 g_row[50].u_rowl_n_2 VSS VSS VDD VDD g_row[50].u_rowl_n_3 sky130_fd_sc_hvl__inv_1
Xg_row_50.u_rowl_g89__9315 FE_OFN3_sel_en row1q[50] VSS VSS VDD VDD g_row[50].u_rowl_n_2 sky130_fd_sc_hvl__nand2_1
Xg_row_51.u_rowl_g81__9945 wlvb[51] g_row[51].u_rowl_n_5 VSS VSS VDD VDD wl0b[51] sky130_fd_sc_hvl__nand2_1
Xg_row_51.u_rowl_g82__2883 g_row[51].u_rowl_n_3 VER FE_OFN10_FE_DBTN0_READb VSS VSS VDD VDD wlvb[51] sky130_fd_sc_hvl__a21oi_1
Xg_row_51.u_rowl_g83__2346 g_row[51].u_rowl_n_3 FE_OFN7_WRANY VSS VSS VDD VDD wsel[51] sky130_fd_sc_hvl__and2_1
Xg_row_51.u_rowl_g84__1666 g_row[51].u_rowl_n_3 FE_OFN6_SENSE VSS VSS VDD VDD sns[51] sky130_fd_sc_hvl__and2_1
Xg_row_51.u_rowl_g85 g_row[51].u_rowl_n_5 VSS VSS VDD VDD wlw[51] sky130_fd_sc_hvl__inv_1
Xg_row_51.u_rowl_g86__7410 g_row[51].u_rowl_n_2 FE_OFN7_WRANY VSS VSS VDD VDD wz[51] sky130_fd_sc_hvl__and2_1
Xg_row_51.u_rowl_g87__6417 g_row[51].u_rowl_n_3 PROG VSS VSS VDD VDD g_row[51].u_rowl_n_5 sky130_fd_sc_hvl__nand2_1
Xg_row_51.u_rowl_g88 g_row[51].u_rowl_n_2 VSS VSS VDD VDD g_row[51].u_rowl_n_3 sky130_fd_sc_hvl__inv_1
Xg_row_51.u_rowl_g89__5477 sel_en row1q[51] VSS VSS VDD VDD g_row[51].u_rowl_n_2 sky130_fd_sc_hvl__nand2_1
Xg_row_52.u_rowl_g81__2398 wlvb[52] g_row[52].u_rowl_n_5 VSS VSS VDD VDD wl0b[52] sky130_fd_sc_hvl__nand2_1
Xg_row_52.u_rowl_g82__5107 g_row[52].u_rowl_n_3 VER FE_DBTN0_READb VSS VSS VDD VDD wlvb[52] sky130_fd_sc_hvl__a21oi_1
Xg_row_52.u_rowl_g83__6260 g_row[52].u_rowl_n_3 FE_OFN7_WRANY VSS VSS VDD VDD wsel[52] sky130_fd_sc_hvl__and2_1
Xg_row_52.u_rowl_g84__4319 g_row[52].u_rowl_n_3 SENSE VSS VSS VDD VDD sns[52] sky130_fd_sc_hvl__and2_1
Xg_row_52.u_rowl_g85 g_row[52].u_rowl_n_5 VSS VSS VDD VDD wlw[52] sky130_fd_sc_hvl__inv_1
Xg_row_52.u_rowl_g86__8428 g_row[52].u_rowl_n_2 WRANY VSS VSS VDD VDD wz[52] sky130_fd_sc_hvl__and2_1
Xg_row_52.u_rowl_g87__5526 g_row[52].u_rowl_n_3 PROG VSS VSS VDD VDD g_row[52].u_rowl_n_5 sky130_fd_sc_hvl__nand2_1
Xg_row_52.u_rowl_g88 g_row[52].u_rowl_n_2 VSS VSS VDD VDD g_row[52].u_rowl_n_3 sky130_fd_sc_hvl__inv_1
Xg_row_52.u_rowl_g89__6783 sel_en row1q[52] VSS VSS VDD VDD g_row[52].u_rowl_n_2 sky130_fd_sc_hvl__nand2_1
Xg_row_53.u_rowl_g81__3680 wlvb[53] g_row[53].u_rowl_n_5 VSS VSS VDD VDD wl0b[53] sky130_fd_sc_hvl__nand2_1
Xg_row_53.u_rowl_g82__1617 g_row[53].u_rowl_n_3 VER FE_DBTN0_READb VSS VSS VDD VDD wlvb[53] sky130_fd_sc_hvl__a21oi_1
Xg_row_53.u_rowl_g83__2802 g_row[53].u_rowl_n_3 WRANY VSS VSS VDD VDD wsel[53] sky130_fd_sc_hvl__and2_1
Xg_row_53.u_rowl_g84__1705 g_row[53].u_rowl_n_3 SENSE VSS VSS VDD VDD sns[53] sky130_fd_sc_hvl__and2_1
Xg_row_53.u_rowl_g85 g_row[53].u_rowl_n_5 VSS VSS VDD VDD wlw[53] sky130_fd_sc_hvl__inv_1
Xg_row_53.u_rowl_g86__5122 g_row[53].u_rowl_n_2 WRANY VSS VSS VDD VDD wz[53] sky130_fd_sc_hvl__and2_1
Xg_row_53.u_rowl_g87__8246 g_row[53].u_rowl_n_3 PROG VSS VSS VDD VDD g_row[53].u_rowl_n_5 sky130_fd_sc_hvl__nand2_1
Xg_row_53.u_rowl_g88 g_row[53].u_rowl_n_2 VSS VSS VDD VDD g_row[53].u_rowl_n_3 sky130_fd_sc_hvl__inv_1
Xg_row_53.u_rowl_g89__7098 sel_en row1q[53] VSS VSS VDD VDD g_row[53].u_rowl_n_2 sky130_fd_sc_hvl__nand2_1
Xg_row_54.u_rowl_g81__6131 wlvb[54] g_row[54].u_rowl_n_5 VSS VSS VDD VDD wl0b[54] sky130_fd_sc_hvl__nand2_1
Xg_row_54.u_rowl_g82__1881 g_row[54].u_rowl_n_3 FE_OFN5_VER FE_OFN10_FE_DBTN0_READb VSS VSS VDD VDD wlvb[54] sky130_fd_sc_hvl__a21oi_1
Xg_row_54.u_rowl_g83__5115 g_row[54].u_rowl_n_3 FE_OFN9_n VSS VSS VDD VDD wsel[54] sky130_fd_sc_hvl__and2_1
Xg_row_54.u_rowl_g84__7482 g_row[54].u_rowl_n_3 FE_OFN6_SENSE VSS VSS VDD VDD sns[54] sky130_fd_sc_hvl__and2_1
Xg_row_54.u_rowl_g85 g_row[54].u_rowl_n_5 VSS VSS VDD VDD wlw[54] sky130_fd_sc_hvl__inv_1
Xg_row_54.u_rowl_g86__4733 g_row[54].u_rowl_n_2 FE_OFN9_n VSS VSS VDD VDD wz[54] sky130_fd_sc_hvl__and2_1
Xg_row_54.u_rowl_g87__6161 g_row[54].u_rowl_n_3 FE_OFN4_PROG VSS VSS VDD VDD g_row[54].u_rowl_n_5 sky130_fd_sc_hvl__nand2_1
Xg_row_54.u_rowl_g88 g_row[54].u_rowl_n_2 VSS VSS VDD VDD g_row[54].u_rowl_n_3 sky130_fd_sc_hvl__inv_1
Xg_row_54.u_rowl_g89__9315 FE_OFN3_sel_en row1q[54] VSS VSS VDD VDD g_row[54].u_rowl_n_2 sky130_fd_sc_hvl__nand2_1
Xg_row_55.u_rowl_g81__9945 wlvb[55] g_row[55].u_rowl_n_5 VSS VSS VDD VDD wl0b[55] sky130_fd_sc_hvl__nand2_1
Xg_row_55.u_rowl_g82__2883 g_row[55].u_rowl_n_3 FE_OFN5_VER FE_OFN10_FE_DBTN0_READb VSS VSS VDD VDD wlvb[55] sky130_fd_sc_hvl__a21oi_1
Xg_row_55.u_rowl_g83__2346 g_row[55].u_rowl_n_3 FE_OFN9_n VSS VSS VDD VDD wsel[55] sky130_fd_sc_hvl__and2_1
Xg_row_55.u_rowl_g84__1666 g_row[55].u_rowl_n_3 FE_OFN6_SENSE VSS VSS VDD VDD sns[55] sky130_fd_sc_hvl__and2_1
Xg_row_55.u_rowl_g85 g_row[55].u_rowl_n_5 VSS VSS VDD VDD wlw[55] sky130_fd_sc_hvl__inv_1
Xg_row_55.u_rowl_g86__7410 g_row[55].u_rowl_n_2 FE_OFN9_n VSS VSS VDD VDD wz[55] sky130_fd_sc_hvl__and2_1
Xg_row_55.u_rowl_g87__6417 g_row[55].u_rowl_n_3 FE_OFN4_PROG VSS VSS VDD VDD g_row[55].u_rowl_n_5 sky130_fd_sc_hvl__nand2_1
Xg_row_55.u_rowl_g88 g_row[55].u_rowl_n_2 VSS VSS VDD VDD g_row[55].u_rowl_n_3 sky130_fd_sc_hvl__inv_1
Xg_row_55.u_rowl_g89__5477 FE_OFN3_sel_en row1q[55] VSS VSS VDD VDD g_row[55].u_rowl_n_2 sky130_fd_sc_hvl__nand2_1
Xg_row_56.u_rowl_g81__2398 wlvb[56] g_row[56].u_rowl_n_5 VSS VSS VDD VDD wl0b[56] sky130_fd_sc_hvl__nand2_1
Xg_row_56.u_rowl_g82__5107 g_row[56].u_rowl_n_3 VER FE_OFN10_FE_DBTN0_READb VSS VSS VDD VDD wlvb[56] sky130_fd_sc_hvl__a21oi_1
Xg_row_56.u_rowl_g83__6260 g_row[56].u_rowl_n_3 FE_OFN7_WRANY VSS VSS VDD VDD wsel[56] sky130_fd_sc_hvl__and2_1
Xg_row_56.u_rowl_g84__4319 g_row[56].u_rowl_n_3 FE_OFN6_SENSE VSS VSS VDD VDD sns[56] sky130_fd_sc_hvl__and2_1
Xg_row_56.u_rowl_g85 g_row[56].u_rowl_n_5 VSS VSS VDD VDD wlw[56] sky130_fd_sc_hvl__inv_1
Xg_row_56.u_rowl_g86__8428 g_row[56].u_rowl_n_2 FE_OFN7_WRANY VSS VSS VDD VDD wz[56] sky130_fd_sc_hvl__and2_1
Xg_row_56.u_rowl_g87__5526 g_row[56].u_rowl_n_3 FE_OFN4_PROG VSS VSS VDD VDD g_row[56].u_rowl_n_5 sky130_fd_sc_hvl__nand2_1
Xg_row_56.u_rowl_g88 g_row[56].u_rowl_n_2 VSS VSS VDD VDD g_row[56].u_rowl_n_3 sky130_fd_sc_hvl__inv_1
Xg_row_56.u_rowl_g89__6783 FE_OFN3_sel_en row1q[56] VSS VSS VDD VDD g_row[56].u_rowl_n_2 sky130_fd_sc_hvl__nand2_1
Xg_row_57.u_rowl_g81__3680 wlvb[57] g_row[57].u_rowl_n_5 VSS VSS VDD VDD wl0b[57] sky130_fd_sc_hvl__nand2_1
Xg_row_57.u_rowl_g82__1617 g_row[57].u_rowl_n_3 VER FE_OFN10_FE_DBTN0_READb VSS VSS VDD VDD wlvb[57] sky130_fd_sc_hvl__a21oi_1
Xg_row_57.u_rowl_g83__2802 g_row[57].u_rowl_n_3 FE_OFN7_WRANY VSS VSS VDD VDD wsel[57] sky130_fd_sc_hvl__and2_1
Xg_row_57.u_rowl_g84__1705 g_row[57].u_rowl_n_3 FE_OFN6_SENSE VSS VSS VDD VDD sns[57] sky130_fd_sc_hvl__and2_1
Xg_row_57.u_rowl_g85 g_row[57].u_rowl_n_5 VSS VSS VDD VDD wlw[57] sky130_fd_sc_hvl__inv_1
Xg_row_57.u_rowl_g86__5122 g_row[57].u_rowl_n_2 FE_OFN7_WRANY VSS VSS VDD VDD wz[57] sky130_fd_sc_hvl__and2_1
Xg_row_57.u_rowl_g87__8246 g_row[57].u_rowl_n_3 PROG VSS VSS VDD VDD g_row[57].u_rowl_n_5 sky130_fd_sc_hvl__nand2_1
Xg_row_57.u_rowl_g88 g_row[57].u_rowl_n_2 VSS VSS VDD VDD g_row[57].u_rowl_n_3 sky130_fd_sc_hvl__inv_1
Xg_row_57.u_rowl_g89__7098 sel_en row1q[57] VSS VSS VDD VDD g_row[57].u_rowl_n_2 sky130_fd_sc_hvl__nand2_1
Xg_row_58.u_rowl_g81__6131 wlvb[58] g_row[58].u_rowl_n_5 VSS VSS VDD VDD wl0b[58] sky130_fd_sc_hvl__nand2_1
Xg_row_58.u_rowl_g82__1881 g_row[58].u_rowl_n_3 VER FE_DBTN0_READb VSS VSS VDD VDD wlvb[58] sky130_fd_sc_hvl__a21oi_1
Xg_row_58.u_rowl_g83__5115 g_row[58].u_rowl_n_3 FE_OFN7_WRANY VSS VSS VDD VDD wsel[58] sky130_fd_sc_hvl__and2_1
Xg_row_58.u_rowl_g84__7482 g_row[58].u_rowl_n_3 SENSE VSS VSS VDD VDD sns[58] sky130_fd_sc_hvl__and2_1
Xg_row_58.u_rowl_g85 g_row[58].u_rowl_n_5 VSS VSS VDD VDD wlw[58] sky130_fd_sc_hvl__inv_1
Xg_row_58.u_rowl_g86__4733 g_row[58].u_rowl_n_2 WRANY VSS VSS VDD VDD wz[58] sky130_fd_sc_hvl__and2_1
Xg_row_58.u_rowl_g87__6161 g_row[58].u_rowl_n_3 PROG VSS VSS VDD VDD g_row[58].u_rowl_n_5 sky130_fd_sc_hvl__nand2_1
Xg_row_58.u_rowl_g88 g_row[58].u_rowl_n_2 VSS VSS VDD VDD g_row[58].u_rowl_n_3 sky130_fd_sc_hvl__inv_1
Xg_row_58.u_rowl_g89__9315 sel_en row1q[58] VSS VSS VDD VDD g_row[58].u_rowl_n_2 sky130_fd_sc_hvl__nand2_1
Xg_row_59.u_rowl_g81__9945 wlvb[59] g_row[59].u_rowl_n_5 VSS VSS VDD VDD wl0b[59] sky130_fd_sc_hvl__nand2_1
Xg_row_59.u_rowl_g82__2883 g_row[59].u_rowl_n_3 VER FE_DBTN0_READb VSS VSS VDD VDD wlvb[59] sky130_fd_sc_hvl__a21oi_1
Xg_row_59.u_rowl_g83__2346 g_row[59].u_rowl_n_3 WRANY VSS VSS VDD VDD wsel[59] sky130_fd_sc_hvl__and2_1
Xg_row_59.u_rowl_g84__1666 g_row[59].u_rowl_n_3 SENSE VSS VSS VDD VDD sns[59] sky130_fd_sc_hvl__and2_1
Xg_row_59.u_rowl_g85 g_row[59].u_rowl_n_5 VSS VSS VDD VDD wlw[59] sky130_fd_sc_hvl__inv_1
Xg_row_59.u_rowl_g86__7410 g_row[59].u_rowl_n_2 WRANY VSS VSS VDD VDD wz[59] sky130_fd_sc_hvl__and2_1
Xg_row_59.u_rowl_g87__6417 g_row[59].u_rowl_n_3 PROG VSS VSS VDD VDD g_row[59].u_rowl_n_5 sky130_fd_sc_hvl__nand2_1
Xg_row_59.u_rowl_g88 g_row[59].u_rowl_n_2 VSS VSS VDD VDD g_row[59].u_rowl_n_3 sky130_fd_sc_hvl__inv_1
Xg_row_59.u_rowl_g89__5477 sel_en row1q[59] VSS VSS VDD VDD g_row[59].u_rowl_n_2 sky130_fd_sc_hvl__nand2_1
Xg_row_60.u_rowl_g81__2398 wlvb[60] g_row[60].u_rowl_n_5 VSS VSS VDD VDD wl0b[60] sky130_fd_sc_hvl__nand2_1
Xg_row_60.u_rowl_g82__5107 g_row[60].u_rowl_n_3 FE_OFN5_VER FE_OFN10_FE_DBTN0_READb VSS VSS VDD VDD wlvb[60] sky130_fd_sc_hvl__a21oi_1
Xg_row_60.u_rowl_g83__6260 g_row[60].u_rowl_n_3 FE_OFN9_n VSS VSS VDD VDD wsel[60] sky130_fd_sc_hvl__and2_1
Xg_row_60.u_rowl_g84__4319 g_row[60].u_rowl_n_3 FE_OFN6_SENSE VSS VSS VDD VDD sns[60] sky130_fd_sc_hvl__and2_1
Xg_row_60.u_rowl_g85 g_row[60].u_rowl_n_5 VSS VSS VDD VDD wlw[60] sky130_fd_sc_hvl__inv_1
Xg_row_60.u_rowl_g86__8428 g_row[60].u_rowl_n_2 FE_OFN9_n VSS VSS VDD VDD wz[60] sky130_fd_sc_hvl__and2_1
Xg_row_60.u_rowl_g87__5526 g_row[60].u_rowl_n_3 FE_OFN4_PROG VSS VSS VDD VDD g_row[60].u_rowl_n_5 sky130_fd_sc_hvl__nand2_1
Xg_row_60.u_rowl_g88 g_row[60].u_rowl_n_2 VSS VSS VDD VDD g_row[60].u_rowl_n_3 sky130_fd_sc_hvl__inv_1
Xg_row_60.u_rowl_g89__6783 FE_OFN3_sel_en row1q[60] VSS VSS VDD VDD g_row[60].u_rowl_n_2 sky130_fd_sc_hvl__nand2_1
Xg_row_61.u_rowl_g81__3680 wlvb[61] g_row[61].u_rowl_n_5 VSS VSS VDD VDD wl0b[61] sky130_fd_sc_hvl__nand2_1
Xg_row_61.u_rowl_g82__1617 g_row[61].u_rowl_n_3 FE_OFN5_VER FE_OFN10_FE_DBTN0_READb VSS VSS VDD VDD wlvb[61] sky130_fd_sc_hvl__a21oi_1
Xg_row_61.u_rowl_g83__2802 g_row[61].u_rowl_n_3 FE_OFN7_WRANY VSS VSS VDD VDD wsel[61] sky130_fd_sc_hvl__and2_1
Xg_row_61.u_rowl_g84__1705 g_row[61].u_rowl_n_3 FE_OFN6_SENSE VSS VSS VDD VDD sns[61] sky130_fd_sc_hvl__and2_1
Xg_row_61.u_rowl_g85 g_row[61].u_rowl_n_5 VSS VSS VDD VDD wlw[61] sky130_fd_sc_hvl__inv_1
Xg_row_61.u_rowl_g86__5122 g_row[61].u_rowl_n_2 FE_OFN7_WRANY VSS VSS VDD VDD wz[61] sky130_fd_sc_hvl__and2_1
Xg_row_61.u_rowl_g87__8246 g_row[61].u_rowl_n_3 FE_OFN4_PROG VSS VSS VDD VDD g_row[61].u_rowl_n_5 sky130_fd_sc_hvl__nand2_1
Xg_row_61.u_rowl_g88 g_row[61].u_rowl_n_2 VSS VSS VDD VDD g_row[61].u_rowl_n_3 sky130_fd_sc_hvl__inv_1
Xg_row_61.u_rowl_g89__7098 FE_OFN3_sel_en row1q[61] VSS VSS VDD VDD g_row[61].u_rowl_n_2 sky130_fd_sc_hvl__nand2_1
Xg_row_62.u_rowl_g81__6131 wlvb[62] g_row[62].u_rowl_n_5 VSS VSS VDD VDD wl0b[62] sky130_fd_sc_hvl__nand2_1
Xg_row_62.u_rowl_g82__1881 g_row[62].u_rowl_n_3 VER FE_OFN10_FE_DBTN0_READb VSS VSS VDD VDD wlvb[62] sky130_fd_sc_hvl__a21oi_1
Xg_row_62.u_rowl_g83__5115 g_row[62].u_rowl_n_3 FE_OFN7_WRANY VSS VSS VDD VDD wsel[62] sky130_fd_sc_hvl__and2_1
Xg_row_62.u_rowl_g84__7482 g_row[62].u_rowl_n_3 FE_OFN6_SENSE VSS VSS VDD VDD sns[62] sky130_fd_sc_hvl__and2_1
Xg_row_62.u_rowl_g85 g_row[62].u_rowl_n_5 VSS VSS VDD VDD wlw[62] sky130_fd_sc_hvl__inv_1
Xg_row_62.u_rowl_g86__4733 g_row[62].u_rowl_n_2 FE_OFN7_WRANY VSS VSS VDD VDD wz[62] sky130_fd_sc_hvl__and2_1
Xg_row_62.u_rowl_g87__6161 g_row[62].u_rowl_n_3 FE_OFN4_PROG VSS VSS VDD VDD g_row[62].u_rowl_n_5 sky130_fd_sc_hvl__nand2_1
Xg_row_62.u_rowl_g88 g_row[62].u_rowl_n_2 VSS VSS VDD VDD g_row[62].u_rowl_n_3 sky130_fd_sc_hvl__inv_1
Xg_row_62.u_rowl_g89__9315 FE_OFN3_sel_en row1q[62] VSS VSS VDD VDD g_row[62].u_rowl_n_2 sky130_fd_sc_hvl__nand2_1
Xg_row_63.u_rowl_g81__9945 wlvb[63] g_row[63].u_rowl_n_5 VSS VSS VDD VDD wl0b[63] sky130_fd_sc_hvl__nand2_1
Xg_row_63.u_rowl_g82__2883 g_row[63].u_rowl_n_3 VER FE_OFN10_FE_DBTN0_READb VSS VSS VDD VDD wlvb[63] sky130_fd_sc_hvl__a21oi_1
Xg_row_63.u_rowl_g83__2346 g_row[63].u_rowl_n_3 FE_OFN7_WRANY VSS VSS VDD VDD wsel[63] sky130_fd_sc_hvl__and2_1
Xg_row_63.u_rowl_g84__1666 g_row[63].u_rowl_n_3 SENSE VSS VSS VDD VDD sns[63] sky130_fd_sc_hvl__and2_1
Xg_row_63.u_rowl_g85 g_row[63].u_rowl_n_5 VSS VSS VDD VDD wlw[63] sky130_fd_sc_hvl__inv_1
Xg_row_63.u_rowl_g86__7410 g_row[63].u_rowl_n_2 FE_OFN7_WRANY VSS VSS VDD VDD wz[63] sky130_fd_sc_hvl__and2_1
Xg_row_63.u_rowl_g87__6417 g_row[63].u_rowl_n_3 PROG VSS VSS VDD VDD g_row[63].u_rowl_n_5 sky130_fd_sc_hvl__nand2_1
Xg_row_63.u_rowl_g88 g_row[63].u_rowl_n_2 VSS VSS VDD VDD g_row[63].u_rowl_n_3 sky130_fd_sc_hvl__inv_1
Xg_row_63.u_rowl_g89__5477 FE_OFN3_sel_en row1q[63] VSS VSS VDD VDD g_row[63].u_rowl_n_2 sky130_fd_sc_hvl__nand2_1
Xg_row_64.u_rowl_g81__2398 wlvb[64] g_row[64].u_rowl_n_5 VSS VSS VDD VDD wl0b[64] sky130_fd_sc_hvl__nand2_1
Xg_row_64.u_rowl_g82__5107 g_row[64].u_rowl_n_3 VER FE_DBTN0_READb VSS VSS VDD VDD wlvb[64] sky130_fd_sc_hvl__a21oi_1
Xg_row_64.u_rowl_g83__6260 g_row[64].u_rowl_n_3 FE_OFN7_WRANY VSS VSS VDD VDD wsel[64] sky130_fd_sc_hvl__and2_1
Xg_row_64.u_rowl_g84__4319 g_row[64].u_rowl_n_3 SENSE VSS VSS VDD VDD sns[64] sky130_fd_sc_hvl__and2_1
Xg_row_64.u_rowl_g85 g_row[64].u_rowl_n_5 VSS VSS VDD VDD wlw[64] sky130_fd_sc_hvl__inv_1
Xg_row_64.u_rowl_g86__8428 g_row[64].u_rowl_n_2 WRANY VSS VSS VDD VDD wz[64] sky130_fd_sc_hvl__and2_1
Xg_row_64.u_rowl_g87__5526 g_row[64].u_rowl_n_3 PROG VSS VSS VDD VDD g_row[64].u_rowl_n_5 sky130_fd_sc_hvl__nand2_1
Xg_row_64.u_rowl_g88 g_row[64].u_rowl_n_2 VSS VSS VDD VDD g_row[64].u_rowl_n_3 sky130_fd_sc_hvl__inv_1
Xg_row_64.u_rowl_g89__6783 sel_en row1q[64] VSS VSS VDD VDD g_row[64].u_rowl_n_2 sky130_fd_sc_hvl__nand2_1
Xg_row_65.u_rowl_g81__3680 wlvb[65] g_row[65].u_rowl_n_5 VSS VSS VDD VDD wl0b[65] sky130_fd_sc_hvl__nand2_1
Xg_row_65.u_rowl_g82__1617 g_row[65].u_rowl_n_3 VER FE_DBTN0_READb VSS VSS VDD VDD wlvb[65] sky130_fd_sc_hvl__a21oi_1
Xg_row_65.u_rowl_g83__2802 g_row[65].u_rowl_n_3 WRANY VSS VSS VDD VDD wsel[65] sky130_fd_sc_hvl__and2_1
Xg_row_65.u_rowl_g84__1705 g_row[65].u_rowl_n_3 SENSE VSS VSS VDD VDD sns[65] sky130_fd_sc_hvl__and2_1
Xg_row_65.u_rowl_g85 g_row[65].u_rowl_n_5 VSS VSS VDD VDD wlw[65] sky130_fd_sc_hvl__inv_1
Xg_row_65.u_rowl_g86__5122 g_row[65].u_rowl_n_2 WRANY VSS VSS VDD VDD wz[65] sky130_fd_sc_hvl__and2_1
Xg_row_65.u_rowl_g87__8246 g_row[65].u_rowl_n_3 PROG VSS VSS VDD VDD g_row[65].u_rowl_n_5 sky130_fd_sc_hvl__nand2_1
Xg_row_65.u_rowl_g88 g_row[65].u_rowl_n_2 VSS VSS VDD VDD g_row[65].u_rowl_n_3 sky130_fd_sc_hvl__inv_1
Xg_row_65.u_rowl_g89__7098 sel_en row1q[65] VSS VSS VDD VDD g_row[65].u_rowl_n_2 sky130_fd_sc_hvl__nand2_1
Xg_row_66.u_rowl_g81__6131 wlvb[66] g_row[66].u_rowl_n_5 VSS VSS VDD VDD wl0b[66] sky130_fd_sc_hvl__nand2_1
Xg_row_66.u_rowl_g82__1881 g_row[66].u_rowl_n_3 FE_OFN5_VER FE_OFN10_FE_DBTN0_READb VSS VSS VDD VDD wlvb[66] sky130_fd_sc_hvl__a21oi_1
Xg_row_66.u_rowl_g83__5115 g_row[66].u_rowl_n_3 FE_OFN9_n VSS VSS VDD VDD wsel[66] sky130_fd_sc_hvl__and2_1
Xg_row_66.u_rowl_g84__7482 g_row[66].u_rowl_n_3 FE_OFN6_SENSE VSS VSS VDD VDD sns[66] sky130_fd_sc_hvl__and2_1
Xg_row_66.u_rowl_g85 g_row[66].u_rowl_n_5 VSS VSS VDD VDD wlw[66] sky130_fd_sc_hvl__inv_1
Xg_row_66.u_rowl_g86__4733 g_row[66].u_rowl_n_2 FE_OFN9_n VSS VSS VDD VDD wz[66] sky130_fd_sc_hvl__and2_1
Xg_row_66.u_rowl_g87__6161 g_row[66].u_rowl_n_3 FE_OFN4_PROG VSS VSS VDD VDD g_row[66].u_rowl_n_5 sky130_fd_sc_hvl__nand2_1
Xg_row_66.u_rowl_g88 g_row[66].u_rowl_n_2 VSS VSS VDD VDD g_row[66].u_rowl_n_3 sky130_fd_sc_hvl__inv_1
Xg_row_66.u_rowl_g89__9315 FE_OFN3_sel_en row1q[66] VSS VSS VDD VDD g_row[66].u_rowl_n_2 sky130_fd_sc_hvl__nand2_1
Xg_row_67.u_rowl_g81__9945 wlvb[67] g_row[67].u_rowl_n_5 VSS VSS VDD VDD wl0b[67] sky130_fd_sc_hvl__nand2_1
Xg_row_67.u_rowl_g82__2883 g_row[67].u_rowl_n_3 FE_OFN5_VER FE_OFN10_FE_DBTN0_READb VSS VSS VDD VDD wlvb[67] sky130_fd_sc_hvl__a21oi_1
Xg_row_67.u_rowl_g83__2346 g_row[67].u_rowl_n_3 FE_OFN7_WRANY VSS VSS VDD VDD wsel[67] sky130_fd_sc_hvl__and2_1
Xg_row_67.u_rowl_g84__1666 g_row[67].u_rowl_n_3 FE_OFN6_SENSE VSS VSS VDD VDD sns[67] sky130_fd_sc_hvl__and2_1
Xg_row_67.u_rowl_g85 g_row[67].u_rowl_n_5 VSS VSS VDD VDD wlw[67] sky130_fd_sc_hvl__inv_1
Xg_row_67.u_rowl_g86__7410 g_row[67].u_rowl_n_2 FE_OFN7_WRANY VSS VSS VDD VDD wz[67] sky130_fd_sc_hvl__and2_1
Xg_row_67.u_rowl_g87__6417 g_row[67].u_rowl_n_3 FE_OFN4_PROG VSS VSS VDD VDD g_row[67].u_rowl_n_5 sky130_fd_sc_hvl__nand2_1
Xg_row_67.u_rowl_g88 g_row[67].u_rowl_n_2 VSS VSS VDD VDD g_row[67].u_rowl_n_3 sky130_fd_sc_hvl__inv_1
Xg_row_67.u_rowl_g89__5477 FE_OFN3_sel_en row1q[67] VSS VSS VDD VDD g_row[67].u_rowl_n_2 sky130_fd_sc_hvl__nand2_1
Xg_row_68.u_rowl_g81__2398 wlvb[68] g_row[68].u_rowl_n_5 VSS VSS VDD VDD wl0b[68] sky130_fd_sc_hvl__nand2_1
Xg_row_68.u_rowl_g82__5107 g_row[68].u_rowl_n_3 VER FE_OFN10_FE_DBTN0_READb VSS VSS VDD VDD wlvb[68] sky130_fd_sc_hvl__a21oi_1
Xg_row_68.u_rowl_g83__6260 g_row[68].u_rowl_n_3 FE_OFN7_WRANY VSS VSS VDD VDD wsel[68] sky130_fd_sc_hvl__and2_1
Xg_row_68.u_rowl_g84__4319 g_row[68].u_rowl_n_3 FE_OFN6_SENSE VSS VSS VDD VDD sns[68] sky130_fd_sc_hvl__and2_1
Xg_row_68.u_rowl_g85 g_row[68].u_rowl_n_5 VSS VSS VDD VDD wlw[68] sky130_fd_sc_hvl__inv_1
Xg_row_68.u_rowl_g86__8428 g_row[68].u_rowl_n_2 FE_OFN7_WRANY VSS VSS VDD VDD wz[68] sky130_fd_sc_hvl__and2_1
Xg_row_68.u_rowl_g87__5526 g_row[68].u_rowl_n_3 FE_OFN4_PROG VSS VSS VDD VDD g_row[68].u_rowl_n_5 sky130_fd_sc_hvl__nand2_1
Xg_row_68.u_rowl_g88 g_row[68].u_rowl_n_2 VSS VSS VDD VDD g_row[68].u_rowl_n_3 sky130_fd_sc_hvl__inv_1
Xg_row_68.u_rowl_g89__6783 FE_OFN3_sel_en row1q[68] VSS VSS VDD VDD g_row[68].u_rowl_n_2 sky130_fd_sc_hvl__nand2_1
Xg_row_69.u_rowl_g81__3680 wlvb[69] g_row[69].u_rowl_n_5 VSS VSS VDD VDD wl0b[69] sky130_fd_sc_hvl__nand2_1
Xg_row_69.u_rowl_g82__1617 g_row[69].u_rowl_n_3 VER FE_OFN10_FE_DBTN0_READb VSS VSS VDD VDD wlvb[69] sky130_fd_sc_hvl__a21oi_1
Xg_row_69.u_rowl_g83__2802 g_row[69].u_rowl_n_3 WRANY VSS VSS VDD VDD wsel[69] sky130_fd_sc_hvl__and2_1
Xg_row_69.u_rowl_g84__1705 g_row[69].u_rowl_n_3 SENSE VSS VSS VDD VDD sns[69] sky130_fd_sc_hvl__and2_1
Xg_row_69.u_rowl_g85 g_row[69].u_rowl_n_5 VSS VSS VDD VDD wlw[69] sky130_fd_sc_hvl__inv_1
Xg_row_69.u_rowl_g86__5122 g_row[69].u_rowl_n_2 WRANY VSS VSS VDD VDD wz[69] sky130_fd_sc_hvl__and2_1
Xg_row_69.u_rowl_g87__8246 g_row[69].u_rowl_n_3 PROG VSS VSS VDD VDD g_row[69].u_rowl_n_5 sky130_fd_sc_hvl__nand2_1
Xg_row_69.u_rowl_g88 g_row[69].u_rowl_n_2 VSS VSS VDD VDD g_row[69].u_rowl_n_3 sky130_fd_sc_hvl__inv_1
Xg_row_69.u_rowl_g89__7098 sel_en row1q[69] VSS VSS VDD VDD g_row[69].u_rowl_n_2 sky130_fd_sc_hvl__nand2_1
Xg_row_70.u_rowl_g81__6131 wlvb[70] g_row[70].u_rowl_n_5 VSS VSS VDD VDD wl0b[70] sky130_fd_sc_hvl__nand2_1
Xg_row_70.u_rowl_g82__1881 g_row[70].u_rowl_n_3 VER FE_DBTN0_READb VSS VSS VDD VDD wlvb[70] sky130_fd_sc_hvl__a21oi_1
Xg_row_70.u_rowl_g83__5115 g_row[70].u_rowl_n_3 WRANY VSS VSS VDD VDD wsel[70] sky130_fd_sc_hvl__and2_1
Xg_row_70.u_rowl_g84__7482 g_row[70].u_rowl_n_3 SENSE VSS VSS VDD VDD sns[70] sky130_fd_sc_hvl__and2_1
Xg_row_70.u_rowl_g85 g_row[70].u_rowl_n_5 VSS VSS VDD VDD wlw[70] sky130_fd_sc_hvl__inv_1
Xg_row_70.u_rowl_g86__4733 g_row[70].u_rowl_n_2 WRANY VSS VSS VDD VDD wz[70] sky130_fd_sc_hvl__and2_1
Xg_row_70.u_rowl_g87__6161 g_row[70].u_rowl_n_3 PROG VSS VSS VDD VDD g_row[70].u_rowl_n_5 sky130_fd_sc_hvl__nand2_1
Xg_row_70.u_rowl_g88 g_row[70].u_rowl_n_2 VSS VSS VDD VDD g_row[70].u_rowl_n_3 sky130_fd_sc_hvl__inv_1
Xg_row_70.u_rowl_g89__9315 sel_en row1q[70] VSS VSS VDD VDD g_row[70].u_rowl_n_2 sky130_fd_sc_hvl__nand2_1
Xg_row_71.u_rowl_g81__9945 wlvb[71] g_row[71].u_rowl_n_5 VSS VSS VDD VDD wl0b[71] sky130_fd_sc_hvl__nand2_1
Xg_row_71.u_rowl_g82__2883 g_row[71].u_rowl_n_3 VER FE_DBTN0_READb VSS VSS VDD VDD wlvb[71] sky130_fd_sc_hvl__a21oi_1
Xg_row_71.u_rowl_g83__2346 g_row[71].u_rowl_n_3 WRANY VSS VSS VDD VDD wsel[71] sky130_fd_sc_hvl__and2_1
Xg_row_71.u_rowl_g84__1666 g_row[71].u_rowl_n_3 SENSE VSS VSS VDD VDD sns[71] sky130_fd_sc_hvl__and2_1
Xg_row_71.u_rowl_g85 g_row[71].u_rowl_n_5 VSS VSS VDD VDD wlw[71] sky130_fd_sc_hvl__inv_1
Xg_row_71.u_rowl_g86__7410 g_row[71].u_rowl_n_2 WRANY VSS VSS VDD VDD wz[71] sky130_fd_sc_hvl__and2_1
Xg_row_71.u_rowl_g87__6417 g_row[71].u_rowl_n_3 PROG VSS VSS VDD VDD g_row[71].u_rowl_n_5 sky130_fd_sc_hvl__nand2_1
Xg_row_71.u_rowl_g88 g_row[71].u_rowl_n_2 VSS VSS VDD VDD g_row[71].u_rowl_n_3 sky130_fd_sc_hvl__inv_1
Xg_row_71.u_rowl_g89__5477 sel_en row1q[71] VSS VSS VDD VDD g_row[71].u_rowl_n_2 sky130_fd_sc_hvl__nand2_1
Xg_row_72.u_rowl_g81__2398 wlvb[72] g_row[72].u_rowl_n_5 VSS VSS VDD VDD wl0b[72] sky130_fd_sc_hvl__nand2_1
Xg_row_72.u_rowl_g82__5107 g_row[72].u_rowl_n_3 FE_OFN5_VER FE_OFN10_FE_DBTN0_READb VSS VSS VDD VDD wlvb[72] sky130_fd_sc_hvl__a21oi_1
Xg_row_72.u_rowl_g83__6260 g_row[72].u_rowl_n_3 FE_OFN9_n VSS VSS VDD VDD wsel[72] sky130_fd_sc_hvl__and2_1
Xg_row_72.u_rowl_g84__4319 g_row[72].u_rowl_n_3 FE_OFN6_SENSE VSS VSS VDD VDD sns[72] sky130_fd_sc_hvl__and2_1
Xg_row_72.u_rowl_g85 g_row[72].u_rowl_n_5 VSS VSS VDD VDD wlw[72] sky130_fd_sc_hvl__inv_1
Xg_row_72.u_rowl_g86__8428 g_row[72].u_rowl_n_2 FE_OFN9_n VSS VSS VDD VDD wz[72] sky130_fd_sc_hvl__and2_1
Xg_row_72.u_rowl_g87__5526 g_row[72].u_rowl_n_3 FE_OFN4_PROG VSS VSS VDD VDD g_row[72].u_rowl_n_5 sky130_fd_sc_hvl__nand2_1
Xg_row_72.u_rowl_g88 g_row[72].u_rowl_n_2 VSS VSS VDD VDD g_row[72].u_rowl_n_3 sky130_fd_sc_hvl__inv_1
Xg_row_72.u_rowl_g89__6783 FE_OFN3_sel_en row1q[72] VSS VSS VDD VDD g_row[72].u_rowl_n_2 sky130_fd_sc_hvl__nand2_1
Xg_row_73.u_rowl_g81__3680 wlvb[73] g_row[73].u_rowl_n_5 VSS VSS VDD VDD wl0b[73] sky130_fd_sc_hvl__nand2_1
Xg_row_73.u_rowl_g82__1617 g_row[73].u_rowl_n_3 FE_OFN5_VER FE_OFN10_FE_DBTN0_READb VSS VSS VDD VDD wlvb[73] sky130_fd_sc_hvl__a21oi_1
Xg_row_73.u_rowl_g83__2802 g_row[73].u_rowl_n_3 FE_OFN7_WRANY VSS VSS VDD VDD wsel[73] sky130_fd_sc_hvl__and2_1
Xg_row_73.u_rowl_g84__1705 g_row[73].u_rowl_n_3 FE_OFN6_SENSE VSS VSS VDD VDD sns[73] sky130_fd_sc_hvl__and2_1
Xg_row_73.u_rowl_g85 g_row[73].u_rowl_n_5 VSS VSS VDD VDD wlw[73] sky130_fd_sc_hvl__inv_1
Xg_row_73.u_rowl_g86__5122 g_row[73].u_rowl_n_2 FE_OFN7_WRANY VSS VSS VDD VDD wz[73] sky130_fd_sc_hvl__and2_1
Xg_row_73.u_rowl_g87__8246 g_row[73].u_rowl_n_3 FE_OFN4_PROG VSS VSS VDD VDD g_row[73].u_rowl_n_5 sky130_fd_sc_hvl__nand2_1
Xg_row_73.u_rowl_g88 g_row[73].u_rowl_n_2 VSS VSS VDD VDD g_row[73].u_rowl_n_3 sky130_fd_sc_hvl__inv_1
Xg_row_73.u_rowl_g89__7098 FE_OFN3_sel_en row1q[73] VSS VSS VDD VDD g_row[73].u_rowl_n_2 sky130_fd_sc_hvl__nand2_1
Xg_row_74.u_rowl_g81__6131 wlvb[74] g_row[74].u_rowl_n_5 VSS VSS VDD VDD wl0b[74] sky130_fd_sc_hvl__nand2_1
Xg_row_74.u_rowl_g82__1881 g_row[74].u_rowl_n_3 VER FE_OFN10_FE_DBTN0_READb VSS VSS VDD VDD wlvb[74] sky130_fd_sc_hvl__a21oi_1
Xg_row_74.u_rowl_g83__5115 g_row[74].u_rowl_n_3 FE_OFN7_WRANY VSS VSS VDD VDD wsel[74] sky130_fd_sc_hvl__and2_1
Xg_row_74.u_rowl_g84__7482 g_row[74].u_rowl_n_3 FE_OFN6_SENSE VSS VSS VDD VDD sns[74] sky130_fd_sc_hvl__and2_1
Xg_row_74.u_rowl_g85 g_row[74].u_rowl_n_5 VSS VSS VDD VDD wlw[74] sky130_fd_sc_hvl__inv_1
Xg_row_74.u_rowl_g86__4733 g_row[74].u_rowl_n_2 FE_OFN7_WRANY VSS VSS VDD VDD wz[74] sky130_fd_sc_hvl__and2_1
Xg_row_74.u_rowl_g87__6161 g_row[74].u_rowl_n_3 FE_OFN4_PROG VSS VSS VDD VDD g_row[74].u_rowl_n_5 sky130_fd_sc_hvl__nand2_1
Xg_row_74.u_rowl_g88 g_row[74].u_rowl_n_2 VSS VSS VDD VDD g_row[74].u_rowl_n_3 sky130_fd_sc_hvl__inv_1
Xg_row_74.u_rowl_g89__9315 FE_OFN3_sel_en row1q[74] VSS VSS VDD VDD g_row[74].u_rowl_n_2 sky130_fd_sc_hvl__nand2_1
Xg_row_75.u_rowl_g81__9945 wlvb[75] g_row[75].u_rowl_n_5 VSS VSS VDD VDD wl0b[75] sky130_fd_sc_hvl__nand2_1
Xg_row_75.u_rowl_g82__2883 g_row[75].u_rowl_n_3 VER FE_OFN10_FE_DBTN0_READb VSS VSS VDD VDD wlvb[75] sky130_fd_sc_hvl__a21oi_1
Xg_row_75.u_rowl_g83__2346 g_row[75].u_rowl_n_3 WRANY VSS VSS VDD VDD wsel[75] sky130_fd_sc_hvl__and2_1
Xg_row_75.u_rowl_g84__1666 g_row[75].u_rowl_n_3 SENSE VSS VSS VDD VDD sns[75] sky130_fd_sc_hvl__and2_1
Xg_row_75.u_rowl_g85 g_row[75].u_rowl_n_5 VSS VSS VDD VDD wlw[75] sky130_fd_sc_hvl__inv_1
Xg_row_75.u_rowl_g86__7410 g_row[75].u_rowl_n_2 WRANY VSS VSS VDD VDD wz[75] sky130_fd_sc_hvl__and2_1
Xg_row_75.u_rowl_g87__6417 g_row[75].u_rowl_n_3 PROG VSS VSS VDD VDD g_row[75].u_rowl_n_5 sky130_fd_sc_hvl__nand2_1
Xg_row_75.u_rowl_g88 g_row[75].u_rowl_n_2 VSS VSS VDD VDD g_row[75].u_rowl_n_3 sky130_fd_sc_hvl__inv_1
Xg_row_75.u_rowl_g89__5477 FE_OFN3_sel_en row1q[75] VSS VSS VDD VDD g_row[75].u_rowl_n_2 sky130_fd_sc_hvl__nand2_1
Xg_row_76.u_rowl_g81__2398 wlvb[76] g_row[76].u_rowl_n_5 VSS VSS VDD VDD wl0b[76] sky130_fd_sc_hvl__nand2_1
Xg_row_76.u_rowl_g82__5107 g_row[76].u_rowl_n_3 VER FE_DBTN0_READb VSS VSS VDD VDD wlvb[76] sky130_fd_sc_hvl__a21oi_1
Xg_row_76.u_rowl_g83__6260 g_row[76].u_rowl_n_3 WRANY VSS VSS VDD VDD wsel[76] sky130_fd_sc_hvl__and2_1
Xg_row_76.u_rowl_g84__4319 g_row[76].u_rowl_n_3 SENSE VSS VSS VDD VDD sns[76] sky130_fd_sc_hvl__and2_1
Xg_row_76.u_rowl_g85 g_row[76].u_rowl_n_5 VSS VSS VDD VDD wlw[76] sky130_fd_sc_hvl__inv_1
Xg_row_76.u_rowl_g86__8428 g_row[76].u_rowl_n_2 WRANY VSS VSS VDD VDD wz[76] sky130_fd_sc_hvl__and2_1
Xg_row_76.u_rowl_g87__5526 g_row[76].u_rowl_n_3 PROG VSS VSS VDD VDD g_row[76].u_rowl_n_5 sky130_fd_sc_hvl__nand2_1
Xg_row_76.u_rowl_g88 g_row[76].u_rowl_n_2 VSS VSS VDD VDD g_row[76].u_rowl_n_3 sky130_fd_sc_hvl__inv_1
Xg_row_76.u_rowl_g89__6783 sel_en row1q[76] VSS VSS VDD VDD g_row[76].u_rowl_n_2 sky130_fd_sc_hvl__nand2_1
Xg_row_77.u_rowl_g81__3680 wlvb[77] g_row[77].u_rowl_n_5 VSS VSS VDD VDD wl0b[77] sky130_fd_sc_hvl__nand2_1
Xg_row_77.u_rowl_g82__1617 g_row[77].u_rowl_n_3 VER FE_DBTN0_READb VSS VSS VDD VDD wlvb[77] sky130_fd_sc_hvl__a21oi_1
Xg_row_77.u_rowl_g83__2802 g_row[77].u_rowl_n_3 WRANY VSS VSS VDD VDD wsel[77] sky130_fd_sc_hvl__and2_1
Xg_row_77.u_rowl_g84__1705 g_row[77].u_rowl_n_3 SENSE VSS VSS VDD VDD sns[77] sky130_fd_sc_hvl__and2_1
Xg_row_77.u_rowl_g85 g_row[77].u_rowl_n_5 VSS VSS VDD VDD wlw[77] sky130_fd_sc_hvl__inv_1
Xg_row_77.u_rowl_g86__5122 g_row[77].u_rowl_n_2 WRANY VSS VSS VDD VDD wz[77] sky130_fd_sc_hvl__and2_1
Xg_row_77.u_rowl_g87__8246 g_row[77].u_rowl_n_3 PROG VSS VSS VDD VDD g_row[77].u_rowl_n_5 sky130_fd_sc_hvl__nand2_1
Xg_row_77.u_rowl_g88 g_row[77].u_rowl_n_2 VSS VSS VDD VDD g_row[77].u_rowl_n_3 sky130_fd_sc_hvl__inv_1
Xg_row_77.u_rowl_g89__7098 sel_en row1q[77] VSS VSS VDD VDD g_row[77].u_rowl_n_2 sky130_fd_sc_hvl__nand2_1
Xg_row_78.u_rowl_g81__6131 wlvb[78] g_row[78].u_rowl_n_5 VSS VSS VDD VDD wl0b[78] sky130_fd_sc_hvl__nand2_1
Xg_row_78.u_rowl_g82__1881 g_row[78].u_rowl_n_3 FE_OFN5_VER FE_OFN10_FE_DBTN0_READb VSS VSS VDD VDD wlvb[78] sky130_fd_sc_hvl__a21oi_1
Xg_row_78.u_rowl_g83__5115 g_row[78].u_rowl_n_3 FE_OFN9_n VSS VSS VDD VDD wsel[78] sky130_fd_sc_hvl__and2_1
Xg_row_78.u_rowl_g84__7482 g_row[78].u_rowl_n_3 FE_OFN6_SENSE VSS VSS VDD VDD sns[78] sky130_fd_sc_hvl__and2_1
Xg_row_78.u_rowl_g85 g_row[78].u_rowl_n_5 VSS VSS VDD VDD wlw[78] sky130_fd_sc_hvl__inv_1
Xg_row_78.u_rowl_g86__4733 g_row[78].u_rowl_n_2 FE_OFN9_n VSS VSS VDD VDD wz[78] sky130_fd_sc_hvl__and2_1
Xg_row_78.u_rowl_g87__6161 g_row[78].u_rowl_n_3 FE_OFN4_PROG VSS VSS VDD VDD g_row[78].u_rowl_n_5 sky130_fd_sc_hvl__nand2_1
Xg_row_78.u_rowl_g88 g_row[78].u_rowl_n_2 VSS VSS VDD VDD g_row[78].u_rowl_n_3 sky130_fd_sc_hvl__inv_1
Xg_row_78.u_rowl_g89__9315 FE_OFN3_sel_en row1q[78] VSS VSS VDD VDD g_row[78].u_rowl_n_2 sky130_fd_sc_hvl__nand2_1
Xg_row_79.u_rowl_g81__9945 wlvb[79] g_row[79].u_rowl_n_5 VSS VSS VDD VDD wl0b[79] sky130_fd_sc_hvl__nand2_1
Xg_row_79.u_rowl_g82__2883 g_row[79].u_rowl_n_3 FE_OFN5_VER FE_OFN10_FE_DBTN0_READb VSS VSS VDD VDD wlvb[79] sky130_fd_sc_hvl__a21oi_1
Xg_row_79.u_rowl_g83__2346 g_row[79].u_rowl_n_3 FE_OFN7_WRANY VSS VSS VDD VDD wsel[79] sky130_fd_sc_hvl__and2_1
Xg_row_79.u_rowl_g84__1666 g_row[79].u_rowl_n_3 FE_OFN6_SENSE VSS VSS VDD VDD sns[79] sky130_fd_sc_hvl__and2_1
Xg_row_79.u_rowl_g85 g_row[79].u_rowl_n_5 VSS VSS VDD VDD wlw[79] sky130_fd_sc_hvl__inv_1
Xg_row_79.u_rowl_g86__7410 g_row[79].u_rowl_n_2 FE_OFN7_WRANY VSS VSS VDD VDD wz[79] sky130_fd_sc_hvl__and2_1
Xg_row_79.u_rowl_g87__6417 g_row[79].u_rowl_n_3 FE_OFN4_PROG VSS VSS VDD VDD g_row[79].u_rowl_n_5 sky130_fd_sc_hvl__nand2_1
Xg_row_79.u_rowl_g88 g_row[79].u_rowl_n_2 VSS VSS VDD VDD g_row[79].u_rowl_n_3 sky130_fd_sc_hvl__inv_1
Xg_row_79.u_rowl_g89__5477 FE_OFN3_sel_en row1q[79] VSS VSS VDD VDD g_row[79].u_rowl_n_2 sky130_fd_sc_hvl__nand2_1
Xg_row_80.u_rowl_g81__2398 wlvb[80] g_row[80].u_rowl_n_5 VSS VSS VDD VDD wl0b[80] sky130_fd_sc_hvl__nand2_1
Xg_row_80.u_rowl_g82__5107 g_row[80].u_rowl_n_3 VER FE_OFN10_FE_DBTN0_READb VSS VSS VDD VDD wlvb[80] sky130_fd_sc_hvl__a21oi_1
Xg_row_80.u_rowl_g83__6260 g_row[80].u_rowl_n_3 FE_OFN7_WRANY VSS VSS VDD VDD wsel[80] sky130_fd_sc_hvl__and2_1
Xg_row_80.u_rowl_g84__4319 g_row[80].u_rowl_n_3 FE_OFN6_SENSE VSS VSS VDD VDD sns[80] sky130_fd_sc_hvl__and2_1
Xg_row_80.u_rowl_g85 g_row[80].u_rowl_n_5 VSS VSS VDD VDD wlw[80] sky130_fd_sc_hvl__inv_1
Xg_row_80.u_rowl_g86__8428 g_row[80].u_rowl_n_2 FE_OFN7_WRANY VSS VSS VDD VDD wz[80] sky130_fd_sc_hvl__and2_1
Xg_row_80.u_rowl_g87__5526 g_row[80].u_rowl_n_3 FE_OFN4_PROG VSS VSS VDD VDD g_row[80].u_rowl_n_5 sky130_fd_sc_hvl__nand2_1
Xg_row_80.u_rowl_g88 g_row[80].u_rowl_n_2 VSS VSS VDD VDD g_row[80].u_rowl_n_3 sky130_fd_sc_hvl__inv_1
Xg_row_80.u_rowl_g89__6783 FE_OFN3_sel_en row1q[80] VSS VSS VDD VDD g_row[80].u_rowl_n_2 sky130_fd_sc_hvl__nand2_1
Xg_row_81.u_rowl_g81__3680 wlvb[81] g_row[81].u_rowl_n_5 VSS VSS VDD VDD wl0b[81] sky130_fd_sc_hvl__nand2_1
Xg_row_81.u_rowl_g82__1617 g_row[81].u_rowl_n_3 VER FE_OFN10_FE_DBTN0_READb VSS VSS VDD VDD wlvb[81] sky130_fd_sc_hvl__a21oi_1
Xg_row_81.u_rowl_g83__2802 g_row[81].u_rowl_n_3 WRANY VSS VSS VDD VDD wsel[81] sky130_fd_sc_hvl__and2_1
Xg_row_81.u_rowl_g84__1705 g_row[81].u_rowl_n_3 SENSE VSS VSS VDD VDD sns[81] sky130_fd_sc_hvl__and2_1
Xg_row_81.u_rowl_g85 g_row[81].u_rowl_n_5 VSS VSS VDD VDD wlw[81] sky130_fd_sc_hvl__inv_1
Xg_row_81.u_rowl_g86__5122 g_row[81].u_rowl_n_2 WRANY VSS VSS VDD VDD wz[81] sky130_fd_sc_hvl__and2_1
Xg_row_81.u_rowl_g87__8246 g_row[81].u_rowl_n_3 PROG VSS VSS VDD VDD g_row[81].u_rowl_n_5 sky130_fd_sc_hvl__nand2_1
Xg_row_81.u_rowl_g88 g_row[81].u_rowl_n_2 VSS VSS VDD VDD g_row[81].u_rowl_n_3 sky130_fd_sc_hvl__inv_1
Xg_row_81.u_rowl_g89__7098 FE_OFN3_sel_en row1q[81] VSS VSS VDD VDD g_row[81].u_rowl_n_2 sky130_fd_sc_hvl__nand2_1
Xg_row_82.u_rowl_g81__6131 wlvb[82] g_row[82].u_rowl_n_5 VSS VSS VDD VDD wl0b[82] sky130_fd_sc_hvl__nand2_1
Xg_row_82.u_rowl_g82__1881 g_row[82].u_rowl_n_3 VER FE_DBTN0_READb VSS VSS VDD VDD wlvb[82] sky130_fd_sc_hvl__a21oi_1
Xg_row_82.u_rowl_g83__5115 g_row[82].u_rowl_n_3 WRANY VSS VSS VDD VDD wsel[82] sky130_fd_sc_hvl__and2_1
Xg_row_82.u_rowl_g84__7482 g_row[82].u_rowl_n_3 SENSE VSS VSS VDD VDD sns[82] sky130_fd_sc_hvl__and2_1
Xg_row_82.u_rowl_g85 g_row[82].u_rowl_n_5 VSS VSS VDD VDD wlw[82] sky130_fd_sc_hvl__inv_1
Xg_row_82.u_rowl_g86__4733 g_row[82].u_rowl_n_2 WRANY VSS VSS VDD VDD wz[82] sky130_fd_sc_hvl__and2_1
Xg_row_82.u_rowl_g87__6161 g_row[82].u_rowl_n_3 PROG VSS VSS VDD VDD g_row[82].u_rowl_n_5 sky130_fd_sc_hvl__nand2_1
Xg_row_82.u_rowl_g88 g_row[82].u_rowl_n_2 VSS VSS VDD VDD g_row[82].u_rowl_n_3 sky130_fd_sc_hvl__inv_1
Xg_row_82.u_rowl_g89__9315 sel_en row1q[82] VSS VSS VDD VDD g_row[82].u_rowl_n_2 sky130_fd_sc_hvl__nand2_1
Xg_row_83.u_rowl_g81__9945 wlvb[83] g_row[83].u_rowl_n_5 VSS VSS VDD VDD wl0b[83] sky130_fd_sc_hvl__nand2_1
Xg_row_83.u_rowl_g82__2883 g_row[83].u_rowl_n_3 VER FE_DBTN0_READb VSS VSS VDD VDD wlvb[83] sky130_fd_sc_hvl__a21oi_1
Xg_row_83.u_rowl_g83__2346 g_row[83].u_rowl_n_3 WRANY VSS VSS VDD VDD wsel[83] sky130_fd_sc_hvl__and2_1
Xg_row_83.u_rowl_g84__1666 g_row[83].u_rowl_n_3 SENSE VSS VSS VDD VDD sns[83] sky130_fd_sc_hvl__and2_1
Xg_row_83.u_rowl_g85 g_row[83].u_rowl_n_5 VSS VSS VDD VDD wlw[83] sky130_fd_sc_hvl__inv_1
Xg_row_83.u_rowl_g86__7410 g_row[83].u_rowl_n_2 WRANY VSS VSS VDD VDD wz[83] sky130_fd_sc_hvl__and2_1
Xg_row_83.u_rowl_g87__6417 g_row[83].u_rowl_n_3 PROG VSS VSS VDD VDD g_row[83].u_rowl_n_5 sky130_fd_sc_hvl__nand2_1
Xg_row_83.u_rowl_g88 g_row[83].u_rowl_n_2 VSS VSS VDD VDD g_row[83].u_rowl_n_3 sky130_fd_sc_hvl__inv_1
Xg_row_83.u_rowl_g89__5477 sel_en row1q[83] VSS VSS VDD VDD g_row[83].u_rowl_n_2 sky130_fd_sc_hvl__nand2_1
Xg_row_84.u_rowl_g81__2398 wlvb[84] g_row[84].u_rowl_n_5 VSS VSS VDD VDD wl0b[84] sky130_fd_sc_hvl__nand2_1
Xg_row_84.u_rowl_g82__5107 g_row[84].u_rowl_n_3 FE_OFN5_VER FE_OFN10_FE_DBTN0_READb VSS VSS VDD VDD wlvb[84] sky130_fd_sc_hvl__a21oi_1
Xg_row_84.u_rowl_g83__6260 g_row[84].u_rowl_n_3 FE_OFN9_n VSS VSS VDD VDD wsel[84] sky130_fd_sc_hvl__and2_1
Xg_row_84.u_rowl_g84__4319 g_row[84].u_rowl_n_3 FE_OFN6_SENSE VSS VSS VDD VDD sns[84] sky130_fd_sc_hvl__and2_1
Xg_row_84.u_rowl_g85 g_row[84].u_rowl_n_5 VSS VSS VDD VDD wlw[84] sky130_fd_sc_hvl__inv_1
Xg_row_84.u_rowl_g86__8428 g_row[84].u_rowl_n_2 FE_OFN9_n VSS VSS VDD VDD wz[84] sky130_fd_sc_hvl__and2_1
Xg_row_84.u_rowl_g87__5526 g_row[84].u_rowl_n_3 FE_OFN4_PROG VSS VSS VDD VDD g_row[84].u_rowl_n_5 sky130_fd_sc_hvl__nand2_1
Xg_row_84.u_rowl_g88 g_row[84].u_rowl_n_2 VSS VSS VDD VDD g_row[84].u_rowl_n_3 sky130_fd_sc_hvl__inv_1
Xg_row_84.u_rowl_g89__6783 FE_OFN3_sel_en row1q[84] VSS VSS VDD VDD g_row[84].u_rowl_n_2 sky130_fd_sc_hvl__nand2_1
Xg_row_85.u_rowl_g81__3680 wlvb[85] g_row[85].u_rowl_n_5 VSS VSS VDD VDD wl0b[85] sky130_fd_sc_hvl__nand2_1
Xg_row_85.u_rowl_g82__1617 g_row[85].u_rowl_n_3 FE_OFN5_VER FE_OFN10_FE_DBTN0_READb VSS VSS VDD VDD wlvb[85] sky130_fd_sc_hvl__a21oi_1
Xg_row_85.u_rowl_g83__2802 g_row[85].u_rowl_n_3 FE_OFN7_WRANY VSS VSS VDD VDD wsel[85] sky130_fd_sc_hvl__and2_1
Xg_row_85.u_rowl_g84__1705 g_row[85].u_rowl_n_3 FE_OFN6_SENSE VSS VSS VDD VDD sns[85] sky130_fd_sc_hvl__and2_1
Xg_row_85.u_rowl_g85 g_row[85].u_rowl_n_5 VSS VSS VDD VDD wlw[85] sky130_fd_sc_hvl__inv_1
Xg_row_85.u_rowl_g86__5122 g_row[85].u_rowl_n_2 FE_OFN7_WRANY VSS VSS VDD VDD wz[85] sky130_fd_sc_hvl__and2_1
Xg_row_85.u_rowl_g87__8246 g_row[85].u_rowl_n_3 FE_OFN4_PROG VSS VSS VDD VDD g_row[85].u_rowl_n_5 sky130_fd_sc_hvl__nand2_1
Xg_row_85.u_rowl_g88 g_row[85].u_rowl_n_2 VSS VSS VDD VDD g_row[85].u_rowl_n_3 sky130_fd_sc_hvl__inv_1
Xg_row_85.u_rowl_g89__7098 FE_OFN3_sel_en row1q[85] VSS VSS VDD VDD g_row[85].u_rowl_n_2 sky130_fd_sc_hvl__nand2_1
Xg_row_86.u_rowl_g81__6131 wlvb[86] g_row[86].u_rowl_n_5 VSS VSS VDD VDD wl0b[86] sky130_fd_sc_hvl__nand2_1
Xg_row_86.u_rowl_g82__1881 g_row[86].u_rowl_n_3 VER FE_OFN10_FE_DBTN0_READb VSS VSS VDD VDD wlvb[86] sky130_fd_sc_hvl__a21oi_1
Xg_row_86.u_rowl_g83__5115 g_row[86].u_rowl_n_3 FE_OFN7_WRANY VSS VSS VDD VDD wsel[86] sky130_fd_sc_hvl__and2_1
Xg_row_86.u_rowl_g84__7482 g_row[86].u_rowl_n_3 FE_OFN6_SENSE VSS VSS VDD VDD sns[86] sky130_fd_sc_hvl__and2_1
Xg_row_86.u_rowl_g85 g_row[86].u_rowl_n_5 VSS VSS VDD VDD wlw[86] sky130_fd_sc_hvl__inv_1
Xg_row_86.u_rowl_g86__4733 g_row[86].u_rowl_n_2 FE_OFN7_WRANY VSS VSS VDD VDD wz[86] sky130_fd_sc_hvl__and2_1
Xg_row_86.u_rowl_g87__6161 g_row[86].u_rowl_n_3 FE_OFN4_PROG VSS VSS VDD VDD g_row[86].u_rowl_n_5 sky130_fd_sc_hvl__nand2_1
Xg_row_86.u_rowl_g88 g_row[86].u_rowl_n_2 VSS VSS VDD VDD g_row[86].u_rowl_n_3 sky130_fd_sc_hvl__inv_1
Xg_row_86.u_rowl_g89__9315 FE_OFN3_sel_en row1q[86] VSS VSS VDD VDD g_row[86].u_rowl_n_2 sky130_fd_sc_hvl__nand2_1
Xg_row_87.u_rowl_g81__9945 wlvb[87] g_row[87].u_rowl_n_5 VSS VSS VDD VDD wl0b[87] sky130_fd_sc_hvl__nand2_1
Xg_row_87.u_rowl_g82__2883 g_row[87].u_rowl_n_3 VER FE_OFN10_FE_DBTN0_READb VSS VSS VDD VDD wlvb[87] sky130_fd_sc_hvl__a21oi_1
Xg_row_87.u_rowl_g83__2346 g_row[87].u_rowl_n_3 WRANY VSS VSS VDD VDD wsel[87] sky130_fd_sc_hvl__and2_1
Xg_row_87.u_rowl_g84__1666 g_row[87].u_rowl_n_3 SENSE VSS VSS VDD VDD sns[87] sky130_fd_sc_hvl__and2_1
Xg_row_87.u_rowl_g85 g_row[87].u_rowl_n_5 VSS VSS VDD VDD wlw[87] sky130_fd_sc_hvl__inv_1
Xg_row_87.u_rowl_g86__7410 g_row[87].u_rowl_n_2 WRANY VSS VSS VDD VDD wz[87] sky130_fd_sc_hvl__and2_1
Xg_row_87.u_rowl_g87__6417 g_row[87].u_rowl_n_3 PROG VSS VSS VDD VDD g_row[87].u_rowl_n_5 sky130_fd_sc_hvl__nand2_1
Xg_row_87.u_rowl_g88 g_row[87].u_rowl_n_2 VSS VSS VDD VDD g_row[87].u_rowl_n_3 sky130_fd_sc_hvl__inv_1
Xg_row_87.u_rowl_g89__5477 FE_OFN3_sel_en row1q[87] VSS VSS VDD VDD g_row[87].u_rowl_n_2 sky130_fd_sc_hvl__nand2_1
Xg_row_88.u_rowl_g81__2398 wlvb[88] g_row[88].u_rowl_n_5 VSS VSS VDD VDD wl0b[88] sky130_fd_sc_hvl__nand2_1
Xg_row_88.u_rowl_g82__5107 g_row[88].u_rowl_n_3 VER FE_DBTN0_READb VSS VSS VDD VDD wlvb[88] sky130_fd_sc_hvl__a21oi_1
Xg_row_88.u_rowl_g83__6260 g_row[88].u_rowl_n_3 WRANY VSS VSS VDD VDD wsel[88] sky130_fd_sc_hvl__and2_1
Xg_row_88.u_rowl_g84__4319 g_row[88].u_rowl_n_3 SENSE VSS VSS VDD VDD sns[88] sky130_fd_sc_hvl__and2_1
Xg_row_88.u_rowl_g85 g_row[88].u_rowl_n_5 VSS VSS VDD VDD wlw[88] sky130_fd_sc_hvl__inv_1
Xg_row_88.u_rowl_g86__8428 g_row[88].u_rowl_n_2 WRANY VSS VSS VDD VDD wz[88] sky130_fd_sc_hvl__and2_1
Xg_row_88.u_rowl_g87__5526 g_row[88].u_rowl_n_3 PROG VSS VSS VDD VDD g_row[88].u_rowl_n_5 sky130_fd_sc_hvl__nand2_1
Xg_row_88.u_rowl_g88 g_row[88].u_rowl_n_2 VSS VSS VDD VDD g_row[88].u_rowl_n_3 sky130_fd_sc_hvl__inv_1
Xg_row_88.u_rowl_g89__6783 sel_en row1q[88] VSS VSS VDD VDD g_row[88].u_rowl_n_2 sky130_fd_sc_hvl__nand2_1
Xg_row_89.u_rowl_g81__3680 wlvb[89] g_row[89].u_rowl_n_5 VSS VSS VDD VDD wl0b[89] sky130_fd_sc_hvl__nand2_1
Xg_row_89.u_rowl_g82__1617 g_row[89].u_rowl_n_3 VER FE_DBTN0_READb VSS VSS VDD VDD wlvb[89] sky130_fd_sc_hvl__a21oi_1
Xg_row_89.u_rowl_g83__2802 g_row[89].u_rowl_n_3 WRANY VSS VSS VDD VDD wsel[89] sky130_fd_sc_hvl__and2_1
Xg_row_89.u_rowl_g84__1705 g_row[89].u_rowl_n_3 SENSE VSS VSS VDD VDD sns[89] sky130_fd_sc_hvl__and2_1
Xg_row_89.u_rowl_g85 g_row[89].u_rowl_n_5 VSS VSS VDD VDD wlw[89] sky130_fd_sc_hvl__inv_1
Xg_row_89.u_rowl_g86__5122 g_row[89].u_rowl_n_2 WRANY VSS VSS VDD VDD wz[89] sky130_fd_sc_hvl__and2_1
Xg_row_89.u_rowl_g87__8246 g_row[89].u_rowl_n_3 PROG VSS VSS VDD VDD g_row[89].u_rowl_n_5 sky130_fd_sc_hvl__nand2_1
Xg_row_89.u_rowl_g88 g_row[89].u_rowl_n_2 VSS VSS VDD VDD g_row[89].u_rowl_n_3 sky130_fd_sc_hvl__inv_1
Xg_row_89.u_rowl_g89__7098 sel_en row1q[89] VSS VSS VDD VDD g_row[89].u_rowl_n_2 sky130_fd_sc_hvl__nand2_1
Xg_row_90.u_rowl_g81__6131 wlvb[90] g_row[90].u_rowl_n_5 VSS VSS VDD VDD wl0b[90] sky130_fd_sc_hvl__nand2_1
Xg_row_90.u_rowl_g82__1881 g_row[90].u_rowl_n_3 FE_OFN5_VER FE_OFN10_FE_DBTN0_READb VSS VSS VDD VDD wlvb[90] sky130_fd_sc_hvl__a21oi_1
Xg_row_90.u_rowl_g83__5115 g_row[90].u_rowl_n_3 FE_OFN9_n VSS VSS VDD VDD wsel[90] sky130_fd_sc_hvl__and2_1
Xg_row_90.u_rowl_g84__7482 g_row[90].u_rowl_n_3 FE_OFN6_SENSE VSS VSS VDD VDD sns[90] sky130_fd_sc_hvl__and2_1
Xg_row_90.u_rowl_g85 g_row[90].u_rowl_n_5 VSS VSS VDD VDD wlw[90] sky130_fd_sc_hvl__inv_1
Xg_row_90.u_rowl_g86__4733 g_row[90].u_rowl_n_2 FE_OFN9_n VSS VSS VDD VDD wz[90] sky130_fd_sc_hvl__and2_1
Xg_row_90.u_rowl_g87__6161 g_row[90].u_rowl_n_3 FE_OFN4_PROG VSS VSS VDD VDD g_row[90].u_rowl_n_5 sky130_fd_sc_hvl__nand2_1
Xg_row_90.u_rowl_g88 g_row[90].u_rowl_n_2 VSS VSS VDD VDD g_row[90].u_rowl_n_3 sky130_fd_sc_hvl__inv_1
Xg_row_90.u_rowl_g89__9315 FE_OFN3_sel_en row1q[90] VSS VSS VDD VDD g_row[90].u_rowl_n_2 sky130_fd_sc_hvl__nand2_1
Xg_row_91.u_rowl_g81__9945 wlvb[91] g_row[91].u_rowl_n_5 VSS VSS VDD VDD wl0b[91] sky130_fd_sc_hvl__nand2_1
Xg_row_91.u_rowl_g82__2883 g_row[91].u_rowl_n_3 FE_OFN5_VER FE_OFN10_FE_DBTN0_READb VSS VSS VDD VDD wlvb[91] sky130_fd_sc_hvl__a21oi_1
Xg_row_91.u_rowl_g83__2346 g_row[91].u_rowl_n_3 FE_OFN7_WRANY VSS VSS VDD VDD wsel[91] sky130_fd_sc_hvl__and2_1
Xg_row_91.u_rowl_g84__1666 g_row[91].u_rowl_n_3 FE_OFN6_SENSE VSS VSS VDD VDD sns[91] sky130_fd_sc_hvl__and2_1
Xg_row_91.u_rowl_g85 g_row[91].u_rowl_n_5 VSS VSS VDD VDD wlw[91] sky130_fd_sc_hvl__inv_1
Xg_row_91.u_rowl_g86__7410 g_row[91].u_rowl_n_2 FE_OFN7_WRANY VSS VSS VDD VDD wz[91] sky130_fd_sc_hvl__and2_1
Xg_row_91.u_rowl_g87__6417 g_row[91].u_rowl_n_3 FE_OFN4_PROG VSS VSS VDD VDD g_row[91].u_rowl_n_5 sky130_fd_sc_hvl__nand2_1
Xg_row_91.u_rowl_g88 g_row[91].u_rowl_n_2 VSS VSS VDD VDD g_row[91].u_rowl_n_3 sky130_fd_sc_hvl__inv_1
Xg_row_91.u_rowl_g89__5477 FE_OFN3_sel_en row1q[91] VSS VSS VDD VDD g_row[91].u_rowl_n_2 sky130_fd_sc_hvl__nand2_1
Xg_row_92.u_rowl_g81__2398 wlvb[92] g_row[92].u_rowl_n_5 VSS VSS VDD VDD wl0b[92] sky130_fd_sc_hvl__nand2_1
Xg_row_92.u_rowl_g82__5107 g_row[92].u_rowl_n_3 VER FE_OFN10_FE_DBTN0_READb VSS VSS VDD VDD wlvb[92] sky130_fd_sc_hvl__a21oi_1
Xg_row_92.u_rowl_g83__6260 g_row[92].u_rowl_n_3 FE_OFN7_WRANY VSS VSS VDD VDD wsel[92] sky130_fd_sc_hvl__and2_1
Xg_row_92.u_rowl_g84__4319 g_row[92].u_rowl_n_3 FE_OFN6_SENSE VSS VSS VDD VDD sns[92] sky130_fd_sc_hvl__and2_1
Xg_row_92.u_rowl_g85 g_row[92].u_rowl_n_5 VSS VSS VDD VDD wlw[92] sky130_fd_sc_hvl__inv_1
Xg_row_92.u_rowl_g86__8428 g_row[92].u_rowl_n_2 FE_OFN7_WRANY VSS VSS VDD VDD wz[92] sky130_fd_sc_hvl__and2_1
Xg_row_92.u_rowl_g87__5526 g_row[92].u_rowl_n_3 FE_OFN4_PROG VSS VSS VDD VDD g_row[92].u_rowl_n_5 sky130_fd_sc_hvl__nand2_1
Xg_row_92.u_rowl_g88 g_row[92].u_rowl_n_2 VSS VSS VDD VDD g_row[92].u_rowl_n_3 sky130_fd_sc_hvl__inv_1
Xg_row_92.u_rowl_g89__6783 FE_OFN3_sel_en row1q[92] VSS VSS VDD VDD g_row[92].u_rowl_n_2 sky130_fd_sc_hvl__nand2_1
Xg_row_93.u_rowl_g81__3680 wlvb[93] g_row[93].u_rowl_n_5 VSS VSS VDD VDD wl0b[93] sky130_fd_sc_hvl__nand2_1
Xg_row_93.u_rowl_g82__1617 g_row[93].u_rowl_n_3 VER FE_OFN10_FE_DBTN0_READb VSS VSS VDD VDD wlvb[93] sky130_fd_sc_hvl__a21oi_1
Xg_row_93.u_rowl_g83__2802 g_row[93].u_rowl_n_3 WRANY VSS VSS VDD VDD wsel[93] sky130_fd_sc_hvl__and2_1
Xg_row_93.u_rowl_g84__1705 g_row[93].u_rowl_n_3 SENSE VSS VSS VDD VDD sns[93] sky130_fd_sc_hvl__and2_1
Xg_row_93.u_rowl_g85 g_row[93].u_rowl_n_5 VSS VSS VDD VDD wlw[93] sky130_fd_sc_hvl__inv_1
Xg_row_93.u_rowl_g86__5122 g_row[93].u_rowl_n_2 WRANY VSS VSS VDD VDD wz[93] sky130_fd_sc_hvl__and2_1
Xg_row_93.u_rowl_g87__8246 g_row[93].u_rowl_n_3 PROG VSS VSS VDD VDD g_row[93].u_rowl_n_5 sky130_fd_sc_hvl__nand2_1
Xg_row_93.u_rowl_g88 g_row[93].u_rowl_n_2 VSS VSS VDD VDD g_row[93].u_rowl_n_3 sky130_fd_sc_hvl__inv_1
Xg_row_93.u_rowl_g89__7098 FE_OFN3_sel_en row1q[93] VSS VSS VDD VDD g_row[93].u_rowl_n_2 sky130_fd_sc_hvl__nand2_1
Xg_row_94.u_rowl_g81__6131 wlvb[94] g_row[94].u_rowl_n_5 VSS VSS VDD VDD wl0b[94] sky130_fd_sc_hvl__nand2_1
Xg_row_94.u_rowl_g82__1881 g_row[94].u_rowl_n_3 VER FE_DBTN0_READb VSS VSS VDD VDD wlvb[94] sky130_fd_sc_hvl__a21oi_1
Xg_row_94.u_rowl_g83__5115 g_row[94].u_rowl_n_3 WRANY VSS VSS VDD VDD wsel[94] sky130_fd_sc_hvl__and2_1
Xg_row_94.u_rowl_g84__7482 g_row[94].u_rowl_n_3 SENSE VSS VSS VDD VDD sns[94] sky130_fd_sc_hvl__and2_1
Xg_row_94.u_rowl_g85 g_row[94].u_rowl_n_5 VSS VSS VDD VDD wlw[94] sky130_fd_sc_hvl__inv_1
Xg_row_94.u_rowl_g86__4733 g_row[94].u_rowl_n_2 WRANY VSS VSS VDD VDD wz[94] sky130_fd_sc_hvl__and2_1
Xg_row_94.u_rowl_g87__6161 g_row[94].u_rowl_n_3 PROG VSS VSS VDD VDD g_row[94].u_rowl_n_5 sky130_fd_sc_hvl__nand2_1
Xg_row_94.u_rowl_g88 g_row[94].u_rowl_n_2 VSS VSS VDD VDD g_row[94].u_rowl_n_3 sky130_fd_sc_hvl__inv_1
Xg_row_94.u_rowl_g89__9315 sel_en row1q[94] VSS VSS VDD VDD g_row[94].u_rowl_n_2 sky130_fd_sc_hvl__nand2_1
Xg_row_95.u_rowl_g81__9945 wlvb[95] g_row[95].u_rowl_n_5 VSS VSS VDD VDD wl0b[95] sky130_fd_sc_hvl__nand2_1
Xg_row_95.u_rowl_g82__2883 g_row[95].u_rowl_n_3 VER FE_DBTN0_READb VSS VSS VDD VDD wlvb[95] sky130_fd_sc_hvl__a21oi_1
Xg_row_95.u_rowl_g83__2346 g_row[95].u_rowl_n_3 WRANY VSS VSS VDD VDD wsel[95] sky130_fd_sc_hvl__and2_1
Xg_row_95.u_rowl_g84__1666 g_row[95].u_rowl_n_3 SENSE VSS VSS VDD VDD sns[95] sky130_fd_sc_hvl__and2_1
Xg_row_95.u_rowl_g85 g_row[95].u_rowl_n_5 VSS VSS VDD VDD wlw[95] sky130_fd_sc_hvl__inv_1
Xg_row_95.u_rowl_g86__7410 g_row[95].u_rowl_n_2 WRANY VSS VSS VDD VDD wz[95] sky130_fd_sc_hvl__and2_1
Xg_row_95.u_rowl_g87__6417 g_row[95].u_rowl_n_3 PROG VSS VSS VDD VDD g_row[95].u_rowl_n_5 sky130_fd_sc_hvl__nand2_1
Xg_row_95.u_rowl_g88 g_row[95].u_rowl_n_2 VSS VSS VDD VDD g_row[95].u_rowl_n_3 sky130_fd_sc_hvl__inv_1
Xg_row_95.u_rowl_g89__5477 sel_en row1q[95] VSS VSS VDD VDD g_row[95].u_rowl_n_2 sky130_fd_sc_hvl__nand2_1
Xg_row_96.u_rowl_g81__2398 wlvb[96] g_row[96].u_rowl_n_5 VSS VSS VDD VDD wl0b[96] sky130_fd_sc_hvl__nand2_1
Xg_row_96.u_rowl_g82__5107 g_row[96].u_rowl_n_3 FE_OFN5_VER FE_OFN10_FE_DBTN0_READb VSS VSS VDD VDD wlvb[96] sky130_fd_sc_hvl__a21oi_1
Xg_row_96.u_rowl_g83__6260 g_row[96].u_rowl_n_3 FE_OFN9_n VSS VSS VDD VDD wsel[96] sky130_fd_sc_hvl__and2_1
Xg_row_96.u_rowl_g84__4319 g_row[96].u_rowl_n_3 FE_OFN6_SENSE VSS VSS VDD VDD sns[96] sky130_fd_sc_hvl__and2_1
Xg_row_96.u_rowl_g85 g_row[96].u_rowl_n_5 VSS VSS VDD VDD wlw[96] sky130_fd_sc_hvl__inv_1
Xg_row_96.u_rowl_g86__8428 g_row[96].u_rowl_n_2 FE_OFN9_n VSS VSS VDD VDD wz[96] sky130_fd_sc_hvl__and2_1
Xg_row_96.u_rowl_g87__5526 g_row[96].u_rowl_n_3 FE_OFN4_PROG VSS VSS VDD VDD g_row[96].u_rowl_n_5 sky130_fd_sc_hvl__nand2_1
Xg_row_96.u_rowl_g88 g_row[96].u_rowl_n_2 VSS VSS VDD VDD g_row[96].u_rowl_n_3 sky130_fd_sc_hvl__inv_1
Xg_row_96.u_rowl_g89__6783 FE_OFN3_sel_en row1q[96] VSS VSS VDD VDD g_row[96].u_rowl_n_2 sky130_fd_sc_hvl__nand2_1
Xg_row_97.u_rowl_g81__3680 wlvb[97] g_row[97].u_rowl_n_5 VSS VSS VDD VDD wl0b[97] sky130_fd_sc_hvl__nand2_1
Xg_row_97.u_rowl_g82__1617 g_row[97].u_rowl_n_3 FE_OFN5_VER FE_OFN10_FE_DBTN0_READb VSS VSS VDD VDD wlvb[97] sky130_fd_sc_hvl__a21oi_1
Xg_row_97.u_rowl_g83__2802 g_row[97].u_rowl_n_3 FE_OFN7_WRANY VSS VSS VDD VDD wsel[97] sky130_fd_sc_hvl__and2_1
Xg_row_97.u_rowl_g84__1705 g_row[97].u_rowl_n_3 FE_OFN6_SENSE VSS VSS VDD VDD sns[97] sky130_fd_sc_hvl__and2_1
Xg_row_97.u_rowl_g85 g_row[97].u_rowl_n_5 VSS VSS VDD VDD wlw[97] sky130_fd_sc_hvl__inv_1
Xg_row_97.u_rowl_g86__5122 g_row[97].u_rowl_n_2 FE_OFN7_WRANY VSS VSS VDD VDD wz[97] sky130_fd_sc_hvl__and2_1
Xg_row_97.u_rowl_g87__8246 g_row[97].u_rowl_n_3 FE_OFN4_PROG VSS VSS VDD VDD g_row[97].u_rowl_n_5 sky130_fd_sc_hvl__nand2_1
Xg_row_97.u_rowl_g88 g_row[97].u_rowl_n_2 VSS VSS VDD VDD g_row[97].u_rowl_n_3 sky130_fd_sc_hvl__inv_1
Xg_row_97.u_rowl_g89__7098 FE_OFN3_sel_en row1q[97] VSS VSS VDD VDD g_row[97].u_rowl_n_2 sky130_fd_sc_hvl__nand2_1
Xg_row_98.u_rowl_g81__6131 wlvb[98] g_row[98].u_rowl_n_5 VSS VSS VDD VDD wl0b[98] sky130_fd_sc_hvl__nand2_1
Xg_row_98.u_rowl_g82__1881 g_row[98].u_rowl_n_3 VER FE_OFN10_FE_DBTN0_READb VSS VSS VDD VDD wlvb[98] sky130_fd_sc_hvl__a21oi_1
Xg_row_98.u_rowl_g83__5115 g_row[98].u_rowl_n_3 FE_OFN7_WRANY VSS VSS VDD VDD wsel[98] sky130_fd_sc_hvl__and2_1
Xg_row_98.u_rowl_g84__7482 g_row[98].u_rowl_n_3 FE_OFN6_SENSE VSS VSS VDD VDD sns[98] sky130_fd_sc_hvl__and2_1
Xg_row_98.u_rowl_g85 g_row[98].u_rowl_n_5 VSS VSS VDD VDD wlw[98] sky130_fd_sc_hvl__inv_1
Xg_row_98.u_rowl_g86__4733 g_row[98].u_rowl_n_2 WRANY VSS VSS VDD VDD wz[98] sky130_fd_sc_hvl__and2_1
Xg_row_98.u_rowl_g87__6161 g_row[98].u_rowl_n_3 FE_OFN4_PROG VSS VSS VDD VDD g_row[98].u_rowl_n_5 sky130_fd_sc_hvl__nand2_1
Xg_row_98.u_rowl_g88 g_row[98].u_rowl_n_2 VSS VSS VDD VDD g_row[98].u_rowl_n_3 sky130_fd_sc_hvl__inv_1
Xg_row_98.u_rowl_g89__9315 FE_OFN3_sel_en row1q[98] VSS VSS VDD VDD g_row[98].u_rowl_n_2 sky130_fd_sc_hvl__nand2_1
Xg_row_99.u_rowl_g81__9945 wlvb[99] g_row[99].u_rowl_n_5 VSS VSS VDD VDD wl0b[99] sky130_fd_sc_hvl__nand2_1
Xg_row_99.u_rowl_g82__2883 g_row[99].u_rowl_n_3 VER FE_OFN10_FE_DBTN0_READb VSS VSS VDD VDD wlvb[99] sky130_fd_sc_hvl__a21oi_1
Xg_row_99.u_rowl_g83__2346 g_row[99].u_rowl_n_3 WRANY VSS VSS VDD VDD wsel[99] sky130_fd_sc_hvl__and2_1
Xg_row_99.u_rowl_g84__1666 g_row[99].u_rowl_n_3 SENSE VSS VSS VDD VDD sns[99] sky130_fd_sc_hvl__and2_1
Xg_row_99.u_rowl_g85 g_row[99].u_rowl_n_5 VSS VSS VDD VDD wlw[99] sky130_fd_sc_hvl__inv_1
Xg_row_99.u_rowl_g86__7410 g_row[99].u_rowl_n_2 WRANY VSS VSS VDD VDD wz[99] sky130_fd_sc_hvl__and2_1
Xg_row_99.u_rowl_g87__6417 g_row[99].u_rowl_n_3 PROG VSS VSS VDD VDD g_row[99].u_rowl_n_5 sky130_fd_sc_hvl__nand2_1
Xg_row_99.u_rowl_g88 g_row[99].u_rowl_n_2 VSS VSS VDD VDD g_row[99].u_rowl_n_3 sky130_fd_sc_hvl__inv_1
Xg_row_99.u_rowl_g89__5477 FE_OFN3_sel_en row1q[99] VSS VSS VDD VDD g_row[99].u_rowl_n_2 sky130_fd_sc_hvl__nand2_1
Xg_row_100.u_rowl_g81__2398 wlvb[100] g_row[100].u_rowl_n_5 VSS VSS VDD VDD wl0b[100] sky130_fd_sc_hvl__nand2_1
Xg_row_100.u_rowl_g82__5107 g_row[100].u_rowl_n_3 VER FE_DBTN0_READb VSS VSS VDD VDD wlvb[100] sky130_fd_sc_hvl__a21oi_1
Xg_row_100.u_rowl_g83__6260 g_row[100].u_rowl_n_3 WRANY VSS VSS VDD VDD wsel[100] sky130_fd_sc_hvl__and2_1
Xg_row_100.u_rowl_g84__4319 g_row[100].u_rowl_n_3 SENSE VSS VSS VDD VDD sns[100] sky130_fd_sc_hvl__and2_1
Xg_row_100.u_rowl_g85 g_row[100].u_rowl_n_5 VSS VSS VDD VDD wlw[100] sky130_fd_sc_hvl__inv_1
Xg_row_100.u_rowl_g86__8428 g_row[100].u_rowl_n_2 WRANY VSS VSS VDD VDD wz[100] sky130_fd_sc_hvl__and2_1
Xg_row_100.u_rowl_g87__5526 g_row[100].u_rowl_n_3 PROG VSS VSS VDD VDD g_row[100].u_rowl_n_5 sky130_fd_sc_hvl__nand2_1
Xg_row_100.u_rowl_g88 g_row[100].u_rowl_n_2 VSS VSS VDD VDD g_row[100].u_rowl_n_3 sky130_fd_sc_hvl__inv_1
Xg_row_100.u_rowl_g89__6783 sel_en row2q[0] VSS VSS VDD VDD g_row[100].u_rowl_n_2 sky130_fd_sc_hvl__nand2_1
Xg_row_101.u_rowl_g81__3680 wlvb[101] g_row[101].u_rowl_n_5 VSS VSS VDD VDD wl0b[101] sky130_fd_sc_hvl__nand2_1
Xg_row_101.u_rowl_g82__1617 g_row[101].u_rowl_n_3 VER FE_DBTN0_READb VSS VSS VDD VDD wlvb[101] sky130_fd_sc_hvl__a21oi_1
Xg_row_101.u_rowl_g83__2802 g_row[101].u_rowl_n_3 WRANY VSS VSS VDD VDD wsel[101] sky130_fd_sc_hvl__and2_1
Xg_row_101.u_rowl_g84__1705 g_row[101].u_rowl_n_3 SENSE VSS VSS VDD VDD sns[101] sky130_fd_sc_hvl__and2_1
Xg_row_101.u_rowl_g85 g_row[101].u_rowl_n_5 VSS VSS VDD VDD wlw[101] sky130_fd_sc_hvl__inv_1
Xg_row_101.u_rowl_g86__5122 g_row[101].u_rowl_n_2 WRANY VSS VSS VDD VDD wz[101] sky130_fd_sc_hvl__and2_1
Xg_row_101.u_rowl_g87__8246 g_row[101].u_rowl_n_3 PROG VSS VSS VDD VDD g_row[101].u_rowl_n_5 sky130_fd_sc_hvl__nand2_1
Xg_row_101.u_rowl_g88 g_row[101].u_rowl_n_2 VSS VSS VDD VDD g_row[101].u_rowl_n_3 sky130_fd_sc_hvl__inv_1
Xg_row_101.u_rowl_g89__7098 sel_en row2q[1] VSS VSS VDD VDD g_row[101].u_rowl_n_2 sky130_fd_sc_hvl__nand2_1
Xg_row_102.u_rowl_g81__6131 wlvb[102] g_row[102].u_rowl_n_5 VSS VSS VDD VDD wl0b[102] sky130_fd_sc_hvl__nand2_1
Xg_row_102.u_rowl_g82__1881 g_row[102].u_rowl_n_3 FE_OFN5_VER FE_OFN10_FE_DBTN0_READb VSS VSS VDD VDD wlvb[102] sky130_fd_sc_hvl__a21oi_1
Xg_row_102.u_rowl_g83__5115 g_row[102].u_rowl_n_3 FE_OFN9_n VSS VSS VDD VDD wsel[102] sky130_fd_sc_hvl__and2_1
Xg_row_102.u_rowl_g84__7482 g_row[102].u_rowl_n_3 FE_OFN6_SENSE VSS VSS VDD VDD sns[102] sky130_fd_sc_hvl__and2_1
Xg_row_102.u_rowl_g85 g_row[102].u_rowl_n_5 VSS VSS VDD VDD wlw[102] sky130_fd_sc_hvl__inv_1
Xg_row_102.u_rowl_g86__4733 g_row[102].u_rowl_n_2 FE_OFN9_n VSS VSS VDD VDD wz[102] sky130_fd_sc_hvl__and2_1
Xg_row_102.u_rowl_g87__6161 g_row[102].u_rowl_n_3 FE_OFN4_PROG VSS VSS VDD VDD g_row[102].u_rowl_n_5 sky130_fd_sc_hvl__nand2_1
Xg_row_102.u_rowl_g88 g_row[102].u_rowl_n_2 VSS VSS VDD VDD g_row[102].u_rowl_n_3 sky130_fd_sc_hvl__inv_1
Xg_row_102.u_rowl_g89__9315 sel_en row2q[2] VSS VSS VDD VDD g_row[102].u_rowl_n_2 sky130_fd_sc_hvl__nand2_1
Xg_row_103.u_rowl_g81__9945 wlvb[103] g_row[103].u_rowl_n_5 VSS VSS VDD VDD wl0b[103] sky130_fd_sc_hvl__nand2_1
Xg_row_103.u_rowl_g82__2883 g_row[103].u_rowl_n_3 FE_OFN5_VER FE_OFN10_FE_DBTN0_READb VSS VSS VDD VDD wlvb[103] sky130_fd_sc_hvl__a21oi_1
Xg_row_103.u_rowl_g83__2346 g_row[103].u_rowl_n_3 FE_OFN7_WRANY VSS VSS VDD VDD wsel[103] sky130_fd_sc_hvl__and2_1
Xg_row_103.u_rowl_g84__1666 g_row[103].u_rowl_n_3 FE_OFN6_SENSE VSS VSS VDD VDD sns[103] sky130_fd_sc_hvl__and2_1
Xg_row_103.u_rowl_g85 g_row[103].u_rowl_n_5 VSS VSS VDD VDD wlw[103] sky130_fd_sc_hvl__inv_1
Xg_row_103.u_rowl_g86__7410 g_row[103].u_rowl_n_2 FE_OFN7_WRANY VSS VSS VDD VDD wz[103] sky130_fd_sc_hvl__and2_1
Xg_row_103.u_rowl_g87__6417 g_row[103].u_rowl_n_3 FE_OFN4_PROG VSS VSS VDD VDD g_row[103].u_rowl_n_5 sky130_fd_sc_hvl__nand2_1
Xg_row_103.u_rowl_g88 g_row[103].u_rowl_n_2 VSS VSS VDD VDD g_row[103].u_rowl_n_3 sky130_fd_sc_hvl__inv_1
Xg_row_103.u_rowl_g89__5477 sel_en row2q[3] VSS VSS VDD VDD g_row[103].u_rowl_n_2 sky130_fd_sc_hvl__nand2_1
Xg_row_104.u_rowl_g81__2398 wlvb[104] g_row[104].u_rowl_n_5 VSS VSS VDD VDD wl0b[104] sky130_fd_sc_hvl__nand2_1
Xg_row_104.u_rowl_g82__5107 g_row[104].u_rowl_n_3 VER FE_OFN10_FE_DBTN0_READb VSS VSS VDD VDD wlvb[104] sky130_fd_sc_hvl__a21oi_1
Xg_row_104.u_rowl_g83__6260 g_row[104].u_rowl_n_3 FE_OFN7_WRANY VSS VSS VDD VDD wsel[104] sky130_fd_sc_hvl__and2_1
Xg_row_104.u_rowl_g84__4319 g_row[104].u_rowl_n_3 FE_OFN6_SENSE VSS VSS VDD VDD sns[104] sky130_fd_sc_hvl__and2_1
Xg_row_104.u_rowl_g85 g_row[104].u_rowl_n_5 VSS VSS VDD VDD wlw[104] sky130_fd_sc_hvl__inv_1
Xg_row_104.u_rowl_g86__8428 g_row[104].u_rowl_n_2 WRANY VSS VSS VDD VDD wz[104] sky130_fd_sc_hvl__and2_1
Xg_row_104.u_rowl_g87__5526 g_row[104].u_rowl_n_3 FE_OFN4_PROG VSS VSS VDD VDD g_row[104].u_rowl_n_5 sky130_fd_sc_hvl__nand2_1
Xg_row_104.u_rowl_g88 g_row[104].u_rowl_n_2 VSS VSS VDD VDD g_row[104].u_rowl_n_3 sky130_fd_sc_hvl__inv_1
Xg_row_104.u_rowl_g89__6783 sel_en row2q[4] VSS VSS VDD VDD g_row[104].u_rowl_n_2 sky130_fd_sc_hvl__nand2_1
Xg_row_105.u_rowl_g81__3680 wlvb[105] g_row[105].u_rowl_n_5 VSS VSS VDD VDD wl0b[105] sky130_fd_sc_hvl__nand2_1
Xg_row_105.u_rowl_g82__1617 g_row[105].u_rowl_n_3 VER FE_OFN10_FE_DBTN0_READb VSS VSS VDD VDD wlvb[105] sky130_fd_sc_hvl__a21oi_1
Xg_row_105.u_rowl_g83__2802 g_row[105].u_rowl_n_3 WRANY VSS VSS VDD VDD wsel[105] sky130_fd_sc_hvl__and2_1
Xg_row_105.u_rowl_g84__1705 g_row[105].u_rowl_n_3 SENSE VSS VSS VDD VDD sns[105] sky130_fd_sc_hvl__and2_1
Xg_row_105.u_rowl_g85 g_row[105].u_rowl_n_5 VSS VSS VDD VDD wlw[105] sky130_fd_sc_hvl__inv_1
Xg_row_105.u_rowl_g86__5122 g_row[105].u_rowl_n_2 WRANY VSS VSS VDD VDD wz[105] sky130_fd_sc_hvl__and2_1
Xg_row_105.u_rowl_g87__8246 g_row[105].u_rowl_n_3 PROG VSS VSS VDD VDD g_row[105].u_rowl_n_5 sky130_fd_sc_hvl__nand2_1
Xg_row_105.u_rowl_g88 g_row[105].u_rowl_n_2 VSS VSS VDD VDD g_row[105].u_rowl_n_3 sky130_fd_sc_hvl__inv_1
Xg_row_105.u_rowl_g89__7098 sel_en row2q[5] VSS VSS VDD VDD g_row[105].u_rowl_n_2 sky130_fd_sc_hvl__nand2_1
Xrm0_XT1 vw row[0] wsel[0] wselb[0] VDD VSS rb_tgw_n20
Xrm0_XT3 vzero row[0] wz[0] wzb[0] VDD VSS rb_tg_n2
Xrm0_XT5 row[0] R1 sns[0] snsb[0] VDD VSS rb_tg_n2
Xrm0_XW1 wl[0] wlv[0] wlvb[0] VDD VSS rb_tg_n2_av
Xrm0_XW2 vwl wl[0] wlw[0] g_row[0].u_rowl_n_5 VDD VSS rb_tg_n2
Xrm0_XW3 wl[0] wl0[0] wl0b[0] VDD VSS rb_tg_n2_as
Xrm1_XT1 vw row[1] wsel[1] wselb[1] VDD VSS rb_tgw_n20
Xrm1_XT3 vzero row[1] wz[1] wzb[1] VDD VSS rb_tg_n2
Xrm1_XT5 row[1] R1 sns[1] snsb[1] VDD VSS rb_tg_n2
Xrm1_XW1 wl[1] wlv[1] wlvb[1] VDD VSS rb_tg_n2_av
Xrm1_XW2 vwl wl[1] wlw[1] g_row[1].u_rowl_n_5 VDD VSS rb_tg_n2
Xrm1_XW3 wl[1] wl0[1] wl0b[1] VDD VSS rb_tg_n2_as
Xrm2_XT1 vw row[2] wsel[2] wselb[2] VDD VSS rb_tgw_n20
Xrm2_XT3 vzero row[2] wz[2] wzb[2] VDD VSS rb_tg_n2
Xrm2_XT5 row[2] R1 sns[2] snsb[2] VDD VSS rb_tg_n2
Xrm2_XW1 wl[2] wlv[2] wlvb[2] VDD VSS rb_tg_n2_av
Xrm2_XW2 vwl wl[2] wlw[2] g_row[2].u_rowl_n_5 VDD VSS rb_tg_n2
Xrm2_XW3 wl[2] wl0[2] wl0b[2] VDD VSS rb_tg_n2_as
Xrm3_XT1 vw row[3] wsel[3] wselb[3] VDD VSS rb_tgw_n20
Xrm3_XT3 vzero row[3] wz[3] wzb[3] VDD VSS rb_tg_n2
Xrm3_XT5 row[3] R1 sns[3] snsb[3] VDD VSS rb_tg_n2
Xrm3_XW1 wl[3] wlv[3] wlvb[3] VDD VSS rb_tg_n2_av
Xrm3_XW2 vwl wl[3] wlw[3] g_row[3].u_rowl_n_5 VDD VSS rb_tg_n2
Xrm3_XW3 wl[3] wl0[3] wl0b[3] VDD VSS rb_tg_n2_as
Xrm4_XT1 vw row[4] wsel[4] wselb[4] VDD VSS rb_tgw_n20
Xrm4_XT3 vzero row[4] wz[4] wzb[4] VDD VSS rb_tg_n2
Xrm4_XT5 row[4] R1 sns[4] snsb[4] VDD VSS rb_tg_n2
Xrm4_XW1 wl[4] wlv[4] wlvb[4] VDD VSS rb_tg_n2_av
Xrm4_XW2 vwl wl[4] wlw[4] g_row[4].u_rowl_n_5 VDD VSS rb_tg_n2
Xrm4_XW3 wl[4] wl0[4] wl0b[4] VDD VSS rb_tg_n2_as
Xrm5_XT1 vw row[5] wsel[5] wselb[5] VDD VSS rb_tgw_n20
Xrm5_XT3 vzero row[5] wz[5] wzb[5] VDD VSS rb_tg_n2
Xrm5_XT5 row[5] R1 sns[5] snsb[5] VDD VSS rb_tg_n2
Xrm5_XW1 wl[5] wlv[5] wlvb[5] VDD VSS rb_tg_n2_av
Xrm5_XW2 vwl wl[5] wlw[5] g_row[5].u_rowl_n_5 VDD VSS rb_tg_n2
Xrm5_XW3 wl[5] wl0[5] wl0b[5] VDD VSS rb_tg_n2_as
Xrm6_XT1 vw row[6] wsel[6] wselb[6] VDD VSS rb_tgw_n20
Xrm6_XT3 vzero row[6] wz[6] wzb[6] VDD VSS rb_tg_n2
Xrm6_XT5 row[6] R1 sns[6] snsb[6] VDD VSS rb_tg_n2
Xrm6_XW1 wl[6] wlv[6] wlvb[6] VDD VSS rb_tg_n2_av
Xrm6_XW2 vwl wl[6] wlw[6] g_row[6].u_rowl_n_5 VDD VSS rb_tg_n2
Xrm6_XW3 wl[6] wl0[6] wl0b[6] VDD VSS rb_tg_n2_as
Xrm7_XT1 vw row[7] wsel[7] wselb[7] VDD VSS rb_tgw_n20
Xrm7_XT3 vzero row[7] wz[7] wzb[7] VDD VSS rb_tg_n2
Xrm7_XT5 row[7] R1 sns[7] snsb[7] VDD VSS rb_tg_n2
Xrm7_XW1 wl[7] wlv[7] wlvb[7] VDD VSS rb_tg_n2_av
Xrm7_XW2 vwl wl[7] wlw[7] g_row[7].u_rowl_n_5 VDD VSS rb_tg_n2
Xrm7_XW3 wl[7] wl0[7] wl0b[7] VDD VSS rb_tg_n2_as
Xrm8_XT1 vw row[8] wsel[8] wselb[8] VDD VSS rb_tgw_n20
Xrm8_XT3 vzero row[8] wz[8] wzb[8] VDD VSS rb_tg_n2
Xrm8_XT5 row[8] R1 sns[8] snsb[8] VDD VSS rb_tg_n2
Xrm8_XW1 wl[8] wlv[8] wlvb[8] VDD VSS rb_tg_n2_av
Xrm8_XW2 vwl wl[8] wlw[8] g_row[8].u_rowl_n_5 VDD VSS rb_tg_n2
Xrm8_XW3 wl[8] wl0[8] wl0b[8] VDD VSS rb_tg_n2_as
Xrm9_XT1 vw row[9] wsel[9] wselb[9] VDD VSS rb_tgw_n20
Xrm9_XT3 vzero row[9] wz[9] wzb[9] VDD VSS rb_tg_n2
Xrm9_XT5 row[9] R1 sns[9] snsb[9] VDD VSS rb_tg_n2
Xrm9_XW1 wl[9] wlv[9] wlvb[9] VDD VSS rb_tg_n2_av
Xrm9_XW2 vwl wl[9] wlw[9] g_row[9].u_rowl_n_5 VDD VSS rb_tg_n2
Xrm9_XW3 wl[9] wl0[9] wl0b[9] VDD VSS rb_tg_n2_as
Xrm10_XT1 vw row[10] wsel[10] wselb[10] VDD VSS rb_tgw_n20
Xrm10_XT3 vzero row[10] wz[10] wzb[10] VDD VSS rb_tg_n2
Xrm10_XT5 row[10] R1 sns[10] snsb[10] VDD VSS rb_tg_n2
Xrm10_XW1 wl[10] wlv[10] wlvb[10] VDD VSS rb_tg_n2_av
Xrm10_XW2 vwl wl[10] wlw[10] g_row[10].u_rowl_n_5 VDD VSS rb_tg_n2
Xrm10_XW3 wl[10] wl0[10] wl0b[10] VDD VSS rb_tg_n2_as
Xrm11_XT1 vw row[11] wsel[11] wselb[11] VDD VSS rb_tgw_n20
Xrm11_XT3 vzero row[11] wz[11] wzb[11] VDD VSS rb_tg_n2
Xrm11_XT5 row[11] R1 sns[11] snsb[11] VDD VSS rb_tg_n2
Xrm11_XW1 wl[11] wlv[11] wlvb[11] VDD VSS rb_tg_n2_av
Xrm11_XW2 vwl wl[11] wlw[11] g_row[11].u_rowl_n_5 VDD VSS rb_tg_n2
Xrm11_XW3 wl[11] wl0[11] wl0b[11] VDD VSS rb_tg_n2_as
Xrm12_XT1 vw row[12] wsel[12] wselb[12] VDD VSS rb_tgw_n20
Xrm12_XT3 vzero row[12] wz[12] wzb[12] VDD VSS rb_tg_n2
Xrm12_XT5 row[12] R1 sns[12] snsb[12] VDD VSS rb_tg_n2
Xrm12_XW1 wl[12] wlv[12] wlvb[12] VDD VSS rb_tg_n2_av
Xrm12_XW2 vwl wl[12] wlw[12] g_row[12].u_rowl_n_5 VDD VSS rb_tg_n2
Xrm12_XW3 wl[12] wl0[12] wl0b[12] VDD VSS rb_tg_n2_as
Xrm13_XT1 vw row[13] wsel[13] wselb[13] VDD VSS rb_tgw_n20
Xrm13_XT3 vzero row[13] wz[13] wzb[13] VDD VSS rb_tg_n2
Xrm13_XT5 row[13] R1 sns[13] snsb[13] VDD VSS rb_tg_n2
Xrm13_XW1 wl[13] wlv[13] wlvb[13] VDD VSS rb_tg_n2_av
Xrm13_XW2 vwl wl[13] wlw[13] g_row[13].u_rowl_n_5 VDD VSS rb_tg_n2
Xrm13_XW3 wl[13] wl0[13] wl0b[13] VDD VSS rb_tg_n2_as
Xrm14_XT1 vw row[14] wsel[14] wselb[14] VDD VSS rb_tgw_n20
Xrm14_XT3 vzero row[14] wz[14] wzb[14] VDD VSS rb_tg_n2
Xrm14_XT5 row[14] R1 sns[14] snsb[14] VDD VSS rb_tg_n2
Xrm14_XW1 wl[14] wlv[14] wlvb[14] VDD VSS rb_tg_n2_av
Xrm14_XW2 vwl wl[14] wlw[14] g_row[14].u_rowl_n_5 VDD VSS rb_tg_n2
Xrm14_XW3 wl[14] wl0[14] wl0b[14] VDD VSS rb_tg_n2_as
Xrm15_XT1 vw row[15] wsel[15] wselb[15] VDD VSS rb_tgw_n20
Xrm15_XT3 vzero row[15] wz[15] wzb[15] VDD VSS rb_tg_n2
Xrm15_XT5 row[15] R1 sns[15] snsb[15] VDD VSS rb_tg_n2
Xrm15_XW1 wl[15] wlv[15] wlvb[15] VDD VSS rb_tg_n2_av
Xrm15_XW2 vwl wl[15] wlw[15] g_row[15].u_rowl_n_5 VDD VSS rb_tg_n2
Xrm15_XW3 wl[15] wl0[15] wl0b[15] VDD VSS rb_tg_n2_as
Xrm16_XT1 vw row[16] wsel[16] wselb[16] VDD VSS rb_tgw_n20
Xrm16_XT3 vzero row[16] wz[16] wzb[16] VDD VSS rb_tg_n2
Xrm16_XT5 row[16] R1 sns[16] snsb[16] VDD VSS rb_tg_n2
Xrm16_XW1 wl[16] wlv[16] wlvb[16] VDD VSS rb_tg_n2_av
Xrm16_XW2 vwl wl[16] wlw[16] g_row[16].u_rowl_n_5 VDD VSS rb_tg_n2
Xrm16_XW3 wl[16] wl0[16] wl0b[16] VDD VSS rb_tg_n2_as
Xrm17_XT1 vw row[17] wsel[17] wselb[17] VDD VSS rb_tgw_n20
Xrm17_XT3 vzero row[17] wz[17] wzb[17] VDD VSS rb_tg_n2
Xrm17_XT5 row[17] R1 sns[17] snsb[17] VDD VSS rb_tg_n2
Xrm17_XW1 wl[17] wlv[17] wlvb[17] VDD VSS rb_tg_n2_av
Xrm17_XW2 vwl wl[17] wlw[17] g_row[17].u_rowl_n_5 VDD VSS rb_tg_n2
Xrm17_XW3 wl[17] wl0[17] wl0b[17] VDD VSS rb_tg_n2_as
Xrm18_XT1 vw row[18] wsel[18] wselb[18] VDD VSS rb_tgw_n20
Xrm18_XT3 vzero row[18] wz[18] wzb[18] VDD VSS rb_tg_n2
Xrm18_XT5 row[18] R1 sns[18] snsb[18] VDD VSS rb_tg_n2
Xrm18_XW1 wl[18] wlv[18] wlvb[18] VDD VSS rb_tg_n2_av
Xrm18_XW2 vwl wl[18] wlw[18] g_row[18].u_rowl_n_5 VDD VSS rb_tg_n2
Xrm18_XW3 wl[18] wl0[18] wl0b[18] VDD VSS rb_tg_n2_as
Xrm19_XT1 vw row[19] wsel[19] wselb[19] VDD VSS rb_tgw_n20
Xrm19_XT3 vzero row[19] wz[19] wzb[19] VDD VSS rb_tg_n2
Xrm19_XT5 row[19] R1 sns[19] snsb[19] VDD VSS rb_tg_n2
Xrm19_XW1 wl[19] wlv[19] wlvb[19] VDD VSS rb_tg_n2_av
Xrm19_XW2 vwl wl[19] wlw[19] g_row[19].u_rowl_n_5 VDD VSS rb_tg_n2
Xrm19_XW3 wl[19] wl0[19] wl0b[19] VDD VSS rb_tg_n2_as
Xrm20_XT1 vw row[20] wsel[20] wselb[20] VDD VSS rb_tgw_n20
Xrm20_XT3 vzero row[20] wz[20] wzb[20] VDD VSS rb_tg_n2
Xrm20_XT5 row[20] R1 sns[20] snsb[20] VDD VSS rb_tg_n2
Xrm20_XW1 wl[20] wlv[20] wlvb[20] VDD VSS rb_tg_n2_av
Xrm20_XW2 vwl wl[20] wlw[20] g_row[20].u_rowl_n_5 VDD VSS rb_tg_n2
Xrm20_XW3 wl[20] wl0[20] wl0b[20] VDD VSS rb_tg_n2_as
Xrm21_XT1 vw row[21] wsel[21] wselb[21] VDD VSS rb_tgw_n20
Xrm21_XT3 vzero row[21] wz[21] wzb[21] VDD VSS rb_tg_n2
Xrm21_XT5 row[21] R1 sns[21] snsb[21] VDD VSS rb_tg_n2
Xrm21_XW1 wl[21] wlv[21] wlvb[21] VDD VSS rb_tg_n2_av
Xrm21_XW2 vwl wl[21] wlw[21] g_row[21].u_rowl_n_5 VDD VSS rb_tg_n2
Xrm21_XW3 wl[21] wl0[21] wl0b[21] VDD VSS rb_tg_n2_as
Xrm22_XT1 vw row[22] wsel[22] wselb[22] VDD VSS rb_tgw_n20
Xrm22_XT3 vzero row[22] wz[22] wzb[22] VDD VSS rb_tg_n2
Xrm22_XT5 row[22] R1 sns[22] snsb[22] VDD VSS rb_tg_n2
Xrm22_XW1 wl[22] wlv[22] wlvb[22] VDD VSS rb_tg_n2_av
Xrm22_XW2 vwl wl[22] wlw[22] g_row[22].u_rowl_n_5 VDD VSS rb_tg_n2
Xrm22_XW3 wl[22] wl0[22] wl0b[22] VDD VSS rb_tg_n2_as
Xrm23_XT1 vw row[23] wsel[23] wselb[23] VDD VSS rb_tgw_n20
Xrm23_XT3 vzero row[23] wz[23] wzb[23] VDD VSS rb_tg_n2
Xrm23_XT5 row[23] R1 sns[23] snsb[23] VDD VSS rb_tg_n2
Xrm23_XW1 wl[23] wlv[23] wlvb[23] VDD VSS rb_tg_n2_av
Xrm23_XW2 vwl wl[23] wlw[23] g_row[23].u_rowl_n_5 VDD VSS rb_tg_n2
Xrm23_XW3 wl[23] wl0[23] wl0b[23] VDD VSS rb_tg_n2_as
Xrm24_XT1 vw row[24] wsel[24] wselb[24] VDD VSS rb_tgw_n20
Xrm24_XT3 vzero row[24] wz[24] wzb[24] VDD VSS rb_tg_n2
Xrm24_XT5 row[24] R1 sns[24] snsb[24] VDD VSS rb_tg_n2
Xrm24_XW1 wl[24] wlv[24] wlvb[24] VDD VSS rb_tg_n2_av
Xrm24_XW2 vwl wl[24] wlw[24] g_row[24].u_rowl_n_5 VDD VSS rb_tg_n2
Xrm24_XW3 wl[24] wl0[24] wl0b[24] VDD VSS rb_tg_n2_as
Xrm25_XT1 vw row[25] wsel[25] wselb[25] VDD VSS rb_tgw_n20
Xrm25_XT3 vzero row[25] wz[25] wzb[25] VDD VSS rb_tg_n2
Xrm25_XT5 row[25] R1 sns[25] snsb[25] VDD VSS rb_tg_n2
Xrm25_XW1 wl[25] wlv[25] wlvb[25] VDD VSS rb_tg_n2_av
Xrm25_XW2 vwl wl[25] wlw[25] g_row[25].u_rowl_n_5 VDD VSS rb_tg_n2
Xrm25_XW3 wl[25] wl0[25] wl0b[25] VDD VSS rb_tg_n2_as
Xrm26_XT1 vw row[26] wsel[26] wselb[26] VDD VSS rb_tgw_n20
Xrm26_XT3 vzero row[26] wz[26] wzb[26] VDD VSS rb_tg_n2
Xrm26_XT5 row[26] R1 sns[26] snsb[26] VDD VSS rb_tg_n2
Xrm26_XW1 wl[26] wlv[26] wlvb[26] VDD VSS rb_tg_n2_av
Xrm26_XW2 vwl wl[26] wlw[26] g_row[26].u_rowl_n_5 VDD VSS rb_tg_n2
Xrm26_XW3 wl[26] wl0[26] wl0b[26] VDD VSS rb_tg_n2_as
Xrm27_XT1 vw row[27] wsel[27] wselb[27] VDD VSS rb_tgw_n20
Xrm27_XT3 vzero row[27] wz[27] wzb[27] VDD VSS rb_tg_n2
Xrm27_XT5 row[27] R1 sns[27] snsb[27] VDD VSS rb_tg_n2
Xrm27_XW1 wl[27] wlv[27] wlvb[27] VDD VSS rb_tg_n2_av
Xrm27_XW2 vwl wl[27] wlw[27] g_row[27].u_rowl_n_5 VDD VSS rb_tg_n2
Xrm27_XW3 wl[27] wl0[27] wl0b[27] VDD VSS rb_tg_n2_as
Xrm28_XT1 vw row[28] wsel[28] wselb[28] VDD VSS rb_tgw_n20
Xrm28_XT3 vzero row[28] wz[28] wzb[28] VDD VSS rb_tg_n2
Xrm28_XT5 row[28] R1 sns[28] snsb[28] VDD VSS rb_tg_n2
Xrm28_XW1 wl[28] wlv[28] wlvb[28] VDD VSS rb_tg_n2_av
Xrm28_XW2 vwl wl[28] wlw[28] g_row[28].u_rowl_n_5 VDD VSS rb_tg_n2
Xrm28_XW3 wl[28] wl0[28] wl0b[28] VDD VSS rb_tg_n2_as
Xrm29_XT1 vw row[29] wsel[29] wselb[29] VDD VSS rb_tgw_n20
Xrm29_XT3 vzero row[29] wz[29] wzb[29] VDD VSS rb_tg_n2
Xrm29_XT5 row[29] R1 sns[29] snsb[29] VDD VSS rb_tg_n2
Xrm29_XW1 wl[29] wlv[29] wlvb[29] VDD VSS rb_tg_n2_av
Xrm29_XW2 vwl wl[29] wlw[29] g_row[29].u_rowl_n_5 VDD VSS rb_tg_n2
Xrm29_XW3 wl[29] wl0[29] wl0b[29] VDD VSS rb_tg_n2_as
Xrm30_XT1 vw row[30] wsel[30] wselb[30] VDD VSS rb_tgw_n20
Xrm30_XT3 vzero row[30] wz[30] wzb[30] VDD VSS rb_tg_n2
Xrm30_XT5 row[30] R1 sns[30] snsb[30] VDD VSS rb_tg_n2
Xrm30_XW1 wl[30] wlv[30] wlvb[30] VDD VSS rb_tg_n2_av
Xrm30_XW2 vwl wl[30] wlw[30] g_row[30].u_rowl_n_5 VDD VSS rb_tg_n2
Xrm30_XW3 wl[30] wl0[30] wl0b[30] VDD VSS rb_tg_n2_as
Xrm31_XT1 vw row[31] wsel[31] wselb[31] VDD VSS rb_tgw_n20
Xrm31_XT3 vzero row[31] wz[31] wzb[31] VDD VSS rb_tg_n2
Xrm31_XT5 row[31] R1 sns[31] snsb[31] VDD VSS rb_tg_n2
Xrm31_XW1 wl[31] wlv[31] wlvb[31] VDD VSS rb_tg_n2_av
Xrm31_XW2 vwl wl[31] wlw[31] g_row[31].u_rowl_n_5 VDD VSS rb_tg_n2
Xrm31_XW3 wl[31] wl0[31] wl0b[31] VDD VSS rb_tg_n2_as
Xrm32_XT1 vw row[32] wsel[32] wselb[32] VDD VSS rb_tgw_n20
Xrm32_XT3 vzero row[32] wz[32] wzb[32] VDD VSS rb_tg_n2
Xrm32_XT5 row[32] R1 sns[32] snsb[32] VDD VSS rb_tg_n2
Xrm32_XW1 wl[32] wlv[32] wlvb[32] VDD VSS rb_tg_n2_av
Xrm32_XW2 vwl wl[32] wlw[32] g_row[32].u_rowl_n_5 VDD VSS rb_tg_n2
Xrm32_XW3 wl[32] wl0[32] wl0b[32] VDD VSS rb_tg_n2_as
Xrm33_XT1 vw row[33] wsel[33] wselb[33] VDD VSS rb_tgw_n20
Xrm33_XT3 vzero row[33] wz[33] wzb[33] VDD VSS rb_tg_n2
Xrm33_XT5 row[33] R1 sns[33] snsb[33] VDD VSS rb_tg_n2
Xrm33_XW1 wl[33] wlv[33] wlvb[33] VDD VSS rb_tg_n2_av
Xrm33_XW2 vwl wl[33] wlw[33] g_row[33].u_rowl_n_5 VDD VSS rb_tg_n2
Xrm33_XW3 wl[33] wl0[33] wl0b[33] VDD VSS rb_tg_n2_as
Xrm34_XT1 vw row[34] wsel[34] wselb[34] VDD VSS rb_tgw_n20
Xrm34_XT3 vzero row[34] wz[34] wzb[34] VDD VSS rb_tg_n2
Xrm34_XT5 row[34] R1 sns[34] snsb[34] VDD VSS rb_tg_n2
Xrm34_XW1 wl[34] wlv[34] wlvb[34] VDD VSS rb_tg_n2_av
Xrm34_XW2 vwl wl[34] wlw[34] g_row[34].u_rowl_n_5 VDD VSS rb_tg_n2
Xrm34_XW3 wl[34] wl0[34] wl0b[34] VDD VSS rb_tg_n2_as
Xrm35_XT1 vw row[35] wsel[35] wselb[35] VDD VSS rb_tgw_n20
Xrm35_XT3 vzero row[35] wz[35] wzb[35] VDD VSS rb_tg_n2
Xrm35_XT5 row[35] R1 sns[35] snsb[35] VDD VSS rb_tg_n2
Xrm35_XW1 wl[35] wlv[35] wlvb[35] VDD VSS rb_tg_n2_av
Xrm35_XW2 vwl wl[35] wlw[35] g_row[35].u_rowl_n_5 VDD VSS rb_tg_n2
Xrm35_XW3 wl[35] wl0[35] wl0b[35] VDD VSS rb_tg_n2_as
Xrm36_XT1 vw row[36] wsel[36] wselb[36] VDD VSS rb_tgw_n20
Xrm36_XT3 vzero row[36] wz[36] wzb[36] VDD VSS rb_tg_n2
Xrm36_XT5 row[36] R1 sns[36] snsb[36] VDD VSS rb_tg_n2
Xrm36_XW1 wl[36] wlv[36] wlvb[36] VDD VSS rb_tg_n2_av
Xrm36_XW2 vwl wl[36] wlw[36] g_row[36].u_rowl_n_5 VDD VSS rb_tg_n2
Xrm36_XW3 wl[36] wl0[36] wl0b[36] VDD VSS rb_tg_n2_as
Xrm37_XT1 vw row[37] wsel[37] wselb[37] VDD VSS rb_tgw_n20
Xrm37_XT3 vzero row[37] wz[37] wzb[37] VDD VSS rb_tg_n2
Xrm37_XT5 row[37] R1 sns[37] snsb[37] VDD VSS rb_tg_n2
Xrm37_XW1 wl[37] wlv[37] wlvb[37] VDD VSS rb_tg_n2_av
Xrm37_XW2 vwl wl[37] wlw[37] g_row[37].u_rowl_n_5 VDD VSS rb_tg_n2
Xrm37_XW3 wl[37] wl0[37] wl0b[37] VDD VSS rb_tg_n2_as
Xrm38_XT1 vw row[38] wsel[38] wselb[38] VDD VSS rb_tgw_n20
Xrm38_XT3 vzero row[38] wz[38] wzb[38] VDD VSS rb_tg_n2
Xrm38_XT5 row[38] R1 sns[38] snsb[38] VDD VSS rb_tg_n2
Xrm38_XW1 wl[38] wlv[38] wlvb[38] VDD VSS rb_tg_n2_av
Xrm38_XW2 vwl wl[38] wlw[38] g_row[38].u_rowl_n_5 VDD VSS rb_tg_n2
Xrm38_XW3 wl[38] wl0[38] wl0b[38] VDD VSS rb_tg_n2_as
Xrm39_XT1 vw row[39] wsel[39] wselb[39] VDD VSS rb_tgw_n20
Xrm39_XT3 vzero row[39] wz[39] wzb[39] VDD VSS rb_tg_n2
Xrm39_XT5 row[39] R1 sns[39] snsb[39] VDD VSS rb_tg_n2
Xrm39_XW1 wl[39] wlv[39] wlvb[39] VDD VSS rb_tg_n2_av
Xrm39_XW2 vwl wl[39] wlw[39] g_row[39].u_rowl_n_5 VDD VSS rb_tg_n2
Xrm39_XW3 wl[39] wl0[39] wl0b[39] VDD VSS rb_tg_n2_as
Xrm40_XT1 vw row[40] wsel[40] wselb[40] VDD VSS rb_tgw_n20
Xrm40_XT3 vzero row[40] wz[40] wzb[40] VDD VSS rb_tg_n2
Xrm40_XT5 row[40] R1 sns[40] snsb[40] VDD VSS rb_tg_n2
Xrm40_XW1 wl[40] wlv[40] wlvb[40] VDD VSS rb_tg_n2_av
Xrm40_XW2 vwl wl[40] wlw[40] g_row[40].u_rowl_n_5 VDD VSS rb_tg_n2
Xrm40_XW3 wl[40] wl0[40] wl0b[40] VDD VSS rb_tg_n2_as
Xrm41_XT1 vw row[41] wsel[41] wselb[41] VDD VSS rb_tgw_n20
Xrm41_XT3 vzero row[41] wz[41] wzb[41] VDD VSS rb_tg_n2
Xrm41_XT5 row[41] R1 sns[41] snsb[41] VDD VSS rb_tg_n2
Xrm41_XW1 wl[41] wlv[41] wlvb[41] VDD VSS rb_tg_n2_av
Xrm41_XW2 vwl wl[41] wlw[41] g_row[41].u_rowl_n_5 VDD VSS rb_tg_n2
Xrm41_XW3 wl[41] wl0[41] wl0b[41] VDD VSS rb_tg_n2_as
Xrm42_XT1 vw row[42] wsel[42] wselb[42] VDD VSS rb_tgw_n20
Xrm42_XT3 vzero row[42] wz[42] wzb[42] VDD VSS rb_tg_n2
Xrm42_XT5 row[42] R1 sns[42] snsb[42] VDD VSS rb_tg_n2
Xrm42_XW1 wl[42] wlv[42] wlvb[42] VDD VSS rb_tg_n2_av
Xrm42_XW2 vwl wl[42] wlw[42] g_row[42].u_rowl_n_5 VDD VSS rb_tg_n2
Xrm42_XW3 wl[42] wl0[42] wl0b[42] VDD VSS rb_tg_n2_as
Xrm43_XT1 vw row[43] wsel[43] wselb[43] VDD VSS rb_tgw_n20
Xrm43_XT3 vzero row[43] wz[43] wzb[43] VDD VSS rb_tg_n2
Xrm43_XT5 row[43] R1 sns[43] snsb[43] VDD VSS rb_tg_n2
Xrm43_XW1 wl[43] wlv[43] wlvb[43] VDD VSS rb_tg_n2_av
Xrm43_XW2 vwl wl[43] wlw[43] g_row[43].u_rowl_n_5 VDD VSS rb_tg_n2
Xrm43_XW3 wl[43] wl0[43] wl0b[43] VDD VSS rb_tg_n2_as
Xrm44_XT1 vw row[44] wsel[44] wselb[44] VDD VSS rb_tgw_n20
Xrm44_XT3 vzero row[44] wz[44] wzb[44] VDD VSS rb_tg_n2
Xrm44_XT5 row[44] R1 sns[44] snsb[44] VDD VSS rb_tg_n2
Xrm44_XW1 wl[44] wlv[44] wlvb[44] VDD VSS rb_tg_n2_av
Xrm44_XW2 vwl wl[44] wlw[44] g_row[44].u_rowl_n_5 VDD VSS rb_tg_n2
Xrm44_XW3 wl[44] wl0[44] wl0b[44] VDD VSS rb_tg_n2_as
Xrm45_XT1 vw row[45] wsel[45] wselb[45] VDD VSS rb_tgw_n20
Xrm45_XT3 vzero row[45] wz[45] wzb[45] VDD VSS rb_tg_n2
Xrm45_XT5 row[45] R1 sns[45] snsb[45] VDD VSS rb_tg_n2
Xrm45_XW1 wl[45] wlv[45] wlvb[45] VDD VSS rb_tg_n2_av
Xrm45_XW2 vwl wl[45] wlw[45] g_row[45].u_rowl_n_5 VDD VSS rb_tg_n2
Xrm45_XW3 wl[45] wl0[45] wl0b[45] VDD VSS rb_tg_n2_as
Xrm46_XT1 vw row[46] wsel[46] wselb[46] VDD VSS rb_tgw_n20
Xrm46_XT3 vzero row[46] wz[46] wzb[46] VDD VSS rb_tg_n2
Xrm46_XT5 row[46] R1 sns[46] snsb[46] VDD VSS rb_tg_n2
Xrm46_XW1 wl[46] wlv[46] wlvb[46] VDD VSS rb_tg_n2_av
Xrm46_XW2 vwl wl[46] wlw[46] g_row[46].u_rowl_n_5 VDD VSS rb_tg_n2
Xrm46_XW3 wl[46] wl0[46] wl0b[46] VDD VSS rb_tg_n2_as
Xrm47_XT1 vw row[47] wsel[47] wselb[47] VDD VSS rb_tgw_n20
Xrm47_XT3 vzero row[47] wz[47] wzb[47] VDD VSS rb_tg_n2
Xrm47_XT5 row[47] R1 sns[47] snsb[47] VDD VSS rb_tg_n2
Xrm47_XW1 wl[47] wlv[47] wlvb[47] VDD VSS rb_tg_n2_av
Xrm47_XW2 vwl wl[47] wlw[47] g_row[47].u_rowl_n_5 VDD VSS rb_tg_n2
Xrm47_XW3 wl[47] wl0[47] wl0b[47] VDD VSS rb_tg_n2_as
Xrm48_XT1 vw row[48] wsel[48] wselb[48] VDD VSS rb_tgw_n20
Xrm48_XT3 vzero row[48] wz[48] wzb[48] VDD VSS rb_tg_n2
Xrm48_XT5 row[48] R1 sns[48] snsb[48] VDD VSS rb_tg_n2
Xrm48_XW1 wl[48] wlv[48] wlvb[48] VDD VSS rb_tg_n2_av
Xrm48_XW2 vwl wl[48] wlw[48] g_row[48].u_rowl_n_5 VDD VSS rb_tg_n2
Xrm48_XW3 wl[48] wl0[48] wl0b[48] VDD VSS rb_tg_n2_as
Xrm49_XT1 vw row[49] wsel[49] wselb[49] VDD VSS rb_tgw_n20
Xrm49_XT3 vzero row[49] wz[49] wzb[49] VDD VSS rb_tg_n2
Xrm49_XT5 row[49] R1 sns[49] snsb[49] VDD VSS rb_tg_n2
Xrm49_XW1 wl[49] wlv[49] wlvb[49] VDD VSS rb_tg_n2_av
Xrm49_XW2 vwl wl[49] wlw[49] g_row[49].u_rowl_n_5 VDD VSS rb_tg_n2
Xrm49_XW3 wl[49] wl0[49] wl0b[49] VDD VSS rb_tg_n2_as
Xrm50_XT1 vw row[50] wsel[50] wselb[50] VDD VSS rb_tgw_n20
Xrm50_XT3 vzero row[50] wz[50] wzb[50] VDD VSS rb_tg_n2
Xrm50_XT5 row[50] R1 sns[50] snsb[50] VDD VSS rb_tg_n2
Xrm50_XW1 wl[50] wlv[50] wlvb[50] VDD VSS rb_tg_n2_av
Xrm50_XW2 vwl wl[50] wlw[50] g_row[50].u_rowl_n_5 VDD VSS rb_tg_n2
Xrm50_XW3 wl[50] wl0[50] wl0b[50] VDD VSS rb_tg_n2_as
Xrm51_XT1 vw row[51] wsel[51] wselb[51] VDD VSS rb_tgw_n20
Xrm51_XT3 vzero row[51] wz[51] wzb[51] VDD VSS rb_tg_n2
Xrm51_XT5 row[51] R1 sns[51] snsb[51] VDD VSS rb_tg_n2
Xrm51_XW1 wl[51] wlv[51] wlvb[51] VDD VSS rb_tg_n2_av
Xrm51_XW2 vwl wl[51] wlw[51] g_row[51].u_rowl_n_5 VDD VSS rb_tg_n2
Xrm51_XW3 wl[51] wl0[51] wl0b[51] VDD VSS rb_tg_n2_as
Xrm52_XT1 vw row[52] wsel[52] wselb[52] VDD VSS rb_tgw_n20
Xrm52_XT3 vzero row[52] wz[52] wzb[52] VDD VSS rb_tg_n2
Xrm52_XT5 row[52] R1 sns[52] snsb[52] VDD VSS rb_tg_n2
Xrm52_XW1 wl[52] wlv[52] wlvb[52] VDD VSS rb_tg_n2_av
Xrm52_XW2 vwl wl[52] wlw[52] g_row[52].u_rowl_n_5 VDD VSS rb_tg_n2
Xrm52_XW3 wl[52] wl0[52] wl0b[52] VDD VSS rb_tg_n2_as
Xrm53_XT1 vw row[53] wsel[53] wselb[53] VDD VSS rb_tgw_n20
Xrm53_XT3 vzero row[53] wz[53] wzb[53] VDD VSS rb_tg_n2
Xrm53_XT5 row[53] R1 sns[53] snsb[53] VDD VSS rb_tg_n2
Xrm53_XW1 wl[53] wlv[53] wlvb[53] VDD VSS rb_tg_n2_av
Xrm53_XW2 vwl wl[53] wlw[53] g_row[53].u_rowl_n_5 VDD VSS rb_tg_n2
Xrm53_XW3 wl[53] wl0[53] wl0b[53] VDD VSS rb_tg_n2_as
Xrm54_XT1 vw row[54] wsel[54] wselb[54] VDD VSS rb_tgw_n20
Xrm54_XT3 vzero row[54] wz[54] wzb[54] VDD VSS rb_tg_n2
Xrm54_XT5 row[54] R1 sns[54] snsb[54] VDD VSS rb_tg_n2
Xrm54_XW1 wl[54] wlv[54] wlvb[54] VDD VSS rb_tg_n2_av
Xrm54_XW2 vwl wl[54] wlw[54] g_row[54].u_rowl_n_5 VDD VSS rb_tg_n2
Xrm54_XW3 wl[54] wl0[54] wl0b[54] VDD VSS rb_tg_n2_as
Xrm55_XT1 vw row[55] wsel[55] wselb[55] VDD VSS rb_tgw_n20
Xrm55_XT3 vzero row[55] wz[55] wzb[55] VDD VSS rb_tg_n2
Xrm55_XT5 row[55] R1 sns[55] snsb[55] VDD VSS rb_tg_n2
Xrm55_XW1 wl[55] wlv[55] wlvb[55] VDD VSS rb_tg_n2_av
Xrm55_XW2 vwl wl[55] wlw[55] g_row[55].u_rowl_n_5 VDD VSS rb_tg_n2
Xrm55_XW3 wl[55] wl0[55] wl0b[55] VDD VSS rb_tg_n2_as
Xrm56_XT1 vw row[56] wsel[56] wselb[56] VDD VSS rb_tgw_n20
Xrm56_XT3 vzero row[56] wz[56] wzb[56] VDD VSS rb_tg_n2
Xrm56_XT5 row[56] R1 sns[56] snsb[56] VDD VSS rb_tg_n2
Xrm56_XW1 wl[56] wlv[56] wlvb[56] VDD VSS rb_tg_n2_av
Xrm56_XW2 vwl wl[56] wlw[56] g_row[56].u_rowl_n_5 VDD VSS rb_tg_n2
Xrm56_XW3 wl[56] wl0[56] wl0b[56] VDD VSS rb_tg_n2_as
Xrm57_XT1 vw row[57] wsel[57] wselb[57] VDD VSS rb_tgw_n20
Xrm57_XT3 vzero row[57] wz[57] wzb[57] VDD VSS rb_tg_n2
Xrm57_XT5 row[57] R1 sns[57] snsb[57] VDD VSS rb_tg_n2
Xrm57_XW1 wl[57] wlv[57] wlvb[57] VDD VSS rb_tg_n2_av
Xrm57_XW2 vwl wl[57] wlw[57] g_row[57].u_rowl_n_5 VDD VSS rb_tg_n2
Xrm57_XW3 wl[57] wl0[57] wl0b[57] VDD VSS rb_tg_n2_as
Xrm58_XT1 vw row[58] wsel[58] wselb[58] VDD VSS rb_tgw_n20
Xrm58_XT3 vzero row[58] wz[58] wzb[58] VDD VSS rb_tg_n2
Xrm58_XT5 row[58] R1 sns[58] snsb[58] VDD VSS rb_tg_n2
Xrm58_XW1 wl[58] wlv[58] wlvb[58] VDD VSS rb_tg_n2_av
Xrm58_XW2 vwl wl[58] wlw[58] g_row[58].u_rowl_n_5 VDD VSS rb_tg_n2
Xrm58_XW3 wl[58] wl0[58] wl0b[58] VDD VSS rb_tg_n2_as
Xrm59_XT1 vw row[59] wsel[59] wselb[59] VDD VSS rb_tgw_n20
Xrm59_XT3 vzero row[59] wz[59] wzb[59] VDD VSS rb_tg_n2
Xrm59_XT5 row[59] R1 sns[59] snsb[59] VDD VSS rb_tg_n2
Xrm59_XW1 wl[59] wlv[59] wlvb[59] VDD VSS rb_tg_n2_av
Xrm59_XW2 vwl wl[59] wlw[59] g_row[59].u_rowl_n_5 VDD VSS rb_tg_n2
Xrm59_XW3 wl[59] wl0[59] wl0b[59] VDD VSS rb_tg_n2_as
Xrm60_XT1 vw row[60] wsel[60] wselb[60] VDD VSS rb_tgw_n20
Xrm60_XT3 vzero row[60] wz[60] wzb[60] VDD VSS rb_tg_n2
Xrm60_XT5 row[60] R1 sns[60] snsb[60] VDD VSS rb_tg_n2
Xrm60_XW1 wl[60] wlv[60] wlvb[60] VDD VSS rb_tg_n2_av
Xrm60_XW2 vwl wl[60] wlw[60] g_row[60].u_rowl_n_5 VDD VSS rb_tg_n2
Xrm60_XW3 wl[60] wl0[60] wl0b[60] VDD VSS rb_tg_n2_as
Xrm61_XT1 vw row[61] wsel[61] wselb[61] VDD VSS rb_tgw_n20
Xrm61_XT3 vzero row[61] wz[61] wzb[61] VDD VSS rb_tg_n2
Xrm61_XT5 row[61] R1 sns[61] snsb[61] VDD VSS rb_tg_n2
Xrm61_XW1 wl[61] wlv[61] wlvb[61] VDD VSS rb_tg_n2_av
Xrm61_XW2 vwl wl[61] wlw[61] g_row[61].u_rowl_n_5 VDD VSS rb_tg_n2
Xrm61_XW3 wl[61] wl0[61] wl0b[61] VDD VSS rb_tg_n2_as
Xrm62_XT1 vw row[62] wsel[62] wselb[62] VDD VSS rb_tgw_n20
Xrm62_XT3 vzero row[62] wz[62] wzb[62] VDD VSS rb_tg_n2
Xrm62_XT5 row[62] R1 sns[62] snsb[62] VDD VSS rb_tg_n2
Xrm62_XW1 wl[62] wlv[62] wlvb[62] VDD VSS rb_tg_n2_av
Xrm62_XW2 vwl wl[62] wlw[62] g_row[62].u_rowl_n_5 VDD VSS rb_tg_n2
Xrm62_XW3 wl[62] wl0[62] wl0b[62] VDD VSS rb_tg_n2_as
Xrm63_XT1 vw row[63] wsel[63] wselb[63] VDD VSS rb_tgw_n20
Xrm63_XT3 vzero row[63] wz[63] wzb[63] VDD VSS rb_tg_n2
Xrm63_XT5 row[63] R1 sns[63] snsb[63] VDD VSS rb_tg_n2
Xrm63_XW1 wl[63] wlv[63] wlvb[63] VDD VSS rb_tg_n2_av
Xrm63_XW2 vwl wl[63] wlw[63] g_row[63].u_rowl_n_5 VDD VSS rb_tg_n2
Xrm63_XW3 wl[63] wl0[63] wl0b[63] VDD VSS rb_tg_n2_as
Xrm64_XT1 vw row[64] wsel[64] wselb[64] VDD VSS rb_tgw_n20
Xrm64_XT3 vzero row[64] wz[64] wzb[64] VDD VSS rb_tg_n2
Xrm64_XT5 row[64] R1 sns[64] snsb[64] VDD VSS rb_tg_n2
Xrm64_XW1 wl[64] wlv[64] wlvb[64] VDD VSS rb_tg_n2_av
Xrm64_XW2 vwl wl[64] wlw[64] g_row[64].u_rowl_n_5 VDD VSS rb_tg_n2
Xrm64_XW3 wl[64] wl0[64] wl0b[64] VDD VSS rb_tg_n2_as
Xrm65_XT1 vw row[65] wsel[65] wselb[65] VDD VSS rb_tgw_n20
Xrm65_XT3 vzero row[65] wz[65] wzb[65] VDD VSS rb_tg_n2
Xrm65_XT5 row[65] R1 sns[65] snsb[65] VDD VSS rb_tg_n2
Xrm65_XW1 wl[65] wlv[65] wlvb[65] VDD VSS rb_tg_n2_av
Xrm65_XW2 vwl wl[65] wlw[65] g_row[65].u_rowl_n_5 VDD VSS rb_tg_n2
Xrm65_XW3 wl[65] wl0[65] wl0b[65] VDD VSS rb_tg_n2_as
Xrm66_XT1 vw row[66] wsel[66] wselb[66] VDD VSS rb_tgw_n20
Xrm66_XT3 vzero row[66] wz[66] wzb[66] VDD VSS rb_tg_n2
Xrm66_XT5 row[66] R1 sns[66] snsb[66] VDD VSS rb_tg_n2
Xrm66_XW1 wl[66] wlv[66] wlvb[66] VDD VSS rb_tg_n2_av
Xrm66_XW2 vwl wl[66] wlw[66] g_row[66].u_rowl_n_5 VDD VSS rb_tg_n2
Xrm66_XW3 wl[66] wl0[66] wl0b[66] VDD VSS rb_tg_n2_as
Xrm67_XT1 vw row[67] wsel[67] wselb[67] VDD VSS rb_tgw_n20
Xrm67_XT3 vzero row[67] wz[67] wzb[67] VDD VSS rb_tg_n2
Xrm67_XT5 row[67] R1 sns[67] snsb[67] VDD VSS rb_tg_n2
Xrm67_XW1 wl[67] wlv[67] wlvb[67] VDD VSS rb_tg_n2_av
Xrm67_XW2 vwl wl[67] wlw[67] g_row[67].u_rowl_n_5 VDD VSS rb_tg_n2
Xrm67_XW3 wl[67] wl0[67] wl0b[67] VDD VSS rb_tg_n2_as
Xrm68_XT1 vw row[68] wsel[68] wselb[68] VDD VSS rb_tgw_n20
Xrm68_XT3 vzero row[68] wz[68] wzb[68] VDD VSS rb_tg_n2
Xrm68_XT5 row[68] R1 sns[68] snsb[68] VDD VSS rb_tg_n2
Xrm68_XW1 wl[68] wlv[68] wlvb[68] VDD VSS rb_tg_n2_av
Xrm68_XW2 vwl wl[68] wlw[68] g_row[68].u_rowl_n_5 VDD VSS rb_tg_n2
Xrm68_XW3 wl[68] wl0[68] wl0b[68] VDD VSS rb_tg_n2_as
Xrm69_XT1 vw row[69] wsel[69] wselb[69] VDD VSS rb_tgw_n20
Xrm69_XT3 vzero row[69] wz[69] wzb[69] VDD VSS rb_tg_n2
Xrm69_XT5 row[69] R1 sns[69] snsb[69] VDD VSS rb_tg_n2
Xrm69_XW1 wl[69] wlv[69] wlvb[69] VDD VSS rb_tg_n2_av
Xrm69_XW2 vwl wl[69] wlw[69] g_row[69].u_rowl_n_5 VDD VSS rb_tg_n2
Xrm69_XW3 wl[69] wl0[69] wl0b[69] VDD VSS rb_tg_n2_as
Xrm70_XT1 vw row[70] wsel[70] wselb[70] VDD VSS rb_tgw_n20
Xrm70_XT3 vzero row[70] wz[70] wzb[70] VDD VSS rb_tg_n2
Xrm70_XT5 row[70] R1 sns[70] snsb[70] VDD VSS rb_tg_n2
Xrm70_XW1 wl[70] wlv[70] wlvb[70] VDD VSS rb_tg_n2_av
Xrm70_XW2 vwl wl[70] wlw[70] g_row[70].u_rowl_n_5 VDD VSS rb_tg_n2
Xrm70_XW3 wl[70] wl0[70] wl0b[70] VDD VSS rb_tg_n2_as
Xrm71_XT1 vw row[71] wsel[71] wselb[71] VDD VSS rb_tgw_n20
Xrm71_XT3 vzero row[71] wz[71] wzb[71] VDD VSS rb_tg_n2
Xrm71_XT5 row[71] R1 sns[71] snsb[71] VDD VSS rb_tg_n2
Xrm71_XW1 wl[71] wlv[71] wlvb[71] VDD VSS rb_tg_n2_av
Xrm71_XW2 vwl wl[71] wlw[71] g_row[71].u_rowl_n_5 VDD VSS rb_tg_n2
Xrm71_XW3 wl[71] wl0[71] wl0b[71] VDD VSS rb_tg_n2_as
Xrm72_XT1 vw row[72] wsel[72] wselb[72] VDD VSS rb_tgw_n20
Xrm72_XT3 vzero row[72] wz[72] wzb[72] VDD VSS rb_tg_n2
Xrm72_XT5 row[72] R1 sns[72] snsb[72] VDD VSS rb_tg_n2
Xrm72_XW1 wl[72] wlv[72] wlvb[72] VDD VSS rb_tg_n2_av
Xrm72_XW2 vwl wl[72] wlw[72] g_row[72].u_rowl_n_5 VDD VSS rb_tg_n2
Xrm72_XW3 wl[72] wl0[72] wl0b[72] VDD VSS rb_tg_n2_as
Xrm73_XT1 vw row[73] wsel[73] wselb[73] VDD VSS rb_tgw_n20
Xrm73_XT3 vzero row[73] wz[73] wzb[73] VDD VSS rb_tg_n2
Xrm73_XT5 row[73] R1 sns[73] snsb[73] VDD VSS rb_tg_n2
Xrm73_XW1 wl[73] wlv[73] wlvb[73] VDD VSS rb_tg_n2_av
Xrm73_XW2 vwl wl[73] wlw[73] g_row[73].u_rowl_n_5 VDD VSS rb_tg_n2
Xrm73_XW3 wl[73] wl0[73] wl0b[73] VDD VSS rb_tg_n2_as
Xrm74_XT1 vw row[74] wsel[74] wselb[74] VDD VSS rb_tgw_n20
Xrm74_XT3 vzero row[74] wz[74] wzb[74] VDD VSS rb_tg_n2
Xrm74_XT5 row[74] R1 sns[74] snsb[74] VDD VSS rb_tg_n2
Xrm74_XW1 wl[74] wlv[74] wlvb[74] VDD VSS rb_tg_n2_av
Xrm74_XW2 vwl wl[74] wlw[74] g_row[74].u_rowl_n_5 VDD VSS rb_tg_n2
Xrm74_XW3 wl[74] wl0[74] wl0b[74] VDD VSS rb_tg_n2_as
Xrm75_XT1 vw row[75] wsel[75] wselb[75] VDD VSS rb_tgw_n20
Xrm75_XT3 vzero row[75] wz[75] wzb[75] VDD VSS rb_tg_n2
Xrm75_XT5 row[75] R1 sns[75] snsb[75] VDD VSS rb_tg_n2
Xrm75_XW1 wl[75] wlv[75] wlvb[75] VDD VSS rb_tg_n2_av
Xrm75_XW2 vwl wl[75] wlw[75] g_row[75].u_rowl_n_5 VDD VSS rb_tg_n2
Xrm75_XW3 wl[75] wl0[75] wl0b[75] VDD VSS rb_tg_n2_as
Xrm76_XT1 vw row[76] wsel[76] wselb[76] VDD VSS rb_tgw_n20
Xrm76_XT3 vzero row[76] wz[76] wzb[76] VDD VSS rb_tg_n2
Xrm76_XT5 row[76] R1 sns[76] snsb[76] VDD VSS rb_tg_n2
Xrm76_XW1 wl[76] wlv[76] wlvb[76] VDD VSS rb_tg_n2_av
Xrm76_XW2 vwl wl[76] wlw[76] g_row[76].u_rowl_n_5 VDD VSS rb_tg_n2
Xrm76_XW3 wl[76] wl0[76] wl0b[76] VDD VSS rb_tg_n2_as
Xrm77_XT1 vw row[77] wsel[77] wselb[77] VDD VSS rb_tgw_n20
Xrm77_XT3 vzero row[77] wz[77] wzb[77] VDD VSS rb_tg_n2
Xrm77_XT5 row[77] R1 sns[77] snsb[77] VDD VSS rb_tg_n2
Xrm77_XW1 wl[77] wlv[77] wlvb[77] VDD VSS rb_tg_n2_av
Xrm77_XW2 vwl wl[77] wlw[77] g_row[77].u_rowl_n_5 VDD VSS rb_tg_n2
Xrm77_XW3 wl[77] wl0[77] wl0b[77] VDD VSS rb_tg_n2_as
Xrm78_XT1 vw row[78] wsel[78] wselb[78] VDD VSS rb_tgw_n20
Xrm78_XT3 vzero row[78] wz[78] wzb[78] VDD VSS rb_tg_n2
Xrm78_XT5 row[78] R1 sns[78] snsb[78] VDD VSS rb_tg_n2
Xrm78_XW1 wl[78] wlv[78] wlvb[78] VDD VSS rb_tg_n2_av
Xrm78_XW2 vwl wl[78] wlw[78] g_row[78].u_rowl_n_5 VDD VSS rb_tg_n2
Xrm78_XW3 wl[78] wl0[78] wl0b[78] VDD VSS rb_tg_n2_as
Xrm79_XT1 vw row[79] wsel[79] wselb[79] VDD VSS rb_tgw_n20
Xrm79_XT3 vzero row[79] wz[79] wzb[79] VDD VSS rb_tg_n2
Xrm79_XT5 row[79] R1 sns[79] snsb[79] VDD VSS rb_tg_n2
Xrm79_XW1 wl[79] wlv[79] wlvb[79] VDD VSS rb_tg_n2_av
Xrm79_XW2 vwl wl[79] wlw[79] g_row[79].u_rowl_n_5 VDD VSS rb_tg_n2
Xrm79_XW3 wl[79] wl0[79] wl0b[79] VDD VSS rb_tg_n2_as
Xrm80_XT1 vw row[80] wsel[80] wselb[80] VDD VSS rb_tgw_n20
Xrm80_XT3 vzero row[80] wz[80] wzb[80] VDD VSS rb_tg_n2
Xrm80_XT5 row[80] R1 sns[80] snsb[80] VDD VSS rb_tg_n2
Xrm80_XW1 wl[80] wlv[80] wlvb[80] VDD VSS rb_tg_n2_av
Xrm80_XW2 vwl wl[80] wlw[80] g_row[80].u_rowl_n_5 VDD VSS rb_tg_n2
Xrm80_XW3 wl[80] wl0[80] wl0b[80] VDD VSS rb_tg_n2_as
Xrm81_XT1 vw row[81] wsel[81] wselb[81] VDD VSS rb_tgw_n20
Xrm81_XT3 vzero row[81] wz[81] wzb[81] VDD VSS rb_tg_n2
Xrm81_XT5 row[81] R1 sns[81] snsb[81] VDD VSS rb_tg_n2
Xrm81_XW1 wl[81] wlv[81] wlvb[81] VDD VSS rb_tg_n2_av
Xrm81_XW2 vwl wl[81] wlw[81] g_row[81].u_rowl_n_5 VDD VSS rb_tg_n2
Xrm81_XW3 wl[81] wl0[81] wl0b[81] VDD VSS rb_tg_n2_as
Xrm82_XT1 vw row[82] wsel[82] wselb[82] VDD VSS rb_tgw_n20
Xrm82_XT3 vzero row[82] wz[82] wzb[82] VDD VSS rb_tg_n2
Xrm82_XT5 row[82] R1 sns[82] snsb[82] VDD VSS rb_tg_n2
Xrm82_XW1 wl[82] wlv[82] wlvb[82] VDD VSS rb_tg_n2_av
Xrm82_XW2 vwl wl[82] wlw[82] g_row[82].u_rowl_n_5 VDD VSS rb_tg_n2
Xrm82_XW3 wl[82] wl0[82] wl0b[82] VDD VSS rb_tg_n2_as
Xrm83_XT1 vw row[83] wsel[83] wselb[83] VDD VSS rb_tgw_n20
Xrm83_XT3 vzero row[83] wz[83] wzb[83] VDD VSS rb_tg_n2
Xrm83_XT5 row[83] R1 sns[83] snsb[83] VDD VSS rb_tg_n2
Xrm83_XW1 wl[83] wlv[83] wlvb[83] VDD VSS rb_tg_n2_av
Xrm83_XW2 vwl wl[83] wlw[83] g_row[83].u_rowl_n_5 VDD VSS rb_tg_n2
Xrm83_XW3 wl[83] wl0[83] wl0b[83] VDD VSS rb_tg_n2_as
Xrm84_XT1 vw row[84] wsel[84] wselb[84] VDD VSS rb_tgw_n20
Xrm84_XT3 vzero row[84] wz[84] wzb[84] VDD VSS rb_tg_n2
Xrm84_XT5 row[84] R1 sns[84] snsb[84] VDD VSS rb_tg_n2
Xrm84_XW1 wl[84] wlv[84] wlvb[84] VDD VSS rb_tg_n2_av
Xrm84_XW2 vwl wl[84] wlw[84] g_row[84].u_rowl_n_5 VDD VSS rb_tg_n2
Xrm84_XW3 wl[84] wl0[84] wl0b[84] VDD VSS rb_tg_n2_as
Xrm85_XT1 vw row[85] wsel[85] wselb[85] VDD VSS rb_tgw_n20
Xrm85_XT3 vzero row[85] wz[85] wzb[85] VDD VSS rb_tg_n2
Xrm85_XT5 row[85] R1 sns[85] snsb[85] VDD VSS rb_tg_n2
Xrm85_XW1 wl[85] wlv[85] wlvb[85] VDD VSS rb_tg_n2_av
Xrm85_XW2 vwl wl[85] wlw[85] g_row[85].u_rowl_n_5 VDD VSS rb_tg_n2
Xrm85_XW3 wl[85] wl0[85] wl0b[85] VDD VSS rb_tg_n2_as
Xrm86_XT1 vw row[86] wsel[86] wselb[86] VDD VSS rb_tgw_n20
Xrm86_XT3 vzero row[86] wz[86] wzb[86] VDD VSS rb_tg_n2
Xrm86_XT5 row[86] R1 sns[86] snsb[86] VDD VSS rb_tg_n2
Xrm86_XW1 wl[86] wlv[86] wlvb[86] VDD VSS rb_tg_n2_av
Xrm86_XW2 vwl wl[86] wlw[86] g_row[86].u_rowl_n_5 VDD VSS rb_tg_n2
Xrm86_XW3 wl[86] wl0[86] wl0b[86] VDD VSS rb_tg_n2_as
Xrm87_XT1 vw row[87] wsel[87] wselb[87] VDD VSS rb_tgw_n20
Xrm87_XT3 vzero row[87] wz[87] wzb[87] VDD VSS rb_tg_n2
Xrm87_XT5 row[87] R1 sns[87] snsb[87] VDD VSS rb_tg_n2
Xrm87_XW1 wl[87] wlv[87] wlvb[87] VDD VSS rb_tg_n2_av
Xrm87_XW2 vwl wl[87] wlw[87] g_row[87].u_rowl_n_5 VDD VSS rb_tg_n2
Xrm87_XW3 wl[87] wl0[87] wl0b[87] VDD VSS rb_tg_n2_as
Xrm88_XT1 vw row[88] wsel[88] wselb[88] VDD VSS rb_tgw_n20
Xrm88_XT3 vzero row[88] wz[88] wzb[88] VDD VSS rb_tg_n2
Xrm88_XT5 row[88] R1 sns[88] snsb[88] VDD VSS rb_tg_n2
Xrm88_XW1 wl[88] wlv[88] wlvb[88] VDD VSS rb_tg_n2_av
Xrm88_XW2 vwl wl[88] wlw[88] g_row[88].u_rowl_n_5 VDD VSS rb_tg_n2
Xrm88_XW3 wl[88] wl0[88] wl0b[88] VDD VSS rb_tg_n2_as
Xrm89_XT1 vw row[89] wsel[89] wselb[89] VDD VSS rb_tgw_n20
Xrm89_XT3 vzero row[89] wz[89] wzb[89] VDD VSS rb_tg_n2
Xrm89_XT5 row[89] R1 sns[89] snsb[89] VDD VSS rb_tg_n2
Xrm89_XW1 wl[89] wlv[89] wlvb[89] VDD VSS rb_tg_n2_av
Xrm89_XW2 vwl wl[89] wlw[89] g_row[89].u_rowl_n_5 VDD VSS rb_tg_n2
Xrm89_XW3 wl[89] wl0[89] wl0b[89] VDD VSS rb_tg_n2_as
Xrm90_XT1 vw row[90] wsel[90] wselb[90] VDD VSS rb_tgw_n20
Xrm90_XT3 vzero row[90] wz[90] wzb[90] VDD VSS rb_tg_n2
Xrm90_XT5 row[90] R1 sns[90] snsb[90] VDD VSS rb_tg_n2
Xrm90_XW1 wl[90] wlv[90] wlvb[90] VDD VSS rb_tg_n2_av
Xrm90_XW2 vwl wl[90] wlw[90] g_row[90].u_rowl_n_5 VDD VSS rb_tg_n2
Xrm90_XW3 wl[90] wl0[90] wl0b[90] VDD VSS rb_tg_n2_as
Xrm91_XT1 vw row[91] wsel[91] wselb[91] VDD VSS rb_tgw_n20
Xrm91_XT3 vzero row[91] wz[91] wzb[91] VDD VSS rb_tg_n2
Xrm91_XT5 row[91] R1 sns[91] snsb[91] VDD VSS rb_tg_n2
Xrm91_XW1 wl[91] wlv[91] wlvb[91] VDD VSS rb_tg_n2_av
Xrm91_XW2 vwl wl[91] wlw[91] g_row[91].u_rowl_n_5 VDD VSS rb_tg_n2
Xrm91_XW3 wl[91] wl0[91] wl0b[91] VDD VSS rb_tg_n2_as
Xrm92_XT1 vw row[92] wsel[92] wselb[92] VDD VSS rb_tgw_n20
Xrm92_XT3 vzero row[92] wz[92] wzb[92] VDD VSS rb_tg_n2
Xrm92_XT5 row[92] R1 sns[92] snsb[92] VDD VSS rb_tg_n2
Xrm92_XW1 wl[92] wlv[92] wlvb[92] VDD VSS rb_tg_n2_av
Xrm92_XW2 vwl wl[92] wlw[92] g_row[92].u_rowl_n_5 VDD VSS rb_tg_n2
Xrm92_XW3 wl[92] wl0[92] wl0b[92] VDD VSS rb_tg_n2_as
Xrm93_XT1 vw row[93] wsel[93] wselb[93] VDD VSS rb_tgw_n20
Xrm93_XT3 vzero row[93] wz[93] wzb[93] VDD VSS rb_tg_n2
Xrm93_XT5 row[93] R1 sns[93] snsb[93] VDD VSS rb_tg_n2
Xrm93_XW1 wl[93] wlv[93] wlvb[93] VDD VSS rb_tg_n2_av
Xrm93_XW2 vwl wl[93] wlw[93] g_row[93].u_rowl_n_5 VDD VSS rb_tg_n2
Xrm93_XW3 wl[93] wl0[93] wl0b[93] VDD VSS rb_tg_n2_as
Xrm94_XT1 vw row[94] wsel[94] wselb[94] VDD VSS rb_tgw_n20
Xrm94_XT3 vzero row[94] wz[94] wzb[94] VDD VSS rb_tg_n2
Xrm94_XT5 row[94] R1 sns[94] snsb[94] VDD VSS rb_tg_n2
Xrm94_XW1 wl[94] wlv[94] wlvb[94] VDD VSS rb_tg_n2_av
Xrm94_XW2 vwl wl[94] wlw[94] g_row[94].u_rowl_n_5 VDD VSS rb_tg_n2
Xrm94_XW3 wl[94] wl0[94] wl0b[94] VDD VSS rb_tg_n2_as
Xrm95_XT1 vw row[95] wsel[95] wselb[95] VDD VSS rb_tgw_n20
Xrm95_XT3 vzero row[95] wz[95] wzb[95] VDD VSS rb_tg_n2
Xrm95_XT5 row[95] R1 sns[95] snsb[95] VDD VSS rb_tg_n2
Xrm95_XW1 wl[95] wlv[95] wlvb[95] VDD VSS rb_tg_n2_av
Xrm95_XW2 vwl wl[95] wlw[95] g_row[95].u_rowl_n_5 VDD VSS rb_tg_n2
Xrm95_XW3 wl[95] wl0[95] wl0b[95] VDD VSS rb_tg_n2_as
Xrm96_XT1 vw row[96] wsel[96] wselb[96] VDD VSS rb_tgw_n20
Xrm96_XT3 vzero row[96] wz[96] wzb[96] VDD VSS rb_tg_n2
Xrm96_XT5 row[96] R1 sns[96] snsb[96] VDD VSS rb_tg_n2
Xrm96_XW1 wl[96] wlv[96] wlvb[96] VDD VSS rb_tg_n2_av
Xrm96_XW2 vwl wl[96] wlw[96] g_row[96].u_rowl_n_5 VDD VSS rb_tg_n2
Xrm96_XW3 wl[96] wl0[96] wl0b[96] VDD VSS rb_tg_n2_as
Xrm97_XT1 vw row[97] wsel[97] wselb[97] VDD VSS rb_tgw_n20
Xrm97_XT3 vzero row[97] wz[97] wzb[97] VDD VSS rb_tg_n2
Xrm97_XT5 row[97] R1 sns[97] snsb[97] VDD VSS rb_tg_n2
Xrm97_XW1 wl[97] wlv[97] wlvb[97] VDD VSS rb_tg_n2_av
Xrm97_XW2 vwl wl[97] wlw[97] g_row[97].u_rowl_n_5 VDD VSS rb_tg_n2
Xrm97_XW3 wl[97] wl0[97] wl0b[97] VDD VSS rb_tg_n2_as
Xrm98_XT1 vw row[98] wsel[98] wselb[98] VDD VSS rb_tgw_n20
Xrm98_XT3 vzero row[98] wz[98] wzb[98] VDD VSS rb_tg_n2
Xrm98_XT5 row[98] R1 sns[98] snsb[98] VDD VSS rb_tg_n2
Xrm98_XW1 wl[98] wlv[98] wlvb[98] VDD VSS rb_tg_n2_av
Xrm98_XW2 vwl wl[98] wlw[98] g_row[98].u_rowl_n_5 VDD VSS rb_tg_n2
Xrm98_XW3 wl[98] wl0[98] wl0b[98] VDD VSS rb_tg_n2_as
Xrm99_XT1 vw row[99] wsel[99] wselb[99] VDD VSS rb_tgw_n20
Xrm99_XT3 vzero row[99] wz[99] wzb[99] VDD VSS rb_tg_n2
Xrm99_XT5 row[99] R1 sns[99] snsb[99] VDD VSS rb_tg_n2
Xrm99_XW1 wl[99] wlv[99] wlvb[99] VDD VSS rb_tg_n2_av
Xrm99_XW2 vwl wl[99] wlw[99] g_row[99].u_rowl_n_5 VDD VSS rb_tg_n2
Xrm99_XW3 wl[99] wl0[99] wl0b[99] VDD VSS rb_tg_n2_as
Xrm100_XT1 vw row[100] wsel[100] wselb[100] VDD VSS rb_tgw_n20
Xrm100_XT3 vzero row[100] wz[100] wzb[100] VDD VSS rb_tg_n2
Xrm100_XT5 row[100] R2 sns[100] snsb[100] VDD VSS rb_tg_n2
Xrm100_XW1 wl[100] wlv[100] wlvb[100] VDD VSS rb_tg_n2_av
Xrm100_XW2 vwl wl[100] wlw[100] g_row[100].u_rowl_n_5 VDD VSS rb_tg_n2
Xrm100_XW3 wl[100] wl0[100] wl0b[100] VDD VSS rb_tg_n2_as
Xrm101_XT1 vw row[101] wsel[101] wselb[101] VDD VSS rb_tgw_n20
Xrm101_XT3 vzero row[101] wz[101] wzb[101] VDD VSS rb_tg_n2
Xrm101_XT5 row[101] R2 sns[101] snsb[101] VDD VSS rb_tg_n2
Xrm101_XW1 wl[101] wlv[101] wlvb[101] VDD VSS rb_tg_n2_av
Xrm101_XW2 vwl wl[101] wlw[101] g_row[101].u_rowl_n_5 VDD VSS rb_tg_n2
Xrm101_XW3 wl[101] wl0[101] wl0b[101] VDD VSS rb_tg_n2_as
Xrm102_XT1 vw row[102] wsel[102] wselb[102] VDD VSS rb_tgw_n20
Xrm102_XT3 vzero row[102] wz[102] wzb[102] VDD VSS rb_tg_n2
Xrm102_XT5 row[102] R2 sns[102] snsb[102] VDD VSS rb_tg_n2
Xrm102_XW1 wl[102] wlv[102] wlvb[102] VDD VSS rb_tg_n2_av
Xrm102_XW2 vwl wl[102] wlw[102] g_row[102].u_rowl_n_5 VDD VSS rb_tg_n2
Xrm102_XW3 wl[102] wl0[102] wl0b[102] VDD VSS rb_tg_n2_as
Xrm103_XT1 vw row[103] wsel[103] wselb[103] VDD VSS rb_tgw_n20
Xrm103_XT3 vzero row[103] wz[103] wzb[103] VDD VSS rb_tg_n2
Xrm103_XT5 row[103] R2 sns[103] snsb[103] VDD VSS rb_tg_n2
Xrm103_XW1 wl[103] wlv[103] wlvb[103] VDD VSS rb_tg_n2_av
Xrm103_XW2 vwl wl[103] wlw[103] g_row[103].u_rowl_n_5 VDD VSS rb_tg_n2
Xrm103_XW3 wl[103] wl0[103] wl0b[103] VDD VSS rb_tg_n2_as
Xrm104_XT1 vw row[104] wsel[104] wselb[104] VDD VSS rb_tgw_n20
Xrm104_XT3 vzero row[104] wz[104] wzb[104] VDD VSS rb_tg_n2
Xrm104_XT5 row[104] R2 sns[104] snsb[104] VDD VSS rb_tg_n2
Xrm104_XW1 wl[104] wlv[104] wlvb[104] VDD VSS rb_tg_n2_av
Xrm104_XW2 vwl wl[104] wlw[104] g_row[104].u_rowl_n_5 VDD VSS rb_tg_n2
Xrm104_XW3 wl[104] wl0[104] wl0b[104] VDD VSS rb_tg_n2_as
Xrm105_XT1 vw row[105] wsel[105] wselb[105] VDD VSS rb_tgw_n20
Xrm105_XT3 vzero row[105] wz[105] wzb[105] VDD VSS rb_tg_n2
Xrm105_XT5 row[105] R2 sns[105] snsb[105] VDD VSS rb_tg_n2
Xrm105_XW1 wl[105] wlv[105] wlvb[105] VDD VSS rb_tg_n2_av
Xrm105_XW2 vwl wl[105] wlw[105] g_row[105].u_rowl_n_5 VDD VSS rb_tg_n2
Xrm105_XW3 wl[105] wl0[105] wl0b[105] VDD VSS rb_tg_n2_as
.ENDS row_blk
