* chip_core r3 — mk_top.py 2026-10-28 07:35, col_blk = digital/col_blk/out/col_blk, arr = layout/top/strap/arr_w3s_128x64.cdl
* LVS source. 블록 CDL 의 .SUBCKT 핀 순서대로 연결. 1'b0 (lo, wl_106–127) = VSS.

.INCLUDE /home/grads/s/seokjindaveoh/work/ep_dr/layout/top/net/lib/sky130_fd_sc_hvl_u.cdl
.INCLUDE /home/grads/s/seokjindaveoh/work/ep_dr/layout/top/net/lib/rb_macros.cdl
.INCLUDE /home/grads/s/seokjindaveoh/work/ep_dr/layout/top/net/lib/cb_tg_n2.cdl
.INCLUDE /home/grads/s/seokjindaveoh/work/ep_dr/layout/top/net/lib/cb_tgw_n20.cdl
.INCLUDE /home/grads/s/seokjindaveoh/work/ep_dr/layout/top/net/lib/clamp_d2r.cdl
.INCLUDE /home/grads/s/seokjindaveoh/work/ep_dr/layout/top/net/lib/arr_w3s_128x64.cdl
.INCLUDE /home/grads/s/seokjindaveoh/work/ep_dr/layout/top/net/lib/input_drive.cdl
.INCLUDE /home/grads/s/seokjindaveoh/work/ep_dr/layout/top/net/lib/row_blk.cdl
.INCLUDE /home/grads/s/seokjindaveoh/work/ep_dr/layout/top/net/lib/col_blk.cdl
.INCLUDE /home/grads/s/seokjindaveoh/work/ep_dr/layout/top/net/lib/data_blk.cdl
.INCLUDE /home/grads/s/seokjindaveoh/work/ep_dr/layout/top/net/lib/wbuf.cdl
.INCLUDE /home/grads/s/seokjindaveoh/work/ep_dr/layout/top/net/lib/tg_n2.cdl
.INCLUDE /home/grads/s/seokjindaveoh/work/ep_dr/layout/top/net/lib/wu.cdl
.INCLUDE /home/grads/s/seokjindaveoh/work/ep_dr/layout/top/net/lib/glob_dig.cdl
.INCLUDE /home/grads/s/seokjindaveoh/work/ep_dr/layout/top/net/lib/bias_beta.cdl
.INCLUDE /home/grads/s/seokjindaveoh/work/ep_dr/layout/top/net/lib/nudge_inj.cdl
.INCLUDE /home/grads/s/seokjindaveoh/work/ep_dr/layout/top/net/lib/tp_tl.cdl
.INCLUDE /home/grads/s/seokjindaveoh/work/ep_dr/layout/top/net/lib/tp_br.cdl
.INCLUDE /home/grads/s/seokjindaveoh/work/ep_dr/layout/top/net/lib/tp_bandl.cdl
.INCLUDE /home/grads/s/seokjindaveoh/work/ep_dr/layout/top/net/lib/tp_bandr.cdl

.SUBCKT chip_core SCK SDI SLD RST SEL_EN WP CK CK3 LAT LQ1 LQ2 VRAILP VRAILM VWH VWLO VWL VBUS_F VBUS_N IBIAS VBNC VBPC IBIASP VDD VSS VCM
Xarr_f row_f_0 row_f_1 row_f_2 row_f_3 row_f_4 row_f_5 row_f_6 row_f_7 row_f_8 row_f_9 row_f_10 row_f_11 row_f_12 row_f_13 row_f_14 row_f_15 row_f_16 row_f_17 row_f_18 row_f_19 row_f_20 row_f_21
+ row_f_22 row_f_23 row_f_24 row_f_25 row_f_26 row_f_27 row_f_28 row_f_29 row_f_30 row_f_31 row_f_32 row_f_33 row_f_34 row_f_35 row_f_36 row_f_37 row_f_38 row_f_39 row_f_40 row_f_41 row_f_42 row_f_43
+ row_f_44 row_f_45 row_f_46 row_f_47 row_f_48 row_f_49 row_f_50 row_f_51 row_f_52 row_f_53 row_f_54 row_f_55 row_f_56 row_f_57 row_f_58 row_f_59 row_f_60 row_f_61 row_f_62 row_f_63 row_f_64 row_f_65
+ row_f_66 row_f_67 row_f_68 row_f_69 row_f_70 row_f_71 row_f_72 row_f_73 row_f_74 row_f_75 row_f_76 row_f_77 row_f_78 row_f_79 row_f_80 row_f_81 row_f_82 row_f_83 row_f_84 row_f_85 row_f_86 row_f_87
+ row_f_88 row_f_89 row_f_90 row_f_91 row_f_92 row_f_93 row_f_94 row_f_95 row_f_96 row_f_97 row_f_98 row_f_99 row_f_100 row_f_101 row_f_102 row_f_103 row_f_104 row_f_105 nc_arr_f_row_106
+ nc_arr_f_row_107 nc_arr_f_row_108 nc_arr_f_row_109 nc_arr_f_row_110 nc_arr_f_row_111 nc_arr_f_row_112 nc_arr_f_row_113 nc_arr_f_row_114 nc_arr_f_row_115 nc_arr_f_row_116 nc_arr_f_row_117
+ nc_arr_f_row_118 nc_arr_f_row_119 nc_arr_f_row_120 nc_arr_f_row_121 nc_arr_f_row_122 nc_arr_f_row_123 nc_arr_f_row_124 nc_arr_f_row_125 nc_arr_f_row_126 nc_arr_f_row_127 wl_f_0 wl_f_1 wl_f_2 wl_f_3
+ wl_f_4 wl_f_5 wl_f_6 wl_f_7 wl_f_8 wl_f_9 wl_f_10 wl_f_11 wl_f_12 wl_f_13 wl_f_14 wl_f_15 wl_f_16 wl_f_17 wl_f_18 wl_f_19 wl_f_20 wl_f_21 wl_f_22 wl_f_23 wl_f_24 wl_f_25 wl_f_26 wl_f_27 wl_f_28
+ wl_f_29 wl_f_30 wl_f_31 wl_f_32 wl_f_33 wl_f_34 wl_f_35 wl_f_36 wl_f_37 wl_f_38 wl_f_39 wl_f_40 wl_f_41 wl_f_42 wl_f_43 wl_f_44 wl_f_45 wl_f_46 wl_f_47 wl_f_48 wl_f_49 wl_f_50 wl_f_51 wl_f_52 wl_f_53
+ wl_f_54 wl_f_55 wl_f_56 wl_f_57 wl_f_58 wl_f_59 wl_f_60 wl_f_61 wl_f_62 wl_f_63 wl_f_64 wl_f_65 wl_f_66 wl_f_67 wl_f_68 wl_f_69 wl_f_70 wl_f_71 wl_f_72 wl_f_73 wl_f_74 wl_f_75 wl_f_76 wl_f_77 wl_f_78
+ wl_f_79 wl_f_80 wl_f_81 wl_f_82 wl_f_83 wl_f_84 wl_f_85 wl_f_86 wl_f_87 wl_f_88 wl_f_89 wl_f_90 wl_f_91 wl_f_92 wl_f_93 wl_f_94 wl_f_95 wl_f_96 wl_f_97 wl_f_98 wl_f_99 wl_f_100 wl_f_101 wl_f_102
+ wl_f_103 wl_f_104 wl_f_105 VSS VSS VSS VSS VSS VSS VSS VSS VSS VSS VSS VSS VSS VSS VSS VSS VSS VSS VSS VSS VSS VSS col_f_0 col_f_1 col_f_2 col_f_3 col_f_4 col_f_5 col_f_6 col_f_7 col_f_8 col_f_9
+ col_f_10 col_f_11 col_f_12 col_f_13 col_f_14 col_f_15 col_f_16 col_f_17 col_f_18 col_f_19 col_f_20 col_f_21 col_f_22 col_f_23 col_f_24 col_f_25 col_f_26 col_f_27 col_f_28 col_f_29 col_f_30 col_f_31
+ col_f_32 col_f_33 col_f_34 col_f_35 col_f_36 col_f_37 col_f_38 col_f_39 col_f_40 col_f_41 col_f_42 col_f_43 col_f_44 col_f_45 col_f_46 col_f_47 col_f_48 col_f_49 col_f_50 col_f_51 col_f_52 col_f_53
+ col_f_54 col_f_55 col_f_56 col_f_57 col_f_58 col_f_59 col_f_60 col_f_61 col_f_62 col_f_63 VSS arr_w3s_128x64
Xarr_n row_n_0 row_n_1 row_n_2 row_n_3 row_n_4 row_n_5 row_n_6 row_n_7 row_n_8 row_n_9 row_n_10 row_n_11 row_n_12 row_n_13 row_n_14 row_n_15 row_n_16 row_n_17 row_n_18 row_n_19 row_n_20 row_n_21
+ row_n_22 row_n_23 row_n_24 row_n_25 row_n_26 row_n_27 row_n_28 row_n_29 row_n_30 row_n_31 row_n_32 row_n_33 row_n_34 row_n_35 row_n_36 row_n_37 row_n_38 row_n_39 row_n_40 row_n_41 row_n_42 row_n_43
+ row_n_44 row_n_45 row_n_46 row_n_47 row_n_48 row_n_49 row_n_50 row_n_51 row_n_52 row_n_53 row_n_54 row_n_55 row_n_56 row_n_57 row_n_58 row_n_59 row_n_60 row_n_61 row_n_62 row_n_63 row_n_64 row_n_65
+ row_n_66 row_n_67 row_n_68 row_n_69 row_n_70 row_n_71 row_n_72 row_n_73 row_n_74 row_n_75 row_n_76 row_n_77 row_n_78 row_n_79 row_n_80 row_n_81 row_n_82 row_n_83 row_n_84 row_n_85 row_n_86 row_n_87
+ row_n_88 row_n_89 row_n_90 row_n_91 row_n_92 row_n_93 row_n_94 row_n_95 row_n_96 row_n_97 row_n_98 row_n_99 row_n_100 row_n_101 row_n_102 row_n_103 row_n_104 row_n_105 nc_arr_n_row_106
+ nc_arr_n_row_107 nc_arr_n_row_108 nc_arr_n_row_109 nc_arr_n_row_110 nc_arr_n_row_111 nc_arr_n_row_112 nc_arr_n_row_113 nc_arr_n_row_114 nc_arr_n_row_115 nc_arr_n_row_116 nc_arr_n_row_117
+ nc_arr_n_row_118 nc_arr_n_row_119 nc_arr_n_row_120 nc_arr_n_row_121 nc_arr_n_row_122 nc_arr_n_row_123 nc_arr_n_row_124 nc_arr_n_row_125 nc_arr_n_row_126 nc_arr_n_row_127 wl_n_0 wl_n_1 wl_n_2 wl_n_3
+ wl_n_4 wl_n_5 wl_n_6 wl_n_7 wl_n_8 wl_n_9 wl_n_10 wl_n_11 wl_n_12 wl_n_13 wl_n_14 wl_n_15 wl_n_16 wl_n_17 wl_n_18 wl_n_19 wl_n_20 wl_n_21 wl_n_22 wl_n_23 wl_n_24 wl_n_25 wl_n_26 wl_n_27 wl_n_28
+ wl_n_29 wl_n_30 wl_n_31 wl_n_32 wl_n_33 wl_n_34 wl_n_35 wl_n_36 wl_n_37 wl_n_38 wl_n_39 wl_n_40 wl_n_41 wl_n_42 wl_n_43 wl_n_44 wl_n_45 wl_n_46 wl_n_47 wl_n_48 wl_n_49 wl_n_50 wl_n_51 wl_n_52 wl_n_53
+ wl_n_54 wl_n_55 wl_n_56 wl_n_57 wl_n_58 wl_n_59 wl_n_60 wl_n_61 wl_n_62 wl_n_63 wl_n_64 wl_n_65 wl_n_66 wl_n_67 wl_n_68 wl_n_69 wl_n_70 wl_n_71 wl_n_72 wl_n_73 wl_n_74 wl_n_75 wl_n_76 wl_n_77 wl_n_78
+ wl_n_79 wl_n_80 wl_n_81 wl_n_82 wl_n_83 wl_n_84 wl_n_85 wl_n_86 wl_n_87 wl_n_88 wl_n_89 wl_n_90 wl_n_91 wl_n_92 wl_n_93 wl_n_94 wl_n_95 wl_n_96 wl_n_97 wl_n_98 wl_n_99 wl_n_100 wl_n_101 wl_n_102
+ wl_n_103 wl_n_104 wl_n_105 VSS VSS VSS VSS VSS VSS VSS VSS VSS VSS VSS VSS VSS VSS VSS VSS VSS VSS VSS VSS VSS VSS col_n_0 col_n_1 col_n_2 col_n_3 col_n_4 col_n_5 col_n_6 col_n_7 col_n_8 col_n_9
+ col_n_10 col_n_11 col_n_12 col_n_13 col_n_14 col_n_15 col_n_16 col_n_17 col_n_18 col_n_19 col_n_20 col_n_21 col_n_22 col_n_23 col_n_24 col_n_25 col_n_26 col_n_27 col_n_28 col_n_29 col_n_30 col_n_31
+ col_n_32 col_n_33 col_n_34 col_n_35 col_n_36 col_n_37 col_n_38 col_n_39 col_n_40 col_n_41 col_n_42 col_n_43 col_n_44 col_n_45 col_n_46 col_n_47 col_n_48 col_n_49 col_n_50 col_n_51 col_n_52 col_n_53
+ col_n_54 col_n_55 col_n_56 col_n_57 col_n_58 col_n_59 col_n_60 col_n_61 col_n_62 col_n_63 VSS arr_w3s_128x64
Xidrv_f row_f_0 row_f_1 row_f_2 row_f_3 row_f_4 row_f_5 row_f_6 row_f_7 row_f_8 row_f_9 row_f_10 row_f_11 row_f_12 row_f_13 row_f_14 row_f_15 row_f_16 row_f_17 row_f_18 row_f_19 row_f_20 row_f_21
+ row_f_22 row_f_23 row_f_24 row_f_25 row_f_26 row_f_27 row_f_28 row_f_29 row_f_30 row_f_31 row_f_32 row_f_33 row_f_34 row_f_35 row_f_36 row_f_37 row_f_38 row_f_39 row_f_40 row_f_41 row_f_42 row_f_43
+ row_f_44 row_f_45 row_f_46 row_f_47 row_f_48 row_f_49 row_f_50 row_f_51 row_f_52 row_f_53 row_f_54 row_f_55 row_f_56 row_f_57 row_f_58 row_f_59 row_f_60 row_f_61 row_f_62 row_f_63 row_f_64 row_f_65
+ row_f_66 row_f_67 row_f_68 row_f_69 row_f_70 row_f_71 row_f_72 row_f_73 row_f_74 row_f_75 row_f_76 row_f_77 row_f_78 row_f_79 row_f_80 row_f_81 row_f_82 row_f_83 row_f_84 row_f_85 row_f_86 row_f_87
+ row_f_88 row_f_89 row_f_90 row_f_91 row_f_92 row_f_93 row_f_94 row_f_95 row_f_96 row_f_97 row_f_98 row_f_99 ga_f_0 ga_f_1 ga_f_2 ga_f_3 ga_f_4 ga_f_5 ga_f_6 ga_f_7 ga_f_8 ga_f_9 ga_f_10 ga_f_11
+ ga_f_12 ga_f_13 ga_f_14 ga_f_15 ga_f_16 ga_f_17 ga_f_18 ga_f_19 ga_f_20 ga_f_21 ga_f_22 ga_f_23 ga_f_24 ga_f_25 ga_f_26 ga_f_27 ga_f_28 ga_f_29 ga_f_30 ga_f_31 ga_f_32 ga_f_33 ga_f_34 ga_f_35 ga_f_36
+ ga_f_37 ga_f_38 ga_f_39 ga_f_40 ga_f_41 ga_f_42 ga_f_43 ga_f_44 ga_f_45 ga_f_46 ga_f_47 ga_f_48 gb_f_0 gb_f_1 gb_f_2 gb_f_3 gb_f_4 gb_f_5 gb_f_6 gb_f_7 gb_f_8 gb_f_9 gb_f_10 gb_f_11 gb_f_12 gb_f_13
+ gb_f_14 gb_f_15 gb_f_16 gb_f_17 gb_f_18 gb_f_19 gb_f_20 gb_f_21 gb_f_22 gb_f_23 gb_f_24 gb_f_25 gb_f_26 gb_f_27 gb_f_28 gb_f_29 gb_f_30 gb_f_31 gb_f_32 gb_f_33 gb_f_34 gb_f_35 gb_f_36 gb_f_37 gb_f_38
+ gb_f_39 gb_f_40 gb_f_41 gb_f_42 gb_f_43 gb_f_44 gb_f_45 gb_f_46 gb_f_47 gb_f_48 READ_f VRAILP VRAILM VSS input_drive
Xidrv_n row_n_0 row_n_1 row_n_2 row_n_3 row_n_4 row_n_5 row_n_6 row_n_7 row_n_8 row_n_9 row_n_10 row_n_11 row_n_12 row_n_13 row_n_14 row_n_15 row_n_16 row_n_17 row_n_18 row_n_19 row_n_20 row_n_21
+ row_n_22 row_n_23 row_n_24 row_n_25 row_n_26 row_n_27 row_n_28 row_n_29 row_n_30 row_n_31 row_n_32 row_n_33 row_n_34 row_n_35 row_n_36 row_n_37 row_n_38 row_n_39 row_n_40 row_n_41 row_n_42 row_n_43
+ row_n_44 row_n_45 row_n_46 row_n_47 row_n_48 row_n_49 row_n_50 row_n_51 row_n_52 row_n_53 row_n_54 row_n_55 row_n_56 row_n_57 row_n_58 row_n_59 row_n_60 row_n_61 row_n_62 row_n_63 row_n_64 row_n_65
+ row_n_66 row_n_67 row_n_68 row_n_69 row_n_70 row_n_71 row_n_72 row_n_73 row_n_74 row_n_75 row_n_76 row_n_77 row_n_78 row_n_79 row_n_80 row_n_81 row_n_82 row_n_83 row_n_84 row_n_85 row_n_86 row_n_87
+ row_n_88 row_n_89 row_n_90 row_n_91 row_n_92 row_n_93 row_n_94 row_n_95 row_n_96 row_n_97 row_n_98 row_n_99 ga_n_0 ga_n_1 ga_n_2 ga_n_3 ga_n_4 ga_n_5 ga_n_6 ga_n_7 ga_n_8 ga_n_9 ga_n_10 ga_n_11
+ ga_n_12 ga_n_13 ga_n_14 ga_n_15 ga_n_16 ga_n_17 ga_n_18 ga_n_19 ga_n_20 ga_n_21 ga_n_22 ga_n_23 ga_n_24 ga_n_25 ga_n_26 ga_n_27 ga_n_28 ga_n_29 ga_n_30 ga_n_31 ga_n_32 ga_n_33 ga_n_34 ga_n_35 ga_n_36
+ ga_n_37 ga_n_38 ga_n_39 ga_n_40 ga_n_41 ga_n_42 ga_n_43 ga_n_44 ga_n_45 ga_n_46 ga_n_47 ga_n_48 gb_n_0 gb_n_1 gb_n_2 gb_n_3 gb_n_4 gb_n_5 gb_n_6 gb_n_7 gb_n_8 gb_n_9 gb_n_10 gb_n_11 gb_n_12 gb_n_13
+ gb_n_14 gb_n_15 gb_n_16 gb_n_17 gb_n_18 gb_n_19 gb_n_20 gb_n_21 gb_n_22 gb_n_23 gb_n_24 gb_n_25 gb_n_26 gb_n_27 gb_n_28 gb_n_29 gb_n_30 gb_n_31 gb_n_32 gb_n_33 gb_n_34 gb_n_35 gb_n_36 gb_n_37 gb_n_38
+ gb_n_39 gb_n_40 gb_n_41 gb_n_42 gb_n_43 gb_n_44 gb_n_45 gb_n_46 gb_n_47 gb_n_48 READ_n VRAILP VRAILM VSS input_drive
Xrowb_f SDI row1_clk_f row2_clk_f rstb_f SEL_EN PROG_f VER_f SENSE_f READb_f WRANY_f vw_f VWL VCM R1_f R2_f row_f_105 row_f_104 row_f_103 row_f_102 row_f_101 row_f_100 row_f_99 row_f_98 row_f_97
+ row_f_96 row_f_95 row_f_94 row_f_93 row_f_92 row_f_91 row_f_90 row_f_89 row_f_88 row_f_87 row_f_86 row_f_85 row_f_84 row_f_83 row_f_82 row_f_81 row_f_80 row_f_79 row_f_78 row_f_77 row_f_76 row_f_75
+ row_f_74 row_f_73 row_f_72 row_f_71 row_f_70 row_f_69 row_f_68 row_f_67 row_f_66 row_f_65 row_f_64 row_f_63 row_f_62 row_f_61 row_f_60 row_f_59 row_f_58 row_f_57 row_f_56 row_f_55 row_f_54 row_f_53
+ row_f_52 row_f_51 row_f_50 row_f_49 row_f_48 row_f_47 row_f_46 row_f_45 row_f_44 row_f_43 row_f_42 row_f_41 row_f_40 row_f_39 row_f_38 row_f_37 row_f_36 row_f_35 row_f_34 row_f_33 row_f_32 row_f_31
+ row_f_30 row_f_29 row_f_28 row_f_27 row_f_26 row_f_25 row_f_24 row_f_23 row_f_22 row_f_21 row_f_20 row_f_19 row_f_18 row_f_17 row_f_16 row_f_15 row_f_14 row_f_13 row_f_12 row_f_11 row_f_10 row_f_9
+ row_f_8 row_f_7 row_f_6 row_f_5 row_f_4 row_f_3 row_f_2 row_f_1 row_f_0 wl_f_105 wl_f_104 wl_f_103 wl_f_102 wl_f_101 wl_f_100 wl_f_99 wl_f_98 wl_f_97 wl_f_96 wl_f_95 wl_f_94 wl_f_93 wl_f_92 wl_f_91
+ wl_f_90 wl_f_89 wl_f_88 wl_f_87 wl_f_86 wl_f_85 wl_f_84 wl_f_83 wl_f_82 wl_f_81 wl_f_80 wl_f_79 wl_f_78 wl_f_77 wl_f_76 wl_f_75 wl_f_74 wl_f_73 wl_f_72 wl_f_71 wl_f_70 wl_f_69 wl_f_68 wl_f_67 wl_f_66
+ wl_f_65 wl_f_64 wl_f_63 wl_f_62 wl_f_61 wl_f_60 wl_f_59 wl_f_58 wl_f_57 wl_f_56 wl_f_55 wl_f_54 wl_f_53 wl_f_52 wl_f_51 wl_f_50 wl_f_49 wl_f_48 wl_f_47 wl_f_46 wl_f_45 wl_f_44 wl_f_43 wl_f_42 wl_f_41
+ wl_f_40 wl_f_39 wl_f_38 wl_f_37 wl_f_36 wl_f_35 wl_f_34 wl_f_33 wl_f_32 wl_f_31 wl_f_30 wl_f_29 wl_f_28 wl_f_27 wl_f_26 wl_f_25 wl_f_24 wl_f_23 wl_f_22 wl_f_21 wl_f_20 wl_f_19 wl_f_18 wl_f_17 wl_f_16
+ wl_f_15 wl_f_14 wl_f_13 wl_f_12 wl_f_11 wl_f_10 wl_f_9 wl_f_8 wl_f_7 wl_f_6 wl_f_5 wl_f_4 wl_f_3 wl_f_2 wl_f_1 wl_f_0 VDD VSS row_blk
Xrowb_n SDI row1_clk_n row2_clk_n rstb_n SEL_EN PROG_n VER_n SENSE_n READb_n WRANY_n vw_n VWL VCM R1_n R2_n row_n_105 row_n_104 row_n_103 row_n_102 row_n_101 row_n_100 row_n_99 row_n_98 row_n_97
+ row_n_96 row_n_95 row_n_94 row_n_93 row_n_92 row_n_91 row_n_90 row_n_89 row_n_88 row_n_87 row_n_86 row_n_85 row_n_84 row_n_83 row_n_82 row_n_81 row_n_80 row_n_79 row_n_78 row_n_77 row_n_76 row_n_75
+ row_n_74 row_n_73 row_n_72 row_n_71 row_n_70 row_n_69 row_n_68 row_n_67 row_n_66 row_n_65 row_n_64 row_n_63 row_n_62 row_n_61 row_n_60 row_n_59 row_n_58 row_n_57 row_n_56 row_n_55 row_n_54 row_n_53
+ row_n_52 row_n_51 row_n_50 row_n_49 row_n_48 row_n_47 row_n_46 row_n_45 row_n_44 row_n_43 row_n_42 row_n_41 row_n_40 row_n_39 row_n_38 row_n_37 row_n_36 row_n_35 row_n_34 row_n_33 row_n_32 row_n_31
+ row_n_30 row_n_29 row_n_28 row_n_27 row_n_26 row_n_25 row_n_24 row_n_23 row_n_22 row_n_21 row_n_20 row_n_19 row_n_18 row_n_17 row_n_16 row_n_15 row_n_14 row_n_13 row_n_12 row_n_11 row_n_10 row_n_9
+ row_n_8 row_n_7 row_n_6 row_n_5 row_n_4 row_n_3 row_n_2 row_n_1 row_n_0 wl_n_105 wl_n_104 wl_n_103 wl_n_102 wl_n_101 wl_n_100 wl_n_99 wl_n_98 wl_n_97 wl_n_96 wl_n_95 wl_n_94 wl_n_93 wl_n_92 wl_n_91
+ wl_n_90 wl_n_89 wl_n_88 wl_n_87 wl_n_86 wl_n_85 wl_n_84 wl_n_83 wl_n_82 wl_n_81 wl_n_80 wl_n_79 wl_n_78 wl_n_77 wl_n_76 wl_n_75 wl_n_74 wl_n_73 wl_n_72 wl_n_71 wl_n_70 wl_n_69 wl_n_68 wl_n_67 wl_n_66
+ wl_n_65 wl_n_64 wl_n_63 wl_n_62 wl_n_61 wl_n_60 wl_n_59 wl_n_58 wl_n_57 wl_n_56 wl_n_55 wl_n_54 wl_n_53 wl_n_52 wl_n_51 wl_n_50 wl_n_49 wl_n_48 wl_n_47 wl_n_46 wl_n_45 wl_n_44 wl_n_43 wl_n_42 wl_n_41
+ wl_n_40 wl_n_39 wl_n_38 wl_n_37 wl_n_36 wl_n_35 wl_n_34 wl_n_33 wl_n_32 wl_n_31 wl_n_30 wl_n_29 wl_n_28 wl_n_27 wl_n_26 wl_n_25 wl_n_24 wl_n_23 wl_n_22 wl_n_21 wl_n_20 wl_n_19 wl_n_18 wl_n_17 wl_n_16
+ wl_n_15 wl_n_14 wl_n_13 wl_n_12 wl_n_11 wl_n_10 wl_n_9 wl_n_8 wl_n_7 wl_n_6 wl_n_5 wl_n_4 wl_n_3 wl_n_2 wl_n_1 wl_n_0 VDD VSS row_blk
Xcolb_f col_f_63 col_f_62 col_f_61 col_f_60 col_f_59 col_f_58 col_f_57 col_f_56 col_f_55 col_f_54 col_f_53 col_f_52 col_f_51 col_f_50 col_f_49 col_f_48 col_f_47 col_f_46 col_f_45 col_f_44 col_f_43
+ col_f_42 col_f_41 col_f_40 col_f_39 col_f_38 col_f_37 col_f_36 col_f_35 col_f_34 col_f_33 col_f_32 col_f_31 col_f_30 col_f_29 col_f_28 col_f_27 col_f_26 col_f_25 col_f_24 col_f_23 col_f_22 col_f_21
+ col_f_20 col_f_19 col_f_18 col_f_17 col_f_16 col_f_15 col_f_14 col_f_13 col_f_12 col_f_11 col_f_10 col_f_9 col_f_8 col_f_7 col_f_6 col_f_5 col_f_4 col_f_3 col_f_2 col_f_1 col_f_0 vw_f VBUS_F C1_f
+ C2_f VCM VRAILP VRAILM SDI rstb_f col1_clk_f col2_clk_f SEL_EN PROG_f VER_f SENSE_f WRANY_f VSS READ_f READb_f VDD VSS col_blk
Xcolb_n col_n_63 col_n_62 col_n_61 col_n_60 col_n_59 col_n_58 col_n_57 col_n_56 col_n_55 col_n_54 col_n_53 col_n_52 col_n_51 col_n_50 col_n_49 col_n_48 col_n_47 col_n_46 col_n_45 col_n_44 col_n_43
+ col_n_42 col_n_41 col_n_40 col_n_39 col_n_38 col_n_37 col_n_36 col_n_35 col_n_34 col_n_33 col_n_32 col_n_31 col_n_30 col_n_29 col_n_28 col_n_27 col_n_26 col_n_25 col_n_24 col_n_23 col_n_22 col_n_21
+ col_n_20 col_n_19 col_n_18 col_n_17 col_n_16 col_n_15 col_n_14 col_n_13 col_n_12 col_n_11 col_n_10 col_n_9 col_n_8 col_n_7 col_n_6 col_n_5 col_n_4 col_n_3 col_n_2 col_n_1 col_n_0 vw_n VBUS_N C1_n
+ C2_n VCM VRAILP VRAILM SDI rstb_n col1_clk_n col2_clk_n SEL_EN PROG_n VER_n SENSE_n WRANY_n VSS READ_n READb_n VDD VSS col_blk
Xdata_f SDI data_clk_f dload_f READ_f rstb_f ga_f_48 ga_f_47 ga_f_46 ga_f_45 ga_f_44 ga_f_43 ga_f_42 ga_f_41 ga_f_40 ga_f_39 ga_f_38 ga_f_37 ga_f_36 ga_f_35 ga_f_34 ga_f_33 ga_f_32 ga_f_31 ga_f_30
+ ga_f_29 ga_f_28 ga_f_27 ga_f_26 ga_f_25 ga_f_24 ga_f_23 ga_f_22 ga_f_21 ga_f_20 ga_f_19 ga_f_18 ga_f_17 ga_f_16 ga_f_15 ga_f_14 ga_f_13 ga_f_12 ga_f_11 ga_f_10 ga_f_9 ga_f_8 ga_f_7 ga_f_6 ga_f_5
+ ga_f_4 ga_f_3 ga_f_2 ga_f_1 ga_f_0 gb_f_48 gb_f_47 gb_f_46 gb_f_45 gb_f_44 gb_f_43 gb_f_42 gb_f_41 gb_f_40 gb_f_39 gb_f_38 gb_f_37 gb_f_36 gb_f_35 gb_f_34 gb_f_33 gb_f_32 gb_f_31 gb_f_30 gb_f_29
+ gb_f_28 gb_f_27 gb_f_26 gb_f_25 gb_f_24 gb_f_23 gb_f_22 gb_f_21 gb_f_20 gb_f_19 gb_f_18 gb_f_17 gb_f_16 gb_f_15 gb_f_14 gb_f_13 gb_f_12 gb_f_11 gb_f_10 gb_f_9 gb_f_8 gb_f_7 gb_f_6 gb_f_5 gb_f_4
+ gb_f_3 gb_f_2 gb_f_1 gb_f_0 nc_data_f_sp_2 nc_data_f_sp_1 nc_data_f_sp_0 nc_data_f_spb_2 nc_data_f_spb_1 nc_data_f_spb_0 nc_data_f_sm_2 nc_data_f_sm_1 nc_data_f_sm_0 nc_data_f_smb_2 nc_data_f_smb_1
+ nc_data_f_smb_0 VDD VSS data_blk
Xdata_n SDI data_clk_n dload_n READ_n rstb_n ga_n_48 ga_n_47 ga_n_46 ga_n_45 ga_n_44 ga_n_43 ga_n_42 ga_n_41 ga_n_40 ga_n_39 ga_n_38 ga_n_37 ga_n_36 ga_n_35 ga_n_34 ga_n_33 ga_n_32 ga_n_31 ga_n_30
+ ga_n_29 ga_n_28 ga_n_27 ga_n_26 ga_n_25 ga_n_24 ga_n_23 ga_n_22 ga_n_21 ga_n_20 ga_n_19 ga_n_18 ga_n_17 ga_n_16 ga_n_15 ga_n_14 ga_n_13 ga_n_12 ga_n_11 ga_n_10 ga_n_9 ga_n_8 ga_n_7 ga_n_6 ga_n_5
+ ga_n_4 ga_n_3 ga_n_2 ga_n_1 ga_n_0 gb_n_48 gb_n_47 gb_n_46 gb_n_45 gb_n_44 gb_n_43 gb_n_42 gb_n_41 gb_n_40 gb_n_39 gb_n_38 gb_n_37 gb_n_36 gb_n_35 gb_n_34 gb_n_33 gb_n_32 gb_n_31 gb_n_30 gb_n_29
+ gb_n_28 gb_n_27 gb_n_26 gb_n_25 gb_n_24 gb_n_23 gb_n_22 gb_n_21 gb_n_20 gb_n_19 gb_n_18 gb_n_17 gb_n_16 gb_n_15 gb_n_14 gb_n_13 gb_n_12 gb_n_11 gb_n_10 gb_n_9 gb_n_8 gb_n_7 gb_n_6 gb_n_5 gb_n_4
+ gb_n_3 gb_n_2 gb_n_1 gb_n_0 sp_n_2 sp_n_1 sp_n_0 spb_n_2 spb_n_1 spb_n_0 sm_n_2 sm_n_1 sm_n_0 smb_n_2 smb_n_1 smb_n_0 VDD VSS data_blk
Xwbuf_f WP pol_f vw_f VWH VWLO VDD VSS wbuf
Xwbuf_n WP pol_n vw_n VWH VWLO VDD VSS wbuf
Xrotg_f R2_f VBUS_F rd_out_f rd_out_b_f VDD VSS tg_n2
Xrotg_n R2_n VBUS_N rd_out_n rd_out_b_n VDD VSS tg_n2
Xwu1 R1_f C1_f R1_n C1_n CK CK3 LAT latb_1 LQ1 nc_wu1_sen nc_wu1_absf nc_wu1_absn nc_wu1_q1 nc_wu1_q2 IBIAS IBIASP VBNC VBPC VDD VSS VCM wu
Xwu2 R2_f C2_f R2_n C2_n CK CK3 LAT latb_2 LQ2 nc_wu2_sen nc_wu2_absf nc_wu2_absn nc_wu2_q1 nc_wu2_q2 IBIAS IBIASP VBNC VBPC VDD VSS VCM wu
Xglob SCK SDI SLD RST data_clk_f data_clk_n row1_clk_f row1_clk_n row2_clk_f row2_clk_n col1_clk_f col1_clk_n col2_clk_f col2_clk_n rstb_f rstb_n READ_f READ_n READb_f READb_n PROG_f PROG_n VER_f VER_n
+ SENSE_f SENSE_n WRANY_f WRANY_n dload_f dload_n pol_f pol_n rd_out_f rd_out_n rd_out_b_f rd_out_b_n VDD VSS glob_dig
Xbias IBIAS IBIASP VBPC pref nref VDD VSS bias_beta
Xninj row_n_100 row_n_101 row_n_102 row_n_103 row_n_104 row_n_105 pref nref sp_n_0 spb_n_0 sm_n_0 smb_n_0 sp_n_1 spb_n_1 sm_n_1 smb_n_1 sp_n_2 spb_n_2 sm_n_2 smb_n_2 VDD VSS nudge_inj
Xtp_tl nc_tp_tl_ro_1_en nc_tp_tl_ro_1_rstb nc_tp_tl_ro_1_out nc_tp_tl_kv_hpo0p35_l_1_f1 nc_tp_tl_kv_hpo0p35_l_1_s1 nc_tp_tl_kv_hpo0p35_l_1_s2 nc_tp_tl_kv_hpo0p35_l_1_f2 nc_tp_tl_kv_hpo1p41_l_1_f1
+ nc_tp_tl_kv_hpo1p41_l_1_s1 nc_tp_tl_kv_hpo1p41_l_1_s2 nc_tp_tl_kv_hpo1p41_l_1_f2 nc_tp_tl_kv_xpo0p35_l_1_f1 nc_tp_tl_kv_xpo0p35_l_1_s1 nc_tp_tl_kv_xpo0p35_l_1_s2 nc_tp_tl_kv_xpo0p35_l_1_f2
+ nc_tp_tl_kv_xpo1p41_l_1_f1 nc_tp_tl_kv_xpo1p41_l_1_s1 nc_tp_tl_kv_xpo1p41_l_1_s2 nc_tp_tl_kv_xpo1p41_l_1_f2 nc_tp_tl_kv_nd_l_1_f1 nc_tp_tl_kv_nd_l_1_s1 nc_tp_tl_kv_nd_l_1_s2 nc_tp_tl_kv_nd_l_1_f2
+ nc_tp_tl_kv_pd_l_1_f1 nc_tp_tl_kv_pd_l_1_s1 nc_tp_tl_kv_pd_l_1_s2 nc_tp_tl_kv_pd_l_1_f2 nc_tp_tl_kv_m1_l_1_f1 nc_tp_tl_kv_m1_l_1_s1 nc_tp_tl_kv_m1_l_1_s2 nc_tp_tl_kv_m1_l_1_f2 nc_tp_tl_kv_m2_l_1_f1
+ nc_tp_tl_kv_m2_l_1_s1 nc_tp_tl_kv_m2_l_1_s2 nc_tp_tl_kv_m2_l_1_f2 nc_tp_tl_kv_m3_l_1_f1 nc_tp_tl_kv_m3_l_1_s1 nc_tp_tl_kv_m3_l_1_s2 nc_tp_tl_kv_m3_l_1_f2 nc_tp_tl_kv_hpo0p35_s_1_f1
+ nc_tp_tl_kv_hpo0p35_s_1_s1 nc_tp_tl_kv_hpo0p35_s_1_s2 nc_tp_tl_kv_hpo0p35_s_1_f2 nc_tp_tl_kv_hpo1p41_s_1_f1 nc_tp_tl_kv_hpo1p41_s_1_s1 nc_tp_tl_kv_hpo1p41_s_1_s2 nc_tp_tl_kv_hpo1p41_s_1_f2
+ nc_tp_tl_kv_xpo0p35_s_1_f1 nc_tp_tl_kv_xpo0p35_s_1_s1 nc_tp_tl_kv_xpo0p35_s_1_s2 nc_tp_tl_kv_xpo0p35_s_1_f2 nc_tp_tl_kv_xpo1p41_s_1_f1 nc_tp_tl_kv_xpo1p41_s_1_s1 nc_tp_tl_kv_xpo1p41_s_1_s2
+ nc_tp_tl_kv_xpo1p41_s_1_f2 nc_tp_tl_kv_nd_s_1_f1 nc_tp_tl_kv_nd_s_1_s1 nc_tp_tl_kv_nd_s_1_s2 nc_tp_tl_kv_nd_s_1_f2 nc_tp_tl_kv_pd_s_1_f1 nc_tp_tl_kv_pd_s_1_s1 nc_tp_tl_kv_pd_s_1_s2
+ nc_tp_tl_kv_pd_s_1_f2 nc_tp_tl_kv_m1_s_1_f1 nc_tp_tl_kv_m1_s_1_s1 nc_tp_tl_kv_m1_s_1_s2 nc_tp_tl_kv_m1_s_1_f2 nc_tp_tl_kv_m2_s_1_f1 nc_tp_tl_kv_m2_s_1_s1 nc_tp_tl_kv_m2_s_1_s2 nc_tp_tl_kv_m2_s_1_f2
+ nc_tp_tl_kv_m3_s_1_f1 nc_tp_tl_kv_m3_s_1_s1 nc_tp_tl_kv_m3_s_1_s2 nc_tp_tl_kv_m3_s_1_f2 nc_tp_tl_ch_poly_1_a nc_tp_tl_ch_poly_1_b nc_tp_tl_ch_ndiff_1_a nc_tp_tl_ch_ndiff_1_b nc_tp_tl_ch_pdiff_1_a
+ nc_tp_tl_ch_pdiff_1_b nc_tp_tl_ch_mcon_1_a nc_tp_tl_ch_mcon_1_b nc_tp_tl_ch_via1_1_a nc_tp_tl_ch_via1_1_b nc_tp_tl_ch_via2_1_a nc_tp_tl_ch_via2_1_b nc_tp_tl_ch_poly_2_a nc_tp_tl_ch_poly_2_b
+ nc_tp_tl_ch_ndiff_2_a nc_tp_tl_ch_ndiff_2_b nc_tp_tl_ch_pdiff_2_a nc_tp_tl_ch_pdiff_2_b nc_tp_tl_ch_mcon_2_a nc_tp_tl_ch_mcon_2_b nc_tp_tl_rr_1_s nc_tp_tl_rr_1_te nc_tp_tl_rr_1_wl nc_tp_tl_rr_2_s
+ nc_tp_tl_rr_2_te nc_tp_tl_rr_2_wl nc_tp_tl_rr_3_s nc_tp_tl_rr_3_te nc_tp_tl_rr_3_wl nc_tp_tl_rr_4_s nc_tp_tl_rr_4_te nc_tp_tl_rr_4_wl nc_tp_tl_nacc_1_s nc_tp_tl_nacc_1_d nc_tp_tl_nacc_1_g
+ nc_tp_tl_nacc_2_s nc_tp_tl_nacc_2_d nc_tp_tl_nacc_2_g nc_tp_tl_pair_1_ns nc_tp_tl_pair_1_ng2 nc_tp_tl_pair_1_nd2 nc_tp_tl_pair_1_ng1 nc_tp_tl_pair_1_nd1 nc_tp_tl_pair_1_pg2 nc_tp_tl_pair_1_ps
+ nc_tp_tl_pair_1_pd2 nc_tp_tl_pair_1_pd1 nc_tp_tl_pair_1_pg1 nc_tp_tl_pair_2_ns nc_tp_tl_pair_2_ng2 nc_tp_tl_pair_2_nd2 nc_tp_tl_pair_2_ng1 nc_tp_tl_pair_2_nd1 nc_tp_tl_pair_2_pg2 nc_tp_tl_pair_2_ps
+ nc_tp_tl_pair_2_pd2 nc_tp_tl_pair_2_pd1 nc_tp_tl_pair_2_pg1 nc_tp_tl_ch_poly_3_a nc_tp_tl_ch_poly_3_b nc_tp_tl_ch_ndiff_3_a nc_tp_tl_ch_ndiff_3_b nc_tp_tl_ch_pdiff_3_a nc_tp_tl_ch_pdiff_3_b
+ nc_tp_tl_ch_mcon_3_a nc_tp_tl_ch_mcon_3_b nc_tp_tl_ch_via1_2_a nc_tp_tl_ch_via1_2_b nc_tp_tl_ch_via2_2_a nc_tp_tl_ch_via2_2_b nc_tp_tl_rr_5_s nc_tp_tl_rr_5_te nc_tp_tl_rr_5_wl nc_tp_tl_nacc_3_s
+ nc_tp_tl_nacc_3_d nc_tp_tl_nacc_3_g nc_tp_tl_rr_6_s nc_tp_tl_rr_6_te nc_tp_tl_rr_6_wl nc_tp_tl_nacc_4_s nc_tp_tl_nacc_4_d nc_tp_tl_nacc_4_g nc_tp_tl_rr_7_s nc_tp_tl_rr_7_te nc_tp_tl_rr_7_wl
+ nc_tp_tl_nacc_5_s nc_tp_tl_nacc_5_d nc_tp_tl_nacc_5_g nc_tp_tl_rr_8_s nc_tp_tl_rr_8_te nc_tp_tl_rr_8_wl nc_tp_tl_nacc_6_s nc_tp_tl_nacc_6_d nc_tp_tl_nacc_6_g nc_tp_tl_rr_9_s nc_tp_tl_rr_9_te
+ nc_tp_tl_rr_9_wl nc_tp_tl_nacc_7_s nc_tp_tl_nacc_7_d nc_tp_tl_nacc_7_g nc_tp_tl_rr_10_s nc_tp_tl_rr_10_te nc_tp_tl_rr_10_wl nc_tp_tl_nacc_8_s nc_tp_tl_nacc_8_d nc_tp_tl_nacc_8_g nc_tp_tl_rr_11_s
+ nc_tp_tl_rr_11_te nc_tp_tl_rr_11_wl nc_tp_tl_nacc_9_s nc_tp_tl_nacc_9_d nc_tp_tl_nacc_9_g nc_tp_tl_rr_12_s nc_tp_tl_rr_12_te nc_tp_tl_rr_12_wl nc_tp_tl_nacc_10_s nc_tp_tl_nacc_10_d nc_tp_tl_nacc_10_g
+ nc_tp_tl_rr_13_s nc_tp_tl_rr_13_te nc_tp_tl_rr_13_wl nc_tp_tl_nacc_11_s nc_tp_tl_nacc_11_d nc_tp_tl_nacc_11_g VDD VSS tp_tl
Xtp_br nc_tp_br_ro_1_en nc_tp_br_ro_1_rstb nc_tp_br_ro_1_out nc_tp_br_kv_hpo0p35_s_1_f1 nc_tp_br_kv_hpo0p35_s_1_s1 nc_tp_br_kv_hpo0p35_s_1_s2 nc_tp_br_kv_hpo0p35_s_1_f2 nc_tp_br_kv_hpo1p41_s_1_f1
+ nc_tp_br_kv_hpo1p41_s_1_s1 nc_tp_br_kv_hpo1p41_s_1_s2 nc_tp_br_kv_hpo1p41_s_1_f2 nc_tp_br_kv_xpo0p35_s_1_f1 nc_tp_br_kv_xpo0p35_s_1_s1 nc_tp_br_kv_xpo0p35_s_1_s2 nc_tp_br_kv_xpo0p35_s_1_f2
+ nc_tp_br_kv_xpo1p41_s_1_f1 nc_tp_br_kv_xpo1p41_s_1_s1 nc_tp_br_kv_xpo1p41_s_1_s2 nc_tp_br_kv_xpo1p41_s_1_f2 nc_tp_br_kv_nd_s_1_f1 nc_tp_br_kv_nd_s_1_s1 nc_tp_br_kv_nd_s_1_s2 nc_tp_br_kv_nd_s_1_f2
+ nc_tp_br_kv_pd_s_1_f1 nc_tp_br_kv_pd_s_1_s1 nc_tp_br_kv_pd_s_1_s2 nc_tp_br_kv_pd_s_1_f2 nc_tp_br_kv_m1_s_1_f1 nc_tp_br_kv_m1_s_1_s1 nc_tp_br_kv_m1_s_1_s2 nc_tp_br_kv_m1_s_1_f2 nc_tp_br_kv_m2_s_1_f1
+ nc_tp_br_kv_m2_s_1_s1 nc_tp_br_kv_m2_s_1_s2 nc_tp_br_kv_m2_s_1_f2 nc_tp_br_kv_m3_s_1_f1 nc_tp_br_kv_m3_s_1_s1 nc_tp_br_kv_m3_s_1_s2 nc_tp_br_kv_m3_s_1_f2 nc_tp_br_kv_hpo0p35_l_1_f1
+ nc_tp_br_kv_hpo0p35_l_1_s1 nc_tp_br_kv_hpo0p35_l_1_s2 nc_tp_br_kv_hpo0p35_l_1_f2 nc_tp_br_kv_hpo1p41_l_1_f1 nc_tp_br_kv_hpo1p41_l_1_s1 nc_tp_br_kv_hpo1p41_l_1_s2 nc_tp_br_kv_hpo1p41_l_1_f2
+ nc_tp_br_kv_xpo0p35_l_1_f1 nc_tp_br_kv_xpo0p35_l_1_s1 nc_tp_br_kv_xpo0p35_l_1_s2 nc_tp_br_kv_xpo0p35_l_1_f2 nc_tp_br_kv_xpo1p41_l_1_f1 nc_tp_br_kv_xpo1p41_l_1_s1 nc_tp_br_kv_xpo1p41_l_1_s2
+ nc_tp_br_kv_xpo1p41_l_1_f2 nc_tp_br_kv_nd_l_1_f1 nc_tp_br_kv_nd_l_1_s1 nc_tp_br_kv_nd_l_1_s2 nc_tp_br_kv_nd_l_1_f2 nc_tp_br_kv_pd_l_1_f1 nc_tp_br_kv_pd_l_1_s1 nc_tp_br_kv_pd_l_1_s2
+ nc_tp_br_kv_pd_l_1_f2 nc_tp_br_kv_m1_l_1_f1 nc_tp_br_kv_m1_l_1_s1 nc_tp_br_kv_m1_l_1_s2 nc_tp_br_kv_m1_l_1_f2 nc_tp_br_kv_m2_l_1_f1 nc_tp_br_kv_m2_l_1_s1 nc_tp_br_kv_m2_l_1_s2 nc_tp_br_kv_m2_l_1_f2
+ nc_tp_br_kv_m3_l_1_f1 nc_tp_br_kv_m3_l_1_s1 nc_tp_br_kv_m3_l_1_s2 nc_tp_br_kv_m3_l_1_f2 nc_tp_br_ch_poly_1_a nc_tp_br_ch_poly_1_b nc_tp_br_ch_ndiff_1_a nc_tp_br_ch_ndiff_1_b nc_tp_br_ch_pdiff_1_a
+ nc_tp_br_ch_pdiff_1_b nc_tp_br_ch_mcon_1_a nc_tp_br_ch_mcon_1_b nc_tp_br_ch_via1_1_a nc_tp_br_ch_via1_1_b nc_tp_br_ch_via2_1_a nc_tp_br_ch_via2_1_b nc_tp_br_ch_poly_2_a nc_tp_br_ch_poly_2_b
+ nc_tp_br_ch_ndiff_2_a nc_tp_br_ch_ndiff_2_b nc_tp_br_ch_pdiff_2_a nc_tp_br_ch_pdiff_2_b nc_tp_br_ch_mcon_2_a nc_tp_br_ch_mcon_2_b nc_tp_br_ch_via1_2_a nc_tp_br_ch_via1_2_b nc_tp_br_ch_via2_2_a
+ nc_tp_br_ch_via2_2_b nc_tp_br_ch_poly_3_a nc_tp_br_ch_poly_3_b nc_tp_br_ch_ndiff_3_a nc_tp_br_ch_ndiff_3_b nc_tp_br_ch_pdiff_3_a nc_tp_br_ch_pdiff_3_b nc_tp_br_ch_mcon_3_a nc_tp_br_ch_mcon_3_b
+ nc_tp_br_rr_1_s nc_tp_br_rr_1_te nc_tp_br_rr_1_wl nc_tp_br_rr_2_s nc_tp_br_rr_2_te nc_tp_br_rr_2_wl nc_tp_br_rr_3_s nc_tp_br_rr_3_te nc_tp_br_rr_3_wl nc_tp_br_rr_4_s nc_tp_br_rr_4_te nc_tp_br_rr_4_wl
+ nc_tp_br_nacc_1_s nc_tp_br_nacc_1_d nc_tp_br_nacc_1_g nc_tp_br_nacc_2_s nc_tp_br_nacc_2_d nc_tp_br_nacc_2_g nc_tp_br_pair_1_ns nc_tp_br_pair_1_ng2 nc_tp_br_pair_1_nd2 nc_tp_br_pair_1_ng1
+ nc_tp_br_pair_1_nd1 nc_tp_br_pair_1_pg2 nc_tp_br_pair_1_ps nc_tp_br_pair_1_pd2 nc_tp_br_pair_1_pd1 nc_tp_br_pair_1_pg1 nc_tp_br_pair_2_ns nc_tp_br_pair_2_ng2 nc_tp_br_pair_2_nd2 nc_tp_br_pair_2_ng1
+ nc_tp_br_pair_2_nd1 nc_tp_br_pair_2_pg2 nc_tp_br_pair_2_ps nc_tp_br_pair_2_pd2 nc_tp_br_pair_2_pd1 nc_tp_br_pair_2_pg1 nc_tp_br_ch_poly_4_a nc_tp_br_ch_poly_4_b nc_tp_br_ch_ndiff_4_a
+ nc_tp_br_ch_ndiff_4_b nc_tp_br_ch_pdiff_4_a nc_tp_br_ch_pdiff_4_b nc_tp_br_ch_mcon_4_a nc_tp_br_ch_mcon_4_b nc_tp_br_ch_via1_3_a nc_tp_br_ch_via1_3_b nc_tp_br_ch_via2_3_a nc_tp_br_ch_via2_3_b
+ nc_tp_br_rr_5_s nc_tp_br_rr_5_te nc_tp_br_rr_5_wl nc_tp_br_nacc_3_s nc_tp_br_nacc_3_d nc_tp_br_nacc_3_g nc_tp_br_pair_3_ns nc_tp_br_pair_3_ng2 nc_tp_br_pair_3_nd2 nc_tp_br_pair_3_ng1
+ nc_tp_br_pair_3_nd1 nc_tp_br_pair_3_pg2 nc_tp_br_pair_3_ps nc_tp_br_pair_3_pd2 nc_tp_br_pair_3_pd1 nc_tp_br_pair_3_pg1 nc_tp_br_rr_6_s nc_tp_br_rr_6_te nc_tp_br_rr_6_wl nc_tp_br_nacc_4_s
+ nc_tp_br_nacc_4_d nc_tp_br_nacc_4_g nc_tp_br_pair_4_ns nc_tp_br_pair_4_ng2 nc_tp_br_pair_4_nd2 nc_tp_br_pair_4_ng1 nc_tp_br_pair_4_nd1 nc_tp_br_pair_4_pg2 nc_tp_br_pair_4_ps nc_tp_br_pair_4_pd2
+ nc_tp_br_pair_4_pd1 nc_tp_br_pair_4_pg1 nc_tp_br_rr_7_s nc_tp_br_rr_7_te nc_tp_br_rr_7_wl nc_tp_br_nacc_5_s nc_tp_br_nacc_5_d nc_tp_br_nacc_5_g nc_tp_br_pair_5_ns nc_tp_br_pair_5_ng2
+ nc_tp_br_pair_5_nd2 nc_tp_br_pair_5_ng1 nc_tp_br_pair_5_nd1 nc_tp_br_pair_5_pg2 nc_tp_br_pair_5_ps nc_tp_br_pair_5_pd2 nc_tp_br_pair_5_pd1 nc_tp_br_pair_5_pg1 nc_tp_br_rr_8_s nc_tp_br_rr_8_te
+ nc_tp_br_rr_8_wl nc_tp_br_nacc_6_s nc_tp_br_nacc_6_d nc_tp_br_nacc_6_g nc_tp_br_pair_6_ns nc_tp_br_pair_6_ng2 nc_tp_br_pair_6_nd2 nc_tp_br_pair_6_ng1 nc_tp_br_pair_6_nd1 nc_tp_br_pair_6_pg2
+ nc_tp_br_pair_6_ps nc_tp_br_pair_6_pd2 nc_tp_br_pair_6_pd1 nc_tp_br_pair_6_pg1 VDD VSS tp_br
Xtp_bandl nc_tp_bandl_ch_poly_1_a nc_tp_bandl_ch_poly_1_b nc_tp_bandl_ch_ndiff_1_a nc_tp_bandl_ch_ndiff_1_b nc_tp_bandl_ch_pdiff_1_a nc_tp_bandl_ch_pdiff_1_b nc_tp_bandl_ch_mcon_1_a
+ nc_tp_bandl_ch_mcon_1_b nc_tp_bandl_ch_via1_1_a nc_tp_bandl_ch_via1_1_b nc_tp_bandl_ch_via2_1_a nc_tp_bandl_ch_via2_1_b nc_tp_bandl_rr_1_s nc_tp_bandl_rr_1_te nc_tp_bandl_rr_1_wl nc_tp_bandl_rr_2_s
+ nc_tp_bandl_rr_2_te nc_tp_bandl_rr_2_wl nc_tp_bandl_nacc_1_s nc_tp_bandl_nacc_1_d nc_tp_bandl_nacc_1_g nc_tp_bandl_nacc_2_s nc_tp_bandl_nacc_2_d nc_tp_bandl_nacc_2_g nc_tp_bandl_kv_hpo0p35_l_1_f1
+ nc_tp_bandl_kv_hpo0p35_l_1_s1 nc_tp_bandl_kv_hpo0p35_l_1_s2 nc_tp_bandl_kv_hpo0p35_l_1_f2 nc_tp_bandl_kv_hpo1p41_l_1_f1 nc_tp_bandl_kv_hpo1p41_l_1_s1 nc_tp_bandl_kv_hpo1p41_l_1_s2
+ nc_tp_bandl_kv_hpo1p41_l_1_f2 nc_tp_bandl_kv_xpo0p35_l_1_f1 nc_tp_bandl_kv_xpo0p35_l_1_s1 nc_tp_bandl_kv_xpo0p35_l_1_s2 nc_tp_bandl_kv_xpo0p35_l_1_f2 nc_tp_bandl_kv_xpo1p41_l_1_f1
+ nc_tp_bandl_kv_xpo1p41_l_1_s1 nc_tp_bandl_kv_xpo1p41_l_1_s2 nc_tp_bandl_kv_xpo1p41_l_1_f2 nc_tp_bandl_kv_nd_l_1_f1 nc_tp_bandl_kv_nd_l_1_s1 nc_tp_bandl_kv_nd_l_1_s2 nc_tp_bandl_kv_nd_l_1_f2
+ nc_tp_bandl_kv_pd_l_1_f1 nc_tp_bandl_kv_pd_l_1_s1 nc_tp_bandl_kv_pd_l_1_s2 nc_tp_bandl_kv_pd_l_1_f2 nc_tp_bandl_kv_m1_l_1_f1 nc_tp_bandl_kv_m1_l_1_s1 nc_tp_bandl_kv_m1_l_1_s2 nc_tp_bandl_kv_m1_l_1_f2
+ nc_tp_bandl_kv_m2_l_1_f1 nc_tp_bandl_kv_m2_l_1_s1 nc_tp_bandl_kv_m2_l_1_s2 nc_tp_bandl_kv_m2_l_1_f2 VDD VSS tp_bandl
Xtp_bandr nc_tp_bandr_kv_hpo0p35_l_1_f1 nc_tp_bandr_kv_hpo0p35_l_1_s1 nc_tp_bandr_kv_hpo0p35_l_1_s2 nc_tp_bandr_kv_hpo0p35_l_1_f2 nc_tp_bandr_kv_hpo1p41_l_1_f1 nc_tp_bandr_kv_hpo1p41_l_1_s1
+ nc_tp_bandr_kv_hpo1p41_l_1_s2 nc_tp_bandr_kv_hpo1p41_l_1_f2 nc_tp_bandr_kv_xpo0p35_l_1_f1 nc_tp_bandr_kv_xpo0p35_l_1_s1 nc_tp_bandr_kv_xpo0p35_l_1_s2 nc_tp_bandr_kv_xpo0p35_l_1_f2
+ nc_tp_bandr_kv_xpo1p41_l_1_f1 nc_tp_bandr_kv_xpo1p41_l_1_s1 nc_tp_bandr_kv_xpo1p41_l_1_s2 nc_tp_bandr_kv_xpo1p41_l_1_f2 nc_tp_bandr_kv_nd_l_1_f1 nc_tp_bandr_kv_nd_l_1_s1 nc_tp_bandr_kv_nd_l_1_s2
+ nc_tp_bandr_kv_nd_l_1_f2 nc_tp_bandr_kv_pd_l_1_f1 nc_tp_bandr_kv_pd_l_1_s1 nc_tp_bandr_kv_pd_l_1_s2 nc_tp_bandr_kv_pd_l_1_f2 nc_tp_bandr_kv_m1_l_1_f1 nc_tp_bandr_kv_m1_l_1_s1 nc_tp_bandr_kv_m1_l_1_s2
+ nc_tp_bandr_kv_m1_l_1_f2 nc_tp_bandr_kv_m2_l_1_f1 nc_tp_bandr_kv_m2_l_1_s1 nc_tp_bandr_kv_m2_l_1_s2 nc_tp_bandr_kv_m2_l_1_f2 nc_tp_bandr_kv_m3_l_1_f1 nc_tp_bandr_kv_m3_l_1_s1 nc_tp_bandr_kv_m3_l_1_s2
+ nc_tp_bandr_kv_m3_l_1_f2 nc_tp_bandr_ch_poly_1_a nc_tp_bandr_ch_poly_1_b nc_tp_bandr_ch_ndiff_1_a nc_tp_bandr_ch_ndiff_1_b nc_tp_bandr_ch_pdiff_1_a nc_tp_bandr_ch_pdiff_1_b nc_tp_bandr_ch_mcon_1_a
+ nc_tp_bandr_ch_mcon_1_b nc_tp_bandr_ch_via1_1_a nc_tp_bandr_ch_via1_1_b nc_tp_bandr_ch_via2_1_a nc_tp_bandr_ch_via2_1_b nc_tp_bandr_nacc_1_s nc_tp_bandr_nacc_1_d nc_tp_bandr_nacc_1_g
+ nc_tp_bandr_ch_poly_2_a nc_tp_bandr_ch_poly_2_b nc_tp_bandr_ch_ndiff_2_a nc_tp_bandr_ch_ndiff_2_b nc_tp_bandr_ch_pdiff_2_a nc_tp_bandr_ch_pdiff_2_b VDD VSS tp_bandr
Xilatb1 LAT VSS VSS VDD VDD latb_1 sky130_fd_sc_hvl__inv_2
Xilatb2 LAT VSS VSS VDD VDD latb_2 sky130_fd_sc_hvl__inv_2
.ENDS chip_core
