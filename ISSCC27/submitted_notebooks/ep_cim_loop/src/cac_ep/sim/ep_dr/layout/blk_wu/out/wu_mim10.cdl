.subckt wu_mim10 top bot
C0 top bot cap_mim_m3__base w=2.080u l=2.080u
.ends wu_mim10
