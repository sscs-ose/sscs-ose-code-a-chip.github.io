.subckt wu_dlat d clk clkb q qb vdd vss
MTn s clk d vss nfet_g5v0d10v5 w=2u l=0.5u
MTp s clkb d vdd pfet_g5v0d10v5 w=4u l=0.5u
MI1n qb s vss vss nfet_g5v0d10v5 w=1u l=0.5u
MI1p qb s vdd vdd pfet_g5v0d10v5 w=2u l=0.5u
MI2n q qb vss vss nfet_g5v0d10v5 w=1u l=0.5u
MI2p q qb vdd vdd pfet_g5v0d10v5 w=2u l=0.5u
.ends wu_dlat
