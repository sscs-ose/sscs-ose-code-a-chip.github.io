* rb_macros.cdl — 사본 (include 를 한 번만), 원본 digital/row_blk/macros/rb_macros.cdl, mk_top.py 2026-10-28 07:35
* rb_macros.cdl -- mk_macros.py 출력 (원본 layout/blocks/tg_n2·tgw_n20 .cdl)
.subckt rb_tg_n2 a b ctl ctlb VDD VSS
Mn_0 b ctl a VSS nfet_g5v0d10v5 w=1.000u l=0.500u
Mn_1 b ctl a VSS nfet_g5v0d10v5 w=1.000u l=0.500u
Mp_0 b ctlb a VDD pfet_g5v0d10v5 w=2.000u l=0.500u
Mp_1 b ctlb a VDD pfet_g5v0d10v5 w=2.000u l=0.500u
.ends rb_tg_n2

.subckt rb_tgw_n20 a b ctl ctlb VDD VSS
Mn_0 b ctl a VSS nfet_g5v0d10v5 w=4.000u l=0.500u
Mn_1 b ctl a VSS nfet_g5v0d10v5 w=4.000u l=0.500u
Mn_2 b ctl a VSS nfet_g5v0d10v5 w=4.000u l=0.500u
Mn_3 b ctl a VSS nfet_g5v0d10v5 w=4.000u l=0.500u
Mn_4 b ctl a VSS nfet_g5v0d10v5 w=4.000u l=0.500u
Mp_0 b ctlb a VDD pfet_g5v0d10v5 w=8.000u l=0.500u
Mp_1 b ctlb a VDD pfet_g5v0d10v5 w=8.000u l=0.500u
Mp_2 b ctlb a VDD pfet_g5v0d10v5 w=8.000u l=0.500u
Mp_3 b ctlb a VDD pfet_g5v0d10v5 w=8.000u l=0.500u
Mp_4 b ctlb a VDD pfet_g5v0d10v5 w=8.000u l=0.500u
.ends rb_tgw_n20

.subckt rb_tg_n2_av b ctl ctlb VDD VSS
Mn_0 b ctl VDD VSS nfet_g5v0d10v5 w=1.000u l=0.500u
Mn_1 b ctl VDD VSS nfet_g5v0d10v5 w=1.000u l=0.500u
Mp_0 b ctlb VDD VDD pfet_g5v0d10v5 w=2.000u l=0.500u
Mp_1 b ctlb VDD VDD pfet_g5v0d10v5 w=2.000u l=0.500u
.ends rb_tg_n2_av

.subckt rb_tg_n2_as b ctl ctlb VDD VSS
Mn_0 b ctl VSS VSS nfet_g5v0d10v5 w=1.000u l=0.500u
Mn_1 b ctl VSS VSS nfet_g5v0d10v5 w=1.000u l=0.500u
Mp_0 b ctlb VSS VDD pfet_g5v0d10v5 w=2.000u l=0.500u
Mp_1 b ctlb VSS VDD pfet_g5v0d10v5 w=2.000u l=0.500u
.ends rb_tg_n2_as
