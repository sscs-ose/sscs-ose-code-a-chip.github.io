* bias_beta.cdl — 사본 (그대로), 원본 layout/blk_analog/out/bias_beta.cdl, mk_top.py 2026-10-28 07:35
.subckt bias_beta vbn vbp vbpc pref nref vdd vss
MXBN vbn vbn vss vss nfet_g5v0d10v5 w=0.9u l=1u
MXMbn pref vbn vss vss nfet_g5v0d10v5 w=5.72u l=1u
MXMNref nref nref vss vss nfet_g5v0d10v5 w=15u l=2u
MXBP x vbp vdd vdd pfet_g5v0d10v5 w=2u l=0.8u
MXBPC vbp vbpc x vdd pfet_g5v0d10v5 w=1.5u l=0.5u
MXMbp bx vbp vdd vdd pfet_g5v0d10v5 w=14.12u l=0.8u
MXMbpc nref vbpc bx vdd pfet_g5v0d10v5 w=10.6u l=0.5u
MXMPref pref pref vdd vdd pfet_g5v0d10v5 w=42u l=2u
.ends bias_beta
