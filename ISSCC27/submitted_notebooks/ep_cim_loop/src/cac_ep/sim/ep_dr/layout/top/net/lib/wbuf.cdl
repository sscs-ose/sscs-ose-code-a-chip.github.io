* wbuf.cdl — 사본 (그대로), 원본 layout/blk_analog/out/wbuf.cdl, mk_top.py 2026-10-28 07:35
.subckt wbuf wp pol out vwh vwl vdd vss
MXN1a s1 wp n1 vss nfet_g5v0d10v5 w=2u l=0.5u
MXN1b s1 pol vss vss nfet_g5v0d10v5 w=2u l=0.5u
MXN2a s2 wp n2 vss nfet_g5v0d10v5 w=2u l=0.5u
MXN2b s2 n1 vss vss nfet_g5v0d10v5 w=2u l=0.5u
MXN3a s3 pol n3 vss nfet_g5v0d10v5 w=2u l=0.5u
MXN3b s3 n1 vss vss nfet_g5v0d10v5 w=2u l=0.5u
MXN4a s4 n2 xr vss nfet_g5v0d10v5 w=2u l=0.5u
MXN4b s4 n3 vss vss nfet_g5v0d10v5 w=2u l=0.5u
MXI0n f0 xr vss vss nfet_g5v0d10v5 w=1u l=0.5u
MXM1 f1 f0 vss vss nfet_g5v0d10v5 w=4u l=0.5u
MXM2 f2 f1 vss vss nfet_g5v0d10v5 w=16u l=0.5u
MXP1a n1 wp vdd vdd pfet_g5v0d10v5 w=2u l=0.5u
MXP1b n1 pol vdd vdd pfet_g5v0d10v5 w=2u l=0.5u
MXP2a n2 wp vdd vdd pfet_g5v0d10v5 w=2u l=0.5u
MXP2b n2 n1 vdd vdd pfet_g5v0d10v5 w=2u l=0.5u
MXP3a n3 pol vdd vdd pfet_g5v0d10v5 w=2u l=0.5u
MXP3b n3 n1 vdd vdd pfet_g5v0d10v5 w=2u l=0.5u
MXP4a xr n2 vdd vdd pfet_g5v0d10v5 w=2u l=0.5u
MXP4b xr n3 vdd vdd pfet_g5v0d10v5 w=2u l=0.5u
MXI0p f0 xr vdd vdd pfet_g5v0d10v5 w=2u l=0.5u
MXP1 f1 f0 vdd vdd pfet_g5v0d10v5 w=8u l=0.5u
MXP2 f2 f1 vdd vdd pfet_g5v0d10v5 w=32u l=0.5u
MXMo out f2 vwl vss nfet_g5v0d10v5 w=200u l=0.5u
MXPo out f2 vwh vdd pfet_g5v0d10v5 w=400u l=0.5u
.ends wbuf
