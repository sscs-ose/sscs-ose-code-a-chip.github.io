* data_blk.cdl -- GENERATED by v2cdl.py from data_blk_pnr.v

.INCLUDE /home/grads/s/seokjindaveoh/work/ep_dr/layout/blk_digital/pdk/sky130_fd_sc_hvl_u.cdl

.SUBCKT data_blk sdi data_clk dload READ rstb ga[48] ga[47] ga[46] ga[45] ga[44] ga[43] ga[42] ga[41] ga[40] ga[39] ga[38] ga[37] ga[36] ga[35] ga[34] ga[33] ga[32] ga[31] ga[30] ga[29] ga[28] ga[27] ga[26] ga[25] ga[24] ga[23] ga[22] ga[21] ga[20] ga[19] ga[18] ga[17] ga[16] ga[15] ga[14] ga[13] ga[12] ga[11] ga[10] ga[9] ga[8] ga[7] ga[6] ga[5] ga[4] ga[3] ga[2] ga[1] ga[0] gb[48] gb[47] gb[46] gb[45] gb[44] gb[43] gb[42] gb[41] gb[40] gb[39] gb[38] gb[37] gb[36] gb[35] gb[34] gb[33] gb[32] gb[31] gb[30] gb[29] gb[28] gb[27] gb[26] gb[25] gb[24] gb[23] gb[22] gb[21] gb[20] gb[19] gb[18] gb[17] gb[16] gb[15] gb[14] gb[13] gb[12] gb[11] gb[10] gb[9] gb[8] gb[7] gb[6] gb[5] gb[4] gb[3] gb[2] gb[1] gb[0] sp[2] sp[1] sp[0] spb[2] spb[1] spb[0] sm[2] sm[1] sm[0] smb[2] smb[1] smb[0] VDD VSS
XFE_OFC101_sm_0 FE_OFN101_sm_0 VSS VSS VDD VDD sm[0] sky130_fd_sc_hvl__buf_1
XFE_OFC100_sm_1 FE_OFN100_sm_1 VSS VSS VDD VDD sm[1] sky130_fd_sc_hvl__buf_1
XFE_OFC99_sm_2 FE_OFN99_sm_2 VSS VSS VDD VDD sm[2] sky130_fd_sc_hvl__buf_1
XFE_OFC98_gb_0 FE_OFN98_gb_0 VSS VSS VDD VDD gb[0] sky130_fd_sc_hvl__buf_8
XFE_OFC97_gb_1 FE_OFN97_gb_1 VSS VSS VDD VDD gb[1] sky130_fd_sc_hvl__buf_8
XFE_OFC96_gb_2 FE_OFN96_gb_2 VSS VSS VDD VDD gb[2] sky130_fd_sc_hvl__buf_8
XFE_OFC95_gb_3 FE_OFN95_gb_3 VSS VSS VDD VDD gb[3] sky130_fd_sc_hvl__buf_8
XFE_OFC94_gb_4 FE_OFN94_gb_4 VSS VSS VDD VDD gb[4] sky130_fd_sc_hvl__buf_8
XFE_OFC93_gb_5 FE_OFN93_gb_5 VSS VSS VDD VDD gb[5] sky130_fd_sc_hvl__buf_8
XFE_OFC92_gb_6 FE_OFN92_gb_6 VSS VSS VDD VDD gb[6] sky130_fd_sc_hvl__buf_8
XFE_OFC91_gb_7 FE_OFN91_gb_7 VSS VSS VDD VDD gb[7] sky130_fd_sc_hvl__buf_8
XFE_OFC90_gb_8 FE_OFN90_gb_8 VSS VSS VDD VDD gb[8] sky130_fd_sc_hvl__buf_8
XFE_OFC89_gb_9 FE_OFN89_gb_9 VSS VSS VDD VDD gb[9] sky130_fd_sc_hvl__buf_8
XFE_OFC88_gb_10 FE_OFN88_gb_10 VSS VSS VDD VDD gb[10] sky130_fd_sc_hvl__buf_8
XFE_OFC87_gb_11 FE_OFN87_gb_11 VSS VSS VDD VDD gb[11] sky130_fd_sc_hvl__buf_8
XFE_OFC86_gb_12 FE_OFN86_gb_12 VSS VSS VDD VDD gb[12] sky130_fd_sc_hvl__buf_8
XFE_OFC85_gb_13 FE_OFN85_gb_13 VSS VSS VDD VDD gb[13] sky130_fd_sc_hvl__buf_8
XFE_OFC84_gb_14 FE_OFN84_gb_14 VSS VSS VDD VDD gb[14] sky130_fd_sc_hvl__buf_8
XFE_OFC83_gb_15 FE_OFN83_gb_15 VSS VSS VDD VDD gb[15] sky130_fd_sc_hvl__buf_8
XFE_OFC82_gb_16 FE_OFN82_gb_16 VSS VSS VDD VDD gb[16] sky130_fd_sc_hvl__buf_8
XFE_OFC81_gb_17 FE_OFN81_gb_17 VSS VSS VDD VDD gb[17] sky130_fd_sc_hvl__buf_8
XFE_OFC80_gb_18 FE_OFN80_gb_18 VSS VSS VDD VDD gb[18] sky130_fd_sc_hvl__buf_8
XFE_OFC79_gb_19 FE_OFN79_gb_19 VSS VSS VDD VDD gb[19] sky130_fd_sc_hvl__buf_8
XFE_OFC78_gb_20 FE_OFN78_gb_20 VSS VSS VDD VDD gb[20] sky130_fd_sc_hvl__buf_8
XFE_OFC77_gb_21 FE_OFN77_gb_21 VSS VSS VDD VDD gb[21] sky130_fd_sc_hvl__buf_8
XFE_OFC76_gb_22 FE_OFN76_gb_22 VSS VSS VDD VDD gb[22] sky130_fd_sc_hvl__buf_8
XFE_OFC75_gb_23 FE_OFN75_gb_23 VSS VSS VDD VDD gb[23] sky130_fd_sc_hvl__buf_8
XFE_OFC74_gb_24 FE_OFN74_gb_24 VSS VSS VDD VDD gb[24] sky130_fd_sc_hvl__buf_8
XFE_OFC73_gb_25 FE_OFN73_gb_25 VSS VSS VDD VDD gb[25] sky130_fd_sc_hvl__buf_8
XFE_OFC72_gb_26 FE_OFN72_gb_26 VSS VSS VDD VDD gb[26] sky130_fd_sc_hvl__buf_8
XFE_OFC71_gb_27 FE_OFN71_gb_27 VSS VSS VDD VDD gb[27] sky130_fd_sc_hvl__buf_8
XFE_OFC70_gb_28 FE_OFN70_gb_28 VSS VSS VDD VDD gb[28] sky130_fd_sc_hvl__buf_8
XFE_OFC69_gb_29 FE_OFN69_gb_29 VSS VSS VDD VDD gb[29] sky130_fd_sc_hvl__buf_8
XFE_OFC68_gb_30 FE_OFN68_gb_30 VSS VSS VDD VDD gb[30] sky130_fd_sc_hvl__buf_8
XFE_OFC67_gb_31 FE_OFN67_gb_31 VSS VSS VDD VDD gb[31] sky130_fd_sc_hvl__buf_8
XFE_OFC66_gb_32 FE_OFN66_gb_32 VSS VSS VDD VDD gb[32] sky130_fd_sc_hvl__buf_8
XFE_OFC65_gb_33 FE_OFN65_gb_33 VSS VSS VDD VDD gb[33] sky130_fd_sc_hvl__buf_8
XFE_OFC64_gb_34 FE_OFN64_gb_34 VSS VSS VDD VDD gb[34] sky130_fd_sc_hvl__buf_8
XFE_OFC63_gb_35 FE_OFN63_gb_35 VSS VSS VDD VDD gb[35] sky130_fd_sc_hvl__buf_8
XFE_OFC62_gb_36 FE_OFN62_gb_36 VSS VSS VDD VDD gb[36] sky130_fd_sc_hvl__buf_8
XFE_OFC61_gb_37 FE_OFN61_gb_37 VSS VSS VDD VDD gb[37] sky130_fd_sc_hvl__buf_8
XFE_OFC60_gb_38 FE_OFN60_gb_38 VSS VSS VDD VDD gb[38] sky130_fd_sc_hvl__buf_8
XFE_OFC59_gb_39 FE_OFN59_gb_39 VSS VSS VDD VDD gb[39] sky130_fd_sc_hvl__buf_8
XFE_OFC58_gb_40 FE_OFN58_gb_40 VSS VSS VDD VDD gb[40] sky130_fd_sc_hvl__buf_8
XFE_OFC57_gb_41 FE_OFN57_gb_41 VSS VSS VDD VDD gb[41] sky130_fd_sc_hvl__buf_8
XFE_OFC56_gb_42 FE_OFN56_gb_42 VSS VSS VDD VDD gb[42] sky130_fd_sc_hvl__buf_8
XFE_OFC55_gb_43 FE_OFN55_gb_43 VSS VSS VDD VDD gb[43] sky130_fd_sc_hvl__buf_8
XFE_OFC54_gb_44 FE_OFN54_gb_44 VSS VSS VDD VDD gb[44] sky130_fd_sc_hvl__buf_8
XFE_OFC53_gb_45 FE_OFN53_gb_45 VSS VSS VDD VDD gb[45] sky130_fd_sc_hvl__buf_8
XFE_OFC52_gb_46 FE_OFN52_gb_46 VSS VSS VDD VDD gb[46] sky130_fd_sc_hvl__buf_8
XFE_OFC51_gb_47 FE_OFN51_gb_47 VSS VSS VDD VDD gb[47] sky130_fd_sc_hvl__buf_8
XFE_OFC50_gb_48 FE_OFN50_gb_48 VSS VSS VDD VDD gb[48] sky130_fd_sc_hvl__buf_8
XFE_OFC49_ga_0 FE_OFN49_ga_0 VSS VSS VDD VDD ga[0] sky130_fd_sc_hvl__buf_8
XFE_OFC48_ga_1 FE_OFN48_ga_1 VSS VSS VDD VDD ga[1] sky130_fd_sc_hvl__buf_8
XFE_OFC47_ga_2 FE_OFN47_ga_2 VSS VSS VDD VDD ga[2] sky130_fd_sc_hvl__buf_8
XFE_OFC46_ga_3 FE_OFN46_ga_3 VSS VSS VDD VDD ga[3] sky130_fd_sc_hvl__buf_8
XFE_OFC45_ga_4 FE_OFN45_ga_4 VSS VSS VDD VDD ga[4] sky130_fd_sc_hvl__buf_8
XFE_OFC44_ga_5 FE_OFN44_ga_5 VSS VSS VDD VDD ga[5] sky130_fd_sc_hvl__buf_8
XFE_OFC43_ga_6 FE_OFN43_ga_6 VSS VSS VDD VDD ga[6] sky130_fd_sc_hvl__buf_8
XFE_OFC42_ga_7 FE_OFN42_ga_7 VSS VSS VDD VDD ga[7] sky130_fd_sc_hvl__buf_8
XFE_OFC41_ga_8 FE_OFN41_ga_8 VSS VSS VDD VDD ga[8] sky130_fd_sc_hvl__buf_8
XFE_OFC40_ga_9 FE_OFN40_ga_9 VSS VSS VDD VDD ga[9] sky130_fd_sc_hvl__buf_8
XFE_OFC39_ga_10 FE_OFN39_ga_10 VSS VSS VDD VDD ga[10] sky130_fd_sc_hvl__buf_8
XFE_OFC38_ga_11 FE_OFN38_ga_11 VSS VSS VDD VDD ga[11] sky130_fd_sc_hvl__buf_8
XFE_OFC37_ga_12 FE_OFN37_ga_12 VSS VSS VDD VDD ga[12] sky130_fd_sc_hvl__buf_8
XFE_OFC36_ga_13 FE_OFN36_ga_13 VSS VSS VDD VDD ga[13] sky130_fd_sc_hvl__buf_8
XFE_OFC35_ga_14 FE_OFN35_ga_14 VSS VSS VDD VDD ga[14] sky130_fd_sc_hvl__buf_8
XFE_OFC34_ga_15 FE_OFN34_ga_15 VSS VSS VDD VDD ga[15] sky130_fd_sc_hvl__buf_8
XFE_OFC33_ga_16 FE_OFN33_ga_16 VSS VSS VDD VDD ga[16] sky130_fd_sc_hvl__buf_8
XFE_OFC32_ga_17 FE_OFN32_ga_17 VSS VSS VDD VDD ga[17] sky130_fd_sc_hvl__buf_8
XFE_OFC31_ga_18 FE_OFN31_ga_18 VSS VSS VDD VDD ga[18] sky130_fd_sc_hvl__buf_8
XFE_OFC30_ga_19 FE_OFN30_ga_19 VSS VSS VDD VDD ga[19] sky130_fd_sc_hvl__buf_8
XFE_OFC29_ga_20 FE_OFN29_ga_20 VSS VSS VDD VDD ga[20] sky130_fd_sc_hvl__buf_8
XFE_OFC28_ga_21 FE_OFN28_ga_21 VSS VSS VDD VDD ga[21] sky130_fd_sc_hvl__buf_8
XFE_OFC27_ga_22 FE_OFN27_ga_22 VSS VSS VDD VDD ga[22] sky130_fd_sc_hvl__buf_8
XFE_OFC26_ga_23 FE_OFN26_ga_23 VSS VSS VDD VDD ga[23] sky130_fd_sc_hvl__buf_8
XFE_OFC25_ga_24 FE_OFN25_ga_24 VSS VSS VDD VDD ga[24] sky130_fd_sc_hvl__buf_8
XFE_OFC24_ga_25 FE_OFN24_ga_25 VSS VSS VDD VDD ga[25] sky130_fd_sc_hvl__buf_8
XFE_OFC23_ga_26 FE_OFN23_ga_26 VSS VSS VDD VDD ga[26] sky130_fd_sc_hvl__buf_8
XFE_OFC22_ga_27 FE_OFN22_ga_27 VSS VSS VDD VDD ga[27] sky130_fd_sc_hvl__buf_8
XFE_OFC21_ga_28 FE_OFN21_ga_28 VSS VSS VDD VDD ga[28] sky130_fd_sc_hvl__buf_8
XFE_OFC20_ga_29 FE_OFN20_ga_29 VSS VSS VDD VDD ga[29] sky130_fd_sc_hvl__buf_8
XFE_OFC19_ga_30 FE_OFN19_ga_30 VSS VSS VDD VDD ga[30] sky130_fd_sc_hvl__buf_8
XFE_OFC18_ga_31 FE_OFN18_ga_31 VSS VSS VDD VDD ga[31] sky130_fd_sc_hvl__buf_8
XFE_OFC17_ga_32 FE_OFN17_ga_32 VSS VSS VDD VDD ga[32] sky130_fd_sc_hvl__buf_8
XFE_OFC16_ga_33 FE_OFN16_ga_33 VSS VSS VDD VDD ga[33] sky130_fd_sc_hvl__buf_8
XFE_OFC15_ga_34 FE_OFN15_ga_34 VSS VSS VDD VDD ga[34] sky130_fd_sc_hvl__buf_8
XFE_OFC14_ga_35 FE_OFN14_ga_35 VSS VSS VDD VDD ga[35] sky130_fd_sc_hvl__buf_8
XFE_OFC13_ga_36 FE_OFN13_ga_36 VSS VSS VDD VDD ga[36] sky130_fd_sc_hvl__buf_8
XFE_OFC12_ga_37 FE_OFN12_ga_37 VSS VSS VDD VDD ga[37] sky130_fd_sc_hvl__buf_8
XFE_OFC11_ga_38 FE_OFN11_ga_38 VSS VSS VDD VDD ga[38] sky130_fd_sc_hvl__buf_8
XFE_OFC10_ga_39 FE_OFN10_ga_39 VSS VSS VDD VDD ga[39] sky130_fd_sc_hvl__buf_8
XFE_OFC9_ga_40 FE_OFN9_ga_40 VSS VSS VDD VDD ga[40] sky130_fd_sc_hvl__buf_8
XFE_OFC8_ga_41 FE_OFN8_ga_41 VSS VSS VDD VDD ga[41] sky130_fd_sc_hvl__buf_8
XFE_OFC7_ga_42 FE_OFN7_ga_42 VSS VSS VDD VDD ga[42] sky130_fd_sc_hvl__buf_8
XFE_OFC6_ga_43 FE_OFN6_ga_43 VSS VSS VDD VDD ga[43] sky130_fd_sc_hvl__buf_8
XFE_OFC5_ga_44 FE_OFN5_ga_44 VSS VSS VDD VDD ga[44] sky130_fd_sc_hvl__buf_8
XFE_OFC4_ga_45 FE_OFN4_ga_45 VSS VSS VDD VDD ga[45] sky130_fd_sc_hvl__buf_8
XFE_OFC3_ga_46 FE_OFN3_ga_46 VSS VSS VDD VDD ga[46] sky130_fd_sc_hvl__buf_8
XFE_OFC2_ga_47 FE_OFN2_ga_47 VSS VSS VDD VDD ga[47] sky130_fd_sc_hvl__buf_8
XFE_OFC1_ga_48 FE_OFN1_ga_48 VSS VSS VDD VDD ga[48] sky130_fd_sc_hvl__buf_8
XFE_OFC0_READ READ VSS VSS VDD VDD FE_OFN0_READ sky130_fd_sc_hvl__buf_1
Xg1161 sm[2] VSS VSS VDD VDD smb[2] sky130_fd_sc_hvl__inv_1
Xg1163 spb[2] VSS VSS VDD VDD sp[2] sky130_fd_sc_hvl__inv_1
Xg1162__2398 dl[51] n_152 VSS VSS VDD VDD FE_OFN99_sm_2 sky130_fd_sc_hvl__nor2_1
Xg1164__5107 READ dl[51] VSS VSS VDD VDD spb[2] sky130_fd_sc_hvl__nand2_1
Xg1167 spb[1] VSS VSS VDD VDD sp[1] sky130_fd_sc_hvl__inv_1
Xg1166 sm[1] VSS VSS VDD VDD smb[1] sky130_fd_sc_hvl__inv_1
Xdl_reg_51 q[51] dload VSS VSS VDD VDD dl[51] sky130_fd_sc_hvl__dlxtp_1
Xg1168__6260 dl[50] n_152 VSS VSS VDD VDD FE_OFN100_sm_1 sky130_fd_sc_hvl__nor2_1
Xg1169__4319 READ dl[50] VSS VSS VDD VDD spb[1] sky130_fd_sc_hvl__nand2_1
Xg1172 sm[0] VSS VSS VDD VDD smb[0] sky130_fd_sc_hvl__inv_1
Xg1173 spb[0] VSS VSS VDD VDD sp[0] sky130_fd_sc_hvl__inv_1
Xq_reg_51 data_clk q[50] rstb VSS VSS VDD VDD q[51] sky130_fd_sc_hvl__dfrtp_1
Xdl_reg_50 q[50] dload VSS VSS VDD VDD dl[50] sky130_fd_sc_hvl__dlxtp_1
Xg1174__8428 dl[49] n_152 VSS VSS VDD VDD FE_OFN101_sm_0 sky130_fd_sc_hvl__nor2_1
Xg1175__5526 READ dl[49] VSS VSS VDD VDD spb[0] sky130_fd_sc_hvl__nand2_1
Xg1178__6783 READ n_144 VSS VSS VDD VDD FE_OFN50_gb_48 sky130_fd_sc_hvl__and2_1
Xdl_reg_49 q[49] dload VSS VSS VDD VDD dl[49] sky130_fd_sc_hvl__dlxtp_1
Xg1179__3680 READ dl[48] VSS VSS VDD VDD FE_OFN1_ga_48 sky130_fd_sc_hvl__and2_1
Xq_reg_50 data_clk q[49] rstb VSS VSS VDD VDD q[50] sky130_fd_sc_hvl__dfrtp_1
Xg1180 dl[48] VSS VSS VDD VDD n_144 sky130_fd_sc_hvl__inv_1
Xg1183__1617 READ n_141 VSS VSS VDD VDD FE_OFN51_gb_47 sky130_fd_sc_hvl__and2_1
Xq_reg_49 data_clk q[48] rstb VSS VSS VDD VDD q[49] sky130_fd_sc_hvl__dfrtp_1
Xg1184__2802 READ dl[47] VSS VSS VDD VDD FE_OFN2_ga_47 sky130_fd_sc_hvl__and2_1
Xdl_reg_48 q[48] dload VSS VSS VDD VDD dl[48] sky130_fd_sc_hvl__dlxtp_1
Xg1185 dl[47] VSS VSS VDD VDD n_141 sky130_fd_sc_hvl__inv_1
Xg1188__1705 READ n_137 VSS VSS VDD VDD FE_OFN52_gb_46 sky130_fd_sc_hvl__and2_1
Xg1189__5122 READ dl[46] VSS VSS VDD VDD FE_OFN3_ga_46 sky130_fd_sc_hvl__and2_1
Xq_reg_48 data_clk q[47] rstb VSS VSS VDD VDD q[48] sky130_fd_sc_hvl__dfrtp_1
Xdl_reg_47 q[47] dload VSS VSS VDD VDD dl[47] sky130_fd_sc_hvl__dlxtp_1
Xg1193__8246 READ n_134 VSS VSS VDD VDD FE_OFN53_gb_45 sky130_fd_sc_hvl__and2_1
Xg1190 dl[46] VSS VSS VDD VDD n_137 sky130_fd_sc_hvl__inv_1
Xg1194__7098 READ dl[45] VSS VSS VDD VDD FE_OFN4_ga_45 sky130_fd_sc_hvl__and2_1
Xq_reg_47 data_clk q[46] rstb VSS VSS VDD VDD q[47] sky130_fd_sc_hvl__dfrtp_1
Xdl_reg_46 q[46] dload VSS VSS VDD VDD dl[46] sky130_fd_sc_hvl__dlxtp_1
Xg1198__6131 READ n_131 VSS VSS VDD VDD FE_OFN54_gb_44 sky130_fd_sc_hvl__and2_1
Xg1195 dl[45] VSS VSS VDD VDD n_134 sky130_fd_sc_hvl__inv_1
Xg1199__1881 READ dl[44] VSS VSS VDD VDD FE_OFN5_ga_44 sky130_fd_sc_hvl__and2_1
Xq_reg_46 data_clk q[45] rstb VSS VSS VDD VDD q[46] sky130_fd_sc_hvl__dfrtp_1
Xdl_reg_45 q[45] dload VSS VSS VDD VDD dl[45] sky130_fd_sc_hvl__dlxtp_1
Xg1203__5115 READ n_129 VSS VSS VDD VDD FE_OFN55_gb_43 sky130_fd_sc_hvl__and2_1
Xg1200 dl[44] VSS VSS VDD VDD n_131 sky130_fd_sc_hvl__inv_1
Xdl_reg_44 q[44] dload VSS VSS VDD VDD dl[44] sky130_fd_sc_hvl__dlxtp_1
Xg1204__7482 READ dl[43] VSS VSS VDD VDD FE_OFN6_ga_43 sky130_fd_sc_hvl__and2_1
Xq_reg_45 data_clk q[44] rstb VSS VSS VDD VDD q[45] sky130_fd_sc_hvl__dfrtp_1
Xg1205 dl[43] VSS VSS VDD VDD n_129 sky130_fd_sc_hvl__inv_1
Xg1208__4733 READ n_126 VSS VSS VDD VDD FE_OFN56_gb_42 sky130_fd_sc_hvl__and2_1
Xq_reg_44 data_clk q[43] rstb VSS VSS VDD VDD q[44] sky130_fd_sc_hvl__dfrtp_1
Xg1209__6161 READ dl[42] VSS VSS VDD VDD FE_OFN7_ga_42 sky130_fd_sc_hvl__and2_1
Xdl_reg_43 q[43] dload VSS VSS VDD VDD dl[43] sky130_fd_sc_hvl__dlxtp_1
Xg1210 dl[42] VSS VSS VDD VDD n_126 sky130_fd_sc_hvl__inv_1
Xg1213__9315 READ n_123 VSS VSS VDD VDD FE_OFN57_gb_41 sky130_fd_sc_hvl__and2_1
Xq_reg_43 data_clk q[42] rstb VSS VSS VDD VDD q[43] sky130_fd_sc_hvl__dfrtp_1
Xg1214__9945 READ dl[41] VSS VSS VDD VDD FE_OFN8_ga_41 sky130_fd_sc_hvl__and2_1
Xdl_reg_42 q[42] dload VSS VSS VDD VDD dl[42] sky130_fd_sc_hvl__dlxtp_1
Xg1215 dl[41] VSS VSS VDD VDD n_123 sky130_fd_sc_hvl__inv_1
Xg1218__2883 READ n_119 VSS VSS VDD VDD FE_OFN58_gb_40 sky130_fd_sc_hvl__and2_1
Xg1219__2346 READ dl[40] VSS VSS VDD VDD FE_OFN9_ga_40 sky130_fd_sc_hvl__and2_1
Xq_reg_42 data_clk q[41] rstb VSS VSS VDD VDD q[42] sky130_fd_sc_hvl__dfrtp_1
Xdl_reg_41 q[41] dload VSS VSS VDD VDD dl[41] sky130_fd_sc_hvl__dlxtp_1
Xg1223__1666 READ n_116 VSS VSS VDD VDD FE_OFN59_gb_39 sky130_fd_sc_hvl__and2_1
Xg1220 dl[40] VSS VSS VDD VDD n_119 sky130_fd_sc_hvl__inv_1
Xg1224__7410 READ dl[39] VSS VSS VDD VDD FE_OFN10_ga_39 sky130_fd_sc_hvl__and2_1
Xq_reg_41 data_clk q[40] rstb VSS VSS VDD VDD q[41] sky130_fd_sc_hvl__dfrtp_1
Xdl_reg_40 q[40] dload VSS VSS VDD VDD dl[40] sky130_fd_sc_hvl__dlxtp_1
Xg1228__6417 READ n_113 VSS VSS VDD VDD FE_OFN60_gb_38 sky130_fd_sc_hvl__and2_1
Xg1225 dl[39] VSS VSS VDD VDD n_116 sky130_fd_sc_hvl__inv_1
Xg1229__5477 READ dl[38] VSS VSS VDD VDD FE_OFN11_ga_38 sky130_fd_sc_hvl__and2_1
Xq_reg_40 data_clk q[39] rstb VSS VSS VDD VDD q[40] sky130_fd_sc_hvl__dfrtp_1
Xdl_reg_39 q[39] dload VSS VSS VDD VDD dl[39] sky130_fd_sc_hvl__dlxtp_1
Xg1233__2398 READ n_110 VSS VSS VDD VDD FE_OFN61_gb_37 sky130_fd_sc_hvl__and2_1
Xg1230 dl[38] VSS VSS VDD VDD n_113 sky130_fd_sc_hvl__inv_1
Xg1234__5107 FE_OFN0_READ dl[37] VSS VSS VDD VDD FE_OFN12_ga_37 sky130_fd_sc_hvl__and2_1
Xq_reg_39 data_clk q[38] rstb VSS VSS VDD VDD q[39] sky130_fd_sc_hvl__dfrtp_1
Xdl_reg_38 q[38] dload VSS VSS VDD VDD dl[38] sky130_fd_sc_hvl__dlxtp_1
Xg1238__6260 FE_OFN0_READ n_107 VSS VSS VDD VDD FE_OFN62_gb_36 sky130_fd_sc_hvl__and2_1
Xg1235 dl[37] VSS VSS VDD VDD n_110 sky130_fd_sc_hvl__inv_1
Xg1239__4319 FE_OFN0_READ dl[36] VSS VSS VDD VDD FE_OFN13_ga_36 sky130_fd_sc_hvl__and2_1
Xq_reg_38 data_clk q[37] rstb VSS VSS VDD VDD q[38] sky130_fd_sc_hvl__dfrtp_1
Xdl_reg_37 q[37] dload VSS VSS VDD VDD dl[37] sky130_fd_sc_hvl__dlxtp_1
Xg1243__8428 FE_OFN0_READ n_104 VSS VSS VDD VDD FE_OFN63_gb_35 sky130_fd_sc_hvl__and2_1
Xg1240 dl[36] VSS VSS VDD VDD n_107 sky130_fd_sc_hvl__inv_1
Xg1244__5526 FE_OFN0_READ dl[35] VSS VSS VDD VDD FE_OFN14_ga_35 sky130_fd_sc_hvl__and2_1
Xq_reg_37 data_clk q[36] rstb VSS VSS VDD VDD q[37] sky130_fd_sc_hvl__dfrtp_1
Xdl_reg_36 q[36] dload VSS VSS VDD VDD dl[36] sky130_fd_sc_hvl__dlxtp_1
Xg1248__6783 FE_OFN0_READ n_102 VSS VSS VDD VDD FE_OFN64_gb_34 sky130_fd_sc_hvl__and2_1
Xg1245 dl[35] VSS VSS VDD VDD n_104 sky130_fd_sc_hvl__inv_1
Xdl_reg_35 q[35] dload VSS VSS VDD VDD dl[35] sky130_fd_sc_hvl__dlxtp_1
Xg1249__3680 FE_OFN0_READ dl[34] VSS VSS VDD VDD FE_OFN15_ga_34 sky130_fd_sc_hvl__and2_1
Xq_reg_36 data_clk q[35] rstb VSS VSS VDD VDD q[36] sky130_fd_sc_hvl__dfrtp_1
Xg1250 dl[34] VSS VSS VDD VDD n_102 sky130_fd_sc_hvl__inv_1
Xg1253__1617 FE_OFN0_READ n_99 VSS VSS VDD VDD FE_OFN65_gb_33 sky130_fd_sc_hvl__and2_1
Xq_reg_35 data_clk q[34] rstb VSS VSS VDD VDD q[35] sky130_fd_sc_hvl__dfrtp_1
Xg1254__2802 FE_OFN0_READ dl[33] VSS VSS VDD VDD FE_OFN16_ga_33 sky130_fd_sc_hvl__and2_1
Xdl_reg_34 q[34] dload VSS VSS VDD VDD dl[34] sky130_fd_sc_hvl__dlxtp_1
Xg1255 dl[33] VSS VSS VDD VDD n_99 sky130_fd_sc_hvl__inv_1
Xg1258__1705 FE_OFN0_READ n_96 VSS VSS VDD VDD FE_OFN66_gb_32 sky130_fd_sc_hvl__and2_1
Xq_reg_34 data_clk q[33] rstb VSS VSS VDD VDD q[34] sky130_fd_sc_hvl__dfrtp_1
Xg1259__5122 FE_OFN0_READ dl[32] VSS VSS VDD VDD FE_OFN17_ga_32 sky130_fd_sc_hvl__and2_1
Xdl_reg_33 q[33] dload VSS VSS VDD VDD dl[33] sky130_fd_sc_hvl__dlxtp_1
Xg1260 dl[32] VSS VSS VDD VDD n_96 sky130_fd_sc_hvl__inv_1
Xg1263__8246 FE_OFN0_READ n_93 VSS VSS VDD VDD FE_OFN67_gb_31 sky130_fd_sc_hvl__and2_1
Xq_reg_33 data_clk q[32] rstb VSS VSS VDD VDD q[33] sky130_fd_sc_hvl__dfrtp_1
Xg1264__7098 FE_OFN0_READ dl[31] VSS VSS VDD VDD FE_OFN18_ga_31 sky130_fd_sc_hvl__and2_1
Xdl_reg_32 q[32] dload VSS VSS VDD VDD dl[32] sky130_fd_sc_hvl__dlxtp_1
Xg1265 dl[31] VSS VSS VDD VDD n_93 sky130_fd_sc_hvl__inv_1
Xg1268__6131 FE_OFN0_READ n_90 VSS VSS VDD VDD FE_OFN68_gb_30 sky130_fd_sc_hvl__and2_1
Xq_reg_32 data_clk q[31] rstb VSS VSS VDD VDD q[32] sky130_fd_sc_hvl__dfrtp_1
Xg1269__1881 FE_OFN0_READ dl[30] VSS VSS VDD VDD FE_OFN19_ga_30 sky130_fd_sc_hvl__and2_1
Xdl_reg_31 q[31] dload VSS VSS VDD VDD dl[31] sky130_fd_sc_hvl__dlxtp_1
Xg1270 dl[30] VSS VSS VDD VDD n_90 sky130_fd_sc_hvl__inv_1
Xg1273__5115 FE_OFN0_READ n_87 VSS VSS VDD VDD FE_OFN69_gb_29 sky130_fd_sc_hvl__and2_1
Xdl_reg_30 q[30] dload VSS VSS VDD VDD dl[30] sky130_fd_sc_hvl__dlxtp_1
Xg1274__7482 FE_OFN0_READ dl[29] VSS VSS VDD VDD FE_OFN20_ga_29 sky130_fd_sc_hvl__and2_1
Xq_reg_31 data_clk q[30] rstb VSS VSS VDD VDD q[31] sky130_fd_sc_hvl__dfrtp_1
Xg1275 dl[29] VSS VSS VDD VDD n_87 sky130_fd_sc_hvl__inv_1
Xg1278__4733 FE_OFN0_READ n_83 VSS VSS VDD VDD FE_OFN70_gb_28 sky130_fd_sc_hvl__and2_1
Xg1279__6161 FE_OFN0_READ dl[28] VSS VSS VDD VDD FE_OFN21_ga_28 sky130_fd_sc_hvl__and2_1
Xq_reg_30 data_clk q[29] rstb VSS VSS VDD VDD q[30] sky130_fd_sc_hvl__dfrtp_1
Xdl_reg_29 q[29] dload VSS VSS VDD VDD dl[29] sky130_fd_sc_hvl__dlxtp_1
Xg1283__9315 FE_OFN0_READ n_80 VSS VSS VDD VDD FE_OFN71_gb_27 sky130_fd_sc_hvl__and2_1
Xg1280 dl[28] VSS VSS VDD VDD n_83 sky130_fd_sc_hvl__inv_1
Xg1284__9945 FE_OFN0_READ dl[27] VSS VSS VDD VDD FE_OFN22_ga_27 sky130_fd_sc_hvl__and2_1
Xdl_reg_28 q[28] dload VSS VSS VDD VDD dl[28] sky130_fd_sc_hvl__dlxtp_1
Xq_reg_29 data_clk q[28] rstb VSS VSS VDD VDD q[29] sky130_fd_sc_hvl__dfrtp_1
Xg1288__2883 FE_OFN0_READ n_77 VSS VSS VDD VDD FE_OFN72_gb_26 sky130_fd_sc_hvl__and2_1
Xg1285 dl[27] VSS VSS VDD VDD n_80 sky130_fd_sc_hvl__inv_1
Xg1289__2346 FE_OFN0_READ dl[26] VSS VSS VDD VDD FE_OFN23_ga_26 sky130_fd_sc_hvl__and2_1
Xq_reg_28 data_clk q[27] rstb VSS VSS VDD VDD q[28] sky130_fd_sc_hvl__dfrtp_1
Xdl_reg_27 q[27] dload VSS VSS VDD VDD dl[27] sky130_fd_sc_hvl__dlxtp_1
Xg1293__1666 FE_OFN0_READ n_74 VSS VSS VDD VDD FE_OFN73_gb_25 sky130_fd_sc_hvl__and2_1
Xg1290 dl[26] VSS VSS VDD VDD n_77 sky130_fd_sc_hvl__inv_1
Xg1294__7410 FE_OFN0_READ dl[25] VSS VSS VDD VDD FE_OFN24_ga_25 sky130_fd_sc_hvl__and2_1
Xq_reg_27 data_clk q[26] rstb VSS VSS VDD VDD q[27] sky130_fd_sc_hvl__dfrtp_1
Xdl_reg_26 q[26] dload VSS VSS VDD VDD dl[26] sky130_fd_sc_hvl__dlxtp_1
Xg1298__6417 FE_OFN0_READ n_71 VSS VSS VDD VDD FE_OFN74_gb_24 sky130_fd_sc_hvl__and2_1
Xg1295 dl[25] VSS VSS VDD VDD n_74 sky130_fd_sc_hvl__inv_1
Xg1299__5477 FE_OFN0_READ dl[24] VSS VSS VDD VDD FE_OFN25_ga_24 sky130_fd_sc_hvl__and2_1
Xq_reg_26 data_clk q[25] rstb VSS VSS VDD VDD q[26] sky130_fd_sc_hvl__dfrtp_1
Xdl_reg_25 q[25] dload VSS VSS VDD VDD dl[25] sky130_fd_sc_hvl__dlxtp_1
Xg1303__2398 FE_OFN0_READ n_68 VSS VSS VDD VDD FE_OFN75_gb_23 sky130_fd_sc_hvl__and2_1
Xg1300 dl[24] VSS VSS VDD VDD n_71 sky130_fd_sc_hvl__inv_1
Xg1304__5107 FE_OFN0_READ dl[23] VSS VSS VDD VDD FE_OFN26_ga_23 sky130_fd_sc_hvl__and2_1
Xq_reg_25 data_clk q[24] rstb VSS VSS VDD VDD q[25] sky130_fd_sc_hvl__dfrtp_1
Xdl_reg_24 q[24] dload VSS VSS VDD VDD dl[24] sky130_fd_sc_hvl__dlxtp_1
Xg1308__6260 FE_OFN0_READ n_66 VSS VSS VDD VDD FE_OFN76_gb_22 sky130_fd_sc_hvl__and2_1
Xg1305 dl[23] VSS VSS VDD VDD n_68 sky130_fd_sc_hvl__inv_1
Xg1309__4319 FE_OFN0_READ dl[22] VSS VSS VDD VDD FE_OFN27_ga_22 sky130_fd_sc_hvl__and2_1
Xq_reg_24 data_clk q[23] rstb VSS VSS VDD VDD q[24] sky130_fd_sc_hvl__dfrtp_1
Xdl_reg_23 q[23] dload VSS VSS VDD VDD dl[23] sky130_fd_sc_hvl__dlxtp_1
Xg1310 dl[22] VSS VSS VDD VDD n_66 sky130_fd_sc_hvl__inv_1
Xg1313__8428 FE_OFN0_READ n_62 VSS VSS VDD VDD FE_OFN77_gb_21 sky130_fd_sc_hvl__and2_1
Xg1314__5526 FE_OFN0_READ dl[21] VSS VSS VDD VDD FE_OFN28_ga_21 sky130_fd_sc_hvl__and2_1
Xq_reg_23 data_clk q[22] rstb VSS VSS VDD VDD q[23] sky130_fd_sc_hvl__dfrtp_1
Xdl_reg_22 q[22] dload VSS VSS VDD VDD dl[22] sky130_fd_sc_hvl__dlxtp_1
Xg1318__6783 FE_OFN0_READ n_59 VSS VSS VDD VDD FE_OFN78_gb_20 sky130_fd_sc_hvl__and2_1
Xg1315 dl[21] VSS VSS VDD VDD n_62 sky130_fd_sc_hvl__inv_1
Xg1319__3680 FE_OFN0_READ dl[20] VSS VSS VDD VDD FE_OFN29_ga_20 sky130_fd_sc_hvl__and2_1
Xq_reg_22 data_clk q[21] rstb VSS VSS VDD VDD q[22] sky130_fd_sc_hvl__dfrtp_1
Xdl_reg_21 q[21] dload VSS VSS VDD VDD dl[21] sky130_fd_sc_hvl__dlxtp_1
Xg1323__1617 FE_OFN0_READ n_56 VSS VSS VDD VDD FE_OFN79_gb_19 sky130_fd_sc_hvl__and2_1
Xg1320 dl[20] VSS VSS VDD VDD n_59 sky130_fd_sc_hvl__inv_1
Xg1324__2802 FE_OFN0_READ dl[19] VSS VSS VDD VDD FE_OFN30_ga_19 sky130_fd_sc_hvl__and2_1
Xq_reg_21 data_clk q[20] rstb VSS VSS VDD VDD q[21] sky130_fd_sc_hvl__dfrtp_1
Xdl_reg_20 q[20] dload VSS VSS VDD VDD dl[20] sky130_fd_sc_hvl__dlxtp_1
Xg1328__1705 FE_OFN0_READ n_53 VSS VSS VDD VDD FE_OFN80_gb_18 sky130_fd_sc_hvl__and2_1
Xg1325 dl[19] VSS VSS VDD VDD n_56 sky130_fd_sc_hvl__inv_1
Xg1329__5122 FE_OFN0_READ dl[18] VSS VSS VDD VDD FE_OFN31_ga_18 sky130_fd_sc_hvl__and2_1
Xq_reg_20 data_clk q[19] rstb VSS VSS VDD VDD q[20] sky130_fd_sc_hvl__dfrtp_1
Xdl_reg_19 q[19] dload VSS VSS VDD VDD dl[19] sky130_fd_sc_hvl__dlxtp_1
Xg1333__8246 FE_OFN0_READ n_50 VSS VSS VDD VDD FE_OFN81_gb_17 sky130_fd_sc_hvl__and2_1
Xg1330 dl[18] VSS VSS VDD VDD n_53 sky130_fd_sc_hvl__inv_1
Xg1334__7098 FE_OFN0_READ dl[17] VSS VSS VDD VDD FE_OFN32_ga_17 sky130_fd_sc_hvl__and2_1
Xq_reg_19 data_clk q[18] rstb VSS VSS VDD VDD q[19] sky130_fd_sc_hvl__dfrtp_1
Xdl_reg_18 q[18] dload VSS VSS VDD VDD dl[18] sky130_fd_sc_hvl__dlxtp_1
Xg1338__6131 FE_OFN0_READ n_48 VSS VSS VDD VDD FE_OFN82_gb_16 sky130_fd_sc_hvl__and2_1
Xg1335 dl[17] VSS VSS VDD VDD n_50 sky130_fd_sc_hvl__inv_1
Xg1339__1881 FE_OFN0_READ dl[16] VSS VSS VDD VDD FE_OFN33_ga_16 sky130_fd_sc_hvl__and2_1
Xq_reg_18 data_clk q[17] rstb VSS VSS VDD VDD q[18] sky130_fd_sc_hvl__dfrtp_1
Xdl_reg_17 q[17] dload VSS VSS VDD VDD dl[17] sky130_fd_sc_hvl__dlxtp_1
Xg1340 dl[16] VSS VSS VDD VDD n_48 sky130_fd_sc_hvl__inv_1
Xg1343__5115 FE_OFN0_READ n_45 VSS VSS VDD VDD FE_OFN83_gb_15 sky130_fd_sc_hvl__and2_1
Xq_reg_17 data_clk q[16] rstb VSS VSS VDD VDD q[17] sky130_fd_sc_hvl__dfrtp_1
Xg1344__7482 FE_OFN0_READ dl[15] VSS VSS VDD VDD FE_OFN34_ga_15 sky130_fd_sc_hvl__and2_1
Xdl_reg_16 q[16] dload VSS VSS VDD VDD dl[16] sky130_fd_sc_hvl__dlxtp_1
Xg1345 dl[15] VSS VSS VDD VDD n_45 sky130_fd_sc_hvl__inv_1
Xg1348__4733 FE_OFN0_READ n_42 VSS VSS VDD VDD FE_OFN84_gb_14 sky130_fd_sc_hvl__and2_1
Xg1349__6161 FE_OFN0_READ dl[14] VSS VSS VDD VDD FE_OFN35_ga_14 sky130_fd_sc_hvl__and2_1
Xq_reg_16 data_clk q[15] rstb VSS VSS VDD VDD q[16] sky130_fd_sc_hvl__dfrtp_1
Xdl_reg_15 q[15] dload VSS VSS VDD VDD dl[15] sky130_fd_sc_hvl__dlxtp_1
Xg1350 dl[14] VSS VSS VDD VDD n_42 sky130_fd_sc_hvl__inv_1
Xg1353__9315 FE_OFN0_READ n_39 VSS VSS VDD VDD FE_OFN85_gb_13 sky130_fd_sc_hvl__and2_1
Xq_reg_15 data_clk q[14] rstb VSS VSS VDD VDD q[15] sky130_fd_sc_hvl__dfrtp_1
Xg1354__9945 FE_OFN0_READ dl[13] VSS VSS VDD VDD FE_OFN36_ga_13 sky130_fd_sc_hvl__and2_1
Xdl_reg_14 q[14] dload VSS VSS VDD VDD dl[14] sky130_fd_sc_hvl__dlxtp_1
Xg1355 dl[13] VSS VSS VDD VDD n_39 sky130_fd_sc_hvl__inv_1
Xg1358__2883 FE_OFN0_READ n_35 VSS VSS VDD VDD FE_OFN86_gb_12 sky130_fd_sc_hvl__and2_1
Xq_reg_14 data_clk q[13] rstb VSS VSS VDD VDD q[14] sky130_fd_sc_hvl__dfrtp_1
Xg1359__2346 FE_OFN0_READ dl[12] VSS VSS VDD VDD FE_OFN37_ga_12 sky130_fd_sc_hvl__and2_1
Xdl_reg_13 q[13] dload VSS VSS VDD VDD dl[13] sky130_fd_sc_hvl__dlxtp_1
Xg1363__1666 FE_OFN0_READ n_33 VSS VSS VDD VDD FE_OFN87_gb_11 sky130_fd_sc_hvl__and2_1
Xg1360 dl[12] VSS VSS VDD VDD n_35 sky130_fd_sc_hvl__inv_1
Xq_reg_13 data_clk q[12] rstb VSS VSS VDD VDD q[13] sky130_fd_sc_hvl__dfrtp_1
Xg1364__7410 FE_OFN0_READ dl[11] VSS VSS VDD VDD FE_OFN38_ga_11 sky130_fd_sc_hvl__and2_1
Xdl_reg_12 q[12] dload VSS VSS VDD VDD dl[12] sky130_fd_sc_hvl__dlxtp_1
Xg1365 dl[11] VSS VSS VDD VDD n_33 sky130_fd_sc_hvl__inv_1
Xg1368__6417 FE_OFN0_READ n_29 VSS VSS VDD VDD FE_OFN88_gb_10 sky130_fd_sc_hvl__and2_1
Xg1369__5477 FE_OFN0_READ dl[10] VSS VSS VDD VDD FE_OFN39_ga_10 sky130_fd_sc_hvl__and2_1
Xq_reg_12 data_clk q[11] rstb VSS VSS VDD VDD q[12] sky130_fd_sc_hvl__dfrtp_1
Xdl_reg_11 q[11] dload VSS VSS VDD VDD dl[11] sky130_fd_sc_hvl__dlxtp_1
Xg1373__2398 FE_OFN0_READ n_27 VSS VSS VDD VDD FE_OFN89_gb_9 sky130_fd_sc_hvl__and2_1
Xg1370 dl[10] VSS VSS VDD VDD n_29 sky130_fd_sc_hvl__inv_1
Xq_reg_11 data_clk q[10] rstb VSS VSS VDD VDD q[11] sky130_fd_sc_hvl__dfrtp_1
Xg1374__5107 FE_OFN0_READ dl[9] VSS VSS VDD VDD FE_OFN40_ga_9 sky130_fd_sc_hvl__and2_1
Xdl_reg_10 q[10] dload VSS VSS VDD VDD dl[10] sky130_fd_sc_hvl__dlxtp_1
Xg1375 dl[9] VSS VSS VDD VDD n_27 sky130_fd_sc_hvl__inv_1
Xg1378__6260 FE_OFN0_READ n_23 VSS VSS VDD VDD FE_OFN90_gb_8 sky130_fd_sc_hvl__and2_1
Xq_reg_10 data_clk q[9] rstb VSS VSS VDD VDD q[10] sky130_fd_sc_hvl__dfrtp_1
Xg1379__4319 FE_OFN0_READ dl[8] VSS VSS VDD VDD FE_OFN41_ga_8 sky130_fd_sc_hvl__and2_1
Xdl_reg_9 q[9] dload VSS VSS VDD VDD dl[9] sky130_fd_sc_hvl__dlxtp_1
Xg1383__8428 FE_OFN0_READ n_21 VSS VSS VDD VDD FE_OFN91_gb_7 sky130_fd_sc_hvl__and2_1
Xg1380 dl[8] VSS VSS VDD VDD n_23 sky130_fd_sc_hvl__inv_1
Xq_reg_9 data_clk q[8] rstb VSS VSS VDD VDD q[9] sky130_fd_sc_hvl__dfrtp_1
Xg1384__5526 FE_OFN0_READ dl[7] VSS VSS VDD VDD FE_OFN42_ga_7 sky130_fd_sc_hvl__and2_1
Xdl_reg_8 q[8] dload VSS VSS VDD VDD dl[8] sky130_fd_sc_hvl__dlxtp_1
Xg1385 dl[7] VSS VSS VDD VDD n_21 sky130_fd_sc_hvl__inv_1
Xg1388__6783 FE_OFN0_READ n_18 VSS VSS VDD VDD FE_OFN92_gb_6 sky130_fd_sc_hvl__and2_1
Xq_reg_8 data_clk q[7] rstb VSS VSS VDD VDD q[8] sky130_fd_sc_hvl__dfrtp_1
Xg1389__3680 FE_OFN0_READ dl[6] VSS VSS VDD VDD FE_OFN43_ga_6 sky130_fd_sc_hvl__and2_1
Xdl_reg_7 q[7] dload VSS VSS VDD VDD dl[7] sky130_fd_sc_hvl__dlxtp_1
Xg1390 dl[6] VSS VSS VDD VDD n_18 sky130_fd_sc_hvl__inv_1
Xg1393__1617 FE_OFN0_READ n_15 VSS VSS VDD VDD FE_OFN93_gb_5 sky130_fd_sc_hvl__and2_1
Xdl_reg_6 q[6] dload VSS VSS VDD VDD dl[6] sky130_fd_sc_hvl__dlxtp_1
Xg1394__2802 FE_OFN0_READ dl[5] VSS VSS VDD VDD FE_OFN44_ga_5 sky130_fd_sc_hvl__and2_1
Xq_reg_7 data_clk q[6] rstb VSS VSS VDD VDD q[7] sky130_fd_sc_hvl__dfrtp_1
Xg1395 dl[5] VSS VSS VDD VDD n_15 sky130_fd_sc_hvl__inv_1
Xg1398__1705 FE_OFN0_READ n_11 VSS VSS VDD VDD FE_OFN94_gb_4 sky130_fd_sc_hvl__and2_1
Xq_reg_6 data_clk q[5] rstb VSS VSS VDD VDD q[6] sky130_fd_sc_hvl__dfrtp_1
Xg1399__5122 FE_OFN0_READ dl[4] VSS VSS VDD VDD FE_OFN45_ga_4 sky130_fd_sc_hvl__and2_1
Xdl_reg_5 q[5] dload VSS VSS VDD VDD dl[5] sky130_fd_sc_hvl__dlxtp_1
Xg1403__8246 FE_OFN0_READ n_9 VSS VSS VDD VDD FE_OFN95_gb_3 sky130_fd_sc_hvl__and2_1
Xg1400 dl[4] VSS VSS VDD VDD n_11 sky130_fd_sc_hvl__inv_1
Xdl_reg_4 q[4] dload VSS VSS VDD VDD dl[4] sky130_fd_sc_hvl__dlxtp_1
Xg1404__7098 FE_OFN0_READ dl[3] VSS VSS VDD VDD FE_OFN46_ga_3 sky130_fd_sc_hvl__and2_1
Xq_reg_5 data_clk q[4] rstb VSS VSS VDD VDD q[5] sky130_fd_sc_hvl__dfrtp_1
Xg1405 dl[3] VSS VSS VDD VDD n_9 sky130_fd_sc_hvl__inv_1
Xg1408__6131 FE_OFN0_READ n_6 VSS VSS VDD VDD FE_OFN96_gb_2 sky130_fd_sc_hvl__and2_1
Xdl_reg_3 q[3] dload VSS VSS VDD VDD dl[3] sky130_fd_sc_hvl__dlxtp_1
Xg1409__1881 FE_OFN0_READ dl[2] VSS VSS VDD VDD FE_OFN47_ga_2 sky130_fd_sc_hvl__and2_1
Xq_reg_4 data_clk q[3] rstb VSS VSS VDD VDD q[4] sky130_fd_sc_hvl__dfrtp_1
Xg1410 dl[2] VSS VSS VDD VDD n_6 sky130_fd_sc_hvl__inv_1
Xg1413__5115 FE_OFN0_READ n_3 VSS VSS VDD VDD FE_OFN97_gb_1 sky130_fd_sc_hvl__and2_1
Xg1414__7482 FE_OFN0_READ dl[1] VSS VSS VDD VDD FE_OFN48_ga_1 sky130_fd_sc_hvl__and2_1
Xq_reg_3 data_clk q[2] rstb VSS VSS VDD VDD q[3] sky130_fd_sc_hvl__dfrtp_1
Xdl_reg_2 q[2] dload VSS VSS VDD VDD dl[2] sky130_fd_sc_hvl__dlxtp_1
Xg1415 dl[1] VSS VSS VDD VDD n_3 sky130_fd_sc_hvl__inv_1
Xg1418__4733 FE_OFN0_READ n_0 VSS VSS VDD VDD FE_OFN98_gb_0 sky130_fd_sc_hvl__and2_1
Xdl_reg_1 q[1] dload VSS VSS VDD VDD dl[1] sky130_fd_sc_hvl__dlxtp_1
Xg1419__6161 FE_OFN0_READ dl[0] VSS VSS VDD VDD FE_OFN49_ga_0 sky130_fd_sc_hvl__and2_1
Xq_reg_2 data_clk q[1] rstb VSS VSS VDD VDD q[2] sky130_fd_sc_hvl__dfrtp_1
Xg1421 dl[0] VSS VSS VDD VDD n_0 sky130_fd_sc_hvl__inv_1
Xdl_reg_0 q[0] dload VSS VSS VDD VDD dl[0] sky130_fd_sc_hvl__dlxtp_1
Xq_reg_1 data_clk q[0] rstb VSS VSS VDD VDD q[1] sky130_fd_sc_hvl__dfrtp_1
Xq_reg_0 data_clk sdi rstb VSS VSS VDD VDD q[0] sky130_fd_sc_hvl__dfrtp_1
Xg1425 READ VSS VSS VDD VDD n_152 sky130_fd_sc_hvl__inv_1
.ENDS data_blk
