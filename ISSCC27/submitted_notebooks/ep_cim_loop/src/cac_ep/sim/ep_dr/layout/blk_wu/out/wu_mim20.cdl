.subckt wu_mim20 top bot
C0 top bot cap_mim_m3__base w=3.005u l=3.005u
.ends wu_mim20
