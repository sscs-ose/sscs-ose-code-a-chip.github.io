* tp_bandr.cdl — 사본 (그대로), 원본 layout/top/testpat/out/tp_bandr.cdl, mk_top.py 2026-10-28 07:35
* tp_bandr — test pattern 블록 (testpat/gen_tp.py, 10/28). 패드 연결 없음, 핀 = 블록 변 met3.
* subckt tp_kv_hpo0p35_l 뺌 — 앞 include tp_tl.cdl 에 같은 내용 이 있음
* subckt tp_kv_hpo1p41_l 뺌 — 앞 include tp_tl.cdl 에 같은 내용 이 있음
* subckt tp_kv_xpo0p35_l 뺌 — 앞 include tp_tl.cdl 에 같은 내용 이 있음
* subckt tp_kv_xpo1p41_l 뺌 — 앞 include tp_tl.cdl 에 같은 내용 이 있음
* subckt tp_kv_nd_l 뺌 — 앞 include tp_tl.cdl 에 같은 내용 이 있음
* subckt tp_kv_pd_l 뺌 — 앞 include tp_tl.cdl 에 같은 내용 이 있음
* subckt tp_kv_m1_l 뺌 — 앞 include tp_tl.cdl 에 같은 내용 이 있음
* subckt tp_kv_m2_l 뺌 — 앞 include tp_tl.cdl 에 같은 내용 이 있음
* subckt tp_kv_m3_l 뺌 — 앞 include tp_tl.cdl 에 같은 내용 이 있음
* subckt tp_ch_poly 뺌 — 앞 include tp_tl.cdl 에 같은 내용 이 있음
* subckt tp_ch_ndiff 뺌 — 앞 include tp_tl.cdl 에 같은 내용 이 있음
* subckt tp_ch_pdiff 뺌 — 앞 include tp_tl.cdl 에 같은 내용 이 있음
* subckt tp_ch_mcon 뺌 — 앞 include tp_tl.cdl 에 같은 내용 이 있음
* subckt tp_ch_via1 뺌 — 앞 include tp_tl.cdl 에 같은 내용 이 있음
* subckt tp_ch_via2 뺌 — 앞 include tp_tl.cdl 에 같은 내용 이 있음
* subckt tp_nacc 뺌 — 앞 include tp_tl.cdl 에 같은 내용 이 있음

.subckt tp_bandr kv_hpo0p35_l_1_f1 kv_hpo0p35_l_1_s1 kv_hpo0p35_l_1_s2 kv_hpo0p35_l_1_f2 kv_hpo1p41_l_1_f1 kv_hpo1p41_l_1_s1 kv_hpo1p41_l_1_s2 kv_hpo1p41_l_1_f2 kv_xpo0p35_l_1_f1 kv_xpo0p35_l_1_s1 kv_xpo0p35_l_1_s2 kv_xpo0p35_l_1_f2 kv_xpo1p41_l_1_f1 kv_xpo1p41_l_1_s1 kv_xpo1p41_l_1_s2 kv_xpo1p41_l_1_f2 kv_nd_l_1_f1 kv_nd_l_1_s1 kv_nd_l_1_s2 kv_nd_l_1_f2 kv_pd_l_1_f1 kv_pd_l_1_s1 kv_pd_l_1_s2 kv_pd_l_1_f2 kv_m1_l_1_f1 kv_m1_l_1_s1 kv_m1_l_1_s2 kv_m1_l_1_f2 kv_m2_l_1_f1 kv_m2_l_1_s1 kv_m2_l_1_s2 kv_m2_l_1_f2 kv_m3_l_1_f1 kv_m3_l_1_s1 kv_m3_l_1_s2 kv_m3_l_1_f2 ch_poly_1_a ch_poly_1_b ch_ndiff_1_a ch_ndiff_1_b ch_pdiff_1_a ch_pdiff_1_b ch_mcon_1_a ch_mcon_1_b ch_via1_1_a ch_via1_1_b ch_via2_1_a ch_via2_1_b nacc_1_s nacc_1_d nacc_1_g ch_poly_2_a ch_poly_2_b ch_ndiff_2_a ch_ndiff_2_b ch_pdiff_2_a ch_pdiff_2_b VDD VSS
Xkv_hpo0p35_l_1 kv_hpo0p35_l_1_f1 kv_hpo0p35_l_1_s1 kv_hpo0p35_l_1_s2 kv_hpo0p35_l_1_f2 VSS tp_kv_hpo0p35_l
Xkv_hpo1p41_l_1 kv_hpo1p41_l_1_f1 kv_hpo1p41_l_1_s1 kv_hpo1p41_l_1_s2 kv_hpo1p41_l_1_f2 VSS tp_kv_hpo1p41_l
Xkv_xpo0p35_l_1 kv_xpo0p35_l_1_f1 kv_xpo0p35_l_1_s1 kv_xpo0p35_l_1_s2 kv_xpo0p35_l_1_f2 VSS tp_kv_xpo0p35_l
Xkv_xpo1p41_l_1 kv_xpo1p41_l_1_f1 kv_xpo1p41_l_1_s1 kv_xpo1p41_l_1_s2 kv_xpo1p41_l_1_f2 VSS tp_kv_xpo1p41_l
Xkv_nd_l_1 kv_nd_l_1_f1 kv_nd_l_1_s1 kv_nd_l_1_s2 kv_nd_l_1_f2 VSS tp_kv_nd_l
Xkv_pd_l_1 kv_pd_l_1_f1 kv_pd_l_1_s1 kv_pd_l_1_s2 kv_pd_l_1_f2 VSS VDD tp_kv_pd_l
Xkv_m1_l_1 kv_m1_l_1_f1 kv_m1_l_1_s1 kv_m1_l_1_s2 kv_m1_l_1_f2 VSS tp_kv_m1_l
Xkv_m2_l_1 kv_m2_l_1_f1 kv_m2_l_1_s1 kv_m2_l_1_s2 kv_m2_l_1_f2 VSS tp_kv_m2_l
Xkv_m3_l_1 kv_m3_l_1_f1 kv_m3_l_1_s1 kv_m3_l_1_s2 kv_m3_l_1_f2 VSS tp_kv_m3_l
Xch_poly_1 ch_poly_1_a ch_poly_1_b VSS tp_ch_poly
Xch_ndiff_1 ch_ndiff_1_a ch_ndiff_1_b VSS tp_ch_ndiff
Xch_pdiff_1 ch_pdiff_1_a ch_pdiff_1_b VDD VSS tp_ch_pdiff
Xch_mcon_1 ch_mcon_1_a ch_mcon_1_b VSS tp_ch_mcon
Xch_via1_1 ch_via1_1_a ch_via1_1_b VSS tp_ch_via1
Xch_via2_1 ch_via2_1_a ch_via2_1_b VSS tp_ch_via2
Xnacc_1 nacc_1_s nacc_1_d nacc_1_g VSS tp_nacc
Xch_poly_2 ch_poly_2_a ch_poly_2_b VSS tp_ch_poly
Xch_ndiff_2 ch_ndiff_2_a ch_ndiff_2_b VSS tp_ch_ndiff
Xch_pdiff_2 ch_pdiff_2_a ch_pdiff_2_b VDD VSS tp_ch_pdiff
.ends tp_bandr
