* testpat 단독 시험 tp_pipetest_t
.subckt tp_pipetest a b VSS
R0 a b $[res_generic_m1] $W=0.5u $L=6u
.ends tp_pipetest
.subckt tp_pipetest_t s0_a s0_b VSS
X0 s0_a s0_b VSS tp_pipetest
.ends tp_pipetest_t
