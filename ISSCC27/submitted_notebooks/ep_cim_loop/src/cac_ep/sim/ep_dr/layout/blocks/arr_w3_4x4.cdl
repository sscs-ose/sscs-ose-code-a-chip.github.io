.subckt arr_w3_4x4 row_0 row_1 row_2 row_3 wl_0 wl_1 wl_2 wl_3 col_0 col_1 col_2 col_3 vss
X_c0_r0 row_0 wl_0 col_0 vss c1t1r_w3
X_c1_r0 row_0 wl_0 col_1 vss c1t1r_w3
X_c2_r0 row_0 wl_0 col_2 vss c1t1r_w3
X_c3_r0 row_0 wl_0 col_3 vss c1t1r_w3
X_c0_r1 row_1 wl_1 col_0 vss c1t1r_w3
X_c1_r1 row_1 wl_1 col_1 vss c1t1r_w3
X_c2_r1 row_1 wl_1 col_2 vss c1t1r_w3
X_c3_r1 row_1 wl_1 col_3 vss c1t1r_w3
X_c0_r2 row_2 wl_2 col_0 vss c1t1r_w3
X_c1_r2 row_2 wl_2 col_1 vss c1t1r_w3
X_c2_r2 row_2 wl_2 col_2 vss c1t1r_w3
X_c3_r2 row_2 wl_2 col_3 vss c1t1r_w3
X_c0_r3 row_3 wl_3 col_0 vss c1t1r_w3
X_c1_r3 row_3 wl_3 col_1 vss c1t1r_w3
X_c2_r3 row_3 wl_3 col_2 vss c1t1r_w3
X_c3_r3 row_3 wl_3 col_3 vss c1t1r_w3
.ends arr_w3_4x4

.subckt c1t1r_w3 TE WL S B
R0 TE D $[reram]
M1 D WL S B nfet_g5v0d10v5 w=1.5u l=0.5u
M2 D WL S B nfet_g5v0d10v5 w=1.5u l=0.5u
.ends c1t1r_w3
