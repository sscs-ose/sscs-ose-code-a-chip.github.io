* tp_bandl.cdl — 사본 (그대로), 원본 layout/top/testpat/out/tp_bandl.cdl, mk_top.py 2026-10-28 07:35
* tp_bandl — test pattern 블록 (testpat/gen_tp.py, 10/28). 패드 연결 없음, 핀 = 블록 변 met3.
* subckt tp_ch_poly 뺌 — 앞 include tp_tl.cdl 에 같은 내용 이 있음
* subckt tp_ch_ndiff 뺌 — 앞 include tp_tl.cdl 에 같은 내용 이 있음
* subckt tp_ch_pdiff 뺌 — 앞 include tp_tl.cdl 에 같은 내용 이 있음
* subckt tp_ch_mcon 뺌 — 앞 include tp_tl.cdl 에 같은 내용 이 있음
* subckt tp_ch_via1 뺌 — 앞 include tp_tl.cdl 에 같은 내용 이 있음
* subckt tp_ch_via2 뺌 — 앞 include tp_tl.cdl 에 같은 내용 이 있음
* subckt tp_1t1r 뺌 — 앞 include tp_tl.cdl 에 같은 내용 이 있음
* subckt tp_nacc 뺌 — 앞 include tp_tl.cdl 에 같은 내용 이 있음
* subckt tp_kv_hpo0p35_l 뺌 — 앞 include tp_tl.cdl 에 같은 내용 이 있음
* subckt tp_kv_hpo1p41_l 뺌 — 앞 include tp_tl.cdl 에 같은 내용 이 있음
* subckt tp_kv_xpo0p35_l 뺌 — 앞 include tp_tl.cdl 에 같은 내용 이 있음
* subckt tp_kv_xpo1p41_l 뺌 — 앞 include tp_tl.cdl 에 같은 내용 이 있음
* subckt tp_kv_nd_l 뺌 — 앞 include tp_tl.cdl 에 같은 내용 이 있음
* subckt tp_kv_pd_l 뺌 — 앞 include tp_tl.cdl 에 같은 내용 이 있음
* subckt tp_kv_m1_l 뺌 — 앞 include tp_tl.cdl 에 같은 내용 이 있음
* subckt tp_kv_m2_l 뺌 — 앞 include tp_tl.cdl 에 같은 내용 이 있음

.subckt tp_bandl ch_poly_1_a ch_poly_1_b ch_ndiff_1_a ch_ndiff_1_b ch_pdiff_1_a ch_pdiff_1_b ch_mcon_1_a ch_mcon_1_b ch_via1_1_a ch_via1_1_b ch_via2_1_a ch_via2_1_b rr_1_s rr_1_te rr_1_wl rr_2_s rr_2_te rr_2_wl nacc_1_s nacc_1_d nacc_1_g nacc_2_s nacc_2_d nacc_2_g kv_hpo0p35_l_1_f1 kv_hpo0p35_l_1_s1 kv_hpo0p35_l_1_s2 kv_hpo0p35_l_1_f2 kv_hpo1p41_l_1_f1 kv_hpo1p41_l_1_s1 kv_hpo1p41_l_1_s2 kv_hpo1p41_l_1_f2 kv_xpo0p35_l_1_f1 kv_xpo0p35_l_1_s1 kv_xpo0p35_l_1_s2 kv_xpo0p35_l_1_f2 kv_xpo1p41_l_1_f1 kv_xpo1p41_l_1_s1 kv_xpo1p41_l_1_s2 kv_xpo1p41_l_1_f2 kv_nd_l_1_f1 kv_nd_l_1_s1 kv_nd_l_1_s2 kv_nd_l_1_f2 kv_pd_l_1_f1 kv_pd_l_1_s1 kv_pd_l_1_s2 kv_pd_l_1_f2 kv_m1_l_1_f1 kv_m1_l_1_s1 kv_m1_l_1_s2 kv_m1_l_1_f2 kv_m2_l_1_f1 kv_m2_l_1_s1 kv_m2_l_1_s2 kv_m2_l_1_f2 VDD VSS
Xch_poly_1 ch_poly_1_a ch_poly_1_b VSS tp_ch_poly
Xch_ndiff_1 ch_ndiff_1_a ch_ndiff_1_b VSS tp_ch_ndiff
Xch_pdiff_1 ch_pdiff_1_a ch_pdiff_1_b VDD VSS tp_ch_pdiff
Xch_mcon_1 ch_mcon_1_a ch_mcon_1_b VSS tp_ch_mcon
Xch_via1_1 ch_via1_1_a ch_via1_1_b VSS tp_ch_via1
Xch_via2_1 ch_via2_1_a ch_via2_1_b VSS tp_ch_via2
Xrr_1 rr_1_s rr_1_te rr_1_wl VSS tp_1t1r
Xrr_2 rr_2_s rr_2_te rr_2_wl VSS tp_1t1r
Xnacc_1 nacc_1_s nacc_1_d nacc_1_g VSS tp_nacc
Xnacc_2 nacc_2_s nacc_2_d nacc_2_g VSS tp_nacc
Xkv_hpo0p35_l_1 kv_hpo0p35_l_1_f1 kv_hpo0p35_l_1_s1 kv_hpo0p35_l_1_s2 kv_hpo0p35_l_1_f2 VSS tp_kv_hpo0p35_l
Xkv_hpo1p41_l_1 kv_hpo1p41_l_1_f1 kv_hpo1p41_l_1_s1 kv_hpo1p41_l_1_s2 kv_hpo1p41_l_1_f2 VSS tp_kv_hpo1p41_l
Xkv_xpo0p35_l_1 kv_xpo0p35_l_1_f1 kv_xpo0p35_l_1_s1 kv_xpo0p35_l_1_s2 kv_xpo0p35_l_1_f2 VSS tp_kv_xpo0p35_l
Xkv_xpo1p41_l_1 kv_xpo1p41_l_1_f1 kv_xpo1p41_l_1_s1 kv_xpo1p41_l_1_s2 kv_xpo1p41_l_1_f2 VSS tp_kv_xpo1p41_l
Xkv_nd_l_1 kv_nd_l_1_f1 kv_nd_l_1_s1 kv_nd_l_1_s2 kv_nd_l_1_f2 VSS tp_kv_nd_l
Xkv_pd_l_1 kv_pd_l_1_f1 kv_pd_l_1_s1 kv_pd_l_1_s2 kv_pd_l_1_f2 VSS VDD tp_kv_pd_l
Xkv_m1_l_1 kv_m1_l_1_f1 kv_m1_l_1_s1 kv_m1_l_1_s2 kv_m1_l_1_f2 VSS tp_kv_m1_l
Xkv_m2_l_1 kv_m2_l_1_f1 kv_m2_l_1_s1 kv_m2_l_1_s2 kv_m2_l_1_f2 VSS tp_kv_m2_l
.ends tp_bandl
