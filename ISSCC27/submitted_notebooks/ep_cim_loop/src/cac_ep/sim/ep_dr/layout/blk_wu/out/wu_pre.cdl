.subckt wu_pre inp inn op on vbn vdd vss
MMt tl vbn vss vss nfet_g5v0d10v5 w=3.6u l=1u
MM1 on inp tl vss nfet_g5v0d10v5 w=4u l=1u
MM2 op inn tl vss nfet_g5v0d10v5 w=4u l=1u
ML1 on on vdd vdd pfet_g5v0d10v5 w=1u l=1u
ML2 op op vdd vdd pfet_g5v0d10v5 w=1u l=1u
.ends wu_pre
