* nudge_inj.cdl — 사본 (그대로), 원본 layout/blk_analog/out/nudge_inj.cdl, mk_top.py 2026-10-28 07:35
.subckt nudge_inj yp0 ym0 yp1 ym1 yp2 ym2 pref nref sp0 spb0 sm0 smb0 sp1 spb1 sm1 smb1 sp2 spb2 sm2 smb2 vdd vss
MXMN0 in0 nref vss vss nfet_g5v0d10v5 w=15u l=2u
MXSW1_0n ip0 sp0 yp0 vss nfet_g5v0d10v5 w=2u l=0.5u
MXSW2_0n ip0 sm0 ym0 vss nfet_g5v0d10v5 w=2u l=0.5u
MXSW3_0n in0 sp0 ym0 vss nfet_g5v0d10v5 w=2u l=0.5u
MXSW4_0n in0 sm0 yp0 vss nfet_g5v0d10v5 w=2u l=0.5u
MXMN1 in1 nref vss vss nfet_g5v0d10v5 w=15u l=2u
MXSW1_1n ip1 sp1 yp1 vss nfet_g5v0d10v5 w=2u l=0.5u
MXSW2_1n ip1 sm1 ym1 vss nfet_g5v0d10v5 w=2u l=0.5u
MXSW3_1n in1 sp1 ym1 vss nfet_g5v0d10v5 w=2u l=0.5u
MXSW4_1n in1 sm1 yp1 vss nfet_g5v0d10v5 w=2u l=0.5u
MXMN2 in2 nref vss vss nfet_g5v0d10v5 w=15u l=2u
MXSW1_2n ip2 sp2 yp2 vss nfet_g5v0d10v5 w=2u l=0.5u
MXSW2_2n ip2 sm2 ym2 vss nfet_g5v0d10v5 w=2u l=0.5u
MXSW3_2n in2 sp2 ym2 vss nfet_g5v0d10v5 w=2u l=0.5u
MXSW4_2n in2 sm2 yp2 vss nfet_g5v0d10v5 w=2u l=0.5u
MXMP0 ip0 pref vdd vdd pfet_g5v0d10v5 w=42u l=2u
MXSW1_0p ip0 spb0 yp0 vdd pfet_g5v0d10v5 w=4u l=0.5u
MXSW2_0p ip0 smb0 ym0 vdd pfet_g5v0d10v5 w=4u l=0.5u
MXSW3_0p in0 spb0 ym0 vdd pfet_g5v0d10v5 w=4u l=0.5u
MXSW4_0p in0 smb0 yp0 vdd pfet_g5v0d10v5 w=4u l=0.5u
MXMP1 ip1 pref vdd vdd pfet_g5v0d10v5 w=42u l=2u
MXSW1_1p ip1 spb1 yp1 vdd pfet_g5v0d10v5 w=4u l=0.5u
MXSW2_1p ip1 smb1 ym1 vdd pfet_g5v0d10v5 w=4u l=0.5u
MXSW3_1p in1 spb1 ym1 vdd pfet_g5v0d10v5 w=4u l=0.5u
MXSW4_1p in1 smb1 yp1 vdd pfet_g5v0d10v5 w=4u l=0.5u
MXMP2 ip2 pref vdd vdd pfet_g5v0d10v5 w=42u l=2u
MXSW1_2p ip2 spb2 yp2 vdd pfet_g5v0d10v5 w=4u l=0.5u
MXSW2_2p ip2 smb2 ym2 vdd pfet_g5v0d10v5 w=4u l=0.5u
MXSW3_2p in2 spb2 ym2 vdd pfet_g5v0d10v5 w=4u l=0.5u
MXSW4_2p in2 smb2 yp2 vdd pfet_g5v0d10v5 w=4u l=0.5u
.ends nudge_inj
