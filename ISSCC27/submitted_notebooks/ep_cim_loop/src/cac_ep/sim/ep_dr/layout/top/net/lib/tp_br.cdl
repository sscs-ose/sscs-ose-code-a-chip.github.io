* tp_br.cdl — 사본 (그대로), 원본 layout/top/testpat/out/tp_br.cdl, mk_top.py 2026-10-28 07:35
* tp_br — test pattern 블록 (testpat/gen_tp.py, 10/28). 패드 연결 없음, 핀 = 블록 변 met3.
* subckt sky130_fd_sc_hvl__inv_1 뺌 — 앞 include sky130_fd_sc_hvl_u.cdl 에 같은 내용 이 있음

* subckt sky130_fd_sc_hvl__nand2_1 뺌 — 앞 include sky130_fd_sc_hvl_u.cdl 에 같은 내용 이 있음

* subckt sky130_fd_sc_hvl__dfrtp_1 뺌 — 앞 include sky130_fd_sc_hvl_u.cdl 에 같은 내용 이 있음

* subckt sky130_fd_sc_hvl__buf_4 뺌 — 앞 include sky130_fd_sc_hvl_u.cdl 에 같은 내용 이 있음

* subckt tp_ro 뺌 — 앞 include tp_tl.cdl 에 같은 내용 이 있음
* subckt tp_kv_hpo0p35_s 뺌 — 앞 include tp_tl.cdl 에 같은 내용 이 있음
* subckt tp_kv_hpo1p41_s 뺌 — 앞 include tp_tl.cdl 에 같은 내용 이 있음
* subckt tp_kv_xpo0p35_s 뺌 — 앞 include tp_tl.cdl 에 같은 내용 이 있음
* subckt tp_kv_xpo1p41_s 뺌 — 앞 include tp_tl.cdl 에 같은 내용 이 있음
* subckt tp_kv_nd_s 뺌 — 앞 include tp_tl.cdl 에 같은 내용 이 있음
* subckt tp_kv_pd_s 뺌 — 앞 include tp_tl.cdl 에 같은 내용 이 있음
* subckt tp_kv_m1_s 뺌 — 앞 include tp_tl.cdl 에 같은 내용 이 있음
* subckt tp_kv_m2_s 뺌 — 앞 include tp_tl.cdl 에 같은 내용 이 있음
* subckt tp_kv_m3_s 뺌 — 앞 include tp_tl.cdl 에 같은 내용 이 있음
* subckt tp_kv_hpo0p35_l 뺌 — 앞 include tp_tl.cdl 에 같은 내용 이 있음
* subckt tp_kv_hpo1p41_l 뺌 — 앞 include tp_tl.cdl 에 같은 내용 이 있음
* subckt tp_kv_xpo0p35_l 뺌 — 앞 include tp_tl.cdl 에 같은 내용 이 있음
* subckt tp_kv_xpo1p41_l 뺌 — 앞 include tp_tl.cdl 에 같은 내용 이 있음
* subckt tp_kv_nd_l 뺌 — 앞 include tp_tl.cdl 에 같은 내용 이 있음
* subckt tp_kv_pd_l 뺌 — 앞 include tp_tl.cdl 에 같은 내용 이 있음
* subckt tp_kv_m1_l 뺌 — 앞 include tp_tl.cdl 에 같은 내용 이 있음
* subckt tp_kv_m2_l 뺌 — 앞 include tp_tl.cdl 에 같은 내용 이 있음
* subckt tp_kv_m3_l 뺌 — 앞 include tp_tl.cdl 에 같은 내용 이 있음
* subckt tp_ch_poly 뺌 — 앞 include tp_tl.cdl 에 같은 내용 이 있음
* subckt tp_ch_ndiff 뺌 — 앞 include tp_tl.cdl 에 같은 내용 이 있음
* subckt tp_ch_pdiff 뺌 — 앞 include tp_tl.cdl 에 같은 내용 이 있음
* subckt tp_ch_mcon 뺌 — 앞 include tp_tl.cdl 에 같은 내용 이 있음
* subckt tp_ch_via1 뺌 — 앞 include tp_tl.cdl 에 같은 내용 이 있음
* subckt tp_ch_via2 뺌 — 앞 include tp_tl.cdl 에 같은 내용 이 있음
* subckt tp_1t1r 뺌 — 앞 include tp_tl.cdl 에 같은 내용 이 있음
* subckt tp_nacc 뺌 — 앞 include tp_tl.cdl 에 같은 내용 이 있음
* subckt tp_pair 뺌 — 앞 include tp_tl.cdl 에 같은 내용 이 있음

.subckt tp_br ro_1_en ro_1_rstb ro_1_out kv_hpo0p35_s_1_f1 kv_hpo0p35_s_1_s1 kv_hpo0p35_s_1_s2 kv_hpo0p35_s_1_f2 kv_hpo1p41_s_1_f1 kv_hpo1p41_s_1_s1 kv_hpo1p41_s_1_s2 kv_hpo1p41_s_1_f2 kv_xpo0p35_s_1_f1 kv_xpo0p35_s_1_s1 kv_xpo0p35_s_1_s2 kv_xpo0p35_s_1_f2 kv_xpo1p41_s_1_f1 kv_xpo1p41_s_1_s1 kv_xpo1p41_s_1_s2 kv_xpo1p41_s_1_f2 kv_nd_s_1_f1 kv_nd_s_1_s1 kv_nd_s_1_s2 kv_nd_s_1_f2 kv_pd_s_1_f1 kv_pd_s_1_s1 kv_pd_s_1_s2 kv_pd_s_1_f2 kv_m1_s_1_f1 kv_m1_s_1_s1 kv_m1_s_1_s2 kv_m1_s_1_f2 kv_m2_s_1_f1 kv_m2_s_1_s1 kv_m2_s_1_s2 kv_m2_s_1_f2 kv_m3_s_1_f1 kv_m3_s_1_s1 kv_m3_s_1_s2 kv_m3_s_1_f2 kv_hpo0p35_l_1_f1 kv_hpo0p35_l_1_s1 kv_hpo0p35_l_1_s2 kv_hpo0p35_l_1_f2 kv_hpo1p41_l_1_f1 kv_hpo1p41_l_1_s1 kv_hpo1p41_l_1_s2 kv_hpo1p41_l_1_f2 kv_xpo0p35_l_1_f1 kv_xpo0p35_l_1_s1 kv_xpo0p35_l_1_s2 kv_xpo0p35_l_1_f2 kv_xpo1p41_l_1_f1 kv_xpo1p41_l_1_s1 kv_xpo1p41_l_1_s2 kv_xpo1p41_l_1_f2 kv_nd_l_1_f1 kv_nd_l_1_s1 kv_nd_l_1_s2 kv_nd_l_1_f2 kv_pd_l_1_f1 kv_pd_l_1_s1 kv_pd_l_1_s2 kv_pd_l_1_f2 kv_m1_l_1_f1 kv_m1_l_1_s1 kv_m1_l_1_s2 kv_m1_l_1_f2 kv_m2_l_1_f1 kv_m2_l_1_s1 kv_m2_l_1_s2 kv_m2_l_1_f2 kv_m3_l_1_f1 kv_m3_l_1_s1 kv_m3_l_1_s2 kv_m3_l_1_f2 ch_poly_1_a ch_poly_1_b ch_ndiff_1_a ch_ndiff_1_b ch_pdiff_1_a ch_pdiff_1_b ch_mcon_1_a ch_mcon_1_b ch_via1_1_a ch_via1_1_b ch_via2_1_a ch_via2_1_b ch_poly_2_a ch_poly_2_b ch_ndiff_2_a ch_ndiff_2_b ch_pdiff_2_a ch_pdiff_2_b ch_mcon_2_a ch_mcon_2_b ch_via1_2_a ch_via1_2_b ch_via2_2_a ch_via2_2_b ch_poly_3_a ch_poly_3_b ch_ndiff_3_a ch_ndiff_3_b ch_pdiff_3_a ch_pdiff_3_b ch_mcon_3_a ch_mcon_3_b rr_1_s rr_1_te rr_1_wl rr_2_s rr_2_te rr_2_wl rr_3_s rr_3_te rr_3_wl rr_4_s rr_4_te rr_4_wl nacc_1_s nacc_1_d nacc_1_g nacc_2_s nacc_2_d nacc_2_g pair_1_ns pair_1_ng2 pair_1_nd2 pair_1_ng1 pair_1_nd1 pair_1_pg2 pair_1_ps pair_1_pd2 pair_1_pd1 pair_1_pg1 pair_2_ns pair_2_ng2 pair_2_nd2 pair_2_ng1 pair_2_nd1 pair_2_pg2 pair_2_ps pair_2_pd2 pair_2_pd1 pair_2_pg1 ch_poly_4_a ch_poly_4_b ch_ndiff_4_a ch_ndiff_4_b ch_pdiff_4_a ch_pdiff_4_b ch_mcon_4_a ch_mcon_4_b ch_via1_3_a ch_via1_3_b ch_via2_3_a ch_via2_3_b rr_5_s rr_5_te rr_5_wl nacc_3_s nacc_3_d nacc_3_g pair_3_ns pair_3_ng2 pair_3_nd2 pair_3_ng1 pair_3_nd1 pair_3_pg2 pair_3_ps pair_3_pd2 pair_3_pd1 pair_3_pg1 rr_6_s rr_6_te rr_6_wl nacc_4_s nacc_4_d nacc_4_g pair_4_ns pair_4_ng2 pair_4_nd2 pair_4_ng1 pair_4_nd1 pair_4_pg2 pair_4_ps pair_4_pd2 pair_4_pd1 pair_4_pg1 rr_7_s rr_7_te rr_7_wl nacc_5_s nacc_5_d nacc_5_g pair_5_ns pair_5_ng2 pair_5_nd2 pair_5_ng1 pair_5_nd1 pair_5_pg2 pair_5_ps pair_5_pd2 pair_5_pd1 pair_5_pg1 rr_8_s rr_8_te rr_8_wl nacc_6_s nacc_6_d nacc_6_g pair_6_ns pair_6_ng2 pair_6_nd2 pair_6_ng1 pair_6_nd1 pair_6_pg2 pair_6_ps pair_6_pd2 pair_6_pd1 pair_6_pg1 VDD VSS
Xro_1 ro_1_en ro_1_rstb ro_1_out VSS VDD tp_ro
Xkv_hpo0p35_s_1 kv_hpo0p35_s_1_f1 kv_hpo0p35_s_1_s1 kv_hpo0p35_s_1_s2 kv_hpo0p35_s_1_f2 VSS tp_kv_hpo0p35_s
Xkv_hpo1p41_s_1 kv_hpo1p41_s_1_f1 kv_hpo1p41_s_1_s1 kv_hpo1p41_s_1_s2 kv_hpo1p41_s_1_f2 VSS tp_kv_hpo1p41_s
Xkv_xpo0p35_s_1 kv_xpo0p35_s_1_f1 kv_xpo0p35_s_1_s1 kv_xpo0p35_s_1_s2 kv_xpo0p35_s_1_f2 VSS tp_kv_xpo0p35_s
Xkv_xpo1p41_s_1 kv_xpo1p41_s_1_f1 kv_xpo1p41_s_1_s1 kv_xpo1p41_s_1_s2 kv_xpo1p41_s_1_f2 VSS tp_kv_xpo1p41_s
Xkv_nd_s_1 kv_nd_s_1_f1 kv_nd_s_1_s1 kv_nd_s_1_s2 kv_nd_s_1_f2 VSS tp_kv_nd_s
Xkv_pd_s_1 kv_pd_s_1_f1 kv_pd_s_1_s1 kv_pd_s_1_s2 kv_pd_s_1_f2 VSS VDD tp_kv_pd_s
Xkv_m1_s_1 kv_m1_s_1_f1 kv_m1_s_1_s1 kv_m1_s_1_s2 kv_m1_s_1_f2 VSS tp_kv_m1_s
Xkv_m2_s_1 kv_m2_s_1_f1 kv_m2_s_1_s1 kv_m2_s_1_s2 kv_m2_s_1_f2 VSS tp_kv_m2_s
Xkv_m3_s_1 kv_m3_s_1_f1 kv_m3_s_1_s1 kv_m3_s_1_s2 kv_m3_s_1_f2 VSS tp_kv_m3_s
Xkv_hpo0p35_l_1 kv_hpo0p35_l_1_f1 kv_hpo0p35_l_1_s1 kv_hpo0p35_l_1_s2 kv_hpo0p35_l_1_f2 VSS tp_kv_hpo0p35_l
Xkv_hpo1p41_l_1 kv_hpo1p41_l_1_f1 kv_hpo1p41_l_1_s1 kv_hpo1p41_l_1_s2 kv_hpo1p41_l_1_f2 VSS tp_kv_hpo1p41_l
Xkv_xpo0p35_l_1 kv_xpo0p35_l_1_f1 kv_xpo0p35_l_1_s1 kv_xpo0p35_l_1_s2 kv_xpo0p35_l_1_f2 VSS tp_kv_xpo0p35_l
Xkv_xpo1p41_l_1 kv_xpo1p41_l_1_f1 kv_xpo1p41_l_1_s1 kv_xpo1p41_l_1_s2 kv_xpo1p41_l_1_f2 VSS tp_kv_xpo1p41_l
Xkv_nd_l_1 kv_nd_l_1_f1 kv_nd_l_1_s1 kv_nd_l_1_s2 kv_nd_l_1_f2 VSS tp_kv_nd_l
Xkv_pd_l_1 kv_pd_l_1_f1 kv_pd_l_1_s1 kv_pd_l_1_s2 kv_pd_l_1_f2 VSS VDD tp_kv_pd_l
Xkv_m1_l_1 kv_m1_l_1_f1 kv_m1_l_1_s1 kv_m1_l_1_s2 kv_m1_l_1_f2 VSS tp_kv_m1_l
Xkv_m2_l_1 kv_m2_l_1_f1 kv_m2_l_1_s1 kv_m2_l_1_s2 kv_m2_l_1_f2 VSS tp_kv_m2_l
Xkv_m3_l_1 kv_m3_l_1_f1 kv_m3_l_1_s1 kv_m3_l_1_s2 kv_m3_l_1_f2 VSS tp_kv_m3_l
Xch_poly_1 ch_poly_1_a ch_poly_1_b VSS tp_ch_poly
Xch_ndiff_1 ch_ndiff_1_a ch_ndiff_1_b VSS tp_ch_ndiff
Xch_pdiff_1 ch_pdiff_1_a ch_pdiff_1_b VDD VSS tp_ch_pdiff
Xch_mcon_1 ch_mcon_1_a ch_mcon_1_b VSS tp_ch_mcon
Xch_via1_1 ch_via1_1_a ch_via1_1_b VSS tp_ch_via1
Xch_via2_1 ch_via2_1_a ch_via2_1_b VSS tp_ch_via2
Xch_poly_2 ch_poly_2_a ch_poly_2_b VSS tp_ch_poly
Xch_ndiff_2 ch_ndiff_2_a ch_ndiff_2_b VSS tp_ch_ndiff
Xch_pdiff_2 ch_pdiff_2_a ch_pdiff_2_b VDD VSS tp_ch_pdiff
Xch_mcon_2 ch_mcon_2_a ch_mcon_2_b VSS tp_ch_mcon
Xch_via1_2 ch_via1_2_a ch_via1_2_b VSS tp_ch_via1
Xch_via2_2 ch_via2_2_a ch_via2_2_b VSS tp_ch_via2
Xch_poly_3 ch_poly_3_a ch_poly_3_b VSS tp_ch_poly
Xch_ndiff_3 ch_ndiff_3_a ch_ndiff_3_b VSS tp_ch_ndiff
Xch_pdiff_3 ch_pdiff_3_a ch_pdiff_3_b VDD VSS tp_ch_pdiff
Xch_mcon_3 ch_mcon_3_a ch_mcon_3_b VSS tp_ch_mcon
Xrr_1 rr_1_s rr_1_te rr_1_wl VSS tp_1t1r
Xrr_2 rr_2_s rr_2_te rr_2_wl VSS tp_1t1r
Xrr_3 rr_3_s rr_3_te rr_3_wl VSS tp_1t1r
Xrr_4 rr_4_s rr_4_te rr_4_wl VSS tp_1t1r
Xnacc_1 nacc_1_s nacc_1_d nacc_1_g VSS tp_nacc
Xnacc_2 nacc_2_s nacc_2_d nacc_2_g VSS tp_nacc
Xpair_1 pair_1_ns pair_1_ng2 pair_1_nd2 pair_1_ng1 pair_1_nd1 pair_1_pg2 pair_1_ps pair_1_pd2 pair_1_pd1 pair_1_pg1 VSS VDD tp_pair
Xpair_2 pair_2_ns pair_2_ng2 pair_2_nd2 pair_2_ng1 pair_2_nd1 pair_2_pg2 pair_2_ps pair_2_pd2 pair_2_pd1 pair_2_pg1 VSS VDD tp_pair
Xch_poly_4 ch_poly_4_a ch_poly_4_b VSS tp_ch_poly
Xch_ndiff_4 ch_ndiff_4_a ch_ndiff_4_b VSS tp_ch_ndiff
Xch_pdiff_4 ch_pdiff_4_a ch_pdiff_4_b VDD VSS tp_ch_pdiff
Xch_mcon_4 ch_mcon_4_a ch_mcon_4_b VSS tp_ch_mcon
Xch_via1_3 ch_via1_3_a ch_via1_3_b VSS tp_ch_via1
Xch_via2_3 ch_via2_3_a ch_via2_3_b VSS tp_ch_via2
Xrr_5 rr_5_s rr_5_te rr_5_wl VSS tp_1t1r
Xnacc_3 nacc_3_s nacc_3_d nacc_3_g VSS tp_nacc
Xpair_3 pair_3_ns pair_3_ng2 pair_3_nd2 pair_3_ng1 pair_3_nd1 pair_3_pg2 pair_3_ps pair_3_pd2 pair_3_pd1 pair_3_pg1 VSS VDD tp_pair
Xrr_6 rr_6_s rr_6_te rr_6_wl VSS tp_1t1r
Xnacc_4 nacc_4_s nacc_4_d nacc_4_g VSS tp_nacc
Xpair_4 pair_4_ns pair_4_ng2 pair_4_nd2 pair_4_ng1 pair_4_nd1 pair_4_pg2 pair_4_ps pair_4_pd2 pair_4_pd1 pair_4_pg1 VSS VDD tp_pair
Xrr_7 rr_7_s rr_7_te rr_7_wl VSS tp_1t1r
Xnacc_5 nacc_5_s nacc_5_d nacc_5_g VSS tp_nacc
Xpair_5 pair_5_ns pair_5_ng2 pair_5_nd2 pair_5_ng1 pair_5_nd1 pair_5_pg2 pair_5_ps pair_5_pd2 pair_5_pd1 pair_5_pg1 VSS VDD tp_pair
Xrr_8 rr_8_s rr_8_te rr_8_wl VSS tp_1t1r
Xnacc_6 nacc_6_s nacc_6_d nacc_6_g VSS tp_nacc
Xpair_6 pair_6_ns pair_6_ng2 pair_6_nd2 pair_6_ng1 pair_6_nd1 pair_6_pg2 pair_6_ps pair_6_pd2 pair_6_pd1 pair_6_pg1 VSS VDD tp_pair
.ends tp_br
