.subckt wu_sa inp inn clk q qb vdd vss
MMt tl clk vss vss nfet_g5v0d10v5 w=1u l=1u
MM1 sp inp tl vss nfet_g5v0d10v5 w=4u l=1u
MM2 sn inn tl vss nfet_g5v0d10v5 w=4u l=1u
MM3 xo yo sp vss nfet_g5v0d10v5 w=2u l=0.5u
MM4 yo xo sn vss nfet_g5v0d10v5 w=2u l=0.5u
MM5 xo yo vdd vdd pfet_g5v0d10v5 w=4u l=0.5u
MM6 yo xo vdd vdd pfet_g5v0d10v5 w=4u l=0.5u
MS1 xo clk vdd vdd pfet_g5v0d10v5 w=1u l=0.5u
MS2 yo clk vdd vdd pfet_g5v0d10v5 w=1u l=0.5u
MS3 sp clk vdd vdd pfet_g5v0d10v5 w=1u l=0.5u
MS4 sn clk vdd vdd pfet_g5v0d10v5 w=1u l=0.5u
MB1n xb xo vss vss nfet_g5v0d10v5 w=1u l=0.5u
MB1p xb xo vdd vdd pfet_g5v0d10v5 w=2u l=0.5u
MB2n yb yo vss vss nfet_g5v0d10v5 w=1u l=0.5u
MB2p yb yo vdd vdd pfet_g5v0d10v5 w=2u l=0.5u
ML1p1 m1 yb vdd vdd pfet_g5v0d10v5 w=4u l=0.5u
ML1p2 q qb m1 vdd pfet_g5v0d10v5 w=4u l=0.5u
ML1n1 q yb vss vss nfet_g5v0d10v5 w=1u l=0.5u
ML1n2 q qb vss vss nfet_g5v0d10v5 w=1u l=0.5u
ML2p1 m2 xb vdd vdd pfet_g5v0d10v5 w=4u l=0.5u
ML2p2 qb q m2 vdd pfet_g5v0d10v5 w=4u l=0.5u
ML2n1 qb xb vss vss nfet_g5v0d10v5 w=1u l=0.5u
ML2n2 qb q vss vss nfet_g5v0d10v5 w=1u l=0.5u
.ends wu_sa
