* testpat 단독 시험 tp_kv_tall
.subckt tp_kv_hpo0p35_l f1 s1 s2 f2 VSS
R0 f1 s1 $SUB=VSS $[res_high_po_0p35] w=0.350u l=2.000u
R1 s1 s2 $SUB=VSS $[res_high_po_0p35] w=0.350u l=20.000u
R2 s2 f2 $SUB=VSS $[res_high_po_0p35] w=0.350u l=2.000u
.ends tp_kv_hpo0p35_l
.subckt tp_kv_hpo0p35_s f1 s1 s2 f2 VSS
R0 f1 s1 $SUB=VSS $[res_high_po_0p35] w=0.350u l=2.000u
R1 s1 s2 $SUB=VSS $[res_high_po_0p35] w=0.350u l=10.000u
R2 s2 f2 $SUB=VSS $[res_high_po_0p35] w=0.350u l=2.000u
.ends tp_kv_hpo0p35_s
.subckt tp_kv_hpo1p41_l f1 s1 s2 f2 VSS
R0 f1 s1 $SUB=VSS $[res_high_po_1p41] w=1.410u l=2.000u
R1 s1 s2 $SUB=VSS $[res_high_po_1p41] w=1.410u l=20.000u
R2 s2 f2 $SUB=VSS $[res_high_po_1p41] w=1.410u l=2.000u
.ends tp_kv_hpo1p41_l
.subckt tp_kv_hpo1p41_s f1 s1 s2 f2 VSS
R0 f1 s1 $SUB=VSS $[res_high_po_1p41] w=1.410u l=2.000u
R1 s1 s2 $SUB=VSS $[res_high_po_1p41] w=1.410u l=10.000u
R2 s2 f2 $SUB=VSS $[res_high_po_1p41] w=1.410u l=2.000u
.ends tp_kv_hpo1p41_s
.subckt tp_kv_xpo0p35_l f1 s1 s2 f2 VSS
R0 f1 s1 $SUB=VSS $[res_xhigh_po_0p35] w=0.350u l=2.000u
R1 s1 s2 $SUB=VSS $[res_xhigh_po_0p35] w=0.350u l=20.000u
R2 s2 f2 $SUB=VSS $[res_xhigh_po_0p35] w=0.350u l=2.000u
.ends tp_kv_xpo0p35_l
.subckt tp_kv_xpo0p35_s f1 s1 s2 f2 VSS
R0 f1 s1 $SUB=VSS $[res_xhigh_po_0p35] w=0.350u l=2.000u
R1 s1 s2 $SUB=VSS $[res_xhigh_po_0p35] w=0.350u l=10.000u
R2 s2 f2 $SUB=VSS $[res_xhigh_po_0p35] w=0.350u l=2.000u
.ends tp_kv_xpo0p35_s
.subckt tp_kv_xpo1p41_l f1 s1 s2 f2 VSS
R0 f1 s1 $SUB=VSS $[res_xhigh_po_1p41] w=1.410u l=2.000u
R1 s1 s2 $SUB=VSS $[res_xhigh_po_1p41] w=1.410u l=20.000u
R2 s2 f2 $SUB=VSS $[res_xhigh_po_1p41] w=1.410u l=2.000u
.ends tp_kv_xpo1p41_l
.subckt tp_kv_xpo1p41_s f1 s1 s2 f2 VSS
R0 f1 s1 $SUB=VSS $[res_xhigh_po_1p41] w=1.410u l=2.000u
R1 s1 s2 $SUB=VSS $[res_xhigh_po_1p41] w=1.410u l=10.000u
R2 s2 f2 $SUB=VSS $[res_xhigh_po_1p41] w=1.410u l=2.000u
.ends tp_kv_xpo1p41_s
.subckt tp_kv_nd_l f1 s1 s2 f2 VSS
R0 f1 s1 240 $[RES_GENERIC_ND] $W=1u $L=2u
R1 s1 s2 2400 $[RES_GENERIC_ND] $W=1u $L=20u
R2 s2 f2 240 $[RES_GENERIC_ND] $W=1u $L=2u
.ends tp_kv_nd_l
.subckt tp_kv_nd_s f1 s1 s2 f2 VSS
R0 f1 s1 240 $[RES_GENERIC_ND] $W=1u $L=2u
R1 s1 s2 1200 $[RES_GENERIC_ND] $W=1u $L=10u
R2 s2 f2 240 $[RES_GENERIC_ND] $W=1u $L=2u
.ends tp_kv_nd_s
.subckt tp_kv_pd_l f1 s1 s2 f2 VSS VDD
R0 f1 s1 394 $[RES_GENERIC_PD] $W=1u $L=2u
R1 s1 s2 3940 $[RES_GENERIC_PD] $W=1u $L=20u
R2 s2 f2 394 $[RES_GENERIC_PD] $W=1u $L=2u
.ends tp_kv_pd_l
.subckt tp_kv_pd_s f1 s1 s2 f2 VSS VDD
R0 f1 s1 394 $[RES_GENERIC_PD] $W=1u $L=2u
R1 s1 s2 1970 $[RES_GENERIC_PD] $W=1u $L=10u
R2 s2 f2 394 $[RES_GENERIC_PD] $W=1u $L=2u
.ends tp_kv_pd_s
.subckt tp_kv_m1_l f1 s1 s2 f2 VSS
R0 f1 s1 $[res_generic_m1] $W=0.4u $L=2u
R1 s1 s2 $[res_generic_m1] $W=0.4u $L=234.8u
R2 s2 f2 $[res_generic_m1] $W=0.4u $L=2u
.ends tp_kv_m1_l
.subckt tp_kv_m1_s f1 s1 s2 f2 VSS
R0 f1 s1 $[res_generic_m1] $W=0.4u $L=2u
R1 s1 s2 $[res_generic_m1] $W=0.4u $L=117.2u
R2 s2 f2 $[res_generic_m1] $W=0.4u $L=2u
.ends tp_kv_m1_s
.subckt tp_kv_m2_l f1 s1 s2 f2 VSS
R0 f1 s1 $[res_generic_m2] $W=0.4u $L=2u
R1 s1 s2 $[res_generic_m2] $W=0.4u $L=234.8u
R2 s2 f2 $[res_generic_m2] $W=0.4u $L=2u
.ends tp_kv_m2_l
.subckt tp_kv_m2_s f1 s1 s2 f2 VSS
R0 f1 s1 $[res_generic_m2] $W=0.4u $L=2u
R1 s1 s2 $[res_generic_m2] $W=0.4u $L=117.2u
R2 s2 f2 $[res_generic_m2] $W=0.4u $L=2u
.ends tp_kv_m2_s
.subckt tp_kv_m3_l f1 s1 s2 f2 VSS
R0 f1 s1 $[res_generic_m3] $W=0.4u $L=2u
R1 s1 s2 $[res_generic_m3] $W=0.4u $L=234.8u
R2 s2 f2 $[res_generic_m3] $W=0.4u $L=2u
.ends tp_kv_m3_l
.subckt tp_kv_m3_s f1 s1 s2 f2 VSS
R0 f1 s1 $[res_generic_m3] $W=0.4u $L=2u
R1 s1 s2 $[res_generic_m3] $W=0.4u $L=117.2u
R2 s2 f2 $[res_generic_m3] $W=0.4u $L=2u
.ends tp_kv_m3_s
.subckt tp_kv_tall s0_f1 s0_s1 s0_s2 s0_f2 s1_f1 s1_s1 s1_s2 s1_f2 s2_f1 s2_s1 s2_s2 s2_f2 s3_f1 s3_s1 s3_s2 s3_f2 s4_f1 s4_s1 s4_s2 s4_f2 s5_f1 s5_s1 s5_s2 s5_f2 s6_f1 s6_s1 s6_s2 s6_f2 s7_f1 s7_s1 s7_s2 s7_f2 s8_f1 s8_s1 s8_s2 s8_f2 s9_f1 s9_s1 s9_s2 s9_f2 s10_f1 s10_s1 s10_s2 s10_f2 s11_f1 s11_s1 s11_s2 s11_f2 s12_f1 s12_s1 s12_s2 s12_f2 s13_f1 s13_s1 s13_s2 s13_f2 s14_f1 s14_s1 s14_s2 s14_f2 s15_f1 s15_s1 s15_s2 s15_f2 s16_f1 s16_s1 s16_s2 s16_f2 s17_f1 s17_s1 s17_s2 s17_f2 VDD VSS
X0 s0_f1 s0_s1 s0_s2 s0_f2 VSS tp_kv_hpo0p35_l
X1 s1_f1 s1_s1 s1_s2 s1_f2 VSS tp_kv_hpo0p35_s
X2 s2_f1 s2_s1 s2_s2 s2_f2 VSS tp_kv_hpo1p41_l
X3 s3_f1 s3_s1 s3_s2 s3_f2 VSS tp_kv_hpo1p41_s
X4 s4_f1 s4_s1 s4_s2 s4_f2 VSS tp_kv_xpo0p35_l
X5 s5_f1 s5_s1 s5_s2 s5_f2 VSS tp_kv_xpo0p35_s
X6 s6_f1 s6_s1 s6_s2 s6_f2 VSS tp_kv_xpo1p41_l
X7 s7_f1 s7_s1 s7_s2 s7_f2 VSS tp_kv_xpo1p41_s
X8 s8_f1 s8_s1 s8_s2 s8_f2 VSS tp_kv_nd_l
X9 s9_f1 s9_s1 s9_s2 s9_f2 VSS tp_kv_nd_s
X10 s10_f1 s10_s1 s10_s2 s10_f2 VSS VDD tp_kv_pd_l
X11 s11_f1 s11_s1 s11_s2 s11_f2 VSS VDD tp_kv_pd_s
X12 s12_f1 s12_s1 s12_s2 s12_f2 VSS tp_kv_m1_l
X13 s13_f1 s13_s1 s13_s2 s13_f2 VSS tp_kv_m1_s
X14 s14_f1 s14_s1 s14_s2 s14_f2 VSS tp_kv_m2_l
X15 s15_f1 s15_s1 s15_s2 s15_f2 VSS tp_kv_m2_s
X16 s16_f1 s16_s1 s16_s2 s16_f2 VSS tp_kv_m3_l
X17 s17_f1 s17_s1 s17_s2 s17_f2 VSS tp_kv_m3_s
.ends tp_kv_tall
