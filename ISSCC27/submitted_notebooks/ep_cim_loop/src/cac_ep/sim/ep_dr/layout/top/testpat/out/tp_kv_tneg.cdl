* testpat 단독 시험 tp_kv_tneg
.subckt tp_kv_m1_l f1 s1 s2 f2 VSS
R0 f1 s1 $[res_generic_m1] $W=0.4u $L=2u
R1 s1 s2 $[res_generic_m1] $W=0.4u $L=258.28u
R2 s2 f2 $[res_generic_m1] $W=0.4u $L=2u
.ends tp_kv_m1_l
.subckt tp_kv_tneg s0_f1 s0_s1 s0_s2 s0_f2 VSS
X0 s0_f1 s0_s1 s0_s2 s0_f2 VSS tp_kv_m1_l
.ends tp_kv_tneg
