* glob_dig.cdl -- GENERATED by v2cdl.py from glob_dig_pnr.v

.INCLUDE /home/grads/s/seokjindaveoh/work/ep_dr/layout/blk_digital/pdk/sky130_fd_sc_hvl_u.cdl

.SUBCKT glob_dig sck sdi sld rst data_clk_f data_clk_n row1_clk_f row1_clk_n row2_clk_f row2_clk_n col1_clk_f col1_clk_n col2_clk_f col2_clk_n rstb_f rstb_n READ_f READ_n READb_f READb_n PROG_f PROG_n VER_f VER_n SENSE_f SENSE_n WRANY_f WRANY_n dload_f dload_n pol_f pol_n rd_out_f rd_out_n rd_out_b_f rd_out_b_n VDD VSS
Xg79 n_44 VSS VSS VDD VDD n_7 sky130_fd_sc_hvl__inv_1
Xg78 cfg[5] VSS VSS VDD VDD n_6 sky130_fd_sc_hvl__inv_1
Xg80 rst VSS VSS VDD VDD rstb sky130_fd_sc_hvl__inv_1
Xg75 sld VSS VSS VDD VDD sldb sky130_fd_sc_hvl__inv_1
Xcfg_reg_11 cq[11] sldb VSS VSS VDD VDD cfg[11] sky130_fd_sc_hvl__dlxtp_1
Xcq_reg_11 n_5 cq[10] rstb VSS VSS VDD VDD cq[11] sky130_fd_sc_hvl__dfrtp_1
Xcfg_reg_10 cq[10] sldb VSS VSS VDD VDD cfg[10] sky130_fd_sc_hvl__dlxtp_1
Xcq_reg_10 n_5 cq[9] rstb VSS VSS VDD VDD cq[10] sky130_fd_sc_hvl__dfrtp_1
Xcfg_reg_9 cq[9] sldb VSS VSS VDD VDD cfg[9] sky130_fd_sc_hvl__dlxtp_1
Xcq_reg_9 n_5 cq[8] rstb VSS VSS VDD VDD cq[9] sky130_fd_sc_hvl__dfrtp_1
Xcfg_reg_8 cq[8] sldb VSS VSS VDD VDD cfg[8] sky130_fd_sc_hvl__dlxtp_1
Xcq_reg_8 n_5 cq[7] rstb VSS VSS VDD VDD cq[8] sky130_fd_sc_hvl__dfrtp_1
Xcfg_reg_7 cq[7] sldb VSS VSS VDD VDD cfg[7] sky130_fd_sc_hvl__dlxtp_1
Xcq_reg_7 n_5 cq[6] rstb VSS VSS VDD VDD cq[7] sky130_fd_sc_hvl__dfrtp_1
Xcfg_reg_6 cq[6] sldb VSS VSS VDD VDD cfg[6] sky130_fd_sc_hvl__dlxtp_1
Xg138__2398 VER PROG VSS VSS VDD VDD WRANY sky130_fd_sc_hvl__or2_1
Xcfg_reg_5 cq[5] sldb VSS VSS VDD VDD cfg[5] sky130_fd_sc_hvl__dlxtp_1
Xcq_reg_6 n_5 cq[5] rstb VSS VSS VDD VDD cq[6] sky130_fd_sc_hvl__dfrtp_1
Xg141__5107 n_4 n_44 VSS VSS VDD VDD SENSE sky130_fd_sc_hvl__nor2_1
Xg142__6260 cfg[1] n_3 cfg[0] n_1 VSS VSS VDD VDD PROG sky130_fd_sc_hvl__o22ai_1
Xcq_reg_5 n_5 cq[4] rstb VSS VSS VDD VDD cq[5] sky130_fd_sc_hvl__dfrtp_1
Xg144 cfg[4] VSS VSS VDD VDD n_4 sky130_fd_sc_hvl__inv_1
Xcfg_reg_4 cq[4] sldb VSS VSS VDD VDD cfg[4] sky130_fd_sc_hvl__dlxtp_1
Xg146__4319 n_1 cfg[0] cfg[2] VSS VSS VDD VDD VER sky130_fd_sc_hvl__and3_1
Xcq_reg_4 n_5 cq[3] rstb VSS VSS VDD VDD cq[4] sky130_fd_sc_hvl__dfrtp_1
Xcfg_reg_3 cq[3] sldb VSS VSS VDD VDD cfg[3] sky130_fd_sc_hvl__dlxtp_1
Xg149__8428 cfg[0] n_2 VSS VSS VDD VDD n_3 sky130_fd_sc_hvl__nand2_1
Xcq_reg_3 n_5 cq[2] rstb VSS VSS VDD VDD cq[3] sky130_fd_sc_hvl__dfrtp_1
Xg151 cfg[2] VSS VSS VDD VDD n_2 sky130_fd_sc_hvl__inv_1
Xcfg_reg_2 cq[2] sldb VSS VSS VDD VDD cfg[2] sky130_fd_sc_hvl__dlxtp_1
Xg153__5526 cfg[1] cfg[0] VSS VSS VDD VDD n_44 sky130_fd_sc_hvl__nand2_1
Xcq_reg_2 n_5 cq[1] rstb VSS VSS VDD VDD cq[2] sky130_fd_sc_hvl__dfrtp_1
Xg155 cfg[1] VSS VSS VDD VDD n_1 sky130_fd_sc_hvl__inv_1
Xcfg_reg_1 cq[1] sldb VSS VSS VDD VDD cfg[1] sky130_fd_sc_hvl__dlxtp_1
Xcq_reg_1 n_5 cq[0] rstb VSS VSS VDD VDD cq[1] sky130_fd_sc_hvl__dfrtp_1
Xcfg_reg_0 cq[0] sldb VSS VSS VDD VDD cfg[0] sky130_fd_sc_hvl__dlxtp_1
Xcq_reg_0 n_5 sdi rstb VSS VSS VDD VDD cq[0] sky130_fd_sc_hvl__dfrtp_1
Xg160__6783 sck sldb VSS VSS VDD VDD sck_r sky130_fd_sc_hvl__and2_1
Xg161__3680 sck sld VSS VSS VDD VDD n_5 sky130_fd_sc_hvl__and2_1
Xu_ck_col1_u_i0 u_ck_col1_nb VSS VSS VDD VDD u_ck_col1_p sky130_fd_sc_hvl__inv_2
Xu_ck_col1_u_if1 u_ck_col1_p VSS VSS VDD VDD u_ck_col1_nf sky130_fd_sc_hvl__inv_4
Xu_ck_col1_u_if2 u_ck_col1_nf VSS VSS VDD VDD col1_clk_f sky130_fd_sc_hvl__inv_8
Xu_ck_col1_u_in1 u_ck_col1_p VSS VSS VDD VDD u_ck_col1_nn sky130_fd_sc_hvl__inv_4
Xu_ck_col1_u_in2 u_ck_col1_nn VSS VSS VDD VDD col1_clk_n sky130_fd_sc_hvl__inv_8
Xu_ck_col1_u_nd sck_r cfg[10] VSS VSS VDD VDD u_ck_col1_nb sky130_fd_sc_hvl__nand2_1
Xu_ck_col2_u_i0 u_ck_col2_nb VSS VSS VDD VDD u_ck_col2_p sky130_fd_sc_hvl__inv_2
Xu_ck_col2_u_if1 u_ck_col2_p VSS VSS VDD VDD u_ck_col2_nf sky130_fd_sc_hvl__inv_4
Xu_ck_col2_u_if2 u_ck_col2_nf VSS VSS VDD VDD col2_clk_f sky130_fd_sc_hvl__inv_8
Xu_ck_col2_u_in1 u_ck_col2_p VSS VSS VDD VDD u_ck_col2_nn sky130_fd_sc_hvl__inv_4
Xu_ck_col2_u_in2 u_ck_col2_nn VSS VSS VDD VDD col2_clk_n sky130_fd_sc_hvl__inv_8
Xu_ck_col2_u_nd sck_r cfg[11] VSS VSS VDD VDD u_ck_col2_nb sky130_fd_sc_hvl__nand2_1
Xu_ck_data_u_i0 u_ck_data_nb VSS VSS VDD VDD u_ck_data_p sky130_fd_sc_hvl__inv_2
Xu_ck_data_u_if1 u_ck_data_p VSS VSS VDD VDD u_ck_data_nf sky130_fd_sc_hvl__inv_4
Xu_ck_data_u_if2 u_ck_data_nf VSS VSS VDD VDD data_clk_f sky130_fd_sc_hvl__inv_8
Xu_ck_data_u_in1 u_ck_data_p VSS VSS VDD VDD u_ck_data_nn sky130_fd_sc_hvl__inv_4
Xu_ck_data_u_in2 u_ck_data_nn VSS VSS VDD VDD data_clk_n sky130_fd_sc_hvl__inv_8
Xu_ck_data_u_nd sck_r cfg[7] VSS VSS VDD VDD u_ck_data_nb sky130_fd_sc_hvl__nand2_1
Xu_ck_row1_u_i0 u_ck_row1_nb VSS VSS VDD VDD u_ck_row1_p sky130_fd_sc_hvl__inv_2
Xu_ck_row1_u_if1 u_ck_row1_p VSS VSS VDD VDD u_ck_row1_nf sky130_fd_sc_hvl__inv_4
Xu_ck_row1_u_if2 u_ck_row1_nf VSS VSS VDD VDD row1_clk_f sky130_fd_sc_hvl__inv_8
Xu_ck_row1_u_in1 u_ck_row1_p VSS VSS VDD VDD u_ck_row1_nn sky130_fd_sc_hvl__inv_4
Xu_ck_row1_u_in2 u_ck_row1_nn VSS VSS VDD VDD row1_clk_n sky130_fd_sc_hvl__inv_8
Xu_ck_row1_u_nd sck_r cfg[8] VSS VSS VDD VDD u_ck_row1_nb sky130_fd_sc_hvl__nand2_1
Xu_ck_row2_u_i0 u_ck_row2_nb VSS VSS VDD VDD u_ck_row2_p sky130_fd_sc_hvl__inv_2
Xu_ck_row2_u_if1 u_ck_row2_p VSS VSS VDD VDD u_ck_row2_nf sky130_fd_sc_hvl__inv_4
Xu_ck_row2_u_if2 u_ck_row2_nf VSS VSS VDD VDD row2_clk_f sky130_fd_sc_hvl__inv_8
Xu_ck_row2_u_in1 u_ck_row2_p VSS VSS VDD VDD u_ck_row2_nn sky130_fd_sc_hvl__inv_4
Xu_ck_row2_u_in2 u_ck_row2_nn VSS VSS VDD VDD row2_clk_n sky130_fd_sc_hvl__inv_8
Xu_ck_row2_u_nd sck_r cfg[9] VSS VSS VDD VDD u_ck_row2_nb sky130_fd_sc_hvl__nand2_1
Xu_ob_dload_u_f cfg[6] VSS VSS VDD VDD dload_f sky130_fd_sc_hvl__buf_4
Xu_ob_dload_u_n cfg[6] VSS VSS VDD VDD dload_n sky130_fd_sc_hvl__buf_4
Xu_ob_pol_u_f cfg[3] VSS VSS VDD VDD pol_f sky130_fd_sc_hvl__buf_4
Xu_ob_pol_u_n cfg[3] VSS VSS VDD VDD pol_n sky130_fd_sc_hvl__buf_4
Xu_ob_prog_u_f PROG VSS VSS VDD VDD PROG_f sky130_fd_sc_hvl__buf_4
Xu_ob_prog_u_n PROG VSS VSS VDD VDD PROG_n sky130_fd_sc_hvl__buf_4
Xu_ob_rdout_u_f cfg[5] VSS VSS VDD VDD rd_out_f sky130_fd_sc_hvl__buf_4
Xu_ob_rdout_u_n cfg[5] VSS VSS VDD VDD rd_out_n sky130_fd_sc_hvl__buf_4
Xu_ob_rdoutb_u_f n_6 VSS VSS VDD VDD rd_out_b_f sky130_fd_sc_hvl__buf_4
Xu_ob_rdoutb_u_n n_6 VSS VSS VDD VDD rd_out_b_n sky130_fd_sc_hvl__buf_4
Xu_ob_read_u_f n_7 VSS VSS VDD VDD READ_f sky130_fd_sc_hvl__buf_4
Xu_ob_read_u_n n_7 VSS VSS VDD VDD READ_n sky130_fd_sc_hvl__buf_4
Xu_ob_readb_u_f n_44 VSS VSS VDD VDD READb_f sky130_fd_sc_hvl__buf_4
Xu_ob_readb_u_n n_44 VSS VSS VDD VDD READb_n sky130_fd_sc_hvl__buf_4
Xu_ob_rstb_u_f rstb VSS VSS VDD VDD rstb_f sky130_fd_sc_hvl__buf_8
Xu_ob_rstb_u_n rstb VSS VSS VDD VDD rstb_n sky130_fd_sc_hvl__buf_8
Xu_ob_sense_u_f SENSE VSS VSS VDD VDD SENSE_f sky130_fd_sc_hvl__buf_4
Xu_ob_sense_u_n SENSE VSS VSS VDD VDD SENSE_n sky130_fd_sc_hvl__buf_4
Xu_ob_ver_u_f VER VSS VSS VDD VDD VER_f sky130_fd_sc_hvl__buf_4
Xu_ob_ver_u_n VER VSS VSS VDD VDD VER_n sky130_fd_sc_hvl__buf_4
Xu_ob_wrany_u_f WRANY VSS VSS VDD VDD WRANY_f sky130_fd_sc_hvl__buf_4
Xu_ob_wrany_u_n WRANY VSS VSS VDD VDD WRANY_n sky130_fd_sc_hvl__buf_4
.ENDS glob_dig
