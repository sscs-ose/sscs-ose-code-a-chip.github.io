.subckt input_drive_t2 row_0 row_1 row_2 row_3 row_4 row_5 row_6 row_7 row_8 row_9 ga0 ga1 ga2 ga3 ga4 gb0 gb1 gb2 gb3 gb4 vrailp vrailm vss
MDm0 row_0 gb0 vrailm vss nfet_g5v0d10v5 w=1000u l=0.5u
MDp0 row_0 ga0 vrailp vss nfet_g5v0d10v5 w=1000u l=0.5u
MDm1 row_1 ga0 vrailm vss nfet_g5v0d10v5 w=1000u l=0.5u
MDp1 row_1 gb0 vrailp vss nfet_g5v0d10v5 w=1000u l=0.5u
MDm2 row_2 gb1 vrailm vss nfet_g5v0d10v5 w=1000u l=0.5u
MDp2 row_2 ga1 vrailp vss nfet_g5v0d10v5 w=1000u l=0.5u
MDm3 row_3 ga1 vrailm vss nfet_g5v0d10v5 w=1000u l=0.5u
MDp3 row_3 gb1 vrailp vss nfet_g5v0d10v5 w=1000u l=0.5u
MDm4 row_4 gb2 vrailm vss nfet_g5v0d10v5 w=1000u l=0.5u
MDp4 row_4 ga2 vrailp vss nfet_g5v0d10v5 w=1000u l=0.5u
MDm5 row_5 ga2 vrailm vss nfet_g5v0d10v5 w=1000u l=0.5u
MDp5 row_5 gb2 vrailp vss nfet_g5v0d10v5 w=1000u l=0.5u
MDm6 row_6 gb3 vrailm vss nfet_g5v0d10v5 w=1000u l=0.5u
MDp6 row_6 ga3 vrailp vss nfet_g5v0d10v5 w=1000u l=0.5u
MDm7 row_7 ga3 vrailm vss nfet_g5v0d10v5 w=1000u l=0.5u
MDp7 row_7 gb3 vrailp vss nfet_g5v0d10v5 w=1000u l=0.5u
MDm8 row_8 gb4 vrailm vss nfet_g5v0d10v5 w=1000u l=0.5u
MDp8 row_8 ga4 vrailp vss nfet_g5v0d10v5 w=1000u l=0.5u
MDm9 row_9 ga4 vrailm vss nfet_g5v0d10v5 w=1000u l=0.5u
MDp9 row_9 gb4 vrailp vss nfet_g5v0d10v5 w=1000u l=0.5u
.ends input_drive_t2
