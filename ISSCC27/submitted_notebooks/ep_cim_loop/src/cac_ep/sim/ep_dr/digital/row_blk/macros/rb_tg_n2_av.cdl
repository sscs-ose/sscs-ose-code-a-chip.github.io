.subckt rb_tg_n2_av b ctl ctlb VDD VSS
Mn_0 b ctl VDD VSS nfet_g5v0d10v5 w=1.000u l=0.500u
Mn_1 b ctl VDD VSS nfet_g5v0d10v5 w=1.000u l=0.500u
Mp_0 b ctlb VDD VDD pfet_g5v0d10v5 w=2.000u l=0.500u
Mp_1 b ctlb VDD VDD pfet_g5v0d10v5 w=2.000u l=0.500u
.ends rb_tg_n2_av
