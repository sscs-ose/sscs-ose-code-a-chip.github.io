* col_blk.cdl -- GENERATED by v2cdl.py from col_blk_pnr.v

.INCLUDE /home/grads/s/seokjindaveoh/work/ep_dr/digital/pdk/sky130_fd_sc_hvl_u.cdl
.INCLUDE /home/grads/s/seokjindaveoh/work/ep_dr/digital/col_blk/macros/cb_tg_n2.cdl
.INCLUDE /home/grads/s/seokjindaveoh/work/ep_dr/digital/col_blk/macros/cb_tgw_n20.cdl
.INCLUDE /home/grads/s/seokjindaveoh/work/ep_dr/digital/col_blk/macros/clamp_d2r.cdl

.SUBCKT col_blk col[63] col[62] col[61] col[60] col[59] col[58] col[57] col[56] col[55] col[54] col[53] col[52] col[51] col[50] col[49] col[48] col[47] col[46] col[45] col[44] col[43] col[42] col[41] col[40] col[39] col[38] col[37] col[36] col[35] col[34] col[33] col[32] col[31] col[30] col[29] col[28] col[27] col[26] col[25] col[24] col[23] col[22] col[21] col[20] col[19] col[18] col[17] col[16] col[15] col[14] col[13] col[12] col[11] col[10] col[9] col[8] col[7] col[6] col[5] col[4] col[3] col[2] col[1] col[0] vw vbus C1 C2 vzero vrailp vrailm sdi rstb col1_clk col2_clk sel_en PROG VER SENSE WRANY lo READ READb VDD VSS
XFE_OFC1_sel_en sel_en VSS VSS VDD VDD FE_OFN4_sel_en sky130_fd_sc_hvl__buf_1
XFE_OFC0_rstb rstb VSS VSS VDD VDD FE_OFN3_rstb sky130_fd_sc_hvl__buf_2
XFE_DBTC2_PROG PROG VSS VSS VDD VDD FE_DBTN2_PROG sky130_fd_sc_hvl__inv_1
XFE_DBTC1_VER VER VSS VSS VDD VDD FE_DBTN1_VER sky130_fd_sc_hvl__inv_1
XFE_DBTC0_SENSE SENSE VSS VSS VDD VDD FE_DBTN0_SENSE sky130_fd_sc_hvl__inv_1
Xg615 wvw[0] VSS VSS VDD VDD wvwb[0] sky130_fd_sc_hvl__inv_1
Xg616 wz[0] VSS VSS VDD VDD wzb[0] sky130_fd_sc_hvl__inv_1
Xg513 sns1[0] VSS VSS VDD VDD sns1b[0] sky130_fd_sc_hvl__inv_1
Xg481 vfy[1] VSS VSS VDD VDD vfyb[1] sky130_fd_sc_hvl__inv_1
Xg604 wvw[3] VSS VSS VDD VDD wvwb[3] sky130_fd_sc_hvl__inv_1
Xg605 wz[6] VSS VSS VDD VDD wzb[6] sky130_fd_sc_hvl__inv_1
Xg525 sns1[12] VSS VSS VDD VDD sns1b[12] sky130_fd_sc_hvl__inv_1
Xg433 vfy[25] VSS VSS VDD VDD vfyb[25] sky130_fd_sc_hvl__inv_1
Xg436 wvw[51] VSS VSS VDD VDD wvwb[51] sky130_fd_sc_hvl__inv_1
Xg380 wz[51] VSS VSS VDD VDD wzb[51] sky130_fd_sc_hvl__inv_1
Xg538 sns1[25] VSS VSS VDD VDD sns1b[25] sky130_fd_sc_hvl__inv_1
Xg343 vfy[51] VSS VSS VDD VDD vfyb[51] sky130_fd_sc_hvl__inv_1
Xg566 sns1[51] VSS VSS VDD VDD sns1b[51] sky130_fd_sc_hvl__inv_1
Xg399 sns2[12] VSS VSS VDD VDD sns2b[12] sky130_fd_sc_hvl__inv_1
Xg371 sns2[25] VSS VSS VDD VDD sns2b[25] sky130_fd_sc_hvl__inv_1
Xg504 sns2[51] VSS VSS VDD VDD sns2b[51] sky130_fd_sc_hvl__inv_1
Xg387 wvw[52] VSS VSS VDD VDD wvwb[52] sky130_fd_sc_hvl__inv_1
Xg372 wvw[26] VSS VSS VDD VDD wvwb[26] sky130_fd_sc_hvl__inv_1
Xg373 wz[52] VSS VSS VDD VDD wzb[52] sky130_fd_sc_hvl__inv_1
Xg338 vfy[52] VSS VSS VDD VDD vfyb[52] sky130_fd_sc_hvl__inv_1
Xg397 vfy[6] VSS VSS VDD VDD vfyb[6] sky130_fd_sc_hvl__inv_1
Xg563 wvw[13] VSS VSS VDD VDD wvwb[13] sky130_fd_sc_hvl__inv_1
Xg564 wz[26] VSS VSS VDD VDD wzb[26] sky130_fd_sc_hvl__inv_1
Xg565 sns1[52] VSS VSS VDD VDD sns1b[52] sky130_fd_sc_hvl__inv_1
Xg505 sns2[52] VSS VSS VDD VDD sns2b[52] sky130_fd_sc_hvl__inv_1
Xg431 vfy[26] VSS VSS VDD VDD vfyb[26] sky130_fd_sc_hvl__inv_1
Xg324 wvw[53] VSS VSS VDD VDD wvwb[53] sky130_fd_sc_hvl__inv_1
Xg365 wz[53] VSS VSS VDD VDD wzb[53] sky130_fd_sc_hvl__inv_1
Xg590 wz[13] VSS VSS VDD VDD wzb[13] sky130_fd_sc_hvl__inv_1
Xg539 sns1[26] VSS VSS VDD VDD sns1b[26] sky130_fd_sc_hvl__inv_1
Xg335 vfy[53] VSS VSS VDD VDD vfyb[53] sky130_fd_sc_hvl__inv_1
Xg497 sns1[53] VSS VSS VDD VDD sns1b[53] sky130_fd_sc_hvl__inv_1
Xg370 sns2[26] VSS VSS VDD VDD sns2b[26] sky130_fd_sc_hvl__inv_1
Xg506 sns2[53] VSS VSS VDD VDD sns2b[53] sky130_fd_sc_hvl__inv_1
Xg594 wvw[54] VSS VSS VDD VDD wvwb[54] sky130_fd_sc_hvl__inv_1
Xg609 wz[3] VSS VSS VDD VDD wzb[3] sky130_fd_sc_hvl__inv_1
Xg519 sns1[6] VSS VSS VDD VDD sns1b[6] sky130_fd_sc_hvl__inv_1
Xg458 vfy[13] VSS VSS VDD VDD vfyb[13] sky130_fd_sc_hvl__inv_1
Xg357 wvw[27] VSS VSS VDD VDD wvwb[27] sky130_fd_sc_hvl__inv_1
Xg358 wz[54] VSS VSS VDD VDD wzb[54] sky130_fd_sc_hvl__inv_1
Xg331 vfy[54] VSS VSS VDD VDD vfyb[54] sky130_fd_sc_hvl__inv_1
Xg495 wz[27] VSS VSS VDD VDD wzb[27] sky130_fd_sc_hvl__inv_1
Xg496 sns1[54] VSS VSS VDD VDD sns1b[54] sky130_fd_sc_hvl__inv_1
Xg507 sns2[54] VSS VSS VDD VDD sns2b[54] sky130_fd_sc_hvl__inv_1
Xg526 sns1[13] VSS VSS VDD VDD sns1b[13] sky130_fd_sc_hvl__inv_1
Xg430 vfy[27] VSS VSS VDD VDD vfyb[27] sky130_fd_sc_hvl__inv_1
Xg499 wvw[55] VSS VSS VDD VDD wvwb[55] sky130_fd_sc_hvl__inv_1
Xg349 wz[55] VSS VSS VDD VDD wzb[55] sky130_fd_sc_hvl__inv_1
Xg540 sns1[27] VSS VSS VDD VDD sns1b[27] sky130_fd_sc_hvl__inv_1
Xg328 vfy[55] VSS VSS VDD VDD vfyb[55] sky130_fd_sc_hvl__inv_1
Xg494 sns1[55] VSS VSS VDD VDD sns1b[55] sky130_fd_sc_hvl__inv_1
Xg410 sns2[6] VSS VSS VDD VDD sns2b[6] sky130_fd_sc_hvl__inv_1
Xg396 sns2[13] VSS VSS VDD VDD sns2b[13] sky130_fd_sc_hvl__inv_1
Xg368 sns2[27] VSS VSS VDD VDD sns2b[27] sky130_fd_sc_hvl__inv_1
Xg508 sns2[55] VSS VSS VDD VDD sns2b[55] sky130_fd_sc_hvl__inv_1
Xg435 wvw[56] VSS VSS VDD VDD wvwb[56] sky130_fd_sc_hvl__inv_1
Xg341 wvw[28] VSS VSS VDD VDD wvwb[28] sky130_fd_sc_hvl__inv_1
Xg342 wz[56] VSS VSS VDD VDD wzb[56] sky130_fd_sc_hvl__inv_1
Xg486 vfy[56] VSS VSS VDD VDD vfyb[56] sky130_fd_sc_hvl__inv_1
Xg491 wvw[14] VSS VSS VDD VDD wvwb[14] sky130_fd_sc_hvl__inv_1
Xg492 wz[28] VSS VSS VDD VDD wzb[28] sky130_fd_sc_hvl__inv_1
Xg493 sns1[56] VSS VSS VDD VDD sns1b[56] sky130_fd_sc_hvl__inv_1
Xg509 sns2[56] VSS VSS VDD VDD sns2b[56] sky130_fd_sc_hvl__inv_1
Xg427 vfy[28] VSS VSS VDD VDD vfyb[28] sky130_fd_sc_hvl__inv_1
Xg323 wvw[57] VSS VSS VDD VDD wvwb[57] sky130_fd_sc_hvl__inv_1
Xg334 wz[57] VSS VSS VDD VDD wzb[57] sky130_fd_sc_hvl__inv_1
Xg514 sns1[1] VSS VSS VDD VDD sns1b[1] sky130_fd_sc_hvl__inv_1
Xg478 vfy[3] VSS VSS VDD VDD vfyb[3] sky130_fd_sc_hvl__inv_1
Xg588 wvw[7] VSS VSS VDD VDD wvwb[7] sky130_fd_sc_hvl__inv_1
Xg589 wz[14] VSS VSS VDD VDD wzb[14] sky130_fd_sc_hvl__inv_1
Xg541 sns1[28] VSS VSS VDD VDD sns1b[28] sky130_fd_sc_hvl__inv_1
Xg617 vfy[57] VSS VSS VDD VDD vfyb[57] sky130_fd_sc_hvl__inv_1
Xg490 sns1[57] VSS VSS VDD VDD sns1b[57] sky130_fd_sc_hvl__inv_1
Xg367 sns2[28] VSS VSS VDD VDD sns2b[28] sky130_fd_sc_hvl__inv_1
Xg510 sns2[57] VSS VSS VDD VDD sns2b[57] sky130_fd_sc_hvl__inv_1
Xg498 wvw[58] VSS VSS VDD VDD wvwb[58] sky130_fd_sc_hvl__inv_1
Xg456 vfy[14] VSS VSS VDD VDD vfyb[14] sky130_fd_sc_hvl__inv_1
Xg326 wvw[29] VSS VSS VDD VDD wvwb[29] sky130_fd_sc_hvl__inv_1
Xg327 wz[58] VSS VSS VDD VDD wzb[58] sky130_fd_sc_hvl__inv_1
Xg621 vfy[58] VSS VSS VDD VDD vfyb[58] sky130_fd_sc_hvl__inv_1
Xg488 wz[29] VSS VSS VDD VDD wzb[29] sky130_fd_sc_hvl__inv_1
Xg489 sns1[58] VSS VSS VDD VDD sns1b[58] sky130_fd_sc_hvl__inv_1
Xg511 sns2[58] VSS VSS VDD VDD sns2b[58] sky130_fd_sc_hvl__inv_1
Xg602 wz[7] VSS VSS VDD VDD wzb[7] sky130_fd_sc_hvl__inv_1
Xg527 sns1[14] VSS VSS VDD VDD sns1b[14] sky130_fd_sc_hvl__inv_1
Xg426 vfy[29] VSS VSS VDD VDD vfyb[29] sky130_fd_sc_hvl__inv_1
Xg322 wvw[59] VSS VSS VDD VDD wvwb[59] sky130_fd_sc_hvl__inv_1
Xg619 wz[59] VSS VSS VDD VDD wzb[59] sky130_fd_sc_hvl__inv_1
Xg542 sns1[29] VSS VSS VDD VDD sns1b[29] sky130_fd_sc_hvl__inv_1
Xg620 vfy[59] VSS VSS VDD VDD vfyb[59] sky130_fd_sc_hvl__inv_1
Xg487 sns1[59] VSS VSS VDD VDD sns1b[59] sky130_fd_sc_hvl__inv_1
Xg395 sns2[14] VSS VSS VDD VDD sns2b[14] sky130_fd_sc_hvl__inv_1
Xg364 sns2[29] VSS VSS VDD VDD sns2b[29] sky130_fd_sc_hvl__inv_1
Xg512 sns2[59] VSS VSS VDD VDD sns2b[59] sky130_fd_sc_hvl__inv_1
Xg618 wvw[30] VSS VSS VDD VDD wvwb[30] sky130_fd_sc_hvl__inv_1
Xg516 sns1[3] VSS VSS VDD VDD sns1b[3] sky130_fd_sc_hvl__inv_1
Xg471 vfy[7] VSS VSS VDD VDD vfyb[7] sky130_fd_sc_hvl__inv_1
Xg484 wvw[15] VSS VSS VDD VDD wvwb[15] sky130_fd_sc_hvl__inv_1
Xg485 wz[30] VSS VSS VDD VDD wzb[30] sky130_fd_sc_hvl__inv_1
Xg424 vfy[30] VSS VSS VDD VDD vfyb[30] sky130_fd_sc_hvl__inv_1
Xg586 wz[15] VSS VSS VDD VDD wzb[15] sky130_fd_sc_hvl__inv_1
Xg543 sns1[30] VSS VSS VDD VDD sns1b[30] sky130_fd_sc_hvl__inv_1
Xg363 sns2[30] VSS VSS VDD VDD sns2b[30] sky130_fd_sc_hvl__inv_1
Xg520 sns1[7] VSS VSS VDD VDD sns1b[7] sky130_fd_sc_hvl__inv_1
Xg455 vfy[15] VSS VSS VDD VDD vfyb[15] sky130_fd_sc_hvl__inv_1
Xg611 wvw[31] VSS VSS VDD VDD wvwb[31] sky130_fd_sc_hvl__inv_1
Xg480 wz[31] VSS VSS VDD VDD wzb[31] sky130_fd_sc_hvl__inv_1
Xg528 sns1[15] VSS VSS VDD VDD sns1b[15] sky130_fd_sc_hvl__inv_1
Xg422 vfy[31] VSS VSS VDD VDD vfyb[31] sky130_fd_sc_hvl__inv_1
Xg544 sns1[31] VSS VSS VDD VDD sns1b[31] sky130_fd_sc_hvl__inv_1
Xg423 sns2[0] VSS VSS VDD VDD sns2b[0] sky130_fd_sc_hvl__inv_1
Xg418 sns2[1] VSS VSS VDD VDD sns2b[1] sky130_fd_sc_hvl__inv_1
Xg415 sns2[3] VSS VSS VDD VDD sns2b[3] sky130_fd_sc_hvl__inv_1
Xg408 sns2[7] VSS VSS VDD VDD sns2b[7] sky130_fd_sc_hvl__inv_1
Xg393 sns2[15] VSS VSS VDD VDD sns2b[15] sky130_fd_sc_hvl__inv_1
Xg361 sns2[31] VSS VSS VDD VDD sns2b[31] sky130_fd_sc_hvl__inv_1
Xg603 wvw[32] VSS VSS VDD VDD wvwb[32] sky130_fd_sc_hvl__inv_1
Xg476 wvw[16] VSS VSS VDD VDD wvwb[16] sky130_fd_sc_hvl__inv_1
Xg477 wz[32] VSS VSS VDD VDD wzb[32] sky130_fd_sc_hvl__inv_1
Xg416 vfy[32] VSS VSS VDD VDD vfyb[32] sky130_fd_sc_hvl__inv_1
Xg584 wvw[8] VSS VSS VDD VDD wvwb[8] sky130_fd_sc_hvl__inv_1
Xg585 wz[16] VSS VSS VDD VDD wzb[16] sky130_fd_sc_hvl__inv_1
Xg545 sns1[32] VSS VSS VDD VDD sns1b[32] sky130_fd_sc_hvl__inv_1
Xg360 sns2[32] VSS VSS VDD VDD sns2b[32] sky130_fd_sc_hvl__inv_1
Xg451 vfy[16] VSS VSS VDD VDD vfyb[16] sky130_fd_sc_hvl__inv_1
Xg596 wvw[33] VSS VSS VDD VDD wvwb[33] sky130_fd_sc_hvl__inv_1
Xg549 wz[33] VSS VSS VDD VDD wzb[33] sky130_fd_sc_hvl__inv_1
Xg600 wvw[4] VSS VSS VDD VDD wvwb[4] sky130_fd_sc_hvl__inv_1
Xg601 wz[8] VSS VSS VDD VDD wzb[8] sky130_fd_sc_hvl__inv_1
Xg529 sns1[16] VSS VSS VDD VDD sns1b[16] sky130_fd_sc_hvl__inv_1
Xg413 vfy[33] VSS VSS VDD VDD vfyb[33] sky130_fd_sc_hvl__inv_1
Xg546 sns1[33] VSS VSS VDD VDD sns1b[33] sky130_fd_sc_hvl__inv_1
Xg392 sns2[16] VSS VSS VDD VDD sns2b[16] sky130_fd_sc_hvl__inv_1
Xg355 sns2[33] VSS VSS VDD VDD sns2b[33] sky130_fd_sc_hvl__inv_1
Xg587 wvw[34] VSS VSS VDD VDD wvwb[34] sky130_fd_sc_hvl__inv_1
Xg466 vfy[8] VSS VSS VDD VDD vfyb[8] sky130_fd_sc_hvl__inv_1
Xg469 wvw[17] VSS VSS VDD VDD wvwb[17] sky130_fd_sc_hvl__inv_1
Xg470 wz[34] VSS VSS VDD VDD wzb[34] sky130_fd_sc_hvl__inv_1
Xg409 vfy[34] VSS VSS VDD VDD vfyb[34] sky130_fd_sc_hvl__inv_1
Xg583 wz[17] VSS VSS VDD VDD wzb[17] sky130_fd_sc_hvl__inv_1
Xg547 sns1[34] VSS VSS VDD VDD sns1b[34] sky130_fd_sc_hvl__inv_1
Xg354 sns2[34] VSS VSS VDD VDD sns2b[34] sky130_fd_sc_hvl__inv_1
Xg607 wvw[2] VSS VSS VDD VDD wvwb[2] sky130_fd_sc_hvl__inv_1
Xg608 wz[4] VSS VSS VDD VDD wzb[4] sky130_fd_sc_hvl__inv_1
Xg521 sns1[8] VSS VSS VDD VDD sns1b[8] sky130_fd_sc_hvl__inv_1
Xg450 vfy[17] VSS VSS VDD VDD vfyb[17] sky130_fd_sc_hvl__inv_1
Xg580 wvw[35] VSS VSS VDD VDD wvwb[35] sky130_fd_sc_hvl__inv_1
Xg464 wz[35] VSS VSS VDD VDD wzb[35] sky130_fd_sc_hvl__inv_1
Xg530 sns1[17] VSS VSS VDD VDD sns1b[17] sky130_fd_sc_hvl__inv_1
Xg406 vfy[35] VSS VSS VDD VDD vfyb[35] sky130_fd_sc_hvl__inv_1
Xg548 sns1[35] VSS VSS VDD VDD sns1b[35] sky130_fd_sc_hvl__inv_1
Xg407 sns2[8] VSS VSS VDD VDD sns2b[8] sky130_fd_sc_hvl__inv_1
Xg386 sns2[17] VSS VSS VDD VDD sns2b[17] sky130_fd_sc_hvl__inv_1
Xg352 sns2[35] VSS VSS VDD VDD sns2b[35] sky130_fd_sc_hvl__inv_1
Xg572 wvw[36] VSS VSS VDD VDD wvwb[36] sky130_fd_sc_hvl__inv_1
Xg460 wvw[18] VSS VSS VDD VDD wvwb[18] sky130_fd_sc_hvl__inv_1
Xg461 wz[36] VSS VSS VDD VDD wzb[36] sky130_fd_sc_hvl__inv_1
Xg401 vfy[36] VSS VSS VDD VDD vfyb[36] sky130_fd_sc_hvl__inv_1
Xg475 vfy[4] VSS VSS VDD VDD vfyb[4] sky130_fd_sc_hvl__inv_1
Xg581 wvw[9] VSS VSS VDD VDD wvwb[9] sky130_fd_sc_hvl__inv_1
Xg582 wz[18] VSS VSS VDD VDD wzb[18] sky130_fd_sc_hvl__inv_1
Xg473 sns1[36] VSS VSS VDD VDD sns1b[36] sky130_fd_sc_hvl__inv_1
Xg351 sns2[36] VSS VSS VDD VDD sns2b[36] sky130_fd_sc_hvl__inv_1
Xg448 vfy[18] VSS VSS VDD VDD vfyb[18] sky130_fd_sc_hvl__inv_1
Xg501 wvw[37] VSS VSS VDD VDD wvwb[37] sky130_fd_sc_hvl__inv_1
Xg457 wz[37] VSS VSS VDD VDD wzb[37] sky130_fd_sc_hvl__inv_1
Xg599 wz[9] VSS VSS VDD VDD wzb[9] sky130_fd_sc_hvl__inv_1
Xg531 sns1[18] VSS VSS VDD VDD sns1b[18] sky130_fd_sc_hvl__inv_1
Xg398 vfy[37] VSS VSS VDD VDD vfyb[37] sky130_fd_sc_hvl__inv_1
Xg550 sns1[37] VSS VSS VDD VDD sns1b[37] sky130_fd_sc_hvl__inv_1
Xg385 sns2[18] VSS VSS VDD VDD sns2b[18] sky130_fd_sc_hvl__inv_1
Xg348 sns2[37] VSS VSS VDD VDD sns2b[37] sky130_fd_sc_hvl__inv_1
Xg483 wvw[38] VSS VSS VDD VDD wvwb[38] sky130_fd_sc_hvl__inv_1
Xg482 vfy[0] VSS VSS VDD VDD vfyb[0] sky130_fd_sc_hvl__inv_1
Xg612 wvw[1] VSS VSS VDD VDD wvwb[1] sky130_fd_sc_hvl__inv_1
Xg613 wz[2] VSS VSS VDD VDD wzb[2] sky130_fd_sc_hvl__inv_1
Xg517 sns1[4] VSS VSS VDD VDD sns1b[4] sky130_fd_sc_hvl__inv_1
Xg465 vfy[9] VSS VSS VDD VDD vfyb[9] sky130_fd_sc_hvl__inv_1
Xg453 wvw[19] VSS VSS VDD VDD wvwb[19] sky130_fd_sc_hvl__inv_1
Xg454 wz[38] VSS VSS VDD VDD wzb[38] sky130_fd_sc_hvl__inv_1
Xg394 vfy[38] VSS VSS VDD VDD vfyb[38] sky130_fd_sc_hvl__inv_1
Xg578 wz[19] VSS VSS VDD VDD wzb[19] sky130_fd_sc_hvl__inv_1
Xg551 sns1[38] VSS VSS VDD VDD sns1b[38] sky130_fd_sc_hvl__inv_1
Xg347 sns2[38] VSS VSS VDD VDD sns2b[38] sky130_fd_sc_hvl__inv_1
Xg522 sns1[9] VSS VSS VDD VDD sns1b[9] sky130_fd_sc_hvl__inv_1
Xg447 vfy[19] VSS VSS VDD VDD vfyb[19] sky130_fd_sc_hvl__inv_1
Xg468 wvw[39] VSS VSS VDD VDD wvwb[39] sky130_fd_sc_hvl__inv_1
Xg449 wz[39] VSS VSS VDD VDD wzb[39] sky130_fd_sc_hvl__inv_1
Xg532 sns1[19] VSS VSS VDD VDD sns1b[19] sky130_fd_sc_hvl__inv_1
Xg391 vfy[39] VSS VSS VDD VDD vfyb[39] sky130_fd_sc_hvl__inv_1
Xg552 sns1[39] VSS VSS VDD VDD sns1b[39] sky130_fd_sc_hvl__inv_1
Xg414 sns2[4] VSS VSS VDD VDD sns2b[4] sky130_fd_sc_hvl__inv_1
Xg403 sns2[9] VSS VSS VDD VDD sns2b[9] sky130_fd_sc_hvl__inv_1
Xg383 sns2[19] VSS VSS VDD VDD sns2b[19] sky130_fd_sc_hvl__inv_1
Xg345 sns2[39] VSS VSS VDD VDD sns2b[39] sky130_fd_sc_hvl__inv_1
Xg452 wvw[40] VSS VSS VDD VDD wvwb[40] sky130_fd_sc_hvl__inv_1
Xg445 wvw[20] VSS VSS VDD VDD wvwb[20] sky130_fd_sc_hvl__inv_1
Xg446 wz[40] VSS VSS VDD VDD wzb[40] sky130_fd_sc_hvl__inv_1
Xg384 vfy[40] VSS VSS VDD VDD vfyb[40] sky130_fd_sc_hvl__inv_1
Xg576 wvw[10] VSS VSS VDD VDD wvwb[10] sky130_fd_sc_hvl__inv_1
Xg577 wz[20] VSS VSS VDD VDD wzb[20] sky130_fd_sc_hvl__inv_1
Xg553 sns1[40] VSS VSS VDD VDD sns1b[40] sky130_fd_sc_hvl__inv_1
Xg344 sns2[40] VSS VSS VDD VDD sns2b[40] sky130_fd_sc_hvl__inv_1
Xg444 vfy[20] VSS VSS VDD VDD vfyb[20] sky130_fd_sc_hvl__inv_1
Xg437 wvw[41] VSS VSS VDD VDD wvwb[41] sky130_fd_sc_hvl__inv_1
Xg442 wz[41] VSS VSS VDD VDD wzb[41] sky130_fd_sc_hvl__inv_1
Xg479 vfy[2] VSS VSS VDD VDD vfyb[2] sky130_fd_sc_hvl__inv_1
Xg597 wvw[5] VSS VSS VDD VDD wvwb[5] sky130_fd_sc_hvl__inv_1
Xg598 wz[10] VSS VSS VDD VDD wzb[10] sky130_fd_sc_hvl__inv_1
Xg533 sns1[20] VSS VSS VDD VDD sns1b[20] sky130_fd_sc_hvl__inv_1
Xg381 vfy[41] VSS VSS VDD VDD vfyb[41] sky130_fd_sc_hvl__inv_1
Xg554 sns1[41] VSS VSS VDD VDD sns1b[41] sky130_fd_sc_hvl__inv_1
Xg382 sns2[20] VSS VSS VDD VDD sns2b[20] sky130_fd_sc_hvl__inv_1
Xg340 sns2[41] VSS VSS VDD VDD sns2b[41] sky130_fd_sc_hvl__inv_1
Xg419 wvw[42] VSS VSS VDD VDD wvwb[42] sky130_fd_sc_hvl__inv_1
Xg463 vfy[10] VSS VSS VDD VDD vfyb[10] sky130_fd_sc_hvl__inv_1
Xg438 wvw[21] VSS VSS VDD VDD wvwb[21] sky130_fd_sc_hvl__inv_1
Xg439 wz[42] VSS VSS VDD VDD wzb[42] sky130_fd_sc_hvl__inv_1
Xg377 vfy[42] VSS VSS VDD VDD vfyb[42] sky130_fd_sc_hvl__inv_1
Xg575 wz[21] VSS VSS VDD VDD wzb[21] sky130_fd_sc_hvl__inv_1
Xg555 sns1[42] VSS VSS VDD VDD sns1b[42] sky130_fd_sc_hvl__inv_1
Xg339 sns2[42] VSS VSS VDD VDD sns2b[42] sky130_fd_sc_hvl__inv_1
Xg606 wz[5] VSS VSS VDD VDD wzb[5] sky130_fd_sc_hvl__inv_1
Xg523 sns1[10] VSS VSS VDD VDD sns1b[10] sky130_fd_sc_hvl__inv_1
Xg443 vfy[21] VSS VSS VDD VDD vfyb[21] sky130_fd_sc_hvl__inv_1
Xg388 wvw[43] VSS VSS VDD VDD wvwb[43] sky130_fd_sc_hvl__inv_1
Xg432 wz[43] VSS VSS VDD VDD wzb[43] sky130_fd_sc_hvl__inv_1
Xg534 sns1[21] VSS VSS VDD VDD sns1b[21] sky130_fd_sc_hvl__inv_1
Xg374 vfy[43] VSS VSS VDD VDD vfyb[43] sky130_fd_sc_hvl__inv_1
Xg556 sns1[43] VSS VSS VDD VDD sns1b[43] sky130_fd_sc_hvl__inv_1
Xg402 sns2[10] VSS VSS VDD VDD sns2b[10] sky130_fd_sc_hvl__inv_1
Xg379 sns2[21] VSS VSS VDD VDD sns2b[21] sky130_fd_sc_hvl__inv_1
Xg337 sns2[43] VSS VSS VDD VDD sns2b[43] sky130_fd_sc_hvl__inv_1
Xg356 wvw[44] VSS VSS VDD VDD wvwb[44] sky130_fd_sc_hvl__inv_1
Xg428 wvw[22] VSS VSS VDD VDD wvwb[22] sky130_fd_sc_hvl__inv_1
Xg429 wz[44] VSS VSS VDD VDD wzb[44] sky130_fd_sc_hvl__inv_1
Xg369 vfy[44] VSS VSS VDD VDD vfyb[44] sky130_fd_sc_hvl__inv_1
Xg614 wz[1] VSS VSS VDD VDD wzb[1] sky130_fd_sc_hvl__inv_1
Xg515 sns1[2] VSS VSS VDD VDD sns1b[2] sky130_fd_sc_hvl__inv_1
Xg474 vfy[5] VSS VSS VDD VDD vfyb[5] sky130_fd_sc_hvl__inv_1
Xg573 wvw[11] VSS VSS VDD VDD wvwb[11] sky130_fd_sc_hvl__inv_1
Xg574 wz[22] VSS VSS VDD VDD wzb[22] sky130_fd_sc_hvl__inv_1
Xg557 sns1[44] VSS VSS VDD VDD sns1b[44] sky130_fd_sc_hvl__inv_1
Xg336 sns2[44] VSS VSS VDD VDD sns2b[44] sky130_fd_sc_hvl__inv_1
Xg441 vfy[22] VSS VSS VDD VDD vfyb[22] sky130_fd_sc_hvl__inv_1
Xg325 wvw[45] VSS VSS VDD VDD wvwb[45] sky130_fd_sc_hvl__inv_1
Xg425 wz[45] VSS VSS VDD VDD wzb[45] sky130_fd_sc_hvl__inv_1
Xg593 wz[11] VSS VSS VDD VDD wzb[11] sky130_fd_sc_hvl__inv_1
Xg535 sns1[22] VSS VSS VDD VDD sns1b[22] sky130_fd_sc_hvl__inv_1
Xg366 vfy[45] VSS VSS VDD VDD vfyb[45] sky130_fd_sc_hvl__inv_1
Xg558 sns1[45] VSS VSS VDD VDD sns1b[45] sky130_fd_sc_hvl__inv_1
Xg378 sns2[22] VSS VSS VDD VDD sns2b[22] sky130_fd_sc_hvl__inv_1
Xg333 sns2[45] VSS VSS VDD VDD sns2b[45] sky130_fd_sc_hvl__inv_1
Xg610 wvw[46] VSS VSS VDD VDD wvwb[46] sky130_fd_sc_hvl__inv_1
Xg518 sns1[5] VSS VSS VDD VDD sns1b[5] sky130_fd_sc_hvl__inv_1
Xg462 vfy[11] VSS VSS VDD VDD vfyb[11] sky130_fd_sc_hvl__inv_1
Xg420 wvw[23] VSS VSS VDD VDD wvwb[23] sky130_fd_sc_hvl__inv_1
Xg421 wz[46] VSS VSS VDD VDD wzb[46] sky130_fd_sc_hvl__inv_1
Xg362 vfy[46] VSS VSS VDD VDD vfyb[46] sky130_fd_sc_hvl__inv_1
Xg571 wz[23] VSS VSS VDD VDD wzb[23] sky130_fd_sc_hvl__inv_1
Xg559 sns1[46] VSS VSS VDD VDD sns1b[46] sky130_fd_sc_hvl__inv_1
Xg332 sns2[46] VSS VSS VDD VDD sns2b[46] sky130_fd_sc_hvl__inv_1
Xg524 sns1[11] VSS VSS VDD VDD sns1b[11] sky130_fd_sc_hvl__inv_1
Xg440 vfy[23] VSS VSS VDD VDD vfyb[23] sky130_fd_sc_hvl__inv_1
Xg595 wvw[47] VSS VSS VDD VDD wvwb[47] sky130_fd_sc_hvl__inv_1
Xg412 wz[47] VSS VSS VDD VDD wzb[47] sky130_fd_sc_hvl__inv_1
Xg536 sns1[23] VSS VSS VDD VDD sns1b[23] sky130_fd_sc_hvl__inv_1
Xg359 vfy[47] VSS VSS VDD VDD vfyb[47] sky130_fd_sc_hvl__inv_1
Xg560 sns1[47] VSS VSS VDD VDD sns1b[47] sky130_fd_sc_hvl__inv_1
Xg417 sns2[2] VSS VSS VDD VDD sns2b[2] sky130_fd_sc_hvl__inv_1
Xg411 sns2[5] VSS VSS VDD VDD sns2b[5] sky130_fd_sc_hvl__inv_1
Xg400 sns2[11] VSS VSS VDD VDD sns2b[11] sky130_fd_sc_hvl__inv_1
Xg376 sns2[23] VSS VSS VDD VDD sns2b[23] sky130_fd_sc_hvl__inv_1
Xg330 sns2[47] VSS VSS VDD VDD sns2b[47] sky130_fd_sc_hvl__inv_1
Xg579 wvw[48] VSS VSS VDD VDD wvwb[48] sky130_fd_sc_hvl__inv_1
Xg404 wvw[24] VSS VSS VDD VDD wvwb[24] sky130_fd_sc_hvl__inv_1
Xg405 wz[48] VSS VSS VDD VDD wzb[48] sky130_fd_sc_hvl__inv_1
Xg353 vfy[48] VSS VSS VDD VDD vfyb[48] sky130_fd_sc_hvl__inv_1
Xg569 wvw[12] VSS VSS VDD VDD wvwb[12] sky130_fd_sc_hvl__inv_1
Xg570 wz[24] VSS VSS VDD VDD wzb[24] sky130_fd_sc_hvl__inv_1
Xg561 sns1[48] VSS VSS VDD VDD sns1b[48] sky130_fd_sc_hvl__inv_1
Xg329 sns2[48] VSS VSS VDD VDD sns2b[48] sky130_fd_sc_hvl__inv_1
Xg434 vfy[24] VSS VSS VDD VDD vfyb[24] sky130_fd_sc_hvl__inv_1
Xg500 wvw[49] VSS VSS VDD VDD wvwb[49] sky130_fd_sc_hvl__inv_1
Xg321 wz[49] VSS VSS VDD VDD wzb[49] sky130_fd_sc_hvl__inv_1
Xg591 wvw[6] VSS VSS VDD VDD wvwb[6] sky130_fd_sc_hvl__inv_1
Xg592 wz[12] VSS VSS VDD VDD wzb[12] sky130_fd_sc_hvl__inv_1
Xg537 sns1[24] VSS VSS VDD VDD sns1b[24] sky130_fd_sc_hvl__inv_1
Xg350 vfy[49] VSS VSS VDD VDD vfyb[49] sky130_fd_sc_hvl__inv_1
Xg562 sns1[49] VSS VSS VDD VDD sns1b[49] sky130_fd_sc_hvl__inv_1
Xg375 sns2[24] VSS VSS VDD VDD sns2b[24] sky130_fd_sc_hvl__inv_1
Xg502 sns2[49] VSS VSS VDD VDD sns2b[49] sky130_fd_sc_hvl__inv_1
Xg467 wvw[50] VSS VSS VDD VDD wvwb[50] sky130_fd_sc_hvl__inv_1
Xg459 vfy[12] VSS VSS VDD VDD vfyb[12] sky130_fd_sc_hvl__inv_1
Xg389 wvw[25] VSS VSS VDD VDD wvwb[25] sky130_fd_sc_hvl__inv_1
Xg390 wz[50] VSS VSS VDD VDD wzb[50] sky130_fd_sc_hvl__inv_1
Xg346 vfy[50] VSS VSS VDD VDD vfyb[50] sky130_fd_sc_hvl__inv_1
Xg567 wz[25] VSS VSS VDD VDD wzb[25] sky130_fd_sc_hvl__inv_1
Xg568 sns1[50] VSS VSS VDD VDD sns1b[50] sky130_fd_sc_hvl__inv_1
Xg503 sns2[50] VSS VSS VDD VDD sns2b[50] sky130_fd_sc_hvl__inv_1
Xcol1q_reg_59 col1_clk col1q[58] FE_OFN3_rstb VSS VSS VDD VDD col1q[59] sky130_fd_sc_hvl__dfrtp_1
Xcol2q_reg_59 col2_clk col2q[58] rstb VSS VSS VDD VDD col2q[59] sky130_fd_sc_hvl__dfrtp_1
Xcol2q_reg_58 col2_clk col2q[57] rstb VSS VSS VDD VDD col2q[58] sky130_fd_sc_hvl__dfrtp_1
Xcol1q_reg_58 col1_clk col1q[57] FE_OFN3_rstb VSS VSS VDD VDD col1q[58] sky130_fd_sc_hvl__dfrtp_1
Xcol1q_reg_57 col1_clk col1q[56] FE_OFN3_rstb VSS VSS VDD VDD col1q[57] sky130_fd_sc_hvl__dfrtp_1
Xcol2q_reg_57 col2_clk col2q[56] rstb VSS VSS VDD VDD col2q[57] sky130_fd_sc_hvl__dfrtp_1
Xcol2q_reg_56 col2_clk col2q[55] rstb VSS VSS VDD VDD col2q[56] sky130_fd_sc_hvl__dfrtp_1
Xcol1q_reg_56 col1_clk col1q[55] FE_OFN3_rstb VSS VSS VDD VDD col1q[56] sky130_fd_sc_hvl__dfrtp_1
Xcol2q_reg_55 col2_clk col2q[54] rstb VSS VSS VDD VDD col2q[55] sky130_fd_sc_hvl__dfrtp_1
Xcol1q_reg_55 col1_clk col1q[54] FE_OFN3_rstb VSS VSS VDD VDD col1q[55] sky130_fd_sc_hvl__dfrtp_1
Xcol1q_reg_54 col1_clk col1q[53] FE_OFN3_rstb VSS VSS VDD VDD col1q[54] sky130_fd_sc_hvl__dfrtp_1
Xcol2q_reg_54 col2_clk col2q[53] rstb VSS VSS VDD VDD col2q[54] sky130_fd_sc_hvl__dfrtp_1
Xcol2q_reg_53 col2_clk col2q[52] rstb VSS VSS VDD VDD col2q[53] sky130_fd_sc_hvl__dfrtp_1
Xcol1q_reg_53 col1_clk col1q[52] FE_OFN3_rstb VSS VSS VDD VDD col1q[53] sky130_fd_sc_hvl__dfrtp_1
Xcol2q_reg_52 col2_clk col2q[51] rstb VSS VSS VDD VDD col2q[52] sky130_fd_sc_hvl__dfrtp_1
Xcol1q_reg_52 col1_clk col1q[51] FE_OFN3_rstb VSS VSS VDD VDD col1q[52] sky130_fd_sc_hvl__dfrtp_1
Xcol2q_reg_51 col2_clk col2q[50] rstb VSS VSS VDD VDD col2q[51] sky130_fd_sc_hvl__dfrtp_1
Xcol1q_reg_51 col1_clk col1q[50] FE_OFN3_rstb VSS VSS VDD VDD col1q[51] sky130_fd_sc_hvl__dfrtp_1
Xcol2q_reg_50 col2_clk col2q[49] rstb VSS VSS VDD VDD col2q[50] sky130_fd_sc_hvl__dfrtp_1
Xcol1q_reg_50 col1_clk col1q[49] FE_OFN3_rstb VSS VSS VDD VDD col1q[50] sky130_fd_sc_hvl__dfrtp_1
Xcol2q_reg_49 col2_clk col2q[48] rstb VSS VSS VDD VDD col2q[49] sky130_fd_sc_hvl__dfrtp_1
Xcol1q_reg_49 col1_clk col1q[48] FE_OFN3_rstb VSS VSS VDD VDD col1q[49] sky130_fd_sc_hvl__dfrtp_1
Xcol2q_reg_48 col2_clk col2q[47] rstb VSS VSS VDD VDD col2q[48] sky130_fd_sc_hvl__dfrtp_1
Xcol1q_reg_48 col1_clk col1q[47] FE_OFN3_rstb VSS VSS VDD VDD col1q[48] sky130_fd_sc_hvl__dfrtp_1
Xcol2q_reg_47 col2_clk col2q[46] rstb VSS VSS VDD VDD col2q[47] sky130_fd_sc_hvl__dfrtp_1
Xcol1q_reg_47 col1_clk col1q[46] FE_OFN3_rstb VSS VSS VDD VDD col1q[47] sky130_fd_sc_hvl__dfrtp_1
Xcol2q_reg_46 col2_clk col2q[45] rstb VSS VSS VDD VDD col2q[46] sky130_fd_sc_hvl__dfrtp_1
Xcol1q_reg_46 col1_clk col1q[45] FE_OFN3_rstb VSS VSS VDD VDD col1q[46] sky130_fd_sc_hvl__dfrtp_1
Xcol2q_reg_45 col2_clk col2q[44] rstb VSS VSS VDD VDD col2q[45] sky130_fd_sc_hvl__dfrtp_1
Xcol1q_reg_45 col1_clk col1q[44] FE_OFN3_rstb VSS VSS VDD VDD col1q[45] sky130_fd_sc_hvl__dfrtp_1
Xcol2q_reg_44 col2_clk col2q[43] rstb VSS VSS VDD VDD col2q[44] sky130_fd_sc_hvl__dfrtp_1
Xcol1q_reg_44 col1_clk col1q[43] FE_OFN3_rstb VSS VSS VDD VDD col1q[44] sky130_fd_sc_hvl__dfrtp_1
Xcol2q_reg_43 col2_clk col2q[42] rstb VSS VSS VDD VDD col2q[43] sky130_fd_sc_hvl__dfrtp_1
Xcol1q_reg_43 col1_clk col1q[42] FE_OFN3_rstb VSS VSS VDD VDD col1q[43] sky130_fd_sc_hvl__dfrtp_1
Xcol2q_reg_42 col2_clk col2q[41] rstb VSS VSS VDD VDD col2q[42] sky130_fd_sc_hvl__dfrtp_1
Xcol1q_reg_42 col1_clk col1q[41] FE_OFN3_rstb VSS VSS VDD VDD col1q[42] sky130_fd_sc_hvl__dfrtp_1
Xcol2q_reg_41 col2_clk col2q[40] rstb VSS VSS VDD VDD col2q[41] sky130_fd_sc_hvl__dfrtp_1
Xcol1q_reg_41 col1_clk col1q[40] FE_OFN3_rstb VSS VSS VDD VDD col1q[41] sky130_fd_sc_hvl__dfrtp_1
Xcol1q_reg_40 col1_clk col1q[39] FE_OFN3_rstb VSS VSS VDD VDD col1q[40] sky130_fd_sc_hvl__dfrtp_1
Xcol2q_reg_40 col2_clk col2q[39] rstb VSS VSS VDD VDD col2q[40] sky130_fd_sc_hvl__dfrtp_1
Xcol2q_reg_39 col2_clk col2q[38] rstb VSS VSS VDD VDD col2q[39] sky130_fd_sc_hvl__dfrtp_1
Xcol1q_reg_39 col1_clk col1q[38] FE_OFN3_rstb VSS VSS VDD VDD col1q[39] sky130_fd_sc_hvl__dfrtp_1
Xcol1q_reg_38 col1_clk col1q[37] FE_OFN3_rstb VSS VSS VDD VDD col1q[38] sky130_fd_sc_hvl__dfrtp_1
Xcol2q_reg_38 col2_clk col2q[37] rstb VSS VSS VDD VDD col2q[38] sky130_fd_sc_hvl__dfrtp_1
Xcol1q_reg_37 col1_clk col1q[36] FE_OFN3_rstb VSS VSS VDD VDD col1q[37] sky130_fd_sc_hvl__dfrtp_1
Xcol2q_reg_37 col2_clk col2q[36] rstb VSS VSS VDD VDD col2q[37] sky130_fd_sc_hvl__dfrtp_1
Xcol1q_reg_36 col1_clk col1q[35] FE_OFN3_rstb VSS VSS VDD VDD col1q[36] sky130_fd_sc_hvl__dfrtp_1
Xcol2q_reg_36 col2_clk col2q[35] rstb VSS VSS VDD VDD col2q[36] sky130_fd_sc_hvl__dfrtp_1
Xcol1q_reg_35 col1_clk col1q[34] FE_OFN3_rstb VSS VSS VDD VDD col1q[35] sky130_fd_sc_hvl__dfrtp_1
Xcol2q_reg_35 col2_clk col2q[34] rstb VSS VSS VDD VDD col2q[35] sky130_fd_sc_hvl__dfrtp_1
Xcol2q_reg_34 col2_clk col2q[33] rstb VSS VSS VDD VDD col2q[34] sky130_fd_sc_hvl__dfrtp_1
Xcol1q_reg_34 col1_clk col1q[33] FE_OFN3_rstb VSS VSS VDD VDD col1q[34] sky130_fd_sc_hvl__dfrtp_1
Xcol2q_reg_33 col2_clk col2q[32] rstb VSS VSS VDD VDD col2q[33] sky130_fd_sc_hvl__dfrtp_1
Xcol1q_reg_33 col1_clk col1q[32] FE_OFN3_rstb VSS VSS VDD VDD col1q[33] sky130_fd_sc_hvl__dfrtp_1
Xcol2q_reg_32 col2_clk col2q[31] rstb VSS VSS VDD VDD col2q[32] sky130_fd_sc_hvl__dfrtp_1
Xcol1q_reg_32 col1_clk col1q[31] FE_OFN3_rstb VSS VSS VDD VDD col1q[32] sky130_fd_sc_hvl__dfrtp_1
Xcol1q_reg_31 col1_clk col1q[30] FE_OFN3_rstb VSS VSS VDD VDD col1q[31] sky130_fd_sc_hvl__dfrtp_1
Xcol2q_reg_31 col2_clk col2q[30] rstb VSS VSS VDD VDD col2q[31] sky130_fd_sc_hvl__dfrtp_1
Xcol2q_reg_30 col2_clk col2q[29] rstb VSS VSS VDD VDD col2q[30] sky130_fd_sc_hvl__dfrtp_1
Xcol1q_reg_30 col1_clk col1q[29] FE_OFN3_rstb VSS VSS VDD VDD col1q[30] sky130_fd_sc_hvl__dfrtp_1
Xcol1q_reg_29 col1_clk col1q[28] FE_OFN3_rstb VSS VSS VDD VDD col1q[29] sky130_fd_sc_hvl__dfrtp_1
Xcol2q_reg_29 col2_clk col2q[28] rstb VSS VSS VDD VDD col2q[29] sky130_fd_sc_hvl__dfrtp_1
Xcol1q_reg_28 col1_clk col1q[27] FE_OFN3_rstb VSS VSS VDD VDD col1q[28] sky130_fd_sc_hvl__dfrtp_1
Xcol2q_reg_28 col2_clk col2q[27] rstb VSS VSS VDD VDD col2q[28] sky130_fd_sc_hvl__dfrtp_1
Xcol1q_reg_27 col1_clk col1q[26] FE_OFN3_rstb VSS VSS VDD VDD col1q[27] sky130_fd_sc_hvl__dfrtp_1
Xcol2q_reg_27 col2_clk col2q[26] rstb VSS VSS VDD VDD col2q[27] sky130_fd_sc_hvl__dfrtp_1
Xcol2q_reg_26 col2_clk col2q[25] rstb VSS VSS VDD VDD col2q[26] sky130_fd_sc_hvl__dfrtp_1
Xcol1q_reg_26 col1_clk col1q[25] FE_OFN3_rstb VSS VSS VDD VDD col1q[26] sky130_fd_sc_hvl__dfrtp_1
Xcol1q_reg_25 col1_clk col1q[24] FE_OFN3_rstb VSS VSS VDD VDD col1q[25] sky130_fd_sc_hvl__dfrtp_1
Xcol2q_reg_25 col2_clk col2q[24] rstb VSS VSS VDD VDD col2q[25] sky130_fd_sc_hvl__dfrtp_1
Xcol2q_reg_24 col2_clk col2q[23] rstb VSS VSS VDD VDD col2q[24] sky130_fd_sc_hvl__dfrtp_1
Xcol1q_reg_24 col1_clk col1q[23] FE_OFN3_rstb VSS VSS VDD VDD col1q[24] sky130_fd_sc_hvl__dfrtp_1
Xcol2q_reg_23 col2_clk col2q[22] rstb VSS VSS VDD VDD col2q[23] sky130_fd_sc_hvl__dfrtp_1
Xcol1q_reg_23 col1_clk col1q[22] FE_OFN3_rstb VSS VSS VDD VDD col1q[23] sky130_fd_sc_hvl__dfrtp_1
Xcol1q_reg_22 col1_clk col1q[21] FE_OFN3_rstb VSS VSS VDD VDD col1q[22] sky130_fd_sc_hvl__dfrtp_1
Xcol2q_reg_22 col2_clk col2q[21] rstb VSS VSS VDD VDD col2q[22] sky130_fd_sc_hvl__dfrtp_1
Xcol2q_reg_21 col2_clk col2q[20] rstb VSS VSS VDD VDD col2q[21] sky130_fd_sc_hvl__dfrtp_1
Xcol1q_reg_21 col1_clk col1q[20] FE_OFN3_rstb VSS VSS VDD VDD col1q[21] sky130_fd_sc_hvl__dfrtp_1
Xcol1q_reg_20 col1_clk col1q[19] FE_OFN3_rstb VSS VSS VDD VDD col1q[20] sky130_fd_sc_hvl__dfrtp_1
Xcol2q_reg_20 col2_clk col2q[19] rstb VSS VSS VDD VDD col2q[20] sky130_fd_sc_hvl__dfrtp_1
Xcol2q_reg_19 col2_clk col2q[18] rstb VSS VSS VDD VDD col2q[19] sky130_fd_sc_hvl__dfrtp_1
Xcol1q_reg_19 col1_clk col1q[18] FE_OFN3_rstb VSS VSS VDD VDD col1q[19] sky130_fd_sc_hvl__dfrtp_1
Xcol2q_reg_18 col2_clk col2q[17] rstb VSS VSS VDD VDD col2q[18] sky130_fd_sc_hvl__dfrtp_1
Xcol1q_reg_18 col1_clk col1q[17] FE_OFN3_rstb VSS VSS VDD VDD col1q[18] sky130_fd_sc_hvl__dfrtp_1
Xcol2q_reg_17 col2_clk col2q[16] rstb VSS VSS VDD VDD col2q[17] sky130_fd_sc_hvl__dfrtp_1
Xcol1q_reg_17 col1_clk col1q[16] FE_OFN3_rstb VSS VSS VDD VDD col1q[17] sky130_fd_sc_hvl__dfrtp_1
Xcol1q_reg_16 col1_clk col1q[15] FE_OFN3_rstb VSS VSS VDD VDD col1q[16] sky130_fd_sc_hvl__dfrtp_1
Xcol2q_reg_16 col2_clk col2q[15] rstb VSS VSS VDD VDD col2q[16] sky130_fd_sc_hvl__dfrtp_1
Xcol2q_reg_15 col2_clk col2q[14] rstb VSS VSS VDD VDD col2q[15] sky130_fd_sc_hvl__dfrtp_1
Xcol1q_reg_15 col1_clk col1q[14] FE_OFN3_rstb VSS VSS VDD VDD col1q[15] sky130_fd_sc_hvl__dfrtp_1
Xcol1q_reg_14 col1_clk col1q[13] FE_OFN3_rstb VSS VSS VDD VDD col1q[14] sky130_fd_sc_hvl__dfrtp_1
Xcol2q_reg_14 col2_clk col2q[13] rstb VSS VSS VDD VDD col2q[14] sky130_fd_sc_hvl__dfrtp_1
Xcol2q_reg_13 col2_clk col2q[12] rstb VSS VSS VDD VDD col2q[13] sky130_fd_sc_hvl__dfrtp_1
Xcol1q_reg_13 col1_clk col1q[12] FE_OFN3_rstb VSS VSS VDD VDD col1q[13] sky130_fd_sc_hvl__dfrtp_1
Xcol1q_reg_12 col1_clk col1q[11] FE_OFN3_rstb VSS VSS VDD VDD col1q[12] sky130_fd_sc_hvl__dfrtp_1
Xcol2q_reg_12 col2_clk col2q[11] rstb VSS VSS VDD VDD col2q[12] sky130_fd_sc_hvl__dfrtp_1
Xcol2q_reg_11 col2_clk col2q[10] rstb VSS VSS VDD VDD col2q[11] sky130_fd_sc_hvl__dfrtp_1
Xcol1q_reg_11 col1_clk col1q[10] FE_OFN3_rstb VSS VSS VDD VDD col1q[11] sky130_fd_sc_hvl__dfrtp_1
Xcol1q_reg_10 col1_clk col1q[9] FE_OFN3_rstb VSS VSS VDD VDD col1q[10] sky130_fd_sc_hvl__dfrtp_1
Xcol2q_reg_10 col2_clk col2q[9] rstb VSS VSS VDD VDD col2q[10] sky130_fd_sc_hvl__dfrtp_1
Xcol1q_reg_9 col1_clk col1q[8] FE_OFN3_rstb VSS VSS VDD VDD col1q[9] sky130_fd_sc_hvl__dfrtp_1
Xcol2q_reg_9 col2_clk col2q[8] rstb VSS VSS VDD VDD col2q[9] sky130_fd_sc_hvl__dfrtp_1
Xcol1q_reg_8 col1_clk col1q[7] FE_OFN3_rstb VSS VSS VDD VDD col1q[8] sky130_fd_sc_hvl__dfrtp_1
Xcol2q_reg_8 col2_clk col2q[7] rstb VSS VSS VDD VDD col2q[8] sky130_fd_sc_hvl__dfrtp_1
Xcol2q_reg_7 col2_clk col2q[6] rstb VSS VSS VDD VDD col2q[7] sky130_fd_sc_hvl__dfrtp_1
Xcol1q_reg_7 col1_clk col1q[6] FE_OFN3_rstb VSS VSS VDD VDD col1q[7] sky130_fd_sc_hvl__dfrtp_1
Xcol2q_reg_6 col2_clk col2q[5] rstb VSS VSS VDD VDD col2q[6] sky130_fd_sc_hvl__dfrtp_1
Xcol1q_reg_6 col1_clk col1q[5] FE_OFN3_rstb VSS VSS VDD VDD col1q[6] sky130_fd_sc_hvl__dfrtp_1
Xcol2q_reg_5 col2_clk col2q[4] rstb VSS VSS VDD VDD col2q[5] sky130_fd_sc_hvl__dfrtp_1
Xcol1q_reg_5 col1_clk col1q[4] FE_OFN3_rstb VSS VSS VDD VDD col1q[5] sky130_fd_sc_hvl__dfrtp_1
Xcol2q_reg_4 col2_clk col2q[3] rstb VSS VSS VDD VDD col2q[4] sky130_fd_sc_hvl__dfrtp_1
Xcol1q_reg_4 col1_clk col1q[3] FE_OFN3_rstb VSS VSS VDD VDD col1q[4] sky130_fd_sc_hvl__dfrtp_1
Xcol2q_reg_3 col2_clk col2q[2] rstb VSS VSS VDD VDD col2q[3] sky130_fd_sc_hvl__dfrtp_1
Xcol1q_reg_3 col1_clk col1q[2] FE_OFN3_rstb VSS VSS VDD VDD col1q[3] sky130_fd_sc_hvl__dfrtp_1
Xcol2q_reg_2 col2_clk col2q[1] rstb VSS VSS VDD VDD col2q[2] sky130_fd_sc_hvl__dfrtp_1
Xcol1q_reg_2 col1_clk col1q[1] FE_OFN3_rstb VSS VSS VDD VDD col1q[2] sky130_fd_sc_hvl__dfrtp_1
Xg472 wvw[63] VSS VSS VDD VDD wvwb[63] sky130_fd_sc_hvl__inv_1
Xg622 wz[63] VSS VSS VDD VDD wzb[63] sky130_fd_sc_hvl__inv_1
Xg623 vfy[63] VSS VSS VDD VDD vfyb[63] sky130_fd_sc_hvl__inv_1
Xcol1q_reg_1 col1_clk col1q[0] FE_OFN3_rstb VSS VSS VDD VDD col1q[1] sky130_fd_sc_hvl__dfrtp_1
Xcol2q_reg_1 col2_clk col2q[0] rstb VSS VSS VDD VDD col2q[1] sky130_fd_sc_hvl__dfrtp_1
Xg624 sns1[63] VSS VSS VDD VDD sns1b[63] sky130_fd_sc_hvl__inv_1
Xcol2q_reg_0 col2_clk sdi rstb VSS VSS VDD VDD col2q[0] sky130_fd_sc_hvl__dfrtp_1
Xcol1q_reg_0 col1_clk sdi FE_OFN3_rstb VSS VSS VDD VDD col1q[0] sky130_fd_sc_hvl__dfrtp_1
Xg_col_0.u_coll_g73__2398 FE_DBTN2_PROG g_col[0].u_coll_n_4 VSS VSS VDD VDD wz[0] sky130_fd_sc_hvl__nor2_1
Xg_col_0.u_coll_g74__5107 FE_DBTN1_VER g_col[0].u_coll_n_4 VSS VSS VDD VDD vfy[0] sky130_fd_sc_hvl__nor2_1
Xg_col_0.u_coll_g75__6260 FE_DBTN0_SENSE g_col[0].u_coll_n_4 VSS VSS VDD VDD sns1[0] sky130_fd_sc_hvl__nor2_1
Xg_col_0.u_coll_g76__4319 g_col[0].u_coll_n_4 WRANY VSS VSS VDD VDD wvw[0] sky130_fd_sc_hvl__and2_1
Xg_col_0.u_coll_g77__8428 sel_en SENSE col2q[0] VSS VSS VDD VDD sns2[0] sky130_fd_sc_hvl__and3_1
Xg_col_0.u_coll_g78__5526 sel_en col1q[0] VSS VSS VDD VDD g_col[0].u_coll_n_4 sky130_fd_sc_hvl__nand2_1
Xg_col_1.u_coll_g73__6783 FE_DBTN2_PROG g_col[1].u_coll_n_4 VSS VSS VDD VDD wz[1] sky130_fd_sc_hvl__nor2_1
Xg_col_1.u_coll_g74__3680 FE_DBTN1_VER g_col[1].u_coll_n_4 VSS VSS VDD VDD vfy[1] sky130_fd_sc_hvl__nor2_1
Xg_col_1.u_coll_g75__1617 FE_DBTN0_SENSE g_col[1].u_coll_n_4 VSS VSS VDD VDD sns1[1] sky130_fd_sc_hvl__nor2_1
Xg_col_1.u_coll_g76__2802 g_col[1].u_coll_n_4 WRANY VSS VSS VDD VDD wvw[1] sky130_fd_sc_hvl__and2_1
Xg_col_1.u_coll_g77__1705 sel_en SENSE col2q[1] VSS VSS VDD VDD sns2[1] sky130_fd_sc_hvl__and3_1
Xg_col_1.u_coll_g78__5122 FE_OFN4_sel_en col1q[1] VSS VSS VDD VDD g_col[1].u_coll_n_4 sky130_fd_sc_hvl__nand2_1
Xg_col_2.u_coll_g73__8246 FE_DBTN2_PROG g_col[2].u_coll_n_4 VSS VSS VDD VDD wz[2] sky130_fd_sc_hvl__nor2_1
Xg_col_2.u_coll_g74__7098 FE_DBTN1_VER g_col[2].u_coll_n_4 VSS VSS VDD VDD vfy[2] sky130_fd_sc_hvl__nor2_1
Xg_col_2.u_coll_g75__6131 FE_DBTN0_SENSE g_col[2].u_coll_n_4 VSS VSS VDD VDD sns1[2] sky130_fd_sc_hvl__nor2_1
Xg_col_2.u_coll_g76__1881 g_col[2].u_coll_n_4 WRANY VSS VSS VDD VDD wvw[2] sky130_fd_sc_hvl__and2_1
Xg_col_2.u_coll_g77__5115 sel_en SENSE col2q[2] VSS VSS VDD VDD sns2[2] sky130_fd_sc_hvl__and3_1
Xg_col_2.u_coll_g78__7482 FE_OFN4_sel_en col1q[2] VSS VSS VDD VDD g_col[2].u_coll_n_4 sky130_fd_sc_hvl__nand2_1
Xg_col_3.u_coll_g73__4733 FE_DBTN2_PROG g_col[3].u_coll_n_4 VSS VSS VDD VDD wz[3] sky130_fd_sc_hvl__nor2_1
Xg_col_3.u_coll_g74__6161 FE_DBTN1_VER g_col[3].u_coll_n_4 VSS VSS VDD VDD vfy[3] sky130_fd_sc_hvl__nor2_1
Xg_col_3.u_coll_g75__9315 FE_DBTN0_SENSE g_col[3].u_coll_n_4 VSS VSS VDD VDD sns1[3] sky130_fd_sc_hvl__nor2_1
Xg_col_3.u_coll_g76__9945 g_col[3].u_coll_n_4 WRANY VSS VSS VDD VDD wvw[3] sky130_fd_sc_hvl__and2_1
Xg_col_3.u_coll_g77__2883 sel_en SENSE col2q[3] VSS VSS VDD VDD sns2[3] sky130_fd_sc_hvl__and3_1
Xg_col_3.u_coll_g78__2346 FE_OFN4_sel_en col1q[3] VSS VSS VDD VDD g_col[3].u_coll_n_4 sky130_fd_sc_hvl__nand2_1
Xg_col_4.u_coll_g73__1666 FE_DBTN2_PROG g_col[4].u_coll_n_4 VSS VSS VDD VDD wz[4] sky130_fd_sc_hvl__nor2_1
Xg_col_4.u_coll_g74__7410 FE_DBTN1_VER g_col[4].u_coll_n_4 VSS VSS VDD VDD vfy[4] sky130_fd_sc_hvl__nor2_1
Xg_col_4.u_coll_g75__6417 FE_DBTN0_SENSE g_col[4].u_coll_n_4 VSS VSS VDD VDD sns1[4] sky130_fd_sc_hvl__nor2_1
Xg_col_4.u_coll_g76__5477 g_col[4].u_coll_n_4 WRANY VSS VSS VDD VDD wvw[4] sky130_fd_sc_hvl__and2_1
Xg_col_4.u_coll_g77__2398 sel_en SENSE col2q[4] VSS VSS VDD VDD sns2[4] sky130_fd_sc_hvl__and3_1
Xg_col_4.u_coll_g78__5107 FE_OFN4_sel_en col1q[4] VSS VSS VDD VDD g_col[4].u_coll_n_4 sky130_fd_sc_hvl__nand2_1
Xg_col_5.u_coll_g73__6260 FE_DBTN2_PROG g_col[5].u_coll_n_4 VSS VSS VDD VDD wz[5] sky130_fd_sc_hvl__nor2_1
Xg_col_5.u_coll_g74__4319 FE_DBTN1_VER g_col[5].u_coll_n_4 VSS VSS VDD VDD vfy[5] sky130_fd_sc_hvl__nor2_1
Xg_col_5.u_coll_g75__8428 FE_DBTN0_SENSE g_col[5].u_coll_n_4 VSS VSS VDD VDD sns1[5] sky130_fd_sc_hvl__nor2_1
Xg_col_5.u_coll_g76__5526 g_col[5].u_coll_n_4 WRANY VSS VSS VDD VDD wvw[5] sky130_fd_sc_hvl__and2_1
Xg_col_5.u_coll_g77__6783 sel_en SENSE col2q[5] VSS VSS VDD VDD sns2[5] sky130_fd_sc_hvl__and3_1
Xg_col_5.u_coll_g78__3680 FE_OFN4_sel_en col1q[5] VSS VSS VDD VDD g_col[5].u_coll_n_4 sky130_fd_sc_hvl__nand2_1
Xg_col_6.u_coll_g73__1617 FE_DBTN2_PROG g_col[6].u_coll_n_4 VSS VSS VDD VDD wz[6] sky130_fd_sc_hvl__nor2_1
Xg_col_6.u_coll_g74__2802 FE_DBTN1_VER g_col[6].u_coll_n_4 VSS VSS VDD VDD vfy[6] sky130_fd_sc_hvl__nor2_1
Xg_col_6.u_coll_g75__1705 FE_DBTN0_SENSE g_col[6].u_coll_n_4 VSS VSS VDD VDD sns1[6] sky130_fd_sc_hvl__nor2_1
Xg_col_6.u_coll_g76__5122 g_col[6].u_coll_n_4 WRANY VSS VSS VDD VDD wvw[6] sky130_fd_sc_hvl__and2_1
Xg_col_6.u_coll_g77__8246 sel_en SENSE col2q[6] VSS VSS VDD VDD sns2[6] sky130_fd_sc_hvl__and3_1
Xg_col_6.u_coll_g78__7098 FE_OFN4_sel_en col1q[6] VSS VSS VDD VDD g_col[6].u_coll_n_4 sky130_fd_sc_hvl__nand2_1
Xg_col_7.u_coll_g73__6131 FE_DBTN2_PROG g_col[7].u_coll_n_4 VSS VSS VDD VDD wz[7] sky130_fd_sc_hvl__nor2_1
Xg_col_7.u_coll_g74__1881 FE_DBTN1_VER g_col[7].u_coll_n_4 VSS VSS VDD VDD vfy[7] sky130_fd_sc_hvl__nor2_1
Xg_col_7.u_coll_g75__5115 FE_DBTN0_SENSE g_col[7].u_coll_n_4 VSS VSS VDD VDD sns1[7] sky130_fd_sc_hvl__nor2_1
Xg_col_7.u_coll_g76__7482 g_col[7].u_coll_n_4 WRANY VSS VSS VDD VDD wvw[7] sky130_fd_sc_hvl__and2_1
Xg_col_7.u_coll_g77__4733 sel_en SENSE col2q[7] VSS VSS VDD VDD sns2[7] sky130_fd_sc_hvl__and3_1
Xg_col_7.u_coll_g78__6161 FE_OFN4_sel_en col1q[7] VSS VSS VDD VDD g_col[7].u_coll_n_4 sky130_fd_sc_hvl__nand2_1
Xg_col_8.u_coll_g73__9315 FE_DBTN2_PROG g_col[8].u_coll_n_4 VSS VSS VDD VDD wz[8] sky130_fd_sc_hvl__nor2_1
Xg_col_8.u_coll_g74__9945 FE_DBTN1_VER g_col[8].u_coll_n_4 VSS VSS VDD VDD vfy[8] sky130_fd_sc_hvl__nor2_1
Xg_col_8.u_coll_g75__2883 FE_DBTN0_SENSE g_col[8].u_coll_n_4 VSS VSS VDD VDD sns1[8] sky130_fd_sc_hvl__nor2_1
Xg_col_8.u_coll_g76__2346 g_col[8].u_coll_n_4 WRANY VSS VSS VDD VDD wvw[8] sky130_fd_sc_hvl__and2_1
Xg_col_8.u_coll_g77__1666 sel_en SENSE col2q[8] VSS VSS VDD VDD sns2[8] sky130_fd_sc_hvl__and3_1
Xg_col_8.u_coll_g78__7410 FE_OFN4_sel_en col1q[8] VSS VSS VDD VDD g_col[8].u_coll_n_4 sky130_fd_sc_hvl__nand2_1
Xg_col_9.u_coll_g73__6417 FE_DBTN2_PROG g_col[9].u_coll_n_4 VSS VSS VDD VDD wz[9] sky130_fd_sc_hvl__nor2_1
Xg_col_9.u_coll_g74__5477 FE_DBTN1_VER g_col[9].u_coll_n_4 VSS VSS VDD VDD vfy[9] sky130_fd_sc_hvl__nor2_1
Xg_col_9.u_coll_g75__2398 FE_DBTN0_SENSE g_col[9].u_coll_n_4 VSS VSS VDD VDD sns1[9] sky130_fd_sc_hvl__nor2_1
Xg_col_9.u_coll_g76__5107 g_col[9].u_coll_n_4 WRANY VSS VSS VDD VDD wvw[9] sky130_fd_sc_hvl__and2_1
Xg_col_9.u_coll_g77__6260 sel_en SENSE col2q[9] VSS VSS VDD VDD sns2[9] sky130_fd_sc_hvl__and3_1
Xg_col_9.u_coll_g78__4319 FE_OFN4_sel_en col1q[9] VSS VSS VDD VDD g_col[9].u_coll_n_4 sky130_fd_sc_hvl__nand2_1
Xg_col_10.u_coll_g73__8428 FE_DBTN2_PROG g_col[10].u_coll_n_4 VSS VSS VDD VDD wz[10] sky130_fd_sc_hvl__nor2_1
Xg_col_10.u_coll_g74__5526 FE_DBTN1_VER g_col[10].u_coll_n_4 VSS VSS VDD VDD vfy[10] sky130_fd_sc_hvl__nor2_1
Xg_col_10.u_coll_g75__6783 FE_DBTN0_SENSE g_col[10].u_coll_n_4 VSS VSS VDD VDD sns1[10] sky130_fd_sc_hvl__nor2_1
Xg_col_10.u_coll_g76__3680 g_col[10].u_coll_n_4 WRANY VSS VSS VDD VDD wvw[10] sky130_fd_sc_hvl__and2_1
Xg_col_10.u_coll_g77__1617 sel_en SENSE col2q[10] VSS VSS VDD VDD sns2[10] sky130_fd_sc_hvl__and3_1
Xg_col_10.u_coll_g78__2802 FE_OFN4_sel_en col1q[10] VSS VSS VDD VDD g_col[10].u_coll_n_4 sky130_fd_sc_hvl__nand2_1
Xg_col_11.u_coll_g73__1705 FE_DBTN2_PROG g_col[11].u_coll_n_4 VSS VSS VDD VDD wz[11] sky130_fd_sc_hvl__nor2_1
Xg_col_11.u_coll_g74__5122 FE_DBTN1_VER g_col[11].u_coll_n_4 VSS VSS VDD VDD vfy[11] sky130_fd_sc_hvl__nor2_1
Xg_col_11.u_coll_g75__8246 FE_DBTN0_SENSE g_col[11].u_coll_n_4 VSS VSS VDD VDD sns1[11] sky130_fd_sc_hvl__nor2_1
Xg_col_11.u_coll_g76__7098 g_col[11].u_coll_n_4 WRANY VSS VSS VDD VDD wvw[11] sky130_fd_sc_hvl__and2_1
Xg_col_11.u_coll_g77__6131 sel_en SENSE col2q[11] VSS VSS VDD VDD sns2[11] sky130_fd_sc_hvl__and3_1
Xg_col_11.u_coll_g78__1881 FE_OFN4_sel_en col1q[11] VSS VSS VDD VDD g_col[11].u_coll_n_4 sky130_fd_sc_hvl__nand2_1
Xg_col_12.u_coll_g73__5115 FE_DBTN2_PROG g_col[12].u_coll_n_4 VSS VSS VDD VDD wz[12] sky130_fd_sc_hvl__nor2_1
Xg_col_12.u_coll_g74__7482 FE_DBTN1_VER g_col[12].u_coll_n_4 VSS VSS VDD VDD vfy[12] sky130_fd_sc_hvl__nor2_1
Xg_col_12.u_coll_g75__4733 FE_DBTN0_SENSE g_col[12].u_coll_n_4 VSS VSS VDD VDD sns1[12] sky130_fd_sc_hvl__nor2_1
Xg_col_12.u_coll_g76__6161 g_col[12].u_coll_n_4 WRANY VSS VSS VDD VDD wvw[12] sky130_fd_sc_hvl__and2_1
Xg_col_12.u_coll_g77__9315 sel_en SENSE col2q[12] VSS VSS VDD VDD sns2[12] sky130_fd_sc_hvl__and3_1
Xg_col_12.u_coll_g78__9945 FE_OFN4_sel_en col1q[12] VSS VSS VDD VDD g_col[12].u_coll_n_4 sky130_fd_sc_hvl__nand2_1
Xg_col_13.u_coll_g73__2883 FE_DBTN2_PROG g_col[13].u_coll_n_4 VSS VSS VDD VDD wz[13] sky130_fd_sc_hvl__nor2_1
Xg_col_13.u_coll_g74__2346 FE_DBTN1_VER g_col[13].u_coll_n_4 VSS VSS VDD VDD vfy[13] sky130_fd_sc_hvl__nor2_1
Xg_col_13.u_coll_g75__1666 FE_DBTN0_SENSE g_col[13].u_coll_n_4 VSS VSS VDD VDD sns1[13] sky130_fd_sc_hvl__nor2_1
Xg_col_13.u_coll_g76__7410 g_col[13].u_coll_n_4 WRANY VSS VSS VDD VDD wvw[13] sky130_fd_sc_hvl__and2_1
Xg_col_13.u_coll_g77__6417 sel_en SENSE col2q[13] VSS VSS VDD VDD sns2[13] sky130_fd_sc_hvl__and3_1
Xg_col_13.u_coll_g78__5477 FE_OFN4_sel_en col1q[13] VSS VSS VDD VDD g_col[13].u_coll_n_4 sky130_fd_sc_hvl__nand2_1
Xg_col_14.u_coll_g73__2398 FE_DBTN2_PROG g_col[14].u_coll_n_4 VSS VSS VDD VDD wz[14] sky130_fd_sc_hvl__nor2_1
Xg_col_14.u_coll_g74__5107 FE_DBTN1_VER g_col[14].u_coll_n_4 VSS VSS VDD VDD vfy[14] sky130_fd_sc_hvl__nor2_1
Xg_col_14.u_coll_g75__6260 FE_DBTN0_SENSE g_col[14].u_coll_n_4 VSS VSS VDD VDD sns1[14] sky130_fd_sc_hvl__nor2_1
Xg_col_14.u_coll_g76__4319 g_col[14].u_coll_n_4 WRANY VSS VSS VDD VDD wvw[14] sky130_fd_sc_hvl__and2_1
Xg_col_14.u_coll_g77__8428 sel_en SENSE col2q[14] VSS VSS VDD VDD sns2[14] sky130_fd_sc_hvl__and3_1
Xg_col_14.u_coll_g78__5526 FE_OFN4_sel_en col1q[14] VSS VSS VDD VDD g_col[14].u_coll_n_4 sky130_fd_sc_hvl__nand2_1
Xg_col_15.u_coll_g73__6783 FE_DBTN2_PROG g_col[15].u_coll_n_4 VSS VSS VDD VDD wz[15] sky130_fd_sc_hvl__nor2_1
Xg_col_15.u_coll_g74__3680 FE_DBTN1_VER g_col[15].u_coll_n_4 VSS VSS VDD VDD vfy[15] sky130_fd_sc_hvl__nor2_1
Xg_col_15.u_coll_g75__1617 FE_DBTN0_SENSE g_col[15].u_coll_n_4 VSS VSS VDD VDD sns1[15] sky130_fd_sc_hvl__nor2_1
Xg_col_15.u_coll_g76__2802 g_col[15].u_coll_n_4 WRANY VSS VSS VDD VDD wvw[15] sky130_fd_sc_hvl__and2_1
Xg_col_15.u_coll_g77__1705 sel_en SENSE col2q[15] VSS VSS VDD VDD sns2[15] sky130_fd_sc_hvl__and3_1
Xg_col_15.u_coll_g78__5122 FE_OFN4_sel_en col1q[15] VSS VSS VDD VDD g_col[15].u_coll_n_4 sky130_fd_sc_hvl__nand2_1
Xg_col_16.u_coll_g73__8246 FE_DBTN2_PROG g_col[16].u_coll_n_4 VSS VSS VDD VDD wz[16] sky130_fd_sc_hvl__nor2_1
Xg_col_16.u_coll_g74__7098 FE_DBTN1_VER g_col[16].u_coll_n_4 VSS VSS VDD VDD vfy[16] sky130_fd_sc_hvl__nor2_1
Xg_col_16.u_coll_g75__6131 FE_DBTN0_SENSE g_col[16].u_coll_n_4 VSS VSS VDD VDD sns1[16] sky130_fd_sc_hvl__nor2_1
Xg_col_16.u_coll_g76__1881 g_col[16].u_coll_n_4 WRANY VSS VSS VDD VDD wvw[16] sky130_fd_sc_hvl__and2_1
Xg_col_16.u_coll_g77__5115 sel_en SENSE col2q[16] VSS VSS VDD VDD sns2[16] sky130_fd_sc_hvl__and3_1
Xg_col_16.u_coll_g78__7482 FE_OFN4_sel_en col1q[16] VSS VSS VDD VDD g_col[16].u_coll_n_4 sky130_fd_sc_hvl__nand2_1
Xg_col_17.u_coll_g73__4733 FE_DBTN2_PROG g_col[17].u_coll_n_4 VSS VSS VDD VDD wz[17] sky130_fd_sc_hvl__nor2_1
Xg_col_17.u_coll_g74__6161 FE_DBTN1_VER g_col[17].u_coll_n_4 VSS VSS VDD VDD vfy[17] sky130_fd_sc_hvl__nor2_1
Xg_col_17.u_coll_g75__9315 FE_DBTN0_SENSE g_col[17].u_coll_n_4 VSS VSS VDD VDD sns1[17] sky130_fd_sc_hvl__nor2_1
Xg_col_17.u_coll_g76__9945 g_col[17].u_coll_n_4 WRANY VSS VSS VDD VDD wvw[17] sky130_fd_sc_hvl__and2_1
Xg_col_17.u_coll_g77__2883 sel_en SENSE col2q[17] VSS VSS VDD VDD sns2[17] sky130_fd_sc_hvl__and3_1
Xg_col_17.u_coll_g78__2346 FE_OFN4_sel_en col1q[17] VSS VSS VDD VDD g_col[17].u_coll_n_4 sky130_fd_sc_hvl__nand2_1
Xg_col_18.u_coll_g73__1666 FE_DBTN2_PROG g_col[18].u_coll_n_4 VSS VSS VDD VDD wz[18] sky130_fd_sc_hvl__nor2_1
Xg_col_18.u_coll_g74__7410 FE_DBTN1_VER g_col[18].u_coll_n_4 VSS VSS VDD VDD vfy[18] sky130_fd_sc_hvl__nor2_1
Xg_col_18.u_coll_g75__6417 FE_DBTN0_SENSE g_col[18].u_coll_n_4 VSS VSS VDD VDD sns1[18] sky130_fd_sc_hvl__nor2_1
Xg_col_18.u_coll_g76__5477 g_col[18].u_coll_n_4 WRANY VSS VSS VDD VDD wvw[18] sky130_fd_sc_hvl__and2_1
Xg_col_18.u_coll_g77__2398 sel_en SENSE col2q[18] VSS VSS VDD VDD sns2[18] sky130_fd_sc_hvl__and3_1
Xg_col_18.u_coll_g78__5107 FE_OFN4_sel_en col1q[18] VSS VSS VDD VDD g_col[18].u_coll_n_4 sky130_fd_sc_hvl__nand2_1
Xg_col_19.u_coll_g73__6260 FE_DBTN2_PROG g_col[19].u_coll_n_4 VSS VSS VDD VDD wz[19] sky130_fd_sc_hvl__nor2_1
Xg_col_19.u_coll_g74__4319 FE_DBTN1_VER g_col[19].u_coll_n_4 VSS VSS VDD VDD vfy[19] sky130_fd_sc_hvl__nor2_1
Xg_col_19.u_coll_g75__8428 FE_DBTN0_SENSE g_col[19].u_coll_n_4 VSS VSS VDD VDD sns1[19] sky130_fd_sc_hvl__nor2_1
Xg_col_19.u_coll_g76__5526 g_col[19].u_coll_n_4 WRANY VSS VSS VDD VDD wvw[19] sky130_fd_sc_hvl__and2_1
Xg_col_19.u_coll_g77__6783 sel_en SENSE col2q[19] VSS VSS VDD VDD sns2[19] sky130_fd_sc_hvl__and3_1
Xg_col_19.u_coll_g78__3680 FE_OFN4_sel_en col1q[19] VSS VSS VDD VDD g_col[19].u_coll_n_4 sky130_fd_sc_hvl__nand2_1
Xg_col_20.u_coll_g73__1617 FE_DBTN2_PROG g_col[20].u_coll_n_4 VSS VSS VDD VDD wz[20] sky130_fd_sc_hvl__nor2_1
Xg_col_20.u_coll_g74__2802 FE_DBTN1_VER g_col[20].u_coll_n_4 VSS VSS VDD VDD vfy[20] sky130_fd_sc_hvl__nor2_1
Xg_col_20.u_coll_g75__1705 FE_DBTN0_SENSE g_col[20].u_coll_n_4 VSS VSS VDD VDD sns1[20] sky130_fd_sc_hvl__nor2_1
Xg_col_20.u_coll_g76__5122 g_col[20].u_coll_n_4 WRANY VSS VSS VDD VDD wvw[20] sky130_fd_sc_hvl__and2_1
Xg_col_20.u_coll_g77__8246 sel_en SENSE col2q[20] VSS VSS VDD VDD sns2[20] sky130_fd_sc_hvl__and3_1
Xg_col_20.u_coll_g78__7098 FE_OFN4_sel_en col1q[20] VSS VSS VDD VDD g_col[20].u_coll_n_4 sky130_fd_sc_hvl__nand2_1
Xg_col_21.u_coll_g73__6131 FE_DBTN2_PROG g_col[21].u_coll_n_4 VSS VSS VDD VDD wz[21] sky130_fd_sc_hvl__nor2_1
Xg_col_21.u_coll_g74__1881 FE_DBTN1_VER g_col[21].u_coll_n_4 VSS VSS VDD VDD vfy[21] sky130_fd_sc_hvl__nor2_1
Xg_col_21.u_coll_g75__5115 FE_DBTN0_SENSE g_col[21].u_coll_n_4 VSS VSS VDD VDD sns1[21] sky130_fd_sc_hvl__nor2_1
Xg_col_21.u_coll_g76__7482 g_col[21].u_coll_n_4 WRANY VSS VSS VDD VDD wvw[21] sky130_fd_sc_hvl__and2_1
Xg_col_21.u_coll_g77__4733 sel_en SENSE col2q[21] VSS VSS VDD VDD sns2[21] sky130_fd_sc_hvl__and3_1
Xg_col_21.u_coll_g78__6161 FE_OFN4_sel_en col1q[21] VSS VSS VDD VDD g_col[21].u_coll_n_4 sky130_fd_sc_hvl__nand2_1
Xg_col_22.u_coll_g73__9315 FE_DBTN2_PROG g_col[22].u_coll_n_4 VSS VSS VDD VDD wz[22] sky130_fd_sc_hvl__nor2_1
Xg_col_22.u_coll_g74__9945 FE_DBTN1_VER g_col[22].u_coll_n_4 VSS VSS VDD VDD vfy[22] sky130_fd_sc_hvl__nor2_1
Xg_col_22.u_coll_g75__2883 FE_DBTN0_SENSE g_col[22].u_coll_n_4 VSS VSS VDD VDD sns1[22] sky130_fd_sc_hvl__nor2_1
Xg_col_22.u_coll_g76__2346 g_col[22].u_coll_n_4 WRANY VSS VSS VDD VDD wvw[22] sky130_fd_sc_hvl__and2_1
Xg_col_22.u_coll_g77__1666 sel_en SENSE col2q[22] VSS VSS VDD VDD sns2[22] sky130_fd_sc_hvl__and3_1
Xg_col_22.u_coll_g78__7410 FE_OFN4_sel_en col1q[22] VSS VSS VDD VDD g_col[22].u_coll_n_4 sky130_fd_sc_hvl__nand2_1
Xg_col_23.u_coll_g73__6417 FE_DBTN2_PROG g_col[23].u_coll_n_4 VSS VSS VDD VDD wz[23] sky130_fd_sc_hvl__nor2_1
Xg_col_23.u_coll_g74__5477 FE_DBTN1_VER g_col[23].u_coll_n_4 VSS VSS VDD VDD vfy[23] sky130_fd_sc_hvl__nor2_1
Xg_col_23.u_coll_g75__2398 FE_DBTN0_SENSE g_col[23].u_coll_n_4 VSS VSS VDD VDD sns1[23] sky130_fd_sc_hvl__nor2_1
Xg_col_23.u_coll_g76__5107 g_col[23].u_coll_n_4 WRANY VSS VSS VDD VDD wvw[23] sky130_fd_sc_hvl__and2_1
Xg_col_23.u_coll_g77__6260 sel_en SENSE col2q[23] VSS VSS VDD VDD sns2[23] sky130_fd_sc_hvl__and3_1
Xg_col_23.u_coll_g78__4319 FE_OFN4_sel_en col1q[23] VSS VSS VDD VDD g_col[23].u_coll_n_4 sky130_fd_sc_hvl__nand2_1
Xg_col_24.u_coll_g73__8428 FE_DBTN2_PROG g_col[24].u_coll_n_4 VSS VSS VDD VDD wz[24] sky130_fd_sc_hvl__nor2_1
Xg_col_24.u_coll_g74__5526 FE_DBTN1_VER g_col[24].u_coll_n_4 VSS VSS VDD VDD vfy[24] sky130_fd_sc_hvl__nor2_1
Xg_col_24.u_coll_g75__6783 FE_DBTN0_SENSE g_col[24].u_coll_n_4 VSS VSS VDD VDD sns1[24] sky130_fd_sc_hvl__nor2_1
Xg_col_24.u_coll_g76__3680 g_col[24].u_coll_n_4 WRANY VSS VSS VDD VDD wvw[24] sky130_fd_sc_hvl__and2_1
Xg_col_24.u_coll_g77__1617 sel_en SENSE col2q[24] VSS VSS VDD VDD sns2[24] sky130_fd_sc_hvl__and3_1
Xg_col_24.u_coll_g78__2802 FE_OFN4_sel_en col1q[24] VSS VSS VDD VDD g_col[24].u_coll_n_4 sky130_fd_sc_hvl__nand2_1
Xg_col_25.u_coll_g73__1705 FE_DBTN2_PROG g_col[25].u_coll_n_4 VSS VSS VDD VDD wz[25] sky130_fd_sc_hvl__nor2_1
Xg_col_25.u_coll_g74__5122 FE_DBTN1_VER g_col[25].u_coll_n_4 VSS VSS VDD VDD vfy[25] sky130_fd_sc_hvl__nor2_1
Xg_col_25.u_coll_g75__8246 FE_DBTN0_SENSE g_col[25].u_coll_n_4 VSS VSS VDD VDD sns1[25] sky130_fd_sc_hvl__nor2_1
Xg_col_25.u_coll_g76__7098 g_col[25].u_coll_n_4 WRANY VSS VSS VDD VDD wvw[25] sky130_fd_sc_hvl__and2_1
Xg_col_25.u_coll_g77__6131 sel_en SENSE col2q[25] VSS VSS VDD VDD sns2[25] sky130_fd_sc_hvl__and3_1
Xg_col_25.u_coll_g78__1881 FE_OFN4_sel_en col1q[25] VSS VSS VDD VDD g_col[25].u_coll_n_4 sky130_fd_sc_hvl__nand2_1
Xg_col_26.u_coll_g73__5115 FE_DBTN2_PROG g_col[26].u_coll_n_4 VSS VSS VDD VDD wz[26] sky130_fd_sc_hvl__nor2_1
Xg_col_26.u_coll_g74__7482 FE_DBTN1_VER g_col[26].u_coll_n_4 VSS VSS VDD VDD vfy[26] sky130_fd_sc_hvl__nor2_1
Xg_col_26.u_coll_g75__4733 FE_DBTN0_SENSE g_col[26].u_coll_n_4 VSS VSS VDD VDD sns1[26] sky130_fd_sc_hvl__nor2_1
Xg_col_26.u_coll_g76__6161 g_col[26].u_coll_n_4 WRANY VSS VSS VDD VDD wvw[26] sky130_fd_sc_hvl__and2_1
Xg_col_26.u_coll_g77__9315 sel_en SENSE col2q[26] VSS VSS VDD VDD sns2[26] sky130_fd_sc_hvl__and3_1
Xg_col_26.u_coll_g78__9945 FE_OFN4_sel_en col1q[26] VSS VSS VDD VDD g_col[26].u_coll_n_4 sky130_fd_sc_hvl__nand2_1
Xg_col_27.u_coll_g73__2883 FE_DBTN2_PROG g_col[27].u_coll_n_4 VSS VSS VDD VDD wz[27] sky130_fd_sc_hvl__nor2_1
Xg_col_27.u_coll_g74__2346 FE_DBTN1_VER g_col[27].u_coll_n_4 VSS VSS VDD VDD vfy[27] sky130_fd_sc_hvl__nor2_1
Xg_col_27.u_coll_g75__1666 FE_DBTN0_SENSE g_col[27].u_coll_n_4 VSS VSS VDD VDD sns1[27] sky130_fd_sc_hvl__nor2_1
Xg_col_27.u_coll_g76__7410 g_col[27].u_coll_n_4 WRANY VSS VSS VDD VDD wvw[27] sky130_fd_sc_hvl__and2_1
Xg_col_27.u_coll_g77__6417 sel_en SENSE col2q[27] VSS VSS VDD VDD sns2[27] sky130_fd_sc_hvl__and3_1
Xg_col_27.u_coll_g78__5477 FE_OFN4_sel_en col1q[27] VSS VSS VDD VDD g_col[27].u_coll_n_4 sky130_fd_sc_hvl__nand2_1
Xg_col_28.u_coll_g73__2398 FE_DBTN2_PROG g_col[28].u_coll_n_4 VSS VSS VDD VDD wz[28] sky130_fd_sc_hvl__nor2_1
Xg_col_28.u_coll_g74__5107 FE_DBTN1_VER g_col[28].u_coll_n_4 VSS VSS VDD VDD vfy[28] sky130_fd_sc_hvl__nor2_1
Xg_col_28.u_coll_g75__6260 FE_DBTN0_SENSE g_col[28].u_coll_n_4 VSS VSS VDD VDD sns1[28] sky130_fd_sc_hvl__nor2_1
Xg_col_28.u_coll_g76__4319 g_col[28].u_coll_n_4 WRANY VSS VSS VDD VDD wvw[28] sky130_fd_sc_hvl__and2_1
Xg_col_28.u_coll_g77__8428 sel_en SENSE col2q[28] VSS VSS VDD VDD sns2[28] sky130_fd_sc_hvl__and3_1
Xg_col_28.u_coll_g78__5526 FE_OFN4_sel_en col1q[28] VSS VSS VDD VDD g_col[28].u_coll_n_4 sky130_fd_sc_hvl__nand2_1
Xg_col_29.u_coll_g73__6783 FE_DBTN2_PROG g_col[29].u_coll_n_4 VSS VSS VDD VDD wz[29] sky130_fd_sc_hvl__nor2_1
Xg_col_29.u_coll_g74__3680 FE_DBTN1_VER g_col[29].u_coll_n_4 VSS VSS VDD VDD vfy[29] sky130_fd_sc_hvl__nor2_1
Xg_col_29.u_coll_g75__1617 FE_DBTN0_SENSE g_col[29].u_coll_n_4 VSS VSS VDD VDD sns1[29] sky130_fd_sc_hvl__nor2_1
Xg_col_29.u_coll_g76__2802 g_col[29].u_coll_n_4 WRANY VSS VSS VDD VDD wvw[29] sky130_fd_sc_hvl__and2_1
Xg_col_29.u_coll_g77__1705 sel_en SENSE col2q[29] VSS VSS VDD VDD sns2[29] sky130_fd_sc_hvl__and3_1
Xg_col_29.u_coll_g78__5122 FE_OFN4_sel_en col1q[29] VSS VSS VDD VDD g_col[29].u_coll_n_4 sky130_fd_sc_hvl__nand2_1
Xg_col_30.u_coll_g73__8246 FE_DBTN2_PROG g_col[30].u_coll_n_4 VSS VSS VDD VDD wz[30] sky130_fd_sc_hvl__nor2_1
Xg_col_30.u_coll_g74__7098 FE_DBTN1_VER g_col[30].u_coll_n_4 VSS VSS VDD VDD vfy[30] sky130_fd_sc_hvl__nor2_1
Xg_col_30.u_coll_g75__6131 FE_DBTN0_SENSE g_col[30].u_coll_n_4 VSS VSS VDD VDD sns1[30] sky130_fd_sc_hvl__nor2_1
Xg_col_30.u_coll_g76__1881 g_col[30].u_coll_n_4 WRANY VSS VSS VDD VDD wvw[30] sky130_fd_sc_hvl__and2_1
Xg_col_30.u_coll_g77__5115 sel_en SENSE col2q[30] VSS VSS VDD VDD sns2[30] sky130_fd_sc_hvl__and3_1
Xg_col_30.u_coll_g78__7482 FE_OFN4_sel_en col1q[30] VSS VSS VDD VDD g_col[30].u_coll_n_4 sky130_fd_sc_hvl__nand2_1
Xg_col_31.u_coll_g73__4733 FE_DBTN2_PROG g_col[31].u_coll_n_4 VSS VSS VDD VDD wz[31] sky130_fd_sc_hvl__nor2_1
Xg_col_31.u_coll_g74__6161 FE_DBTN1_VER g_col[31].u_coll_n_4 VSS VSS VDD VDD vfy[31] sky130_fd_sc_hvl__nor2_1
Xg_col_31.u_coll_g75__9315 FE_DBTN0_SENSE g_col[31].u_coll_n_4 VSS VSS VDD VDD sns1[31] sky130_fd_sc_hvl__nor2_1
Xg_col_31.u_coll_g76__9945 g_col[31].u_coll_n_4 WRANY VSS VSS VDD VDD wvw[31] sky130_fd_sc_hvl__and2_1
Xg_col_31.u_coll_g77__2883 sel_en SENSE col2q[31] VSS VSS VDD VDD sns2[31] sky130_fd_sc_hvl__and3_1
Xg_col_31.u_coll_g78__2346 FE_OFN4_sel_en col1q[31] VSS VSS VDD VDD g_col[31].u_coll_n_4 sky130_fd_sc_hvl__nand2_1
Xg_col_32.u_coll_g73__1666 FE_DBTN2_PROG g_col[32].u_coll_n_4 VSS VSS VDD VDD wz[32] sky130_fd_sc_hvl__nor2_1
Xg_col_32.u_coll_g74__7410 FE_DBTN1_VER g_col[32].u_coll_n_4 VSS VSS VDD VDD vfy[32] sky130_fd_sc_hvl__nor2_1
Xg_col_32.u_coll_g75__6417 FE_DBTN0_SENSE g_col[32].u_coll_n_4 VSS VSS VDD VDD sns1[32] sky130_fd_sc_hvl__nor2_1
Xg_col_32.u_coll_g76__5477 g_col[32].u_coll_n_4 WRANY VSS VSS VDD VDD wvw[32] sky130_fd_sc_hvl__and2_1
Xg_col_32.u_coll_g77__2398 sel_en SENSE col2q[32] VSS VSS VDD VDD sns2[32] sky130_fd_sc_hvl__and3_1
Xg_col_32.u_coll_g78__5107 FE_OFN4_sel_en col1q[32] VSS VSS VDD VDD g_col[32].u_coll_n_4 sky130_fd_sc_hvl__nand2_1
Xg_col_33.u_coll_g73__6260 FE_DBTN2_PROG g_col[33].u_coll_n_4 VSS VSS VDD VDD wz[33] sky130_fd_sc_hvl__nor2_1
Xg_col_33.u_coll_g74__4319 FE_DBTN1_VER g_col[33].u_coll_n_4 VSS VSS VDD VDD vfy[33] sky130_fd_sc_hvl__nor2_1
Xg_col_33.u_coll_g75__8428 FE_DBTN0_SENSE g_col[33].u_coll_n_4 VSS VSS VDD VDD sns1[33] sky130_fd_sc_hvl__nor2_1
Xg_col_33.u_coll_g76__5526 g_col[33].u_coll_n_4 WRANY VSS VSS VDD VDD wvw[33] sky130_fd_sc_hvl__and2_1
Xg_col_33.u_coll_g77__6783 sel_en SENSE col2q[33] VSS VSS VDD VDD sns2[33] sky130_fd_sc_hvl__and3_1
Xg_col_33.u_coll_g78__3680 FE_OFN4_sel_en col1q[33] VSS VSS VDD VDD g_col[33].u_coll_n_4 sky130_fd_sc_hvl__nand2_1
Xg_col_34.u_coll_g73__1617 FE_DBTN2_PROG g_col[34].u_coll_n_4 VSS VSS VDD VDD wz[34] sky130_fd_sc_hvl__nor2_1
Xg_col_34.u_coll_g74__2802 FE_DBTN1_VER g_col[34].u_coll_n_4 VSS VSS VDD VDD vfy[34] sky130_fd_sc_hvl__nor2_1
Xg_col_34.u_coll_g75__1705 FE_DBTN0_SENSE g_col[34].u_coll_n_4 VSS VSS VDD VDD sns1[34] sky130_fd_sc_hvl__nor2_1
Xg_col_34.u_coll_g76__5122 g_col[34].u_coll_n_4 WRANY VSS VSS VDD VDD wvw[34] sky130_fd_sc_hvl__and2_1
Xg_col_34.u_coll_g77__8246 sel_en SENSE col2q[34] VSS VSS VDD VDD sns2[34] sky130_fd_sc_hvl__and3_1
Xg_col_34.u_coll_g78__7098 FE_OFN4_sel_en col1q[34] VSS VSS VDD VDD g_col[34].u_coll_n_4 sky130_fd_sc_hvl__nand2_1
Xg_col_35.u_coll_g73__6131 FE_DBTN2_PROG g_col[35].u_coll_n_4 VSS VSS VDD VDD wz[35] sky130_fd_sc_hvl__nor2_1
Xg_col_35.u_coll_g74__1881 FE_DBTN1_VER g_col[35].u_coll_n_4 VSS VSS VDD VDD vfy[35] sky130_fd_sc_hvl__nor2_1
Xg_col_35.u_coll_g75__5115 FE_DBTN0_SENSE g_col[35].u_coll_n_4 VSS VSS VDD VDD sns1[35] sky130_fd_sc_hvl__nor2_1
Xg_col_35.u_coll_g76__7482 g_col[35].u_coll_n_4 WRANY VSS VSS VDD VDD wvw[35] sky130_fd_sc_hvl__and2_1
Xg_col_35.u_coll_g77__4733 sel_en SENSE col2q[35] VSS VSS VDD VDD sns2[35] sky130_fd_sc_hvl__and3_1
Xg_col_35.u_coll_g78__6161 FE_OFN4_sel_en col1q[35] VSS VSS VDD VDD g_col[35].u_coll_n_4 sky130_fd_sc_hvl__nand2_1
Xg_col_36.u_coll_g73__9315 FE_DBTN2_PROG g_col[36].u_coll_n_4 VSS VSS VDD VDD wz[36] sky130_fd_sc_hvl__nor2_1
Xg_col_36.u_coll_g74__9945 FE_DBTN1_VER g_col[36].u_coll_n_4 VSS VSS VDD VDD vfy[36] sky130_fd_sc_hvl__nor2_1
Xg_col_36.u_coll_g75__2883 FE_DBTN0_SENSE g_col[36].u_coll_n_4 VSS VSS VDD VDD sns1[36] sky130_fd_sc_hvl__nor2_1
Xg_col_36.u_coll_g76__2346 g_col[36].u_coll_n_4 WRANY VSS VSS VDD VDD wvw[36] sky130_fd_sc_hvl__and2_1
Xg_col_36.u_coll_g77__1666 sel_en SENSE col2q[36] VSS VSS VDD VDD sns2[36] sky130_fd_sc_hvl__and3_1
Xg_col_36.u_coll_g78__7410 FE_OFN4_sel_en col1q[36] VSS VSS VDD VDD g_col[36].u_coll_n_4 sky130_fd_sc_hvl__nand2_1
Xg_col_37.u_coll_g73__6417 FE_DBTN2_PROG g_col[37].u_coll_n_4 VSS VSS VDD VDD wz[37] sky130_fd_sc_hvl__nor2_1
Xg_col_37.u_coll_g74__5477 FE_DBTN1_VER g_col[37].u_coll_n_4 VSS VSS VDD VDD vfy[37] sky130_fd_sc_hvl__nor2_1
Xg_col_37.u_coll_g75__2398 FE_DBTN0_SENSE g_col[37].u_coll_n_4 VSS VSS VDD VDD sns1[37] sky130_fd_sc_hvl__nor2_1
Xg_col_37.u_coll_g76__5107 g_col[37].u_coll_n_4 WRANY VSS VSS VDD VDD wvw[37] sky130_fd_sc_hvl__and2_1
Xg_col_37.u_coll_g77__6260 sel_en SENSE col2q[37] VSS VSS VDD VDD sns2[37] sky130_fd_sc_hvl__and3_1
Xg_col_37.u_coll_g78__4319 FE_OFN4_sel_en col1q[37] VSS VSS VDD VDD g_col[37].u_coll_n_4 sky130_fd_sc_hvl__nand2_1
Xg_col_38.u_coll_g73__8428 FE_DBTN2_PROG g_col[38].u_coll_n_4 VSS VSS VDD VDD wz[38] sky130_fd_sc_hvl__nor2_1
Xg_col_38.u_coll_g74__5526 FE_DBTN1_VER g_col[38].u_coll_n_4 VSS VSS VDD VDD vfy[38] sky130_fd_sc_hvl__nor2_1
Xg_col_38.u_coll_g75__6783 FE_DBTN0_SENSE g_col[38].u_coll_n_4 VSS VSS VDD VDD sns1[38] sky130_fd_sc_hvl__nor2_1
Xg_col_38.u_coll_g76__3680 g_col[38].u_coll_n_4 WRANY VSS VSS VDD VDD wvw[38] sky130_fd_sc_hvl__and2_1
Xg_col_38.u_coll_g77__1617 sel_en SENSE col2q[38] VSS VSS VDD VDD sns2[38] sky130_fd_sc_hvl__and3_1
Xg_col_38.u_coll_g78__2802 FE_OFN4_sel_en col1q[38] VSS VSS VDD VDD g_col[38].u_coll_n_4 sky130_fd_sc_hvl__nand2_1
Xg_col_39.u_coll_g73__1705 FE_DBTN2_PROG g_col[39].u_coll_n_4 VSS VSS VDD VDD wz[39] sky130_fd_sc_hvl__nor2_1
Xg_col_39.u_coll_g74__5122 FE_DBTN1_VER g_col[39].u_coll_n_4 VSS VSS VDD VDD vfy[39] sky130_fd_sc_hvl__nor2_1
Xg_col_39.u_coll_g75__8246 FE_DBTN0_SENSE g_col[39].u_coll_n_4 VSS VSS VDD VDD sns1[39] sky130_fd_sc_hvl__nor2_1
Xg_col_39.u_coll_g76__7098 g_col[39].u_coll_n_4 WRANY VSS VSS VDD VDD wvw[39] sky130_fd_sc_hvl__and2_1
Xg_col_39.u_coll_g77__6131 sel_en SENSE col2q[39] VSS VSS VDD VDD sns2[39] sky130_fd_sc_hvl__and3_1
Xg_col_39.u_coll_g78__1881 FE_OFN4_sel_en col1q[39] VSS VSS VDD VDD g_col[39].u_coll_n_4 sky130_fd_sc_hvl__nand2_1
Xg_col_40.u_coll_g73__5115 FE_DBTN2_PROG g_col[40].u_coll_n_4 VSS VSS VDD VDD wz[40] sky130_fd_sc_hvl__nor2_1
Xg_col_40.u_coll_g74__7482 FE_DBTN1_VER g_col[40].u_coll_n_4 VSS VSS VDD VDD vfy[40] sky130_fd_sc_hvl__nor2_1
Xg_col_40.u_coll_g75__4733 FE_DBTN0_SENSE g_col[40].u_coll_n_4 VSS VSS VDD VDD sns1[40] sky130_fd_sc_hvl__nor2_1
Xg_col_40.u_coll_g76__6161 g_col[40].u_coll_n_4 WRANY VSS VSS VDD VDD wvw[40] sky130_fd_sc_hvl__and2_1
Xg_col_40.u_coll_g77__9315 sel_en SENSE col2q[40] VSS VSS VDD VDD sns2[40] sky130_fd_sc_hvl__and3_1
Xg_col_40.u_coll_g78__9945 FE_OFN4_sel_en col1q[40] VSS VSS VDD VDD g_col[40].u_coll_n_4 sky130_fd_sc_hvl__nand2_1
Xg_col_41.u_coll_g73__2883 FE_DBTN2_PROG g_col[41].u_coll_n_4 VSS VSS VDD VDD wz[41] sky130_fd_sc_hvl__nor2_1
Xg_col_41.u_coll_g74__2346 FE_DBTN1_VER g_col[41].u_coll_n_4 VSS VSS VDD VDD vfy[41] sky130_fd_sc_hvl__nor2_1
Xg_col_41.u_coll_g75__1666 FE_DBTN0_SENSE g_col[41].u_coll_n_4 VSS VSS VDD VDD sns1[41] sky130_fd_sc_hvl__nor2_1
Xg_col_41.u_coll_g76__7410 g_col[41].u_coll_n_4 WRANY VSS VSS VDD VDD wvw[41] sky130_fd_sc_hvl__and2_1
Xg_col_41.u_coll_g77__6417 sel_en SENSE col2q[41] VSS VSS VDD VDD sns2[41] sky130_fd_sc_hvl__and3_1
Xg_col_41.u_coll_g78__5477 FE_OFN4_sel_en col1q[41] VSS VSS VDD VDD g_col[41].u_coll_n_4 sky130_fd_sc_hvl__nand2_1
Xg_col_42.u_coll_g73__2398 FE_DBTN2_PROG g_col[42].u_coll_n_4 VSS VSS VDD VDD wz[42] sky130_fd_sc_hvl__nor2_1
Xg_col_42.u_coll_g74__5107 FE_DBTN1_VER g_col[42].u_coll_n_4 VSS VSS VDD VDD vfy[42] sky130_fd_sc_hvl__nor2_1
Xg_col_42.u_coll_g75__6260 FE_DBTN0_SENSE g_col[42].u_coll_n_4 VSS VSS VDD VDD sns1[42] sky130_fd_sc_hvl__nor2_1
Xg_col_42.u_coll_g76__4319 g_col[42].u_coll_n_4 WRANY VSS VSS VDD VDD wvw[42] sky130_fd_sc_hvl__and2_1
Xg_col_42.u_coll_g77__8428 sel_en SENSE col2q[42] VSS VSS VDD VDD sns2[42] sky130_fd_sc_hvl__and3_1
Xg_col_42.u_coll_g78__5526 FE_OFN4_sel_en col1q[42] VSS VSS VDD VDD g_col[42].u_coll_n_4 sky130_fd_sc_hvl__nand2_1
Xg_col_43.u_coll_g73__6783 FE_DBTN2_PROG g_col[43].u_coll_n_4 VSS VSS VDD VDD wz[43] sky130_fd_sc_hvl__nor2_1
Xg_col_43.u_coll_g74__3680 FE_DBTN1_VER g_col[43].u_coll_n_4 VSS VSS VDD VDD vfy[43] sky130_fd_sc_hvl__nor2_1
Xg_col_43.u_coll_g75__1617 FE_DBTN0_SENSE g_col[43].u_coll_n_4 VSS VSS VDD VDD sns1[43] sky130_fd_sc_hvl__nor2_1
Xg_col_43.u_coll_g76__2802 g_col[43].u_coll_n_4 WRANY VSS VSS VDD VDD wvw[43] sky130_fd_sc_hvl__and2_1
Xg_col_43.u_coll_g77__1705 sel_en SENSE col2q[43] VSS VSS VDD VDD sns2[43] sky130_fd_sc_hvl__and3_1
Xg_col_43.u_coll_g78__5122 FE_OFN4_sel_en col1q[43] VSS VSS VDD VDD g_col[43].u_coll_n_4 sky130_fd_sc_hvl__nand2_1
Xg_col_44.u_coll_g73__8246 FE_DBTN2_PROG g_col[44].u_coll_n_4 VSS VSS VDD VDD wz[44] sky130_fd_sc_hvl__nor2_1
Xg_col_44.u_coll_g74__7098 FE_DBTN1_VER g_col[44].u_coll_n_4 VSS VSS VDD VDD vfy[44] sky130_fd_sc_hvl__nor2_1
Xg_col_44.u_coll_g75__6131 FE_DBTN0_SENSE g_col[44].u_coll_n_4 VSS VSS VDD VDD sns1[44] sky130_fd_sc_hvl__nor2_1
Xg_col_44.u_coll_g76__1881 g_col[44].u_coll_n_4 WRANY VSS VSS VDD VDD wvw[44] sky130_fd_sc_hvl__and2_1
Xg_col_44.u_coll_g77__5115 sel_en SENSE col2q[44] VSS VSS VDD VDD sns2[44] sky130_fd_sc_hvl__and3_1
Xg_col_44.u_coll_g78__7482 FE_OFN4_sel_en col1q[44] VSS VSS VDD VDD g_col[44].u_coll_n_4 sky130_fd_sc_hvl__nand2_1
Xg_col_45.u_coll_g73__4733 FE_DBTN2_PROG g_col[45].u_coll_n_4 VSS VSS VDD VDD wz[45] sky130_fd_sc_hvl__nor2_1
Xg_col_45.u_coll_g74__6161 FE_DBTN1_VER g_col[45].u_coll_n_4 VSS VSS VDD VDD vfy[45] sky130_fd_sc_hvl__nor2_1
Xg_col_45.u_coll_g75__9315 FE_DBTN0_SENSE g_col[45].u_coll_n_4 VSS VSS VDD VDD sns1[45] sky130_fd_sc_hvl__nor2_1
Xg_col_45.u_coll_g76__9945 g_col[45].u_coll_n_4 WRANY VSS VSS VDD VDD wvw[45] sky130_fd_sc_hvl__and2_1
Xg_col_45.u_coll_g77__2883 sel_en SENSE col2q[45] VSS VSS VDD VDD sns2[45] sky130_fd_sc_hvl__and3_1
Xg_col_45.u_coll_g78__2346 FE_OFN4_sel_en col1q[45] VSS VSS VDD VDD g_col[45].u_coll_n_4 sky130_fd_sc_hvl__nand2_1
Xg_col_46.u_coll_g73__1666 FE_DBTN2_PROG g_col[46].u_coll_n_4 VSS VSS VDD VDD wz[46] sky130_fd_sc_hvl__nor2_1
Xg_col_46.u_coll_g74__7410 FE_DBTN1_VER g_col[46].u_coll_n_4 VSS VSS VDD VDD vfy[46] sky130_fd_sc_hvl__nor2_1
Xg_col_46.u_coll_g75__6417 FE_DBTN0_SENSE g_col[46].u_coll_n_4 VSS VSS VDD VDD sns1[46] sky130_fd_sc_hvl__nor2_1
Xg_col_46.u_coll_g76__5477 g_col[46].u_coll_n_4 WRANY VSS VSS VDD VDD wvw[46] sky130_fd_sc_hvl__and2_1
Xg_col_46.u_coll_g77__2398 sel_en SENSE col2q[46] VSS VSS VDD VDD sns2[46] sky130_fd_sc_hvl__and3_1
Xg_col_46.u_coll_g78__5107 FE_OFN4_sel_en col1q[46] VSS VSS VDD VDD g_col[46].u_coll_n_4 sky130_fd_sc_hvl__nand2_1
Xg_col_47.u_coll_g73__6260 FE_DBTN2_PROG g_col[47].u_coll_n_4 VSS VSS VDD VDD wz[47] sky130_fd_sc_hvl__nor2_1
Xg_col_47.u_coll_g74__4319 FE_DBTN1_VER g_col[47].u_coll_n_4 VSS VSS VDD VDD vfy[47] sky130_fd_sc_hvl__nor2_1
Xg_col_47.u_coll_g75__8428 FE_DBTN0_SENSE g_col[47].u_coll_n_4 VSS VSS VDD VDD sns1[47] sky130_fd_sc_hvl__nor2_1
Xg_col_47.u_coll_g76__5526 g_col[47].u_coll_n_4 WRANY VSS VSS VDD VDD wvw[47] sky130_fd_sc_hvl__and2_1
Xg_col_47.u_coll_g77__6783 sel_en SENSE col2q[47] VSS VSS VDD VDD sns2[47] sky130_fd_sc_hvl__and3_1
Xg_col_47.u_coll_g78__3680 FE_OFN4_sel_en col1q[47] VSS VSS VDD VDD g_col[47].u_coll_n_4 sky130_fd_sc_hvl__nand2_1
Xg_col_48.u_coll_g73__1617 FE_DBTN2_PROG g_col[48].u_coll_n_4 VSS VSS VDD VDD wz[48] sky130_fd_sc_hvl__nor2_1
Xg_col_48.u_coll_g74__2802 FE_DBTN1_VER g_col[48].u_coll_n_4 VSS VSS VDD VDD vfy[48] sky130_fd_sc_hvl__nor2_1
Xg_col_48.u_coll_g75__1705 FE_DBTN0_SENSE g_col[48].u_coll_n_4 VSS VSS VDD VDD sns1[48] sky130_fd_sc_hvl__nor2_1
Xg_col_48.u_coll_g76__5122 g_col[48].u_coll_n_4 WRANY VSS VSS VDD VDD wvw[48] sky130_fd_sc_hvl__and2_1
Xg_col_48.u_coll_g77__8246 sel_en SENSE col2q[48] VSS VSS VDD VDD sns2[48] sky130_fd_sc_hvl__and3_1
Xg_col_48.u_coll_g78__7098 FE_OFN4_sel_en col1q[48] VSS VSS VDD VDD g_col[48].u_coll_n_4 sky130_fd_sc_hvl__nand2_1
Xg_col_49.u_coll_g73__6131 FE_DBTN2_PROG g_col[49].u_coll_n_4 VSS VSS VDD VDD wz[49] sky130_fd_sc_hvl__nor2_1
Xg_col_49.u_coll_g74__1881 FE_DBTN1_VER g_col[49].u_coll_n_4 VSS VSS VDD VDD vfy[49] sky130_fd_sc_hvl__nor2_1
Xg_col_49.u_coll_g75__5115 FE_DBTN0_SENSE g_col[49].u_coll_n_4 VSS VSS VDD VDD sns1[49] sky130_fd_sc_hvl__nor2_1
Xg_col_49.u_coll_g76__7482 g_col[49].u_coll_n_4 WRANY VSS VSS VDD VDD wvw[49] sky130_fd_sc_hvl__and2_1
Xg_col_49.u_coll_g77__4733 sel_en SENSE col2q[49] VSS VSS VDD VDD sns2[49] sky130_fd_sc_hvl__and3_1
Xg_col_49.u_coll_g78__6161 FE_OFN4_sel_en col1q[49] VSS VSS VDD VDD g_col[49].u_coll_n_4 sky130_fd_sc_hvl__nand2_1
Xg_col_50.u_coll_g73__9315 FE_DBTN2_PROG g_col[50].u_coll_n_4 VSS VSS VDD VDD wz[50] sky130_fd_sc_hvl__nor2_1
Xg_col_50.u_coll_g74__9945 FE_DBTN1_VER g_col[50].u_coll_n_4 VSS VSS VDD VDD vfy[50] sky130_fd_sc_hvl__nor2_1
Xg_col_50.u_coll_g75__2883 FE_DBTN0_SENSE g_col[50].u_coll_n_4 VSS VSS VDD VDD sns1[50] sky130_fd_sc_hvl__nor2_1
Xg_col_50.u_coll_g76__2346 g_col[50].u_coll_n_4 WRANY VSS VSS VDD VDD wvw[50] sky130_fd_sc_hvl__and2_1
Xg_col_50.u_coll_g77__1666 FE_OFN4_sel_en SENSE col2q[50] VSS VSS VDD VDD sns2[50] sky130_fd_sc_hvl__and3_1
Xg_col_50.u_coll_g78__7410 FE_OFN4_sel_en col1q[50] VSS VSS VDD VDD g_col[50].u_coll_n_4 sky130_fd_sc_hvl__nand2_1
Xg_col_51.u_coll_g73__6417 FE_DBTN2_PROG g_col[51].u_coll_n_4 VSS VSS VDD VDD wz[51] sky130_fd_sc_hvl__nor2_1
Xg_col_51.u_coll_g74__5477 FE_DBTN1_VER g_col[51].u_coll_n_4 VSS VSS VDD VDD vfy[51] sky130_fd_sc_hvl__nor2_1
Xg_col_51.u_coll_g75__2398 FE_DBTN0_SENSE g_col[51].u_coll_n_4 VSS VSS VDD VDD sns1[51] sky130_fd_sc_hvl__nor2_1
Xg_col_51.u_coll_g76__5107 g_col[51].u_coll_n_4 WRANY VSS VSS VDD VDD wvw[51] sky130_fd_sc_hvl__and2_1
Xg_col_51.u_coll_g77__6260 FE_OFN4_sel_en SENSE col2q[51] VSS VSS VDD VDD sns2[51] sky130_fd_sc_hvl__and3_1
Xg_col_51.u_coll_g78__4319 FE_OFN4_sel_en col1q[51] VSS VSS VDD VDD g_col[51].u_coll_n_4 sky130_fd_sc_hvl__nand2_1
Xg_col_52.u_coll_g73__8428 FE_DBTN2_PROG g_col[52].u_coll_n_4 VSS VSS VDD VDD wz[52] sky130_fd_sc_hvl__nor2_1
Xg_col_52.u_coll_g74__5526 FE_DBTN1_VER g_col[52].u_coll_n_4 VSS VSS VDD VDD vfy[52] sky130_fd_sc_hvl__nor2_1
Xg_col_52.u_coll_g75__6783 FE_DBTN0_SENSE g_col[52].u_coll_n_4 VSS VSS VDD VDD sns1[52] sky130_fd_sc_hvl__nor2_1
Xg_col_52.u_coll_g76__3680 g_col[52].u_coll_n_4 WRANY VSS VSS VDD VDD wvw[52] sky130_fd_sc_hvl__and2_1
Xg_col_52.u_coll_g77__1617 FE_OFN4_sel_en SENSE col2q[52] VSS VSS VDD VDD sns2[52] sky130_fd_sc_hvl__and3_1
Xg_col_52.u_coll_g78__2802 FE_OFN4_sel_en col1q[52] VSS VSS VDD VDD g_col[52].u_coll_n_4 sky130_fd_sc_hvl__nand2_1
Xg_col_53.u_coll_g73__1705 FE_DBTN2_PROG g_col[53].u_coll_n_4 VSS VSS VDD VDD wz[53] sky130_fd_sc_hvl__nor2_1
Xg_col_53.u_coll_g74__5122 FE_DBTN1_VER g_col[53].u_coll_n_4 VSS VSS VDD VDD vfy[53] sky130_fd_sc_hvl__nor2_1
Xg_col_53.u_coll_g75__8246 FE_DBTN0_SENSE g_col[53].u_coll_n_4 VSS VSS VDD VDD sns1[53] sky130_fd_sc_hvl__nor2_1
Xg_col_53.u_coll_g76__7098 g_col[53].u_coll_n_4 WRANY VSS VSS VDD VDD wvw[53] sky130_fd_sc_hvl__and2_1
Xg_col_53.u_coll_g77__6131 FE_OFN4_sel_en SENSE col2q[53] VSS VSS VDD VDD sns2[53] sky130_fd_sc_hvl__and3_1
Xg_col_53.u_coll_g78__1881 FE_OFN4_sel_en col1q[53] VSS VSS VDD VDD g_col[53].u_coll_n_4 sky130_fd_sc_hvl__nand2_1
Xg_col_54.u_coll_g73__5115 FE_DBTN2_PROG g_col[54].u_coll_n_4 VSS VSS VDD VDD wz[54] sky130_fd_sc_hvl__nor2_1
Xg_col_54.u_coll_g74__7482 FE_DBTN1_VER g_col[54].u_coll_n_4 VSS VSS VDD VDD vfy[54] sky130_fd_sc_hvl__nor2_1
Xg_col_54.u_coll_g75__4733 FE_DBTN0_SENSE g_col[54].u_coll_n_4 VSS VSS VDD VDD sns1[54] sky130_fd_sc_hvl__nor2_1
Xg_col_54.u_coll_g76__6161 g_col[54].u_coll_n_4 WRANY VSS VSS VDD VDD wvw[54] sky130_fd_sc_hvl__and2_1
Xg_col_54.u_coll_g77__9315 FE_OFN4_sel_en SENSE col2q[54] VSS VSS VDD VDD sns2[54] sky130_fd_sc_hvl__and3_1
Xg_col_54.u_coll_g78__9945 FE_OFN4_sel_en col1q[54] VSS VSS VDD VDD g_col[54].u_coll_n_4 sky130_fd_sc_hvl__nand2_1
Xg_col_55.u_coll_g73__2883 FE_DBTN2_PROG g_col[55].u_coll_n_4 VSS VSS VDD VDD wz[55] sky130_fd_sc_hvl__nor2_1
Xg_col_55.u_coll_g74__2346 FE_DBTN1_VER g_col[55].u_coll_n_4 VSS VSS VDD VDD vfy[55] sky130_fd_sc_hvl__nor2_1
Xg_col_55.u_coll_g75__1666 FE_DBTN0_SENSE g_col[55].u_coll_n_4 VSS VSS VDD VDD sns1[55] sky130_fd_sc_hvl__nor2_1
Xg_col_55.u_coll_g76__7410 g_col[55].u_coll_n_4 WRANY VSS VSS VDD VDD wvw[55] sky130_fd_sc_hvl__and2_1
Xg_col_55.u_coll_g77__6417 FE_OFN4_sel_en SENSE col2q[55] VSS VSS VDD VDD sns2[55] sky130_fd_sc_hvl__and3_1
Xg_col_55.u_coll_g78__5477 FE_OFN4_sel_en col1q[55] VSS VSS VDD VDD g_col[55].u_coll_n_4 sky130_fd_sc_hvl__nand2_1
Xg_col_56.u_coll_g73__2398 FE_DBTN2_PROG g_col[56].u_coll_n_4 VSS VSS VDD VDD wz[56] sky130_fd_sc_hvl__nor2_1
Xg_col_56.u_coll_g74__5107 FE_DBTN1_VER g_col[56].u_coll_n_4 VSS VSS VDD VDD vfy[56] sky130_fd_sc_hvl__nor2_1
Xg_col_56.u_coll_g75__6260 FE_DBTN0_SENSE g_col[56].u_coll_n_4 VSS VSS VDD VDD sns1[56] sky130_fd_sc_hvl__nor2_1
Xg_col_56.u_coll_g76__4319 g_col[56].u_coll_n_4 WRANY VSS VSS VDD VDD wvw[56] sky130_fd_sc_hvl__and2_1
Xg_col_56.u_coll_g77__8428 FE_OFN4_sel_en SENSE col2q[56] VSS VSS VDD VDD sns2[56] sky130_fd_sc_hvl__and3_1
Xg_col_56.u_coll_g78__5526 FE_OFN4_sel_en col1q[56] VSS VSS VDD VDD g_col[56].u_coll_n_4 sky130_fd_sc_hvl__nand2_1
Xg_col_57.u_coll_g73__6783 FE_DBTN2_PROG g_col[57].u_coll_n_4 VSS VSS VDD VDD wz[57] sky130_fd_sc_hvl__nor2_1
Xg_col_57.u_coll_g74__3680 FE_DBTN1_VER g_col[57].u_coll_n_4 VSS VSS VDD VDD vfy[57] sky130_fd_sc_hvl__nor2_1
Xg_col_57.u_coll_g75__1617 FE_DBTN0_SENSE g_col[57].u_coll_n_4 VSS VSS VDD VDD sns1[57] sky130_fd_sc_hvl__nor2_1
Xg_col_57.u_coll_g76__2802 g_col[57].u_coll_n_4 WRANY VSS VSS VDD VDD wvw[57] sky130_fd_sc_hvl__and2_1
Xg_col_57.u_coll_g77__1705 FE_OFN4_sel_en SENSE col2q[57] VSS VSS VDD VDD sns2[57] sky130_fd_sc_hvl__and3_1
Xg_col_57.u_coll_g78__5122 FE_OFN4_sel_en col1q[57] VSS VSS VDD VDD g_col[57].u_coll_n_4 sky130_fd_sc_hvl__nand2_1
Xg_col_58.u_coll_g73__8246 FE_DBTN2_PROG g_col[58].u_coll_n_4 VSS VSS VDD VDD wz[58] sky130_fd_sc_hvl__nor2_1
Xg_col_58.u_coll_g74__7098 FE_DBTN1_VER g_col[58].u_coll_n_4 VSS VSS VDD VDD vfy[58] sky130_fd_sc_hvl__nor2_1
Xg_col_58.u_coll_g75__6131 FE_DBTN0_SENSE g_col[58].u_coll_n_4 VSS VSS VDD VDD sns1[58] sky130_fd_sc_hvl__nor2_1
Xg_col_58.u_coll_g76__1881 g_col[58].u_coll_n_4 WRANY VSS VSS VDD VDD wvw[58] sky130_fd_sc_hvl__and2_1
Xg_col_58.u_coll_g77__5115 FE_OFN4_sel_en SENSE col2q[58] VSS VSS VDD VDD sns2[58] sky130_fd_sc_hvl__and3_1
Xg_col_58.u_coll_g78__7482 FE_OFN4_sel_en col1q[58] VSS VSS VDD VDD g_col[58].u_coll_n_4 sky130_fd_sc_hvl__nand2_1
Xg_col_59.u_coll_g73__4733 FE_DBTN2_PROG g_col[59].u_coll_n_4 VSS VSS VDD VDD wz[59] sky130_fd_sc_hvl__nor2_1
Xg_col_59.u_coll_g74__6161 FE_DBTN1_VER g_col[59].u_coll_n_4 VSS VSS VDD VDD vfy[59] sky130_fd_sc_hvl__nor2_1
Xg_col_59.u_coll_g75__9315 FE_DBTN0_SENSE g_col[59].u_coll_n_4 VSS VSS VDD VDD sns1[59] sky130_fd_sc_hvl__nor2_1
Xg_col_59.u_coll_g76__9945 g_col[59].u_coll_n_4 WRANY VSS VSS VDD VDD wvw[59] sky130_fd_sc_hvl__and2_1
Xg_col_59.u_coll_g77__2883 FE_OFN4_sel_en SENSE col2q[59] VSS VSS VDD VDD sns2[59] sky130_fd_sc_hvl__and3_1
Xg_col_59.u_coll_g78__2346 FE_OFN4_sel_en col1q[59] VSS VSS VDD VDD g_col[59].u_coll_n_4 sky130_fd_sc_hvl__nand2_1
Xg_col_60.u_coll_g52__1666 FE_DBTN2_PROG g_col[60].u_coll_n_4 VSS VSS VDD VDD wz[63] sky130_fd_sc_hvl__nor2_1
Xg_col_60.u_coll_g53__7410 FE_DBTN1_VER g_col[60].u_coll_n_4 VSS VSS VDD VDD vfy[63] sky130_fd_sc_hvl__nor2_1
Xg_col_60.u_coll_g54__6417 FE_DBTN0_SENSE g_col[60].u_coll_n_4 VSS VSS VDD VDD sns1[63] sky130_fd_sc_hvl__nor2_1
Xg_col_60.u_coll_g55__5477 g_col[60].u_coll_n_4 WRANY VSS VSS VDD VDD wvw[63] sky130_fd_sc_hvl__and2_1
Xg_col_60.u_coll_g56__2398 lo FE_OFN4_sel_en VSS VSS VDD VDD g_col[60].u_coll_n_4 sky130_fd_sc_hvl__nand2_1
XXCL_c0 col[0] vrailp vrailm VSS clamp_d2r
XXCL_c1 col[1] vrailp vrailm VSS clamp_d2r
XXCL_c2 col[2] vrailp vrailm VSS clamp_d2r
XXCL_c3 col[3] vrailp vrailm VSS clamp_d2r
XXCL_c4 col[4] vrailp vrailm VSS clamp_d2r
XXCL_c5 col[5] vrailp vrailm VSS clamp_d2r
XXCL_c6 col[6] vrailp vrailm VSS clamp_d2r
XXCL_c7 col[7] vrailp vrailm VSS clamp_d2r
XXCL_c8 col[8] vrailp vrailm VSS clamp_d2r
XXCL_c9 col[9] vrailp vrailm VSS clamp_d2r
XXCL_c10 col[10] vrailp vrailm VSS clamp_d2r
XXCL_c11 col[11] vrailp vrailm VSS clamp_d2r
XXCL_c12 col[12] vrailp vrailm VSS clamp_d2r
XXCL_c13 col[13] vrailp vrailm VSS clamp_d2r
XXCL_c14 col[14] vrailp vrailm VSS clamp_d2r
XXCL_c15 col[15] vrailp vrailm VSS clamp_d2r
XXCL_c16 col[16] vrailp vrailm VSS clamp_d2r
XXCL_c17 col[17] vrailp vrailm VSS clamp_d2r
XXCL_c18 col[18] vrailp vrailm VSS clamp_d2r
XXCL_c19 col[19] vrailp vrailm VSS clamp_d2r
XXCL_c20 col[20] vrailp vrailm VSS clamp_d2r
XXCL_c21 col[21] vrailp vrailm VSS clamp_d2r
XXCL_c22 col[22] vrailp vrailm VSS clamp_d2r
XXCL_c23 col[23] vrailp vrailm VSS clamp_d2r
XXCL_c24 col[24] vrailp vrailm VSS clamp_d2r
XXCL_c25 col[25] vrailp vrailm VSS clamp_d2r
XXCL_c26 col[26] vrailp vrailm VSS clamp_d2r
XXCL_c27 col[27] vrailp vrailm VSS clamp_d2r
XXCL_c28 col[28] vrailp vrailm VSS clamp_d2r
XXCL_c29 col[29] vrailp vrailm VSS clamp_d2r
XXCL_c30 col[30] vrailp vrailm VSS clamp_d2r
XXCL_c31 col[31] vrailp vrailm VSS clamp_d2r
XXCL_c32 col[32] vrailp vrailm VSS clamp_d2r
XXCL_c33 col[33] vrailp vrailm VSS clamp_d2r
XXCL_c34 col[34] vrailp vrailm VSS clamp_d2r
XXCL_c35 col[35] vrailp vrailm VSS clamp_d2r
XXCL_c36 col[36] vrailp vrailm VSS clamp_d2r
XXCL_c37 col[37] vrailp vrailm VSS clamp_d2r
XXCL_c38 col[38] vrailp vrailm VSS clamp_d2r
XXCL_c39 col[39] vrailp vrailm VSS clamp_d2r
XXCL_c40 col[40] vrailp vrailm VSS clamp_d2r
XXCL_c41 col[41] vrailp vrailm VSS clamp_d2r
XXCL_c42 col[42] vrailp vrailm VSS clamp_d2r
XXCL_c43 col[43] vrailp vrailm VSS clamp_d2r
XXCL_c44 col[44] vrailp vrailm VSS clamp_d2r
XXCL_c45 col[45] vrailp vrailm VSS clamp_d2r
XXCL_c46 col[46] vrailp vrailm VSS clamp_d2r
XXCL_c47 col[47] vrailp vrailm VSS clamp_d2r
XXCL_c48 col[48] vrailp vrailm VSS clamp_d2r
XXCL_c49 col[49] vrailp vrailm VSS clamp_d2r
XXCL_c50 col[50] vrailp vrailm VSS clamp_d2r
XXCL_c51 col[51] vrailp vrailm VSS clamp_d2r
XXCL_c52 col[52] vrailp vrailm VSS clamp_d2r
XXCL_c53 col[53] vrailp vrailm VSS clamp_d2r
XXCL_c54 col[54] vrailp vrailm VSS clamp_d2r
XXCL_c55 col[55] vrailp vrailm VSS clamp_d2r
XXCL_c56 col[56] vrailp vrailm VSS clamp_d2r
XXCL_c57 col[57] vrailp vrailm VSS clamp_d2r
XXCL_c58 col[58] vrailp vrailm VSS clamp_d2r
XXCL_c59 col[59] vrailp vrailm VSS clamp_d2r
XXT1_c0 vzero col[0] wz[0] wzb[0] VDD VSS cb_tgw_n20
XXT1_c1 vzero col[1] wz[1] wzb[1] VDD VSS cb_tgw_n20
XXT1_c2 vzero col[2] wz[2] wzb[2] VDD VSS cb_tgw_n20
XXT1_c3 vzero col[3] wz[3] wzb[3] VDD VSS cb_tgw_n20
XXT1_c4 vzero col[4] wz[4] wzb[4] VDD VSS cb_tgw_n20
XXT1_c5 vzero col[5] wz[5] wzb[5] VDD VSS cb_tgw_n20
XXT1_c6 vzero col[6] wz[6] wzb[6] VDD VSS cb_tgw_n20
XXT1_c7 vzero col[7] wz[7] wzb[7] VDD VSS cb_tgw_n20
XXT1_c8 vzero col[8] wz[8] wzb[8] VDD VSS cb_tgw_n20
XXT1_c9 vzero col[9] wz[9] wzb[9] VDD VSS cb_tgw_n20
XXT1_c10 vzero col[10] wz[10] wzb[10] VDD VSS cb_tgw_n20
XXT1_c11 vzero col[11] wz[11] wzb[11] VDD VSS cb_tgw_n20
XXT1_c12 vzero col[12] wz[12] wzb[12] VDD VSS cb_tgw_n20
XXT1_c13 vzero col[13] wz[13] wzb[13] VDD VSS cb_tgw_n20
XXT1_c14 vzero col[14] wz[14] wzb[14] VDD VSS cb_tgw_n20
XXT1_c15 vzero col[15] wz[15] wzb[15] VDD VSS cb_tgw_n20
XXT1_c16 vzero col[16] wz[16] wzb[16] VDD VSS cb_tgw_n20
XXT1_c17 vzero col[17] wz[17] wzb[17] VDD VSS cb_tgw_n20
XXT1_c18 vzero col[18] wz[18] wzb[18] VDD VSS cb_tgw_n20
XXT1_c19 vzero col[19] wz[19] wzb[19] VDD VSS cb_tgw_n20
XXT1_c20 vzero col[20] wz[20] wzb[20] VDD VSS cb_tgw_n20
XXT1_c21 vzero col[21] wz[21] wzb[21] VDD VSS cb_tgw_n20
XXT1_c22 vzero col[22] wz[22] wzb[22] VDD VSS cb_tgw_n20
XXT1_c23 vzero col[23] wz[23] wzb[23] VDD VSS cb_tgw_n20
XXT1_c24 vzero col[24] wz[24] wzb[24] VDD VSS cb_tgw_n20
XXT1_c25 vzero col[25] wz[25] wzb[25] VDD VSS cb_tgw_n20
XXT1_c26 vzero col[26] wz[26] wzb[26] VDD VSS cb_tgw_n20
XXT1_c27 vzero col[27] wz[27] wzb[27] VDD VSS cb_tgw_n20
XXT1_c28 vzero col[28] wz[28] wzb[28] VDD VSS cb_tgw_n20
XXT1_c29 vzero col[29] wz[29] wzb[29] VDD VSS cb_tgw_n20
XXT1_c30 vzero col[30] wz[30] wzb[30] VDD VSS cb_tgw_n20
XXT1_c31 vzero col[31] wz[31] wzb[31] VDD VSS cb_tgw_n20
XXT1_c32 vzero col[32] wz[32] wzb[32] VDD VSS cb_tgw_n20
XXT1_c33 vzero col[33] wz[33] wzb[33] VDD VSS cb_tgw_n20
XXT1_c34 vzero col[34] wz[34] wzb[34] VDD VSS cb_tgw_n20
XXT1_c35 vzero col[35] wz[35] wzb[35] VDD VSS cb_tgw_n20
XXT1_c36 vzero col[36] wz[36] wzb[36] VDD VSS cb_tgw_n20
XXT1_c37 vzero col[37] wz[37] wzb[37] VDD VSS cb_tgw_n20
XXT1_c38 vzero col[38] wz[38] wzb[38] VDD VSS cb_tgw_n20
XXT1_c39 vzero col[39] wz[39] wzb[39] VDD VSS cb_tgw_n20
XXT1_c40 vzero col[40] wz[40] wzb[40] VDD VSS cb_tgw_n20
XXT1_c41 vzero col[41] wz[41] wzb[41] VDD VSS cb_tgw_n20
XXT1_c42 vzero col[42] wz[42] wzb[42] VDD VSS cb_tgw_n20
XXT1_c43 vzero col[43] wz[43] wzb[43] VDD VSS cb_tgw_n20
XXT1_c44 vzero col[44] wz[44] wzb[44] VDD VSS cb_tgw_n20
XXT1_c45 vzero col[45] wz[45] wzb[45] VDD VSS cb_tgw_n20
XXT1_c46 vzero col[46] wz[46] wzb[46] VDD VSS cb_tgw_n20
XXT1_c47 vzero col[47] wz[47] wzb[47] VDD VSS cb_tgw_n20
XXT1_c48 vzero col[48] wz[48] wzb[48] VDD VSS cb_tgw_n20
XXT1_c49 vzero col[49] wz[49] wzb[49] VDD VSS cb_tgw_n20
XXT1_c50 vzero col[50] wz[50] wzb[50] VDD VSS cb_tgw_n20
XXT1_c51 vzero col[51] wz[51] wzb[51] VDD VSS cb_tgw_n20
XXT1_c52 vzero col[52] wz[52] wzb[52] VDD VSS cb_tgw_n20
XXT1_c53 vzero col[53] wz[53] wzb[53] VDD VSS cb_tgw_n20
XXT1_c54 vzero col[54] wz[54] wzb[54] VDD VSS cb_tgw_n20
XXT1_c55 vzero col[55] wz[55] wzb[55] VDD VSS cb_tgw_n20
XXT1_c56 vzero col[56] wz[56] wzb[56] VDD VSS cb_tgw_n20
XXT1_c57 vzero col[57] wz[57] wzb[57] VDD VSS cb_tgw_n20
XXT1_c58 vzero col[58] wz[58] wzb[58] VDD VSS cb_tgw_n20
XXT1_c59 vzero col[59] wz[59] wzb[59] VDD VSS cb_tgw_n20
XXT1_c60 vzero col[60] wz[63] wzb[63] VDD VSS cb_tgw_n20
XXT1_c61 vzero col[61] wz[63] wzb[63] VDD VSS cb_tgw_n20
XXT1_c62 vzero col[62] wz[63] wzb[63] VDD VSS cb_tgw_n20
XXT1_c63 vzero col[63] wz[63] wzb[63] VDD VSS cb_tgw_n20
XXT2_c4 vw col[4] wvw[4] wvwb[4] VDD VSS cb_tg_n2
XXT4_c5 col[5] vbus vfy[5] vfyb[5] VDD VSS cb_tg_n2
XXT5_c6 col[6] C1 sns1[6] sns1b[6] VDD VSS cb_tg_n2
XXT6_c7 col[7] C2 sns2[7] sns2b[7] VDD VSS cb_tg_n2
XXT2_c12 vw col[12] wvw[12] wvwb[12] VDD VSS cb_tg_n2
XXT4_c13 col[13] vbus vfy[13] vfyb[13] VDD VSS cb_tg_n2
XXT5_c14 col[14] C1 sns1[14] sns1b[14] VDD VSS cb_tg_n2
XXT6_c15 col[15] C2 sns2[15] sns2b[15] VDD VSS cb_tg_n2
XXT2_c20 vw col[20] wvw[20] wvwb[20] VDD VSS cb_tg_n2
XXT4_c21 col[21] vbus vfy[21] vfyb[21] VDD VSS cb_tg_n2
XXT5_c22 col[22] C1 sns1[22] sns1b[22] VDD VSS cb_tg_n2
XXT6_c23 col[23] C2 sns2[23] sns2b[23] VDD VSS cb_tg_n2
XXT2_c28 vw col[28] wvw[28] wvwb[28] VDD VSS cb_tg_n2
XXT4_c29 col[29] vbus vfy[29] vfyb[29] VDD VSS cb_tg_n2
XXT5_c30 col[30] C1 sns1[30] sns1b[30] VDD VSS cb_tg_n2
XXT6_c31 col[31] C2 sns2[31] sns2b[31] VDD VSS cb_tg_n2
XXT2_c36 vw col[36] wvw[36] wvwb[36] VDD VSS cb_tg_n2
XXT4_c37 col[37] vbus vfy[37] vfyb[37] VDD VSS cb_tg_n2
XXT5_c38 col[38] C1 sns1[38] sns1b[38] VDD VSS cb_tg_n2
XXT6_c39 col[39] C2 sns2[39] sns2b[39] VDD VSS cb_tg_n2
XXT2_c44 vw col[44] wvw[44] wvwb[44] VDD VSS cb_tg_n2
XXT4_c45 col[45] vbus vfy[45] vfyb[45] VDD VSS cb_tg_n2
XXT5_c46 col[46] C1 sns1[46] sns1b[46] VDD VSS cb_tg_n2
XXT6_c47 col[47] C2 sns2[47] sns2b[47] VDD VSS cb_tg_n2
XXT2_c52 vw col[52] wvw[52] wvwb[52] VDD VSS cb_tg_n2
XXT4_c53 col[53] vbus vfy[53] vfyb[53] VDD VSS cb_tg_n2
XXT5_c54 col[54] C1 sns1[54] sns1b[54] VDD VSS cb_tg_n2
XXT6_c55 col[55] C2 sns2[55] sns2b[55] VDD VSS cb_tg_n2
XXT2_c56 vw col[56] wvw[56] wvwb[56] VDD VSS cb_tg_n2
XXT4_c57 col[57] vbus vfy[57] vfyb[57] VDD VSS cb_tg_n2
XXT5_c58 col[58] C1 sns1[58] sns1b[58] VDD VSS cb_tg_n2
XXT6_c59 col[59] C2 sns2[59] sns2b[59] VDD VSS cb_tg_n2
XXSP_c60 col[60] vzero READ READb VDD VSS cb_tg_n2
XXSP_c61 col[61] vzero READ READb VDD VSS cb_tg_n2
XXSP_c62 col[62] vzero READ READb VDD VSS cb_tg_n2
XXSP_c63 col[63] vzero READ READb VDD VSS cb_tg_n2
XXT6_c0 col[0] C2 sns2[0] sns2b[0] VDD VSS cb_tg_n2
XXT6_c1 col[1] C2 sns2[1] sns2b[1] VDD VSS cb_tg_n2
XXT6_c2 col[2] C2 sns2[2] sns2b[2] VDD VSS cb_tg_n2
XXT6_c3 col[3] C2 sns2[3] sns2b[3] VDD VSS cb_tg_n2
XXT6_c4 col[4] C2 sns2[4] sns2b[4] VDD VSS cb_tg_n2
XXT6_c5 col[5] C2 sns2[5] sns2b[5] VDD VSS cb_tg_n2
XXT6_c6 col[6] C2 sns2[6] sns2b[6] VDD VSS cb_tg_n2
XXT6_c8 col[8] C2 sns2[8] sns2b[8] VDD VSS cb_tg_n2
XXT6_c9 col[9] C2 sns2[9] sns2b[9] VDD VSS cb_tg_n2
XXT6_c10 col[10] C2 sns2[10] sns2b[10] VDD VSS cb_tg_n2
XXT6_c11 col[11] C2 sns2[11] sns2b[11] VDD VSS cb_tg_n2
XXT6_c12 col[12] C2 sns2[12] sns2b[12] VDD VSS cb_tg_n2
XXT6_c13 col[13] C2 sns2[13] sns2b[13] VDD VSS cb_tg_n2
XXT6_c14 col[14] C2 sns2[14] sns2b[14] VDD VSS cb_tg_n2
XXT6_c16 col[16] C2 sns2[16] sns2b[16] VDD VSS cb_tg_n2
XXT6_c17 col[17] C2 sns2[17] sns2b[17] VDD VSS cb_tg_n2
XXT6_c18 col[18] C2 sns2[18] sns2b[18] VDD VSS cb_tg_n2
XXT6_c19 col[19] C2 sns2[19] sns2b[19] VDD VSS cb_tg_n2
XXT6_c20 col[20] C2 sns2[20] sns2b[20] VDD VSS cb_tg_n2
XXT6_c21 col[21] C2 sns2[21] sns2b[21] VDD VSS cb_tg_n2
XXT6_c22 col[22] C2 sns2[22] sns2b[22] VDD VSS cb_tg_n2
XXT6_c24 col[24] C2 sns2[24] sns2b[24] VDD VSS cb_tg_n2
XXT6_c25 col[25] C2 sns2[25] sns2b[25] VDD VSS cb_tg_n2
XXT6_c26 col[26] C2 sns2[26] sns2b[26] VDD VSS cb_tg_n2
XXT6_c27 col[27] C2 sns2[27] sns2b[27] VDD VSS cb_tg_n2
XXT6_c28 col[28] C2 sns2[28] sns2b[28] VDD VSS cb_tg_n2
XXT6_c29 col[29] C2 sns2[29] sns2b[29] VDD VSS cb_tg_n2
XXT6_c30 col[30] C2 sns2[30] sns2b[30] VDD VSS cb_tg_n2
XXT6_c32 col[32] C2 sns2[32] sns2b[32] VDD VSS cb_tg_n2
XXT6_c33 col[33] C2 sns2[33] sns2b[33] VDD VSS cb_tg_n2
XXT6_c34 col[34] C2 sns2[34] sns2b[34] VDD VSS cb_tg_n2
XXT6_c35 col[35] C2 sns2[35] sns2b[35] VDD VSS cb_tg_n2
XXT6_c36 col[36] C2 sns2[36] sns2b[36] VDD VSS cb_tg_n2
XXT6_c37 col[37] C2 sns2[37] sns2b[37] VDD VSS cb_tg_n2
XXT6_c38 col[38] C2 sns2[38] sns2b[38] VDD VSS cb_tg_n2
XXT6_c40 col[40] C2 sns2[40] sns2b[40] VDD VSS cb_tg_n2
XXT6_c41 col[41] C2 sns2[41] sns2b[41] VDD VSS cb_tg_n2
XXT6_c42 col[42] C2 sns2[42] sns2b[42] VDD VSS cb_tg_n2
XXT6_c43 col[43] C2 sns2[43] sns2b[43] VDD VSS cb_tg_n2
XXT6_c44 col[44] C2 sns2[44] sns2b[44] VDD VSS cb_tg_n2
XXT6_c45 col[45] C2 sns2[45] sns2b[45] VDD VSS cb_tg_n2
XXT6_c46 col[46] C2 sns2[46] sns2b[46] VDD VSS cb_tg_n2
XXT6_c48 col[48] C2 sns2[48] sns2b[48] VDD VSS cb_tg_n2
XXT6_c49 col[49] C2 sns2[49] sns2b[49] VDD VSS cb_tg_n2
XXT6_c50 col[50] C2 sns2[50] sns2b[50] VDD VSS cb_tg_n2
XXT6_c51 col[51] C2 sns2[51] sns2b[51] VDD VSS cb_tg_n2
XXT6_c52 col[52] C2 sns2[52] sns2b[52] VDD VSS cb_tg_n2
XXT6_c53 col[53] C2 sns2[53] sns2b[53] VDD VSS cb_tg_n2
XXT6_c54 col[54] C2 sns2[54] sns2b[54] VDD VSS cb_tg_n2
XXT6_c56 col[56] C2 sns2[56] sns2b[56] VDD VSS cb_tg_n2
XXT6_c57 col[57] C2 sns2[57] sns2b[57] VDD VSS cb_tg_n2
XXT6_c58 col[58] C2 sns2[58] sns2b[58] VDD VSS cb_tg_n2
XXT6_c60 col[60] C2 sns1[63] sns1b[63] VDD VSS cb_tg_n2
XXT6_c61 col[61] C2 sns1[63] sns1b[63] VDD VSS cb_tg_n2
XXT6_c62 col[62] C2 sns1[63] sns1b[63] VDD VSS cb_tg_n2
XXT6_c63 col[63] C2 sns1[63] sns1b[63] VDD VSS cb_tg_n2
XXT5_c0 col[0] C1 sns1[0] sns1b[0] VDD VSS cb_tg_n2
XXT5_c1 col[1] C1 sns1[1] sns1b[1] VDD VSS cb_tg_n2
XXT5_c2 col[2] C1 sns1[2] sns1b[2] VDD VSS cb_tg_n2
XXT5_c3 col[3] C1 sns1[3] sns1b[3] VDD VSS cb_tg_n2
XXT5_c4 col[4] C1 sns1[4] sns1b[4] VDD VSS cb_tg_n2
XXT5_c5 col[5] C1 sns1[5] sns1b[5] VDD VSS cb_tg_n2
XXT5_c7 col[7] C1 sns1[7] sns1b[7] VDD VSS cb_tg_n2
XXT5_c8 col[8] C1 sns1[8] sns1b[8] VDD VSS cb_tg_n2
XXT5_c9 col[9] C1 sns1[9] sns1b[9] VDD VSS cb_tg_n2
XXT5_c10 col[10] C1 sns1[10] sns1b[10] VDD VSS cb_tg_n2
XXT5_c11 col[11] C1 sns1[11] sns1b[11] VDD VSS cb_tg_n2
XXT5_c12 col[12] C1 sns1[12] sns1b[12] VDD VSS cb_tg_n2
XXT5_c13 col[13] C1 sns1[13] sns1b[13] VDD VSS cb_tg_n2
XXT5_c15 col[15] C1 sns1[15] sns1b[15] VDD VSS cb_tg_n2
XXT5_c16 col[16] C1 sns1[16] sns1b[16] VDD VSS cb_tg_n2
XXT5_c17 col[17] C1 sns1[17] sns1b[17] VDD VSS cb_tg_n2
XXT5_c18 col[18] C1 sns1[18] sns1b[18] VDD VSS cb_tg_n2
XXT5_c19 col[19] C1 sns1[19] sns1b[19] VDD VSS cb_tg_n2
XXT5_c20 col[20] C1 sns1[20] sns1b[20] VDD VSS cb_tg_n2
XXT5_c21 col[21] C1 sns1[21] sns1b[21] VDD VSS cb_tg_n2
XXT5_c23 col[23] C1 sns1[23] sns1b[23] VDD VSS cb_tg_n2
XXT5_c24 col[24] C1 sns1[24] sns1b[24] VDD VSS cb_tg_n2
XXT5_c25 col[25] C1 sns1[25] sns1b[25] VDD VSS cb_tg_n2
XXT5_c26 col[26] C1 sns1[26] sns1b[26] VDD VSS cb_tg_n2
XXT5_c27 col[27] C1 sns1[27] sns1b[27] VDD VSS cb_tg_n2
XXT5_c28 col[28] C1 sns1[28] sns1b[28] VDD VSS cb_tg_n2
XXT5_c29 col[29] C1 sns1[29] sns1b[29] VDD VSS cb_tg_n2
XXT5_c31 col[31] C1 sns1[31] sns1b[31] VDD VSS cb_tg_n2
XXT5_c32 col[32] C1 sns1[32] sns1b[32] VDD VSS cb_tg_n2
XXT5_c33 col[33] C1 sns1[33] sns1b[33] VDD VSS cb_tg_n2
XXT5_c34 col[34] C1 sns1[34] sns1b[34] VDD VSS cb_tg_n2
XXT5_c35 col[35] C1 sns1[35] sns1b[35] VDD VSS cb_tg_n2
XXT5_c36 col[36] C1 sns1[36] sns1b[36] VDD VSS cb_tg_n2
XXT5_c37 col[37] C1 sns1[37] sns1b[37] VDD VSS cb_tg_n2
XXT5_c39 col[39] C1 sns1[39] sns1b[39] VDD VSS cb_tg_n2
XXT5_c40 col[40] C1 sns1[40] sns1b[40] VDD VSS cb_tg_n2
XXT5_c41 col[41] C1 sns1[41] sns1b[41] VDD VSS cb_tg_n2
XXT5_c42 col[42] C1 sns1[42] sns1b[42] VDD VSS cb_tg_n2
XXT5_c43 col[43] C1 sns1[43] sns1b[43] VDD VSS cb_tg_n2
XXT5_c44 col[44] C1 sns1[44] sns1b[44] VDD VSS cb_tg_n2
XXT5_c45 col[45] C1 sns1[45] sns1b[45] VDD VSS cb_tg_n2
XXT5_c47 col[47] C1 sns1[47] sns1b[47] VDD VSS cb_tg_n2
XXT5_c48 col[48] C1 sns1[48] sns1b[48] VDD VSS cb_tg_n2
XXT5_c49 col[49] C1 sns1[49] sns1b[49] VDD VSS cb_tg_n2
XXT5_c50 col[50] C1 sns1[50] sns1b[50] VDD VSS cb_tg_n2
XXT5_c51 col[51] C1 sns1[51] sns1b[51] VDD VSS cb_tg_n2
XXT5_c52 col[52] C1 sns1[52] sns1b[52] VDD VSS cb_tg_n2
XXT5_c53 col[53] C1 sns1[53] sns1b[53] VDD VSS cb_tg_n2
XXT5_c55 col[55] C1 sns1[55] sns1b[55] VDD VSS cb_tg_n2
XXT5_c56 col[56] C1 sns1[56] sns1b[56] VDD VSS cb_tg_n2
XXT5_c57 col[57] C1 sns1[57] sns1b[57] VDD VSS cb_tg_n2
XXT5_c59 col[59] C1 sns1[59] sns1b[59] VDD VSS cb_tg_n2
XXT5_c60 col[60] C1 sns1[63] sns1b[63] VDD VSS cb_tg_n2
XXT5_c61 col[61] C1 sns1[63] sns1b[63] VDD VSS cb_tg_n2
XXT5_c62 col[62] C1 sns1[63] sns1b[63] VDD VSS cb_tg_n2
XXT5_c63 col[63] C1 sns1[63] sns1b[63] VDD VSS cb_tg_n2
XXT4_c0 col[0] vbus vfy[0] vfyb[0] VDD VSS cb_tg_n2
XXT4_c1 col[1] vbus vfy[1] vfyb[1] VDD VSS cb_tg_n2
XXT4_c2 col[2] vbus vfy[2] vfyb[2] VDD VSS cb_tg_n2
XXT4_c3 col[3] vbus vfy[3] vfyb[3] VDD VSS cb_tg_n2
XXT4_c4 col[4] vbus vfy[4] vfyb[4] VDD VSS cb_tg_n2
XXT4_c6 col[6] vbus vfy[6] vfyb[6] VDD VSS cb_tg_n2
XXT4_c7 col[7] vbus vfy[7] vfyb[7] VDD VSS cb_tg_n2
XXT4_c8 col[8] vbus vfy[8] vfyb[8] VDD VSS cb_tg_n2
XXT4_c9 col[9] vbus vfy[9] vfyb[9] VDD VSS cb_tg_n2
XXT4_c10 col[10] vbus vfy[10] vfyb[10] VDD VSS cb_tg_n2
XXT4_c11 col[11] vbus vfy[11] vfyb[11] VDD VSS cb_tg_n2
XXT4_c12 col[12] vbus vfy[12] vfyb[12] VDD VSS cb_tg_n2
XXT4_c14 col[14] vbus vfy[14] vfyb[14] VDD VSS cb_tg_n2
XXT4_c15 col[15] vbus vfy[15] vfyb[15] VDD VSS cb_tg_n2
XXT4_c16 col[16] vbus vfy[16] vfyb[16] VDD VSS cb_tg_n2
XXT4_c17 col[17] vbus vfy[17] vfyb[17] VDD VSS cb_tg_n2
XXT4_c18 col[18] vbus vfy[18] vfyb[18] VDD VSS cb_tg_n2
XXT4_c19 col[19] vbus vfy[19] vfyb[19] VDD VSS cb_tg_n2
XXT4_c20 col[20] vbus vfy[20] vfyb[20] VDD VSS cb_tg_n2
XXT4_c22 col[22] vbus vfy[22] vfyb[22] VDD VSS cb_tg_n2
XXT4_c23 col[23] vbus vfy[23] vfyb[23] VDD VSS cb_tg_n2
XXT4_c24 col[24] vbus vfy[24] vfyb[24] VDD VSS cb_tg_n2
XXT4_c25 col[25] vbus vfy[25] vfyb[25] VDD VSS cb_tg_n2
XXT4_c26 col[26] vbus vfy[26] vfyb[26] VDD VSS cb_tg_n2
XXT4_c27 col[27] vbus vfy[27] vfyb[27] VDD VSS cb_tg_n2
XXT4_c28 col[28] vbus vfy[28] vfyb[28] VDD VSS cb_tg_n2
XXT4_c30 col[30] vbus vfy[30] vfyb[30] VDD VSS cb_tg_n2
XXT4_c31 col[31] vbus vfy[31] vfyb[31] VDD VSS cb_tg_n2
XXT4_c32 col[32] vbus vfy[32] vfyb[32] VDD VSS cb_tg_n2
XXT4_c33 col[33] vbus vfy[33] vfyb[33] VDD VSS cb_tg_n2
XXT4_c34 col[34] vbus vfy[34] vfyb[34] VDD VSS cb_tg_n2
XXT4_c35 col[35] vbus vfy[35] vfyb[35] VDD VSS cb_tg_n2
XXT4_c36 col[36] vbus vfy[36] vfyb[36] VDD VSS cb_tg_n2
XXT4_c38 col[38] vbus vfy[38] vfyb[38] VDD VSS cb_tg_n2
XXT4_c39 col[39] vbus vfy[39] vfyb[39] VDD VSS cb_tg_n2
XXT4_c40 col[40] vbus vfy[40] vfyb[40] VDD VSS cb_tg_n2
XXT4_c41 col[41] vbus vfy[41] vfyb[41] VDD VSS cb_tg_n2
XXT4_c42 col[42] vbus vfy[42] vfyb[42] VDD VSS cb_tg_n2
XXT4_c43 col[43] vbus vfy[43] vfyb[43] VDD VSS cb_tg_n2
XXT4_c44 col[44] vbus vfy[44] vfyb[44] VDD VSS cb_tg_n2
XXT4_c46 col[46] vbus vfy[46] vfyb[46] VDD VSS cb_tg_n2
XXT4_c47 col[47] vbus vfy[47] vfyb[47] VDD VSS cb_tg_n2
XXT4_c48 col[48] vbus vfy[48] vfyb[48] VDD VSS cb_tg_n2
XXT4_c49 col[49] vbus vfy[49] vfyb[49] VDD VSS cb_tg_n2
XXT4_c50 col[50] vbus vfy[50] vfyb[50] VDD VSS cb_tg_n2
XXT4_c51 col[51] vbus vfy[51] vfyb[51] VDD VSS cb_tg_n2
XXT4_c52 col[52] vbus vfy[52] vfyb[52] VDD VSS cb_tg_n2
XXT4_c54 col[54] vbus vfy[54] vfyb[54] VDD VSS cb_tg_n2
XXT4_c55 col[55] vbus vfy[55] vfyb[55] VDD VSS cb_tg_n2
XXT4_c56 col[56] vbus vfy[56] vfyb[56] VDD VSS cb_tg_n2
XXT4_c58 col[58] vbus vfy[58] vfyb[58] VDD VSS cb_tg_n2
XXT4_c59 col[59] vbus vfy[59] vfyb[59] VDD VSS cb_tg_n2
XXT4_c60 col[60] vbus vfy[63] vfyb[63] VDD VSS cb_tg_n2
XXT4_c61 col[61] vbus vfy[63] vfyb[63] VDD VSS cb_tg_n2
XXT4_c62 col[62] vbus vfy[63] vfyb[63] VDD VSS cb_tg_n2
XXT4_c63 col[63] vbus vfy[63] vfyb[63] VDD VSS cb_tg_n2
XXT2_c0 vw col[0] wvw[0] wvwb[0] VDD VSS cb_tg_n2
XXT2_c1 vw col[1] wvw[1] wvwb[1] VDD VSS cb_tg_n2
XXT2_c2 vw col[2] wvw[2] wvwb[2] VDD VSS cb_tg_n2
XXT2_c3 vw col[3] wvw[3] wvwb[3] VDD VSS cb_tg_n2
XXT2_c5 vw col[5] wvw[5] wvwb[5] VDD VSS cb_tg_n2
XXT2_c6 vw col[6] wvw[6] wvwb[6] VDD VSS cb_tg_n2
XXT2_c7 vw col[7] wvw[7] wvwb[7] VDD VSS cb_tg_n2
XXT2_c8 vw col[8] wvw[8] wvwb[8] VDD VSS cb_tg_n2
XXT2_c9 vw col[9] wvw[9] wvwb[9] VDD VSS cb_tg_n2
XXT2_c10 vw col[10] wvw[10] wvwb[10] VDD VSS cb_tg_n2
XXT2_c11 vw col[11] wvw[11] wvwb[11] VDD VSS cb_tg_n2
XXT2_c13 vw col[13] wvw[13] wvwb[13] VDD VSS cb_tg_n2
XXT2_c14 vw col[14] wvw[14] wvwb[14] VDD VSS cb_tg_n2
XXT2_c15 vw col[15] wvw[15] wvwb[15] VDD VSS cb_tg_n2
XXT2_c16 vw col[16] wvw[16] wvwb[16] VDD VSS cb_tg_n2
XXT2_c17 vw col[17] wvw[17] wvwb[17] VDD VSS cb_tg_n2
XXT2_c18 vw col[18] wvw[18] wvwb[18] VDD VSS cb_tg_n2
XXT2_c19 vw col[19] wvw[19] wvwb[19] VDD VSS cb_tg_n2
XXT2_c21 vw col[21] wvw[21] wvwb[21] VDD VSS cb_tg_n2
XXT2_c22 vw col[22] wvw[22] wvwb[22] VDD VSS cb_tg_n2
XXT2_c23 vw col[23] wvw[23] wvwb[23] VDD VSS cb_tg_n2
XXT2_c24 vw col[24] wvw[24] wvwb[24] VDD VSS cb_tg_n2
XXT2_c25 vw col[25] wvw[25] wvwb[25] VDD VSS cb_tg_n2
XXT2_c26 vw col[26] wvw[26] wvwb[26] VDD VSS cb_tg_n2
XXT2_c27 vw col[27] wvw[27] wvwb[27] VDD VSS cb_tg_n2
XXT2_c29 vw col[29] wvw[29] wvwb[29] VDD VSS cb_tg_n2
XXT2_c30 vw col[30] wvw[30] wvwb[30] VDD VSS cb_tg_n2
XXT2_c31 vw col[31] wvw[31] wvwb[31] VDD VSS cb_tg_n2
XXT2_c32 vw col[32] wvw[32] wvwb[32] VDD VSS cb_tg_n2
XXT2_c33 vw col[33] wvw[33] wvwb[33] VDD VSS cb_tg_n2
XXT2_c34 vw col[34] wvw[34] wvwb[34] VDD VSS cb_tg_n2
XXT2_c35 vw col[35] wvw[35] wvwb[35] VDD VSS cb_tg_n2
XXT2_c37 vw col[37] wvw[37] wvwb[37] VDD VSS cb_tg_n2
XXT2_c38 vw col[38] wvw[38] wvwb[38] VDD VSS cb_tg_n2
XXT2_c39 vw col[39] wvw[39] wvwb[39] VDD VSS cb_tg_n2
XXT2_c40 vw col[40] wvw[40] wvwb[40] VDD VSS cb_tg_n2
XXT2_c41 vw col[41] wvw[41] wvwb[41] VDD VSS cb_tg_n2
XXT2_c42 vw col[42] wvw[42] wvwb[42] VDD VSS cb_tg_n2
XXT2_c43 vw col[43] wvw[43] wvwb[43] VDD VSS cb_tg_n2
XXT2_c45 vw col[45] wvw[45] wvwb[45] VDD VSS cb_tg_n2
XXT2_c46 vw col[46] wvw[46] wvwb[46] VDD VSS cb_tg_n2
XXT2_c47 vw col[47] wvw[47] wvwb[47] VDD VSS cb_tg_n2
XXT2_c48 vw col[48] wvw[48] wvwb[48] VDD VSS cb_tg_n2
XXT2_c49 vw col[49] wvw[49] wvwb[49] VDD VSS cb_tg_n2
XXT2_c50 vw col[50] wvw[50] wvwb[50] VDD VSS cb_tg_n2
XXT2_c51 vw col[51] wvw[51] wvwb[51] VDD VSS cb_tg_n2
XXT2_c53 vw col[53] wvw[53] wvwb[53] VDD VSS cb_tg_n2
XXT2_c54 vw col[54] wvw[54] wvwb[54] VDD VSS cb_tg_n2
XXT2_c55 vw col[55] wvw[55] wvwb[55] VDD VSS cb_tg_n2
XXT2_c57 vw col[57] wvw[57] wvwb[57] VDD VSS cb_tg_n2
XXT2_c58 vw col[58] wvw[58] wvwb[58] VDD VSS cb_tg_n2
XXT2_c59 vw col[59] wvw[59] wvwb[59] VDD VSS cb_tg_n2
XXT2_c60 vw col[60] wvw[63] wvwb[63] VDD VSS cb_tg_n2
XXT2_c61 vw col[61] wvw[63] wvwb[63] VDD VSS cb_tg_n2
XXT2_c62 vw col[62] wvw[63] wvwb[63] VDD VSS cb_tg_n2
XXT2_c63 vw col[63] wvw[63] wvwb[63] VDD VSS cb_tg_n2
.ENDS col_blk
