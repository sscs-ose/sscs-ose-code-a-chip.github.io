.subckt rb_tgw_n20 a b ctl ctlb VDD VSS
Mn_0 b ctl a VSS nfet_g5v0d10v5 w=4.000u l=0.500u
Mn_1 b ctl a VSS nfet_g5v0d10v5 w=4.000u l=0.500u
Mn_2 b ctl a VSS nfet_g5v0d10v5 w=4.000u l=0.500u
Mn_3 b ctl a VSS nfet_g5v0d10v5 w=4.000u l=0.500u
Mn_4 b ctl a VSS nfet_g5v0d10v5 w=4.000u l=0.500u
Mp_0 b ctlb a VDD pfet_g5v0d10v5 w=8.000u l=0.500u
Mp_1 b ctlb a VDD pfet_g5v0d10v5 w=8.000u l=0.500u
Mp_2 b ctlb a VDD pfet_g5v0d10v5 w=8.000u l=0.500u
Mp_3 b ctlb a VDD pfet_g5v0d10v5 w=8.000u l=0.500u
Mp_4 b ctlb a VDD pfet_g5v0d10v5 w=8.000u l=0.500u
.ends rb_tgw_n20
