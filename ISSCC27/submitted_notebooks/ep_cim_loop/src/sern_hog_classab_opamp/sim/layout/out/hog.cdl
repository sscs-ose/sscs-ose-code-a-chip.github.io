.subckt hog inp inn out vbn vbp vbnc vbpc VDD VSS
MXMm1 e1 c1 VSS VSS nfet_g5v0d10v5 w=3u l=0.5u
MXMm2 e2 c1 VSS VSS nfet_g5v0d10v5 w=3u l=0.5u
MXMcasn1 c1 vbnc e1 VSS nfet_g5v0d10v5 w=3u l=0.5u
MXMcasn2 s1_out vbnc e2 VSS nfet_g5v0d10v5 w=3u l=0.5u
MXMtail stail vbn VSS VSS nfet_g5v0d10v5 w=3.6u l=1u
MXMinb ndrv vbn VSS VSS nfet_g5v0d10v5 w=0.9u l=1u
MXMd1 d1 inn stail VSS nfet_g5v0d10v5 w=3u l=0.5u
MXMd2 d2 inp stail VSS nfet_g5v0d10v5 w=3u l=0.5u
MXMncs out ndrv VSS VSS nfet_g5v0d10v5 w=3u l=0.5u
MXMnls VDD s1_out ndrv VSS nfet_g5v0d10v5 w=3u l=0.5u
MXMpls VSS s1_out pdrv VDD pfet_g5v0d10v5 w=3u l=0.5u
MXMpcs out pdrv VDD VDD pfet_g5v0d10v5 w=5u l=0.5u
MXMipb pdrv vbp VDD VDD pfet_g5v0d10v5 w=2u l=0.8u
MXMcasp1 c1 vbpc d1 VDD pfet_g5v0d10v5 w=3u l=0.5u
MXMcasp2 s1_out vbpc d2 VDD pfet_g5v0d10v5 w=3u l=0.5u
MXMiref1 d1 vbp VDD VDD pfet_g5v0d10v5 w=8u l=0.8u
MXMiref2 d2 vbp VDD VDD pfet_g5v0d10v5 w=8u l=0.8u
MXDUM0 VSS VSS VSS VSS nfet_g5v0d10v5 w=0.75u l=0.5u
MXDUM1 VSS VSS VSS VSS nfet_g5v0d10v5 w=0.75u l=0.5u
MXDUM2 VSS VSS VSS VSS nfet_g5v0d10v5 w=0.75u l=0.5u
MXDUM3 VSS VSS VSS VSS nfet_g5v0d10v5 w=0.75u l=0.5u
MXDUM4 stail stail stail VSS nfet_g5v0d10v5 w=0.75u l=0.5u
MXDUM5 stail stail stail VSS nfet_g5v0d10v5 w=0.75u l=0.5u
MXDUM6 stail stail stail VSS nfet_g5v0d10v5 w=0.75u l=0.5u
MXDUM7 stail stail stail VSS nfet_g5v0d10v5 w=0.75u l=0.5u
MXDUM8 VDD VDD VDD VDD pfet_g5v0d10v5 w=2u l=0.8u
MXDUM9 VDD VDD VDD VDD pfet_g5v0d10v5 w=2u l=0.8u
MXDUM10 VDD VDD VDD VDD pfet_g5v0d10v5 w=2u l=0.8u
MXDUM11 VDD VDD VDD VDD pfet_g5v0d10v5 w=2u l=0.8u
CCc s1_out cmid cap_mim_m3__base w=6.030u l=8.040u
RRz cmid out $SUB=VSS $[res_xhigh_po_0p35] w=0.350u l=0.680u
.ends hog
