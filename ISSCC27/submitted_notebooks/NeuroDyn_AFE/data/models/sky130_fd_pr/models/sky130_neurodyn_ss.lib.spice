* NeuroDyn-AFE reduced SKY130 TT model wrapper.
* Source: google/skywater-pdk-libs-sky130_fd_pr
* Commit: f62031a1be9aefe902d6d54cddd6f59b57627436
* This wrapper includes only the four devices instantiated by the project.
.param mc_mm_switch=0
.param mc_pr_switch=0
.param sky130_fd_pr__nfet_01v8__toxe_slope=0
.param sky130_fd_pr__pfet_01v8__toxe_slope=0
.param sky130_fd_pr__pfet_01v8__toxe_slope1=0
.param sky130_fd_pr__nfet_01v8_lvt__toxe_slope=0
.param sky130_fd_pr__nfet_01v8_lvt__toxe_slope1=0
.param sky130_fd_pr__nfet_01v8_lvt__vth0_slope=0
.param sky130_fd_pr__nfet_01v8_lvt__vth0_slope2=0
.param sky130_fd_pr__nfet_01v8_lvt__voff_slope=0
.param sky130_fd_pr__nfet_01v8_lvt__nfactor_slope=0
.param sky130_fd_pr__pfet_01v8_lvt__toxe_slope=0
.param sky130_fd_pr__pfet_01v8_lvt__toxe_slope2=0
.param sky130_fd_pr__pfet_01v8_lvt__toxe_slope3=0
.param sky130_fd_pr__pfet_01v8_lvt__vth0_slope=0
.param sky130_fd_pr__pfet_01v8_lvt__vth0_slope1=0
.param sky130_fd_pr__pfet_01v8_lvt__vth0_slope2=0
.param sky130_fd_pr__pfet_01v8_lvt__voff_slope=0
.param sky130_fd_pr__pfet_01v8_lvt__nfactor_slope=0
.include "parameters/critical.spice"
.include "parameters/lod.spice"
.include "parameters/slow.spice"
.include "../cells/nfet_01v8/sky130_fd_pr__nfet_01v8__tt.corner.spice"
.include "../cells/nfet_01v8_lvt/sky130_fd_pr__nfet_01v8_lvt__tt.corner.spice"
.include "../cells/pfet_01v8/sky130_fd_pr__pfet_01v8__tt.corner.spice"
.include "../cells/pfet_01v8_lvt/sky130_fd_pr__pfet_01v8_lvt__tt.corner.spice"
