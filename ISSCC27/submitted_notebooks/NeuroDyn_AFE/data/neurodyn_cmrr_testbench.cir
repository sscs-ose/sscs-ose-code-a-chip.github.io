* CMRR Testbench for NeuroDyn OTA (Common-Mode AC Excitation)
.include "C:/sscs-ose-code-a-chip.github.io/ISSCC27/submitted_notebooks/NeuroDyn_AFE/data/models/sky130_fd_pr/models/sky130_neurodyn_tt.lib.spice"

.option noacct method=gear

* NeuroDyn-AFE Dynamic Operational Transconductance Amplifier (OTA)
* SkyWater SKY130 130nm Process (sky130_fd_pr__nfet_01v8_lvt, sky130_fd_pr__pfet_01v8_lvt)
.subckt neurodyn_ota inp inm outp outm vdd vss vbn_tail vbp vaux_p vaux_n vbn_out

* Tail Current Source (Vbn_tail = 0.36V, Vds >= 75mV >= 3*U_T for weak-inversion saturation)
XM_tail tail vbn_tail vss vss sky130_fd_pr__nfet_01v8_lvt W=10.15u L=2.0u mult=2

* Main Input Differential Pair (2nd-Order Optimal Common-Centroid [D,A,B,B,A,B,A,A,B,D])
XM1 nodep inp tail vss sky130_fd_pr__nfet_01v8_lvt W=20.00u L=2.00u mult=4
XM2 noden inm tail vss sky130_fd_pr__nfet_01v8_lvt W=20.00u L=2.00u mult=4

* Auxiliary Differential Pair for Ripple Reduction Loop (RRL) (1/10th Sized for Fine Steering)
XM1_aux nodep vaux_p tail vss sky130_fd_pr__nfet_01v8_lvt W=2.00u L=2.00u mult=1
XM2_aux noden vaux_n tail vss sky130_fd_pr__nfet_01v8_lvt W=2.00u L=2.00u mult=1

* Active PMOS load with Low-Vt to prevent headroom pinch-off under 0.60V VDD
XM3 nodep vbp_cmfb vdd vdd sky130_fd_pr__pfet_01v8_lvt W=8.00u L=3.50u mult=4
XM4 noden vbp_cmfb vdd vdd sky130_fd_pr__pfet_01v8_lvt W=8.00u L=3.50u mult=4

* Continuous-Time Resistive Common-Mode Sensing Network (50 MEG) with Clamped CMFB VCVS
R_cm1 nodep vcm_sense 50MEG
R_cm2 noden vcm_sense 50MEG
E_cmfb vbp_cmfb_raw 0 VOL='min(0.55, max(0.05, V(vbp) + 15.0*(V(vcm_sense) - 0.30)))'
R_cmfb vbp_cmfb_raw vbp_cmfb 10k
C_cmfb vbp_cmfb 0 10p

* Miller Frequency Compensation Capacitors
C_c1 noden outp 1.2p
C_c2 nodep outm 1.2p

* Second gain stage (common-source output conversion with Low-Vt PMOS and Low-Vt NMOS loads)
* Sized for I_stage2 = 0.20 uA under Vbn_out = 0.2605V
XM5 outp noden vdd vdd sky130_fd_pr__pfet_01v8_lvt W=8.00u L=3.50u mult=4
XM6 outp vbn_out vss vss sky130_fd_pr__nfet_01v8_lvt W=10.15u L=2.0u mult=2

XM7 outm nodep vdd vdd sky130_fd_pr__pfet_01v8_lvt W=8.00u L=3.50u mult=4
XM8 outm vbn_out vss vss sky130_fd_pr__nfet_01v8_lvt W=10.15u L=2.0u mult=2

.ends neurodyn_ota

Vdd vdd 0 DC 0.6
Vss vss 0 DC 0
Vbn_tail vbn_tail 0 DC 0.36
Vbp vbp 0 DC 0.24
Vbn_out vbn_out 0 DC 0.2605

* Common-Mode Excitation: 1.0 V AC on both inputs simultaneously
Vin_cm in_cm 0 DC 0.4 AC 1.0
R_inp in_cm inp 1
R_inm in_cm inm 1

Vauxp vaux_p 0 DC 0
Vauxn vaux_n 0 DC 0

XDUT inp inm outp outm vdd vss vbn_tail vbp vaux_p vaux_n vbn_out neurodyn_ota
E_outdiff outdiff 0 VOL='V(outp) - V(outm)'
CL1 outp vss 5p
CL2 outm vss 5p

.control
set filetype=ascii
ac dec 20 1 10meg
write cmrr_results.raw v(outdiff) v(outp) v(outm) v(in_cm)
.endc
.end
