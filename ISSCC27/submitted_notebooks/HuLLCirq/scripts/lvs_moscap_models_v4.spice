* Qualified one-contiguous-SD MOSCAP representation; no device is removed.
* Parameters come from geometric extraction, not the comparison netlist.
.subckt hullcirq_moscap_nfet_v4 SD G B w=0 l=0 as=0 ps=0 ad=0 pd=0
X0 SD G SD B sky130_fd_pr__nfet_01v8 w={w} l={l} as={as} ps={ps} ad={ad} pd={pd}
.ends hullcirq_moscap_nfet_v4
.subckt hullcirq_moscap_pfet_v4 SD G B w=0 l=0 as=0 ps=0 ad=0 pd=0
X0 SD G SD B sky130_fd_pr__pfet_01v8_hvt w={w} l={l} as={as} ps={ps} ad={ad} pd={pd}
.ends hullcirq_moscap_pfet_v4
