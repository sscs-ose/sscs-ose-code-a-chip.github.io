* NGSPICE file created from vga_core_12t_flat.ext - technology: sky130A

.subckt vga_core_12t vdd gnd vin_p vin_n iref vctrl_p vctrl_n v_out
X0 net5 vin_p net2 gnd sky130_fd_pr__nfet_01v8 ad=0.825 pd=5.33 as=0.825 ps=5.33 w=5 l=8
X1 vdd net4 v_out vdd sky130_fd_pr__pfet_01v8 ad=1.95 pd=10.78 as=0.825 ps=5.33 w=5 l=2
X2 net4 net4 vdd vdd sky130_fd_pr__pfet_01v8 ad=0.825 pd=5.33 as=0.825 ps=5.33 w=5 l=2
X3 net5 vin_p net2 gnd sky130_fd_pr__nfet_01v8 ad=0.825 pd=5.33 as=0.825 ps=5.33 w=5 l=8
X4 net3 vin_n net5 gnd sky130_fd_pr__nfet_01v8 ad=0.825 pd=5.33 as=0.825 ps=5.33 w=5 l=8
X5 net5 vin_p net2 gnd sky130_fd_pr__nfet_01v8 ad=0.825 pd=5.33 as=0.825 ps=5.33 w=5 l=8
X6 net2 vin_p net5 gnd sky130_fd_pr__nfet_01v8 ad=0.825 pd=5.33 as=0.825 ps=5.33 w=5 l=8
X7 net5 vin_n net3 gnd sky130_fd_pr__nfet_01v8 ad=0.825 pd=5.33 as=0.825 ps=5.33 w=5 l=8
X8 net5 vin_n net3 gnd sky130_fd_pr__nfet_01v8 ad=0.825 pd=5.33 as=0.825 ps=5.33 w=5 l=8
X9 net5 vin_p net2 gnd sky130_fd_pr__nfet_01v8 ad=0.825 pd=5.33 as=0.825 ps=5.33 w=5 l=8
X10 vdd net4 v_out vdd sky130_fd_pr__pfet_01v8 ad=0.825 pd=5.33 as=0.825 ps=5.33 w=5 l=2
X11 net3 vin_n net5 gnd sky130_fd_pr__nfet_01v8 ad=0.825 pd=5.33 as=0.825 ps=5.33 w=5 l=8
X12 net5 vin_n net3 gnd sky130_fd_pr__nfet_01v8 ad=0.825 pd=5.33 as=0.825 ps=5.33 w=5 l=8
X13 net5 vin_n net3 gnd sky130_fd_pr__nfet_01v8 ad=0.825 pd=5.33 as=0.825 ps=5.33 w=5 l=8
X14 net5 vin_n net3 gnd sky130_fd_pr__nfet_01v8 ad=0.825 pd=5.33 as=0.825 ps=5.33 w=5 l=8
X15 net5 vin_n net3 gnd sky130_fd_pr__nfet_01v8 ad=0.825 pd=5.33 as=0.825 ps=5.33 w=5 l=8
X16 v_out net4 vdd vdd sky130_fd_pr__pfet_01v8 ad=0.825 pd=5.33 as=0.825 ps=5.33 w=5 l=2
X17 net5 vin_p net2 gnd sky130_fd_pr__nfet_01v8 ad=1.95 pd=10.78 as=0.825 ps=5.33 w=5 l=8
X18 vdd net4 net4 vdd sky130_fd_pr__pfet_01v8 ad=0.825 pd=5.33 as=0.825 ps=5.33 w=5 l=2
X19 net3 vctrl_p v_out gnd sky130_fd_pr__nfet_01v8 ad=0.825 pd=5.33 as=0.825 ps=5.33 w=5 l=2
X20 net4 net4 vdd vdd sky130_fd_pr__pfet_01v8 ad=0.825 pd=5.33 as=1.95 ps=10.78 w=5 l=2
X21 vdd net4 v_out vdd sky130_fd_pr__pfet_01v8 ad=0.825 pd=5.33 as=0.825 ps=5.33 w=5 l=2
X22 vdd net4 net4 vdd sky130_fd_pr__pfet_01v8 ad=0.825 pd=5.33 as=0.825 ps=5.33 w=5 l=2
X23 net3 vin_n net5 gnd sky130_fd_pr__nfet_01v8 ad=0.825 pd=5.33 as=0.825 ps=5.33 w=5 l=8
X24 net4 iref gnd gnd sky130_fd_pr__nfet_01v8 ad=1.95 pd=10.78 as=1.95 ps=10.78 w=5 l=4
X25 net2 vin_p net5 gnd sky130_fd_pr__nfet_01v8 ad=0.825 pd=5.33 as=0.825 ps=5.33 w=5 l=8
X26 net2 vin_p net5 gnd sky130_fd_pr__nfet_01v8 ad=0.825 pd=5.33 as=1.95 ps=10.78 w=5 l=8
X27 net2 vin_p net5 gnd sky130_fd_pr__nfet_01v8 ad=0.825 pd=5.33 as=0.825 ps=5.33 w=5 l=8
X28 net2 vin_p net5 gnd sky130_fd_pr__nfet_01v8 ad=0.825 pd=5.33 as=0.825 ps=5.33 w=5 l=8
X29 net5 vin_n net3 gnd sky130_fd_pr__nfet_01v8 ad=0.825 pd=5.33 as=0.825 ps=5.33 w=5 l=8
X30 vdd net4 v_out vdd sky130_fd_pr__pfet_01v8 ad=0.825 pd=5.33 as=0.825 ps=5.33 w=5 l=2
X31 vdd net4 net4 vdd sky130_fd_pr__pfet_01v8 ad=0.825 pd=5.33 as=0.825 ps=5.33 w=5 l=2
X32 net2 vin_p net5 gnd sky130_fd_pr__nfet_01v8 ad=0.825 pd=5.33 as=0.825 ps=5.33 w=5 l=8
X33 vdd net4 v_out vdd sky130_fd_pr__pfet_01v8 ad=0.825 pd=5.33 as=0.825 ps=5.33 w=5 l=2
X34 net5 vin_p net2 gnd sky130_fd_pr__nfet_01v8 ad=0.825 pd=5.33 as=0.825 ps=5.33 w=5 l=8
X35 net4 net4 vdd vdd sky130_fd_pr__pfet_01v8 ad=0.825 pd=5.33 as=0.825 ps=5.33 w=5 l=2
X36 net3 vin_n net5 gnd sky130_fd_pr__nfet_01v8 ad=0.825 pd=5.33 as=0.825 ps=5.33 w=5 l=8
X37 net5 vin_p net2 gnd sky130_fd_pr__nfet_01v8 ad=0.825 pd=5.33 as=0.825 ps=5.33 w=5 l=8
X38 net2 vin_p net5 gnd sky130_fd_pr__nfet_01v8 ad=0.825 pd=5.33 as=1.95 ps=10.78 w=5 l=8
X39 net5 vin_n net3 gnd sky130_fd_pr__nfet_01v8 ad=0.825 pd=5.33 as=0.825 ps=5.33 w=5 l=8
X40 gnd gnd gnd gnd sky130_fd_pr__nfet_01v8 ad=1.95 pd=10.78 as=144.3 ps=797.71997 w=5 l=2
X41 vdd net4 v_out vdd sky130_fd_pr__pfet_01v8 ad=0.825 pd=5.33 as=0.825 ps=5.33 w=5 l=2
X42 net4 net4 vdd vdd sky130_fd_pr__pfet_01v8 ad=0.825 pd=5.33 as=1.95 ps=10.78 w=5 l=2
X43 net5 vin_p net2 gnd sky130_fd_pr__nfet_01v8 ad=0.825 pd=5.33 as=0.825 ps=5.33 w=5 l=8
X44 v_out net4 vdd vdd sky130_fd_pr__pfet_01v8 ad=0.825 pd=5.33 as=1.95 ps=10.78 w=5 l=2
X45 net3 vin_n net5 gnd sky130_fd_pr__nfet_01v8 ad=0.825 pd=5.33 as=0.825 ps=5.33 w=5 l=8
X46 v_out iref gnd gnd sky130_fd_pr__nfet_01v8 ad=1.95 pd=10.78 as=1.95 ps=10.78 w=5 l=4
X47 net3 vin_n net5 gnd sky130_fd_pr__nfet_01v8 ad=0.825 pd=5.33 as=0.825 ps=5.33 w=5 l=8
X48 net3 vin_n net5 gnd sky130_fd_pr__nfet_01v8 ad=0.825 pd=5.33 as=0.825 ps=5.33 w=5 l=8
X49 v_out net4 vdd vdd sky130_fd_pr__pfet_01v8 ad=0.825 pd=5.33 as=1.95 ps=10.78 w=5 l=2
X50 net5 vin_n net3 gnd sky130_fd_pr__nfet_01v8 ad=1.95 pd=10.78 as=0.825 ps=5.33 w=5 l=8
X51 net4 net4 vdd vdd sky130_fd_pr__pfet_01v8 ad=0.825 pd=5.33 as=1.95 ps=10.78 w=5 l=2
X52 vdd net4 net4 vdd sky130_fd_pr__pfet_01v8 ad=0.825 pd=5.33 as=0.825 ps=5.33 w=5 l=2
X53 v_out net4 vdd vdd sky130_fd_pr__pfet_01v8 ad=0.825 pd=5.33 as=1.95 ps=10.78 w=5 l=2
X54 net3 vin_n net5 gnd sky130_fd_pr__nfet_01v8 ad=0.825 pd=5.33 as=0.825 ps=5.33 w=5 l=8
X55 vdd net4 net4 vdd sky130_fd_pr__pfet_01v8 ad=1.95 pd=10.78 as=0.825 ps=5.33 w=5 l=2
X56 net3 vin_n net5 gnd sky130_fd_pr__nfet_01v8 ad=0.825 pd=5.33 as=0.825 ps=5.33 w=5 l=8
X57 vdd net4 net4 vdd sky130_fd_pr__pfet_01v8 ad=0.825 pd=5.33 as=0.825 ps=5.33 w=5 l=2
X58 net5 vin_n net3 gnd sky130_fd_pr__nfet_01v8 ad=1.95 pd=10.78 as=0.825 ps=5.33 w=5 l=8
X59 vdd net4 v_out vdd sky130_fd_pr__pfet_01v8 ad=0.825 pd=5.33 as=0.825 ps=5.33 w=5 l=2
X60 net2 vin_p net5 gnd sky130_fd_pr__nfet_01v8 ad=0.825 pd=5.33 as=1.95 ps=10.78 w=5 l=8
X61 net3 vin_n net5 gnd sky130_fd_pr__nfet_01v8 ad=0.825 pd=5.33 as=0.825 ps=5.33 w=5 l=8
X62 net5 vin_n net3 gnd sky130_fd_pr__nfet_01v8 ad=0.825 pd=5.33 as=0.825 ps=5.33 w=5 l=8
X63 net5 vin_n net3 gnd sky130_fd_pr__nfet_01v8 ad=0.825 pd=5.33 as=0.825 ps=5.33 w=5 l=8
X64 net2 vin_p net5 gnd sky130_fd_pr__nfet_01v8 ad=0.825 pd=5.33 as=0.825 ps=5.33 w=5 l=8
X65 vdd net4 v_out vdd sky130_fd_pr__pfet_01v8 ad=1.95 pd=10.78 as=0.825 ps=5.33 w=5 l=2
X66 net3 vin_n net5 gnd sky130_fd_pr__nfet_01v8 ad=0.825 pd=5.33 as=1.95 ps=10.78 w=5 l=8
X67 vdd net4 v_out vdd sky130_fd_pr__pfet_01v8 ad=0.825 pd=5.33 as=0.825 ps=5.33 w=5 l=2
X68 net3 vin_n net5 gnd sky130_fd_pr__nfet_01v8 ad=0.825 pd=5.33 as=0.825 ps=5.33 w=5 l=8
X69 net3 vin_n net5 gnd sky130_fd_pr__nfet_01v8 ad=0.825 pd=5.33 as=0.825 ps=5.33 w=5 l=8
X70 net4 net4 vdd vdd sky130_fd_pr__pfet_01v8 ad=0.825 pd=5.33 as=0.825 ps=5.33 w=5 l=2
X71 net5 vin_p net2 gnd sky130_fd_pr__nfet_01v8 ad=0.825 pd=5.33 as=0.825 ps=5.33 w=5 l=8
X72 v_out net4 vdd vdd sky130_fd_pr__pfet_01v8 ad=0.825 pd=5.33 as=0.825 ps=5.33 w=5 l=2
X73 net5 vin_n net3 gnd sky130_fd_pr__nfet_01v8 ad=0.825 pd=5.33 as=0.825 ps=5.33 w=5 l=8
X74 gnd gnd gnd gnd sky130_fd_pr__nfet_01v8 ad=1.95 pd=10.78 as=0 ps=0 w=5 l=8
X75 net2 vin_p net5 gnd sky130_fd_pr__nfet_01v8 ad=0.825 pd=5.33 as=0.825 ps=5.33 w=5 l=8
X76 v_out net4 vdd vdd sky130_fd_pr__pfet_01v8 ad=0.825 pd=5.33 as=0.825 ps=5.33 w=5 l=2
X77 net2 vin_p net5 gnd sky130_fd_pr__nfet_01v8 ad=0.825 pd=5.33 as=0.825 ps=5.33 w=5 l=8
X78 net5 vin_p net2 gnd sky130_fd_pr__nfet_01v8 ad=0.825 pd=5.33 as=0.825 ps=5.33 w=5 l=8
X79 net5 vin_n net3 gnd sky130_fd_pr__nfet_01v8 ad=0.825 pd=5.33 as=0.825 ps=5.33 w=5 l=8
X80 net2 vin_p net5 gnd sky130_fd_pr__nfet_01v8 ad=0.825 pd=5.33 as=0.825 ps=5.33 w=5 l=8
X81 net2 vin_p net5 gnd sky130_fd_pr__nfet_01v8 ad=0.825 pd=5.33 as=0.825 ps=5.33 w=5 l=8
X82 net5 vin_p net2 gnd sky130_fd_pr__nfet_01v8 ad=0.825 pd=5.33 as=0.825 ps=5.33 w=5 l=8
X83 vdd net4 v_out vdd sky130_fd_pr__pfet_01v8 ad=0.825 pd=5.33 as=0.825 ps=5.33 w=5 l=2
X84 net5 vin_p net2 gnd sky130_fd_pr__nfet_01v8 ad=0.825 pd=5.33 as=0.825 ps=5.33 w=5 l=8
X85 vdd net4 net4 vdd sky130_fd_pr__pfet_01v8 ad=0.825 pd=5.33 as=0.825 ps=5.33 w=5 l=2
X86 net5 vin_n net3 gnd sky130_fd_pr__nfet_01v8 ad=0.825 pd=5.33 as=0.825 ps=5.33 w=5 l=8
X87 net2 vin_p net5 gnd sky130_fd_pr__nfet_01v8 ad=0.825 pd=5.33 as=0.825 ps=5.33 w=5 l=8
X88 vdd net4 net4 vdd sky130_fd_pr__pfet_01v8 ad=1.95 pd=10.78 as=0.825 ps=5.33 w=5 l=2
X89 net5 vin_p net2 gnd sky130_fd_pr__nfet_01v8 ad=0.825 pd=5.33 as=0.825 ps=5.33 w=5 l=8
X90 net5 vin_p net2 gnd sky130_fd_pr__nfet_01v8 ad=0.825 pd=5.33 as=0.825 ps=5.33 w=5 l=8
X91 net4 vctrl_p net2 gnd sky130_fd_pr__nfet_01v8 ad=0.825 pd=5.33 as=0.825 ps=5.33 w=5 l=2
X92 net5 vin_n net3 gnd sky130_fd_pr__nfet_01v8 ad=0.825 pd=5.33 as=0.825 ps=5.33 w=5 l=8
X93 net5 vin_n net3 gnd sky130_fd_pr__nfet_01v8 ad=0.825 pd=5.33 as=0.825 ps=5.33 w=5 l=8
X94 net4 net4 vdd vdd sky130_fd_pr__pfet_01v8 ad=0.825 pd=5.33 as=0.825 ps=5.33 w=5 l=2
X95 net4 net4 vdd vdd sky130_fd_pr__pfet_01v8 ad=0.825 pd=5.33 as=0.825 ps=5.33 w=5 l=2
X96 net5 vin_n net3 gnd sky130_fd_pr__nfet_01v8 ad=0.825 pd=5.33 as=0.825 ps=5.33 w=5 l=8
X97 vdd net4 v_out vdd sky130_fd_pr__pfet_01v8 ad=0.825 pd=5.33 as=0.825 ps=5.33 w=5 l=2
X98 net5 vin_n net3 gnd sky130_fd_pr__nfet_01v8 ad=1.95 pd=10.78 as=0.825 ps=5.33 w=5 l=8
X99 vdd vdd vdd vdd sky130_fd_pr__pfet_01v8 ad=1.95 pd=10.78 as=204 ps=1.2016k w=5 l=2
X100 vdd net4 v_out vdd sky130_fd_pr__pfet_01v8 ad=0.825 pd=5.33 as=0.825 ps=5.33 w=5 l=2
X101 gnd gnd gnd gnd sky130_fd_pr__nfet_01v8 ad=1.95 pd=10.78 as=0 ps=0 w=5 l=8
X102 net5 iref gnd gnd sky130_fd_pr__nfet_01v8 ad=1.95 pd=10.78 as=1.95 ps=10.78 w=5 l=4
X103 net4 net4 vdd vdd sky130_fd_pr__pfet_01v8 ad=0.825 pd=5.33 as=0.825 ps=5.33 w=5 l=2
X104 net3 vin_n net5 gnd sky130_fd_pr__nfet_01v8 ad=0.825 pd=5.33 as=0.825 ps=5.33 w=5 l=8
X105 net3 vin_n net5 gnd sky130_fd_pr__nfet_01v8 ad=0.825 pd=5.33 as=0.825 ps=5.33 w=5 l=8
X106 net5 vin_n net3 gnd sky130_fd_pr__nfet_01v8 ad=0.825 pd=5.33 as=0.825 ps=5.33 w=5 l=8
X107 vdd net4 net4 vdd sky130_fd_pr__pfet_01v8 ad=0.825 pd=5.33 as=0.825 ps=5.33 w=5 l=2
X108 net5 vin_n net3 gnd sky130_fd_pr__nfet_01v8 ad=0.825 pd=5.33 as=0.825 ps=5.33 w=5 l=8
X109 v_out net4 vdd vdd sky130_fd_pr__pfet_01v8 ad=0.825 pd=5.33 as=0.825 ps=5.33 w=5 l=2
X110 net5 vin_n net3 gnd sky130_fd_pr__nfet_01v8 ad=0.825 pd=5.33 as=0.825 ps=5.33 w=5 l=8
X111 net3 vin_n net5 gnd sky130_fd_pr__nfet_01v8 ad=0.825 pd=5.33 as=0.825 ps=5.33 w=5 l=8
X112 net5 vin_n net3 gnd sky130_fd_pr__nfet_01v8 ad=0.825 pd=5.33 as=0.825 ps=5.33 w=5 l=8
X113 net5 vin_n net3 gnd sky130_fd_pr__nfet_01v8 ad=0.825 pd=5.33 as=0.825 ps=5.33 w=5 l=8
X114 net4 net4 vdd vdd sky130_fd_pr__pfet_01v8 ad=0.825 pd=5.33 as=0.825 ps=5.33 w=5 l=2
X115 net3 vin_n net5 gnd sky130_fd_pr__nfet_01v8 ad=0.825 pd=5.33 as=1.95 ps=10.78 w=5 l=8
X116 net4 vctrl_p net2 gnd sky130_fd_pr__nfet_01v8 ad=0.825 pd=5.33 as=1.95 ps=10.78 w=5 l=2
X117 net5 vin_p net2 gnd sky130_fd_pr__nfet_01v8 ad=0.825 pd=5.33 as=0.825 ps=5.33 w=5 l=8
X118 vdd net4 net4 vdd sky130_fd_pr__pfet_01v8 ad=0.825 pd=5.33 as=0.825 ps=5.33 w=5 l=2
X119 vdd vctrl_n net2 gnd sky130_fd_pr__nfet_01v8 ad=0.825 pd=5.33 as=1.95 ps=10.78 w=5 l=2
X120 net5 vin_n net3 gnd sky130_fd_pr__nfet_01v8 ad=0.825 pd=5.33 as=0.825 ps=5.33 w=5 l=8
X121 net2 vin_p net5 gnd sky130_fd_pr__nfet_01v8 ad=0.825 pd=5.33 as=0.825 ps=5.33 w=5 l=8
X122 gnd gnd gnd gnd sky130_fd_pr__nfet_01v8 ad=1.95 pd=10.78 as=0 ps=0 w=5 l=2
X123 net5 vin_p net2 gnd sky130_fd_pr__nfet_01v8 ad=0.825 pd=5.33 as=0.825 ps=5.33 w=5 l=8
X124 net2 vin_p net5 gnd sky130_fd_pr__nfet_01v8 ad=0.825 pd=5.33 as=0.825 ps=5.33 w=5 l=8
X125 vdd vdd vdd vdd sky130_fd_pr__pfet_01v8 ad=1.95 pd=10.78 as=0 ps=0 w=5 l=2
X126 net2 vin_p net5 gnd sky130_fd_pr__nfet_01v8 ad=0.825 pd=5.33 as=0.825 ps=5.33 w=5 l=8
X127 net5 vin_p net2 gnd sky130_fd_pr__nfet_01v8 ad=0.825 pd=5.33 as=0.825 ps=5.33 w=5 l=8
X128 net2 vin_p net5 gnd sky130_fd_pr__nfet_01v8 ad=0.825 pd=5.33 as=0.825 ps=5.33 w=5 l=8
X129 net5 vin_p net2 gnd sky130_fd_pr__nfet_01v8 ad=0.825 pd=5.33 as=0.825 ps=5.33 w=5 l=8
X130 net4 iref gnd gnd sky130_fd_pr__nfet_01v8 ad=1.95 pd=10.78 as=1.95 ps=10.78 w=5 l=4
X131 net5 vin_n net3 gnd sky130_fd_pr__nfet_01v8 ad=1.95 pd=10.78 as=0.825 ps=5.33 w=5 l=8
X132 vdd net4 v_out vdd sky130_fd_pr__pfet_01v8 ad=1.95 pd=10.78 as=0.825 ps=5.33 w=5 l=2
X133 net5 vin_n net3 gnd sky130_fd_pr__nfet_01v8 ad=1.95 pd=10.78 as=0.825 ps=5.33 w=5 l=8
X134 net2 vctrl_n vdd gnd sky130_fd_pr__nfet_01v8 ad=1.95 pd=10.78 as=0.825 ps=5.33 w=5 l=2
X135 net2 vin_p net5 gnd sky130_fd_pr__nfet_01v8 ad=0.825 pd=5.33 as=0.825 ps=5.33 w=5 l=8
X136 net2 vctrl_p net4 gnd sky130_fd_pr__nfet_01v8 ad=0.825 pd=5.33 as=0.825 ps=5.33 w=5 l=2
X137 vdd net4 v_out vdd sky130_fd_pr__pfet_01v8 ad=0.825 pd=5.33 as=0.825 ps=5.33 w=5 l=2
X138 vdd net4 net4 vdd sky130_fd_pr__pfet_01v8 ad=0.825 pd=5.33 as=0.825 ps=5.33 w=5 l=2
X139 net3 vin_n net5 gnd sky130_fd_pr__nfet_01v8 ad=0.825 pd=5.33 as=0.825 ps=5.33 w=5 l=8
X140 net2 vin_p net5 gnd sky130_fd_pr__nfet_01v8 ad=0.825 pd=5.33 as=0.825 ps=5.33 w=5 l=8
X141 net3 vin_n net5 gnd sky130_fd_pr__nfet_01v8 ad=0.825 pd=5.33 as=0.825 ps=5.33 w=5 l=8
X142 net5 vin_p net2 gnd sky130_fd_pr__nfet_01v8 ad=0.825 pd=5.33 as=0.825 ps=5.33 w=5 l=8
X143 v_out net4 vdd vdd sky130_fd_pr__pfet_01v8 ad=0.825 pd=5.33 as=0.825 ps=5.33 w=5 l=2
X144 v_out vctrl_p net3 gnd sky130_fd_pr__nfet_01v8 ad=0.825 pd=5.33 as=0.825 ps=5.33 w=5 l=2
X145 vdd net4 net4 vdd sky130_fd_pr__pfet_01v8 ad=0.825 pd=5.33 as=0.825 ps=5.33 w=5 l=2
X146 gnd gnd gnd gnd sky130_fd_pr__nfet_01v8 ad=1.95 pd=10.78 as=0 ps=0 w=5 l=8
X147 v_out net4 vdd vdd sky130_fd_pr__pfet_01v8 ad=0.825 pd=5.33 as=0.825 ps=5.33 w=5 l=2
X148 net3 vin_n net5 gnd sky130_fd_pr__nfet_01v8 ad=0.825 pd=5.33 as=1.95 ps=10.78 w=5 l=8
X149 net4 net4 vdd vdd sky130_fd_pr__pfet_01v8 ad=0.825 pd=5.33 as=0.825 ps=5.33 w=5 l=2
X150 net5 vin_p net2 gnd sky130_fd_pr__nfet_01v8 ad=1.95 pd=10.78 as=0.825 ps=5.33 w=5 l=8
X151 net2 vctrl_n vdd gnd sky130_fd_pr__nfet_01v8 ad=1.95 pd=10.78 as=0.825 ps=5.33 w=5 l=2
X152 v_out net4 vdd vdd sky130_fd_pr__pfet_01v8 ad=0.825 pd=5.33 as=0.825 ps=5.33 w=5 l=2
X153 net3 vin_n net5 gnd sky130_fd_pr__nfet_01v8 ad=0.825 pd=5.33 as=0.825 ps=5.33 w=5 l=8
X154 net5 vin_p net2 gnd sky130_fd_pr__nfet_01v8 ad=0.825 pd=5.33 as=0.825 ps=5.33 w=5 l=8
X155 net4 iref gnd gnd sky130_fd_pr__nfet_01v8 ad=1.95 pd=10.78 as=1.95 ps=10.78 w=5 l=4
X156 net4 net4 vdd vdd sky130_fd_pr__pfet_01v8 ad=0.825 pd=5.33 as=0.825 ps=5.33 w=5 l=2
X157 vdd vdd vdd vdd sky130_fd_pr__pfet_01v8 ad=1.95 pd=10.78 as=0 ps=0 w=5 l=2
X158 net5 vin_n net3 gnd sky130_fd_pr__nfet_01v8 ad=0.825 pd=5.33 as=0.825 ps=5.33 w=5 l=8
X159 net3 vin_n net5 gnd sky130_fd_pr__nfet_01v8 ad=0.825 pd=5.33 as=0.825 ps=5.33 w=5 l=8
X160 net3 vin_n net5 gnd sky130_fd_pr__nfet_01v8 ad=0.825 pd=5.33 as=0.825 ps=5.33 w=5 l=8
X161 net5 vin_n net3 gnd sky130_fd_pr__nfet_01v8 ad=0.825 pd=5.33 as=0.825 ps=5.33 w=5 l=8
X162 net2 vin_p net5 gnd sky130_fd_pr__nfet_01v8 ad=0.825 pd=5.33 as=0.825 ps=5.33 w=5 l=8
X163 net2 vin_p net5 gnd sky130_fd_pr__nfet_01v8 ad=0.825 pd=5.33 as=0.825 ps=5.33 w=5 l=8
X164 net5 iref gnd gnd sky130_fd_pr__nfet_01v8 ad=1.95 pd=10.78 as=1.95 ps=10.78 w=5 l=4
X165 net5 vin_n net3 gnd sky130_fd_pr__nfet_01v8 ad=0.825 pd=5.33 as=0.825 ps=5.33 w=5 l=8
X166 vdd net4 net4 vdd sky130_fd_pr__pfet_01v8 ad=1.95 pd=10.78 as=0.825 ps=5.33 w=5 l=2
X167 vdd net4 v_out vdd sky130_fd_pr__pfet_01v8 ad=0.825 pd=5.33 as=0.825 ps=5.33 w=5 l=2
X168 net3 vin_n net5 gnd sky130_fd_pr__nfet_01v8 ad=0.825 pd=5.33 as=0.825 ps=5.33 w=5 l=8
X169 vdd net4 v_out vdd sky130_fd_pr__pfet_01v8 ad=0.825 pd=5.33 as=0.825 ps=5.33 w=5 l=2
X170 vdd net4 v_out vdd sky130_fd_pr__pfet_01v8 ad=0.825 pd=5.33 as=0.825 ps=5.33 w=5 l=2
X171 gnd gnd gnd gnd sky130_fd_pr__nfet_01v8 ad=1.95 pd=10.78 as=0 ps=0 w=5 l=8
X172 net5 vin_p net2 gnd sky130_fd_pr__nfet_01v8 ad=0.825 pd=5.33 as=0.825 ps=5.33 w=5 l=8
X173 net5 vin_n net3 gnd sky130_fd_pr__nfet_01v8 ad=0.825 pd=5.33 as=0.825 ps=5.33 w=5 l=8
X174 vdd net4 v_out vdd sky130_fd_pr__pfet_01v8 ad=0.825 pd=5.33 as=0.825 ps=5.33 w=5 l=2
X175 vdd net4 v_out vdd sky130_fd_pr__pfet_01v8 ad=1.95 pd=10.78 as=0.825 ps=5.33 w=5 l=2
X176 net5 vin_n net3 gnd sky130_fd_pr__nfet_01v8 ad=0.825 pd=5.33 as=0.825 ps=5.33 w=5 l=8
X177 net2 vin_p net5 gnd sky130_fd_pr__nfet_01v8 ad=0.825 pd=5.33 as=0.825 ps=5.33 w=5 l=8
X178 gnd gnd gnd gnd sky130_fd_pr__nfet_01v8 ad=1.95 pd=10.78 as=0 ps=0 w=5 l=8
X179 net5 vin_n net3 gnd sky130_fd_pr__nfet_01v8 ad=0.825 pd=5.33 as=0.825 ps=5.33 w=5 l=8
X180 vdd vctrl_n net3 gnd sky130_fd_pr__nfet_01v8 ad=0.825 pd=5.33 as=0.825 ps=5.33 w=5 l=2
X181 v_out net4 vdd vdd sky130_fd_pr__pfet_01v8 ad=0.825 pd=5.33 as=0.825 ps=5.33 w=5 l=2
X182 net5 vin_p net2 gnd sky130_fd_pr__nfet_01v8 ad=0.825 pd=5.33 as=0.825 ps=5.33 w=5 l=8
X183 v_out net4 vdd vdd sky130_fd_pr__pfet_01v8 ad=0.825 pd=5.33 as=0.825 ps=5.33 w=5 l=2
X184 net2 vctrl_p net4 gnd sky130_fd_pr__nfet_01v8 ad=0.825 pd=5.33 as=0.825 ps=5.33 w=5 l=2
X185 net4 net4 vdd vdd sky130_fd_pr__pfet_01v8 ad=0.825 pd=5.33 as=0.825 ps=5.33 w=5 l=2
X186 vdd net4 net4 vdd sky130_fd_pr__pfet_01v8 ad=0.825 pd=5.33 as=0.825 ps=5.33 w=5 l=2
X187 net4 net4 vdd vdd sky130_fd_pr__pfet_01v8 ad=0.825 pd=5.33 as=1.95 ps=10.78 w=5 l=2
X188 net5 vin_p net2 gnd sky130_fd_pr__nfet_01v8 ad=0.825 pd=5.33 as=0.825 ps=5.33 w=5 l=8
X189 net5 vin_n net3 gnd sky130_fd_pr__nfet_01v8 ad=1.95 pd=10.78 as=0.825 ps=5.33 w=5 l=8
X190 v_out net4 vdd vdd sky130_fd_pr__pfet_01v8 ad=0.825 pd=5.33 as=0.825 ps=5.33 w=5 l=2
X191 net5 vin_n net3 gnd sky130_fd_pr__nfet_01v8 ad=0.825 pd=5.33 as=0.825 ps=5.33 w=5 l=8
X192 net3 vin_n net5 gnd sky130_fd_pr__nfet_01v8 ad=0.825 pd=5.33 as=0.825 ps=5.33 w=5 l=8
X193 net4 net4 vdd vdd sky130_fd_pr__pfet_01v8 ad=0.825 pd=5.33 as=0.825 ps=5.33 w=5 l=2
X194 vdd vdd vdd vdd sky130_fd_pr__pfet_01v8 ad=1.95 pd=10.78 as=0 ps=0 w=5 l=2
X195 net2 vin_p net5 gnd sky130_fd_pr__nfet_01v8 ad=0.825 pd=5.33 as=0.825 ps=5.33 w=5 l=8
X196 net3 vctrl_p v_out gnd sky130_fd_pr__nfet_01v8 ad=0.825 pd=5.33 as=0.825 ps=5.33 w=5 l=2
X197 net2 vin_p net5 gnd sky130_fd_pr__nfet_01v8 ad=0.825 pd=5.33 as=0.825 ps=5.33 w=5 l=8
X198 net5 iref gnd gnd sky130_fd_pr__nfet_01v8 ad=1.95 pd=10.78 as=1.95 ps=10.78 w=5 l=4
X199 net5 iref gnd gnd sky130_fd_pr__nfet_01v8 ad=1.95 pd=10.78 as=1.95 ps=10.78 w=5 l=4
X200 net3 vin_n net5 gnd sky130_fd_pr__nfet_01v8 ad=0.825 pd=5.33 as=0.825 ps=5.33 w=5 l=8
X201 net5 vin_p net2 gnd sky130_fd_pr__nfet_01v8 ad=0.825 pd=5.33 as=0.825 ps=5.33 w=5 l=8
X202 net4 net4 vdd vdd sky130_fd_pr__pfet_01v8 ad=0.825 pd=5.33 as=0.825 ps=5.33 w=5 l=2
X203 v_out net4 vdd vdd sky130_fd_pr__pfet_01v8 ad=0.825 pd=5.33 as=0.825 ps=5.33 w=5 l=2
X204 net5 vin_p net2 gnd sky130_fd_pr__nfet_01v8 ad=0.825 pd=5.33 as=0.825 ps=5.33 w=5 l=8
X205 net5 vin_n net3 gnd sky130_fd_pr__nfet_01v8 ad=0.825 pd=5.33 as=0.825 ps=5.33 w=5 l=8
X206 vdd vctrl_n net2 gnd sky130_fd_pr__nfet_01v8 ad=0.825 pd=5.33 as=0.825 ps=5.33 w=5 l=2
X207 gnd gnd gnd gnd sky130_fd_pr__nfet_01v8 ad=1.95 pd=10.78 as=0 ps=0 w=5 l=8
X208 gnd gnd gnd gnd sky130_fd_pr__nfet_01v8 ad=1.95 pd=10.78 as=0 ps=0 w=5 l=8
X209 vdd vdd vdd vdd sky130_fd_pr__pfet_01v8 ad=1.95 pd=10.78 as=0 ps=0 w=5 l=2
X210 net5 vin_n net3 gnd sky130_fd_pr__nfet_01v8 ad=0.825 pd=5.33 as=0.825 ps=5.33 w=5 l=8
X211 net2 vin_p net5 gnd sky130_fd_pr__nfet_01v8 ad=0.825 pd=5.33 as=0.825 ps=5.33 w=5 l=8
X212 net3 vctrl_n vdd gnd sky130_fd_pr__nfet_01v8 ad=1.95 pd=10.78 as=0.825 ps=5.33 w=5 l=2
X213 net3 vin_n net5 gnd sky130_fd_pr__nfet_01v8 ad=0.825 pd=5.33 as=0.825 ps=5.33 w=5 l=8
X214 net5 vin_p net2 gnd sky130_fd_pr__nfet_01v8 ad=0.825 pd=5.33 as=0.825 ps=5.33 w=5 l=8
X215 net5 vin_p net2 gnd sky130_fd_pr__nfet_01v8 ad=0.825 pd=5.33 as=0.825 ps=5.33 w=5 l=8
X216 net2 vin_p net5 gnd sky130_fd_pr__nfet_01v8 ad=0.825 pd=5.33 as=0.825 ps=5.33 w=5 l=8
X217 net5 vin_p net2 gnd sky130_fd_pr__nfet_01v8 ad=0.825 pd=5.33 as=0.825 ps=5.33 w=5 l=8
X218 vdd vdd vdd vdd sky130_fd_pr__pfet_01v8 ad=1.95 pd=10.78 as=0 ps=0 w=5 l=2
X219 gnd gnd gnd gnd sky130_fd_pr__nfet_01v8 ad=1.95 pd=10.78 as=0 ps=0 w=5 l=4
X220 net2 vin_p net5 gnd sky130_fd_pr__nfet_01v8 ad=0.825 pd=5.33 as=0.825 ps=5.33 w=5 l=8
X221 net5 vin_n net3 gnd sky130_fd_pr__nfet_01v8 ad=0.825 pd=5.33 as=0.825 ps=5.33 w=5 l=8
X222 net3 vin_n net5 gnd sky130_fd_pr__nfet_01v8 ad=0.825 pd=5.33 as=0.825 ps=5.33 w=5 l=8
X223 vdd net4 net4 vdd sky130_fd_pr__pfet_01v8 ad=1.95 pd=10.78 as=0.825 ps=5.33 w=5 l=2
X224 vdd net4 net4 vdd sky130_fd_pr__pfet_01v8 ad=0.825 pd=5.33 as=0.825 ps=5.33 w=5 l=2
X225 net5 vin_n net3 gnd sky130_fd_pr__nfet_01v8 ad=0.825 pd=5.33 as=0.825 ps=5.33 w=5 l=8
X226 vdd net4 net4 vdd sky130_fd_pr__pfet_01v8 ad=1.95 pd=10.78 as=0.825 ps=5.33 w=5 l=2
X227 net5 iref gnd gnd sky130_fd_pr__nfet_01v8 ad=1.95 pd=10.78 as=1.95 ps=10.78 w=5 l=4
X228 v_out net4 vdd vdd sky130_fd_pr__pfet_01v8 ad=0.825 pd=5.33 as=0.825 ps=5.33 w=5 l=2
X229 net3 vctrl_n vdd gnd sky130_fd_pr__nfet_01v8 ad=0.825 pd=5.33 as=0.825 ps=5.33 w=5 l=2
X230 iref iref gnd gnd sky130_fd_pr__nfet_01v8 ad=1.95 pd=10.78 as=1.95 ps=10.78 w=5 l=4
X231 net3 vin_n net5 gnd sky130_fd_pr__nfet_01v8 ad=0.825 pd=5.33 as=0.825 ps=5.33 w=5 l=8
X232 net5 vin_n net3 gnd sky130_fd_pr__nfet_01v8 ad=0.825 pd=5.33 as=0.825 ps=5.33 w=5 l=8
X233 net4 net4 vdd vdd sky130_fd_pr__pfet_01v8 ad=0.825 pd=5.33 as=0.825 ps=5.33 w=5 l=2
X234 v_out net4 vdd vdd sky130_fd_pr__pfet_01v8 ad=0.825 pd=5.33 as=0.825 ps=5.33 w=5 l=2
X235 net3 vin_n net5 gnd sky130_fd_pr__nfet_01v8 ad=0.825 pd=5.33 as=1.95 ps=10.78 w=5 l=8
X236 gnd gnd gnd gnd sky130_fd_pr__nfet_01v8 ad=1.95 pd=10.78 as=0 ps=0 w=5 l=8
X237 net5 vin_p net2 gnd sky130_fd_pr__nfet_01v8 ad=0.825 pd=5.33 as=0.825 ps=5.33 w=5 l=8
X238 vdd vdd vdd vdd sky130_fd_pr__pfet_01v8 ad=1.95 pd=10.78 as=0 ps=0 w=5 l=2
X239 net3 vin_n net5 gnd sky130_fd_pr__nfet_01v8 ad=0.825 pd=5.33 as=0.825 ps=5.33 w=5 l=8
X240 net5 vin_n net3 gnd sky130_fd_pr__nfet_01v8 ad=0.825 pd=5.33 as=0.825 ps=5.33 w=5 l=8
X241 net3 vin_n net5 gnd sky130_fd_pr__nfet_01v8 ad=0.825 pd=5.33 as=0.825 ps=5.33 w=5 l=8
X242 net5 vin_n net3 gnd sky130_fd_pr__nfet_01v8 ad=1.95 pd=10.78 as=0.825 ps=5.33 w=5 l=8
X243 net3 vctrl_p v_out gnd sky130_fd_pr__nfet_01v8 ad=1.95 pd=10.78 as=0.825 ps=5.33 w=5 l=2
X244 net4 net4 vdd vdd sky130_fd_pr__pfet_01v8 ad=0.825 pd=5.33 as=0.825 ps=5.33 w=5 l=2
X245 net2 vin_p net5 gnd sky130_fd_pr__nfet_01v8 ad=0.825 pd=5.33 as=0.825 ps=5.33 w=5 l=8
X246 net5 vin_n net3 gnd sky130_fd_pr__nfet_01v8 ad=0.825 pd=5.33 as=0.825 ps=5.33 w=5 l=8
X247 net3 vin_n net5 gnd sky130_fd_pr__nfet_01v8 ad=0.825 pd=5.33 as=0.825 ps=5.33 w=5 l=8
X248 vdd vdd vdd vdd sky130_fd_pr__pfet_01v8 ad=1.95 pd=10.78 as=0 ps=0 w=5 l=2
X249 net3 vin_n net5 gnd sky130_fd_pr__nfet_01v8 ad=0.825 pd=5.33 as=0.825 ps=5.33 w=5 l=8
X250 net2 vin_p net5 gnd sky130_fd_pr__nfet_01v8 ad=0.825 pd=5.33 as=0.825 ps=5.33 w=5 l=8
X251 vdd net4 v_out vdd sky130_fd_pr__pfet_01v8 ad=0.825 pd=5.33 as=0.825 ps=5.33 w=5 l=2
X252 net3 vin_n net5 gnd sky130_fd_pr__nfet_01v8 ad=0.825 pd=5.33 as=0.825 ps=5.33 w=5 l=8
X253 net3 vin_n net5 gnd sky130_fd_pr__nfet_01v8 ad=0.825 pd=5.33 as=0.825 ps=5.33 w=5 l=8
X254 net5 vin_p net2 gnd sky130_fd_pr__nfet_01v8 ad=0.825 pd=5.33 as=0.825 ps=5.33 w=5 l=8
X255 net3 vin_n net5 gnd sky130_fd_pr__nfet_01v8 ad=0.825 pd=5.33 as=0.825 ps=5.33 w=5 l=8
X256 vdd net4 v_out vdd sky130_fd_pr__pfet_01v8 ad=1.95 pd=10.78 as=0.825 ps=5.33 w=5 l=2
X257 vdd vctrl_n net3 gnd sky130_fd_pr__nfet_01v8 ad=0.825 pd=5.33 as=0.825 ps=5.33 w=5 l=2
X258 vdd net4 net4 vdd sky130_fd_pr__pfet_01v8 ad=0.825 pd=5.33 as=0.825 ps=5.33 w=5 l=2
X259 v_out iref gnd gnd sky130_fd_pr__nfet_01v8 ad=1.95 pd=10.78 as=1.95 ps=10.78 w=5 l=4
X260 gnd gnd gnd gnd sky130_fd_pr__nfet_01v8 ad=1.95 pd=10.78 as=0 ps=0 w=5 l=8
X261 net5 iref gnd gnd sky130_fd_pr__nfet_01v8 ad=1.95 pd=10.78 as=1.95 ps=10.78 w=5 l=4
X262 net5 vin_n net3 gnd sky130_fd_pr__nfet_01v8 ad=0.825 pd=5.33 as=0.825 ps=5.33 w=5 l=8
X263 net5 vin_p net2 gnd sky130_fd_pr__nfet_01v8 ad=0.825 pd=5.33 as=0.825 ps=5.33 w=5 l=8
X264 net2 vin_p net5 gnd sky130_fd_pr__nfet_01v8 ad=0.825 pd=5.33 as=0.825 ps=5.33 w=5 l=8
X265 vdd net4 net4 vdd sky130_fd_pr__pfet_01v8 ad=0.825 pd=5.33 as=0.825 ps=5.33 w=5 l=2
X266 vdd net4 net4 vdd sky130_fd_pr__pfet_01v8 ad=1.95 pd=10.78 as=0.825 ps=5.33 w=5 l=2
X267 net5 vin_p net2 gnd sky130_fd_pr__nfet_01v8 ad=0.825 pd=5.33 as=0.825 ps=5.33 w=5 l=8
X268 net5 vin_p net2 gnd sky130_fd_pr__nfet_01v8 ad=0.825 pd=5.33 as=0.825 ps=5.33 w=5 l=8
X269 gnd gnd gnd gnd sky130_fd_pr__nfet_01v8 ad=1.95 pd=10.78 as=0 ps=0 w=5 l=2
X270 net5 vin_p net2 gnd sky130_fd_pr__nfet_01v8 ad=0.825 pd=5.33 as=0.825 ps=5.33 w=5 l=8
X271 net2 vin_p net5 gnd sky130_fd_pr__nfet_01v8 ad=0.825 pd=5.33 as=0.825 ps=5.33 w=5 l=8
X272 net5 vin_n net3 gnd sky130_fd_pr__nfet_01v8 ad=0.825 pd=5.33 as=0.825 ps=5.33 w=5 l=8
X273 net2 vin_p net5 gnd sky130_fd_pr__nfet_01v8 ad=0.825 pd=5.33 as=0.825 ps=5.33 w=5 l=8
X274 v_out net4 vdd vdd sky130_fd_pr__pfet_01v8 ad=0.825 pd=5.33 as=0.825 ps=5.33 w=5 l=2
X275 vdd net4 v_out vdd sky130_fd_pr__pfet_01v8 ad=0.825 pd=5.33 as=0.825 ps=5.33 w=5 l=2
X276 net2 vin_p net5 gnd sky130_fd_pr__nfet_01v8 ad=0.825 pd=5.33 as=0.825 ps=5.33 w=5 l=8
X277 v_out net4 vdd vdd sky130_fd_pr__pfet_01v8 ad=0.825 pd=5.33 as=0.825 ps=5.33 w=5 l=2
X278 net5 vin_p net2 gnd sky130_fd_pr__nfet_01v8 ad=1.95 pd=10.78 as=0.825 ps=5.33 w=5 l=8
X279 net5 vin_p net2 gnd sky130_fd_pr__nfet_01v8 ad=0.825 pd=5.33 as=0.825 ps=5.33 w=5 l=8
X280 gnd gnd gnd gnd sky130_fd_pr__nfet_01v8 ad=1.95 pd=10.78 as=0 ps=0 w=5 l=4
X281 v_out net4 vdd vdd sky130_fd_pr__pfet_01v8 ad=0.825 pd=5.33 as=0.825 ps=5.33 w=5 l=2
X282 vdd vdd vdd vdd sky130_fd_pr__pfet_01v8 ad=1.95 pd=10.78 as=0 ps=0 w=5 l=2
X283 net4 net4 vdd vdd sky130_fd_pr__pfet_01v8 ad=0.825 pd=5.33 as=1.95 ps=10.78 w=5 l=2
X284 net5 iref gnd gnd sky130_fd_pr__nfet_01v8 ad=1.95 pd=10.78 as=1.95 ps=10.78 w=5 l=4
X285 net2 vin_p net5 gnd sky130_fd_pr__nfet_01v8 ad=0.825 pd=5.33 as=0.825 ps=5.33 w=5 l=8
X286 net2 vin_p net5 gnd sky130_fd_pr__nfet_01v8 ad=0.825 pd=5.33 as=0.825 ps=5.33 w=5 l=8
X287 net5 vin_n net3 gnd sky130_fd_pr__nfet_01v8 ad=0.825 pd=5.33 as=0.825 ps=5.33 w=5 l=8
X288 net4 net4 vdd vdd sky130_fd_pr__pfet_01v8 ad=0.825 pd=5.33 as=0.825 ps=5.33 w=5 l=2
X289 net5 vin_n net3 gnd sky130_fd_pr__nfet_01v8 ad=0.825 pd=5.33 as=0.825 ps=5.33 w=5 l=8
X290 v_out vctrl_p net3 gnd sky130_fd_pr__nfet_01v8 ad=0.825 pd=5.33 as=0.825 ps=5.33 w=5 l=2
X291 net5 iref gnd gnd sky130_fd_pr__nfet_01v8 ad=1.95 pd=10.78 as=1.95 ps=10.78 w=5 l=4
X292 gnd gnd gnd gnd sky130_fd_pr__nfet_01v8 ad=1.95 pd=10.78 as=0 ps=0 w=5 l=8
X293 gnd gnd gnd gnd sky130_fd_pr__nfet_01v8 ad=1.95 pd=10.78 as=0 ps=0 w=5 l=8
X294 net5 vin_p net2 gnd sky130_fd_pr__nfet_01v8 ad=0.825 pd=5.33 as=0.825 ps=5.33 w=5 l=8
X295 vdd vdd vdd vdd sky130_fd_pr__pfet_01v8 ad=1.95 pd=10.78 as=0 ps=0 w=5 l=2
X296 vdd net4 net4 vdd sky130_fd_pr__pfet_01v8 ad=0.825 pd=5.33 as=0.825 ps=5.33 w=5 l=2
X297 net5 vin_n net3 gnd sky130_fd_pr__nfet_01v8 ad=0.825 pd=5.33 as=0.825 ps=5.33 w=5 l=8
X298 net3 vin_n net5 gnd sky130_fd_pr__nfet_01v8 ad=0.825 pd=5.33 as=0.825 ps=5.33 w=5 l=8
X299 net5 vin_n net3 gnd sky130_fd_pr__nfet_01v8 ad=0.825 pd=5.33 as=0.825 ps=5.33 w=5 l=8
X300 net5 vin_n net3 gnd sky130_fd_pr__nfet_01v8 ad=0.825 pd=5.33 as=0.825 ps=5.33 w=5 l=8
X301 net3 vin_n net5 gnd sky130_fd_pr__nfet_01v8 ad=0.825 pd=5.33 as=0.825 ps=5.33 w=5 l=8
X302 net5 vin_n net3 gnd sky130_fd_pr__nfet_01v8 ad=0.825 pd=5.33 as=0.825 ps=5.33 w=5 l=8
X303 vdd vdd vdd vdd sky130_fd_pr__pfet_01v8 ad=1.95 pd=10.78 as=0 ps=0 w=5 l=2
X304 net5 vin_p net2 gnd sky130_fd_pr__nfet_01v8 ad=0.825 pd=5.33 as=0.825 ps=5.33 w=5 l=8
X305 net3 vin_n net5 gnd sky130_fd_pr__nfet_01v8 ad=0.825 pd=5.33 as=0.825 ps=5.33 w=5 l=8
X306 vdd net4 v_out vdd sky130_fd_pr__pfet_01v8 ad=1.95 pd=10.78 as=0.825 ps=5.33 w=5 l=2
X307 net5 vin_p net2 gnd sky130_fd_pr__nfet_01v8 ad=0.825 pd=5.33 as=0.825 ps=5.33 w=5 l=8
X308 net5 vin_n net3 gnd sky130_fd_pr__nfet_01v8 ad=0.825 pd=5.33 as=0.825 ps=5.33 w=5 l=8
X309 net5 vin_n net3 gnd sky130_fd_pr__nfet_01v8 ad=0.825 pd=5.33 as=0.825 ps=5.33 w=5 l=8
X310 net4 net4 vdd vdd sky130_fd_pr__pfet_01v8 ad=0.825 pd=5.33 as=0.825 ps=5.33 w=5 l=2
X311 vdd net4 net4 vdd sky130_fd_pr__pfet_01v8 ad=0.825 pd=5.33 as=0.825 ps=5.33 w=5 l=2
X312 vdd net4 net4 vdd sky130_fd_pr__pfet_01v8 ad=0.825 pd=5.33 as=0.825 ps=5.33 w=5 l=2
X313 v_out net4 vdd vdd sky130_fd_pr__pfet_01v8 ad=0.825 pd=5.33 as=0.825 ps=5.33 w=5 l=2
X314 net3 vin_n net5 gnd sky130_fd_pr__nfet_01v8 ad=0.825 pd=5.33 as=1.95 ps=10.78 w=5 l=8
X315 net5 vin_p net2 gnd sky130_fd_pr__nfet_01v8 ad=1.95 pd=10.78 as=0.825 ps=5.33 w=5 l=8
X316 net2 vin_p net5 gnd sky130_fd_pr__nfet_01v8 ad=0.825 pd=5.33 as=0.825 ps=5.33 w=5 l=8
X317 net5 vin_p net2 gnd sky130_fd_pr__nfet_01v8 ad=0.825 pd=5.33 as=0.825 ps=5.33 w=5 l=8
X318 net3 vin_n net5 gnd sky130_fd_pr__nfet_01v8 ad=0.825 pd=5.33 as=0.825 ps=5.33 w=5 l=8
X319 net5 iref gnd gnd sky130_fd_pr__nfet_01v8 ad=1.95 pd=10.78 as=1.95 ps=10.78 w=5 l=4
X320 gnd gnd gnd gnd sky130_fd_pr__nfet_01v8 ad=1.95 pd=10.78 as=0 ps=0 w=5 l=2
X321 net5 vin_p net2 gnd sky130_fd_pr__nfet_01v8 ad=0.825 pd=5.33 as=0.825 ps=5.33 w=5 l=8
X322 v_out net4 vdd vdd sky130_fd_pr__pfet_01v8 ad=0.825 pd=5.33 as=0.825 ps=5.33 w=5 l=2
X323 net4 net4 vdd vdd sky130_fd_pr__pfet_01v8 ad=0.825 pd=5.33 as=0.825 ps=5.33 w=5 l=2
X324 net2 vin_p net5 gnd sky130_fd_pr__nfet_01v8 ad=0.825 pd=5.33 as=0.825 ps=5.33 w=5 l=8
X325 gnd gnd gnd gnd sky130_fd_pr__nfet_01v8 ad=1.95 pd=10.78 as=0 ps=0 w=5 l=8
X326 net2 vin_p net5 gnd sky130_fd_pr__nfet_01v8 ad=0.825 pd=5.33 as=0.825 ps=5.33 w=5 l=8
X327 vdd vdd vdd vdd sky130_fd_pr__pfet_01v8 ad=1.95 pd=10.78 as=0 ps=0 w=5 l=2
X328 net2 vin_p net5 gnd sky130_fd_pr__nfet_01v8 ad=0.825 pd=5.33 as=0.825 ps=5.33 w=5 l=8
X329 net4 net4 vdd vdd sky130_fd_pr__pfet_01v8 ad=0.825 pd=5.33 as=0.825 ps=5.33 w=5 l=2
X330 net2 vin_p net5 gnd sky130_fd_pr__nfet_01v8 ad=0.825 pd=5.33 as=0.825 ps=5.33 w=5 l=8
X331 net5 vin_p net2 gnd sky130_fd_pr__nfet_01v8 ad=1.95 pd=10.78 as=0.825 ps=5.33 w=5 l=8
X332 v_out net4 vdd vdd sky130_fd_pr__pfet_01v8 ad=0.825 pd=5.33 as=0.825 ps=5.33 w=5 l=2
X333 net5 vin_p net2 gnd sky130_fd_pr__nfet_01v8 ad=0.825 pd=5.33 as=0.825 ps=5.33 w=5 l=8
X334 net2 vin_p net5 gnd sky130_fd_pr__nfet_01v8 ad=0.825 pd=5.33 as=0.825 ps=5.33 w=5 l=8
X335 net2 vin_p net5 gnd sky130_fd_pr__nfet_01v8 ad=0.825 pd=5.33 as=1.95 ps=10.78 w=5 l=8
X336 vdd vdd vdd vdd sky130_fd_pr__pfet_01v8 ad=1.95 pd=10.78 as=0 ps=0 w=5 l=2
X337 vdd vdd vdd vdd sky130_fd_pr__pfet_01v8 ad=1.95 pd=10.78 as=0 ps=0 w=5 l=2
X338 vdd net4 net4 vdd sky130_fd_pr__pfet_01v8 ad=0.825 pd=5.33 as=0.825 ps=5.33 w=5 l=2
X339 net2 vin_p net5 gnd sky130_fd_pr__nfet_01v8 ad=0.825 pd=5.33 as=1.95 ps=10.78 w=5 l=8
X340 net2 vin_p net5 gnd sky130_fd_pr__nfet_01v8 ad=0.825 pd=5.33 as=0.825 ps=5.33 w=5 l=8
X341 vdd net4 v_out vdd sky130_fd_pr__pfet_01v8 ad=0.825 pd=5.33 as=0.825 ps=5.33 w=5 l=2
X342 vdd net4 net4 vdd sky130_fd_pr__pfet_01v8 ad=0.825 pd=5.33 as=0.825 ps=5.33 w=5 l=2
X343 net2 vin_p net5 gnd sky130_fd_pr__nfet_01v8 ad=0.825 pd=5.33 as=0.825 ps=5.33 w=5 l=8
X344 vdd net4 v_out vdd sky130_fd_pr__pfet_01v8 ad=0.825 pd=5.33 as=0.825 ps=5.33 w=5 l=2
X345 net5 vin_p net2 gnd sky130_fd_pr__nfet_01v8 ad=0.825 pd=5.33 as=0.825 ps=5.33 w=5 l=8
X346 vdd net4 v_out vdd sky130_fd_pr__pfet_01v8 ad=0.825 pd=5.33 as=0.825 ps=5.33 w=5 l=2
X347 net3 vin_n net5 gnd sky130_fd_pr__nfet_01v8 ad=0.825 pd=5.33 as=0.825 ps=5.33 w=5 l=8
X348 gnd gnd gnd gnd sky130_fd_pr__nfet_01v8 ad=1.95 pd=10.78 as=0 ps=0 w=5 l=8
X349 net3 vin_n net5 gnd sky130_fd_pr__nfet_01v8 ad=0.825 pd=5.33 as=0.825 ps=5.33 w=5 l=8
X350 v_out iref gnd gnd sky130_fd_pr__nfet_01v8 ad=1.95 pd=10.78 as=1.95 ps=10.78 w=5 l=4
X351 net5 vin_n net3 gnd sky130_fd_pr__nfet_01v8 ad=0.825 pd=5.33 as=0.825 ps=5.33 w=5 l=8
X352 net3 vin_n net5 gnd sky130_fd_pr__nfet_01v8 ad=0.825 pd=5.33 as=0.825 ps=5.33 w=5 l=8
X353 net5 iref gnd gnd sky130_fd_pr__nfet_01v8 ad=1.95 pd=10.78 as=1.95 ps=10.78 w=5 l=4
X354 gnd gnd gnd gnd sky130_fd_pr__nfet_01v8 ad=1.95 pd=10.78 as=0 ps=0 w=5 l=2
X355 vdd vctrl_n net2 gnd sky130_fd_pr__nfet_01v8 ad=0.825 pd=5.33 as=1.95 ps=10.78 w=5 l=2
X356 vdd vctrl_n net2 gnd sky130_fd_pr__nfet_01v8 ad=0.825 pd=5.33 as=0.825 ps=5.33 w=5 l=2
X357 v_out net4 vdd vdd sky130_fd_pr__pfet_01v8 ad=0.825 pd=5.33 as=0.825 ps=5.33 w=5 l=2
X358 net5 vin_p net2 gnd sky130_fd_pr__nfet_01v8 ad=0.825 pd=5.33 as=0.825 ps=5.33 w=5 l=8
X359 net5 vin_n net3 gnd sky130_fd_pr__nfet_01v8 ad=0.825 pd=5.33 as=0.825 ps=5.33 w=5 l=8
X360 v_out net4 vdd vdd sky130_fd_pr__pfet_01v8 ad=0.825 pd=5.33 as=0.825 ps=5.33 w=5 l=2
X361 net3 vin_n net5 gnd sky130_fd_pr__nfet_01v8 ad=0.825 pd=5.33 as=0.825 ps=5.33 w=5 l=8
X362 net4 vctrl_p net2 gnd sky130_fd_pr__nfet_01v8 ad=0.825 pd=5.33 as=1.95 ps=10.78 w=5 l=2
X363 net3 vin_n net5 gnd sky130_fd_pr__nfet_01v8 ad=0.825 pd=5.33 as=0.825 ps=5.33 w=5 l=8
X364 net3 vin_n net5 gnd sky130_fd_pr__nfet_01v8 ad=0.825 pd=5.33 as=0.825 ps=5.33 w=5 l=8
X365 gnd gnd gnd gnd sky130_fd_pr__nfet_01v8 ad=1.95 pd=10.78 as=0 ps=0 w=5 l=2
X366 net4 net4 vdd vdd sky130_fd_pr__pfet_01v8 ad=0.825 pd=5.33 as=0.825 ps=5.33 w=5 l=2
X367 v_out net4 vdd vdd sky130_fd_pr__pfet_01v8 ad=0.825 pd=5.33 as=1.95 ps=10.78 w=5 l=2
X368 net4 net4 vdd vdd sky130_fd_pr__pfet_01v8 ad=0.825 pd=5.33 as=1.95 ps=10.78 w=5 l=2
X369 net5 vin_p net2 gnd sky130_fd_pr__nfet_01v8 ad=1.95 pd=10.78 as=0.825 ps=5.33 w=5 l=8
X370 v_out net4 vdd vdd sky130_fd_pr__pfet_01v8 ad=0.825 pd=5.33 as=1.95 ps=10.78 w=5 l=2
X371 net3 vin_n net5 gnd sky130_fd_pr__nfet_01v8 ad=0.825 pd=5.33 as=1.95 ps=10.78 w=5 l=8
X372 net2 vctrl_p net4 gnd sky130_fd_pr__nfet_01v8 ad=1.95 pd=10.78 as=0.825 ps=5.33 w=5 l=2
X373 gnd gnd gnd gnd sky130_fd_pr__nfet_01v8 ad=1.95 pd=10.78 as=0 ps=0 w=5 l=4
X374 net5 vin_p net2 gnd sky130_fd_pr__nfet_01v8 ad=0.825 pd=5.33 as=0.825 ps=5.33 w=5 l=8
X375 net5 vin_p net2 gnd sky130_fd_pr__nfet_01v8 ad=0.825 pd=5.33 as=0.825 ps=5.33 w=5 l=8
X376 net5 vin_p net2 gnd sky130_fd_pr__nfet_01v8 ad=0.825 pd=5.33 as=0.825 ps=5.33 w=5 l=8
X377 net2 vin_p net5 gnd sky130_fd_pr__nfet_01v8 ad=0.825 pd=5.33 as=0.825 ps=5.33 w=5 l=8
X378 net3 vin_n net5 gnd sky130_fd_pr__nfet_01v8 ad=0.825 pd=5.33 as=0.825 ps=5.33 w=5 l=8
X379 net5 vin_n net3 gnd sky130_fd_pr__nfet_01v8 ad=0.825 pd=5.33 as=0.825 ps=5.33 w=5 l=8
X380 net2 vin_p net5 gnd sky130_fd_pr__nfet_01v8 ad=0.825 pd=5.33 as=0.825 ps=5.33 w=5 l=8
X381 gnd gnd gnd gnd sky130_fd_pr__nfet_01v8 ad=1.95 pd=10.78 as=0 ps=0 w=5 l=8
X382 vdd net4 v_out vdd sky130_fd_pr__pfet_01v8 ad=1.95 pd=10.78 as=0.825 ps=5.33 w=5 l=2
X383 net5 vin_p net2 gnd sky130_fd_pr__nfet_01v8 ad=0.825 pd=5.33 as=0.825 ps=5.33 w=5 l=8
X384 gnd gnd gnd gnd sky130_fd_pr__nfet_01v8 ad=1.95 pd=10.78 as=0 ps=0 w=5 l=8
X385 net5 vin_p net2 gnd sky130_fd_pr__nfet_01v8 ad=0.825 pd=5.33 as=0.825 ps=5.33 w=5 l=8
X386 net2 vin_p net5 gnd sky130_fd_pr__nfet_01v8 ad=0.825 pd=5.33 as=0.825 ps=5.33 w=5 l=8
X387 net5 vin_n net3 gnd sky130_fd_pr__nfet_01v8 ad=0.825 pd=5.33 as=0.825 ps=5.33 w=5 l=8
X388 net5 vin_p net2 gnd sky130_fd_pr__nfet_01v8 ad=0.825 pd=5.33 as=0.825 ps=5.33 w=5 l=8
X389 net2 vin_p net5 gnd sky130_fd_pr__nfet_01v8 ad=0.825 pd=5.33 as=0.825 ps=5.33 w=5 l=8
X390 net2 vin_p net5 gnd sky130_fd_pr__nfet_01v8 ad=0.825 pd=5.33 as=0.825 ps=5.33 w=5 l=8
X391 net5 vin_n net3 gnd sky130_fd_pr__nfet_01v8 ad=0.825 pd=5.33 as=0.825 ps=5.33 w=5 l=8
X392 vdd net4 net4 vdd sky130_fd_pr__pfet_01v8 ad=1.95 pd=10.78 as=0.825 ps=5.33 w=5 l=2
X393 net5 vin_n net3 gnd sky130_fd_pr__nfet_01v8 ad=0.825 pd=5.33 as=0.825 ps=5.33 w=5 l=8
X394 net5 vin_p net2 gnd sky130_fd_pr__nfet_01v8 ad=1.95 pd=10.78 as=0.825 ps=5.33 w=5 l=8
X395 net2 vctrl_n vdd gnd sky130_fd_pr__nfet_01v8 ad=0.825 pd=5.33 as=0.825 ps=5.33 w=5 l=2
X396 vdd net4 v_out vdd sky130_fd_pr__pfet_01v8 ad=0.825 pd=5.33 as=0.825 ps=5.33 w=5 l=2
X397 net4 net4 vdd vdd sky130_fd_pr__pfet_01v8 ad=0.825 pd=5.33 as=0.825 ps=5.33 w=5 l=2
X398 vdd net4 net4 vdd sky130_fd_pr__pfet_01v8 ad=0.825 pd=5.33 as=0.825 ps=5.33 w=5 l=2
X399 net2 vin_p net5 gnd sky130_fd_pr__nfet_01v8 ad=0.825 pd=5.33 as=0.825 ps=5.33 w=5 l=8
X400 net3 vin_n net5 gnd sky130_fd_pr__nfet_01v8 ad=0.825 pd=5.33 as=0.825 ps=5.33 w=5 l=8
X401 vdd vctrl_n net3 gnd sky130_fd_pr__nfet_01v8 ad=0.825 pd=5.33 as=1.95 ps=10.78 w=5 l=2
X402 net5 vin_n net3 gnd sky130_fd_pr__nfet_01v8 ad=0.825 pd=5.33 as=0.825 ps=5.33 w=5 l=8
X403 net5 vin_p net2 gnd sky130_fd_pr__nfet_01v8 ad=0.825 pd=5.33 as=0.825 ps=5.33 w=5 l=8
X404 v_out net4 vdd vdd sky130_fd_pr__pfet_01v8 ad=0.825 pd=5.33 as=0.825 ps=5.33 w=5 l=2
X405 net5 vin_p net2 gnd sky130_fd_pr__nfet_01v8 ad=0.825 pd=5.33 as=0.825 ps=5.33 w=5 l=8
X406 net5 vin_p net2 gnd sky130_fd_pr__nfet_01v8 ad=0.825 pd=5.33 as=0.825 ps=5.33 w=5 l=8
X407 v_out vctrl_p net3 gnd sky130_fd_pr__nfet_01v8 ad=0.825 pd=5.33 as=1.95 ps=10.78 w=5 l=2
X408 net2 vin_p net5 gnd sky130_fd_pr__nfet_01v8 ad=0.825 pd=5.33 as=1.95 ps=10.78 w=5 l=8
X409 net3 vin_n net5 gnd sky130_fd_pr__nfet_01v8 ad=0.825 pd=5.33 as=0.825 ps=5.33 w=5 l=8
X410 net2 vctrl_p net4 gnd sky130_fd_pr__nfet_01v8 ad=1.95 pd=10.78 as=0.825 ps=5.33 w=5 l=2
X411 gnd gnd gnd gnd sky130_fd_pr__nfet_01v8 ad=1.95 pd=10.78 as=0 ps=0 w=5 l=2
X412 net4 net4 vdd vdd sky130_fd_pr__pfet_01v8 ad=0.825 pd=5.33 as=0.825 ps=5.33 w=5 l=2
X413 gnd gnd gnd gnd sky130_fd_pr__nfet_01v8 ad=1.95 pd=10.78 as=0 ps=0 w=5 l=8
X414 net4 net4 vdd vdd sky130_fd_pr__pfet_01v8 ad=0.825 pd=5.33 as=0.825 ps=5.33 w=5 l=2
X415 net3 vin_n net5 gnd sky130_fd_pr__nfet_01v8 ad=0.825 pd=5.33 as=0.825 ps=5.33 w=5 l=8
X416 net5 vin_n net3 gnd sky130_fd_pr__nfet_01v8 ad=0.825 pd=5.33 as=0.825 ps=5.33 w=5 l=8
X417 net5 vin_n net3 gnd sky130_fd_pr__nfet_01v8 ad=1.95 pd=10.78 as=0.825 ps=5.33 w=5 l=8
X418 net4 net4 vdd vdd sky130_fd_pr__pfet_01v8 ad=0.825 pd=5.33 as=0.825 ps=5.33 w=5 l=2
X419 vdd net4 v_out vdd sky130_fd_pr__pfet_01v8 ad=0.825 pd=5.33 as=0.825 ps=5.33 w=5 l=2
X420 net2 vctrl_n vdd gnd sky130_fd_pr__nfet_01v8 ad=0.825 pd=5.33 as=0.825 ps=5.33 w=5 l=2
X421 v_out net4 vdd vdd sky130_fd_pr__pfet_01v8 ad=0.825 pd=5.33 as=1.95 ps=10.78 w=5 l=2
X422 vdd net4 net4 vdd sky130_fd_pr__pfet_01v8 ad=0.825 pd=5.33 as=0.825 ps=5.33 w=5 l=2
X423 vdd vdd vdd vdd sky130_fd_pr__pfet_01v8 ad=1.95 pd=10.78 as=0 ps=0 w=5 l=2
X424 net3 vin_n net5 gnd sky130_fd_pr__nfet_01v8 ad=0.825 pd=5.33 as=1.95 ps=10.78 w=5 l=8
X425 net2 vin_p net5 gnd sky130_fd_pr__nfet_01v8 ad=0.825 pd=5.33 as=0.825 ps=5.33 w=5 l=8
X426 net5 vin_p net2 gnd sky130_fd_pr__nfet_01v8 ad=0.825 pd=5.33 as=0.825 ps=5.33 w=5 l=8
X427 net3 vin_n net5 gnd sky130_fd_pr__nfet_01v8 ad=0.825 pd=5.33 as=0.825 ps=5.33 w=5 l=8
X428 net3 vctrl_p v_out gnd sky130_fd_pr__nfet_01v8 ad=1.95 pd=10.78 as=0.825 ps=5.33 w=5 l=2
X429 net3 vin_n net5 gnd sky130_fd_pr__nfet_01v8 ad=0.825 pd=5.33 as=0.825 ps=5.33 w=5 l=8
X430 vdd net4 net4 vdd sky130_fd_pr__pfet_01v8 ad=0.825 pd=5.33 as=0.825 ps=5.33 w=5 l=2
X431 net5 vin_p net2 gnd sky130_fd_pr__nfet_01v8 ad=0.825 pd=5.33 as=0.825 ps=5.33 w=5 l=8
X432 vdd net4 v_out vdd sky130_fd_pr__pfet_01v8 ad=0.825 pd=5.33 as=0.825 ps=5.33 w=5 l=2
X433 vdd net4 net4 vdd sky130_fd_pr__pfet_01v8 ad=0.825 pd=5.33 as=0.825 ps=5.33 w=5 l=2
X434 net3 vin_n net5 gnd sky130_fd_pr__nfet_01v8 ad=0.825 pd=5.33 as=0.825 ps=5.33 w=5 l=8
X435 net2 vin_p net5 gnd sky130_fd_pr__nfet_01v8 ad=0.825 pd=5.33 as=0.825 ps=5.33 w=5 l=8
X436 net2 vin_p net5 gnd sky130_fd_pr__nfet_01v8 ad=0.825 pd=5.33 as=0.825 ps=5.33 w=5 l=8
X437 gnd gnd gnd gnd sky130_fd_pr__nfet_01v8 ad=1.95 pd=10.78 as=0 ps=0 w=5 l=4
X438 net2 vin_p net5 gnd sky130_fd_pr__nfet_01v8 ad=0.825 pd=5.33 as=0.825 ps=5.33 w=5 l=8
X439 net3 vin_n net5 gnd sky130_fd_pr__nfet_01v8 ad=0.825 pd=5.33 as=1.95 ps=10.78 w=5 l=8
X440 net5 vin_p net2 gnd sky130_fd_pr__nfet_01v8 ad=0.825 pd=5.33 as=0.825 ps=5.33 w=5 l=8
X441 net3 vin_n net5 gnd sky130_fd_pr__nfet_01v8 ad=0.825 pd=5.33 as=0.825 ps=5.33 w=5 l=8
X442 net4 net4 vdd vdd sky130_fd_pr__pfet_01v8 ad=0.825 pd=5.33 as=0.825 ps=5.33 w=5 l=2
X443 v_out vctrl_p net3 gnd sky130_fd_pr__nfet_01v8 ad=0.825 pd=5.33 as=1.95 ps=10.78 w=5 l=2
X444 v_out net4 vdd vdd sky130_fd_pr__pfet_01v8 ad=0.825 pd=5.33 as=1.95 ps=10.78 w=5 l=2
X445 net3 vin_n net5 gnd sky130_fd_pr__nfet_01v8 ad=0.825 pd=5.33 as=0.825 ps=5.33 w=5 l=8
X446 net5 vin_n net3 gnd sky130_fd_pr__nfet_01v8 ad=0.825 pd=5.33 as=0.825 ps=5.33 w=5 l=8
X447 net4 net4 vdd vdd sky130_fd_pr__pfet_01v8 ad=0.825 pd=5.33 as=1.95 ps=10.78 w=5 l=2
X448 v_out net4 vdd vdd sky130_fd_pr__pfet_01v8 ad=0.825 pd=5.33 as=0.825 ps=5.33 w=5 l=2
X449 vdd vctrl_n net3 gnd sky130_fd_pr__nfet_01v8 ad=0.825 pd=5.33 as=1.95 ps=10.78 w=5 l=2
X450 net2 vin_p net5 gnd sky130_fd_pr__nfet_01v8 ad=0.825 pd=5.33 as=0.825 ps=5.33 w=5 l=8
X451 net5 iref gnd gnd sky130_fd_pr__nfet_01v8 ad=1.95 pd=10.78 as=1.95 ps=10.78 w=5 l=4
X452 net2 vin_p net5 gnd sky130_fd_pr__nfet_01v8 ad=0.825 pd=5.33 as=0.825 ps=5.33 w=5 l=8
X453 gnd gnd gnd gnd sky130_fd_pr__nfet_01v8 ad=1.95 pd=10.78 as=0 ps=0 w=5 l=2
X454 v_out net4 vdd vdd sky130_fd_pr__pfet_01v8 ad=0.825 pd=5.33 as=0.825 ps=5.33 w=5 l=2
X455 net4 net4 vdd vdd sky130_fd_pr__pfet_01v8 ad=0.825 pd=5.33 as=1.95 ps=10.78 w=5 l=2
X456 net3 vin_n net5 gnd sky130_fd_pr__nfet_01v8 ad=0.825 pd=5.33 as=0.825 ps=5.33 w=5 l=8
X457 net5 vin_p net2 gnd sky130_fd_pr__nfet_01v8 ad=1.95 pd=10.78 as=0.825 ps=5.33 w=5 l=8
X458 v_out net4 vdd vdd sky130_fd_pr__pfet_01v8 ad=0.825 pd=5.33 as=1.95 ps=10.78 w=5 l=2
X459 vdd net4 v_out vdd sky130_fd_pr__pfet_01v8 ad=0.825 pd=5.33 as=0.825 ps=5.33 w=5 l=2
X460 vdd vdd vdd vdd sky130_fd_pr__pfet_01v8 ad=1.95 pd=10.78 as=0 ps=0 w=5 l=2
X461 net2 vin_p net5 gnd sky130_fd_pr__nfet_01v8 ad=0.825 pd=5.33 as=1.95 ps=10.78 w=5 l=8
X462 vdd net4 v_out vdd sky130_fd_pr__pfet_01v8 ad=1.95 pd=10.78 as=0.825 ps=5.33 w=5 l=2
X463 net3 vctrl_n vdd gnd sky130_fd_pr__nfet_01v8 ad=1.95 pd=10.78 as=0.825 ps=5.33 w=5 l=2
X464 net2 vin_p net5 gnd sky130_fd_pr__nfet_01v8 ad=0.825 pd=5.33 as=0.825 ps=5.33 w=5 l=8
X465 net5 vin_p net2 gnd sky130_fd_pr__nfet_01v8 ad=0.825 pd=5.33 as=0.825 ps=5.33 w=5 l=8
X466 net2 vin_p net5 gnd sky130_fd_pr__nfet_01v8 ad=0.825 pd=5.33 as=0.825 ps=5.33 w=5 l=8
X467 net4 vctrl_p net2 gnd sky130_fd_pr__nfet_01v8 ad=0.825 pd=5.33 as=0.825 ps=5.33 w=5 l=2
X468 net2 vin_p net5 gnd sky130_fd_pr__nfet_01v8 ad=0.825 pd=5.33 as=0.825 ps=5.33 w=5 l=8
X469 net5 vin_n net3 gnd sky130_fd_pr__nfet_01v8 ad=0.825 pd=5.33 as=0.825 ps=5.33 w=5 l=8
X470 net5 vin_p net2 gnd sky130_fd_pr__nfet_01v8 ad=0.825 pd=5.33 as=0.825 ps=5.33 w=5 l=8
X471 net3 vin_n net5 gnd sky130_fd_pr__nfet_01v8 ad=0.825 pd=5.33 as=0.825 ps=5.33 w=5 l=8
X472 vdd net4 net4 vdd sky130_fd_pr__pfet_01v8 ad=1.95 pd=10.78 as=0.825 ps=5.33 w=5 l=2
X473 net3 vin_n net5 gnd sky130_fd_pr__nfet_01v8 ad=0.825 pd=5.33 as=0.825 ps=5.33 w=5 l=8
X474 net2 vin_p net5 gnd sky130_fd_pr__nfet_01v8 ad=0.825 pd=5.33 as=1.95 ps=10.78 w=5 l=8
X475 vdd net4 net4 vdd sky130_fd_pr__pfet_01v8 ad=0.825 pd=5.33 as=0.825 ps=5.33 w=5 l=2
X476 net3 vin_n net5 gnd sky130_fd_pr__nfet_01v8 ad=0.825 pd=5.33 as=0.825 ps=5.33 w=5 l=8
X477 net3 vctrl_n vdd gnd sky130_fd_pr__nfet_01v8 ad=0.825 pd=5.33 as=0.825 ps=5.33 w=5 l=2
.ends
