.subckt vga_core_12t vdd gnd vin_p vin_n iref vctrl_p vctrl_n v_out
XM1 net4 net4 vdd vdd sky130_fd_pr__pfet_01v8 L=0.5 W=640 nf=128 ad=92.8 as=94.25 pd=677.12 ps=687.7 nrd=0.000453125 nrs=0.000453125 sa=0 sb=0 sd=0 mult=1
XM4 v_out net4 vdd vdd sky130_fd_pr__pfet_01v8 L=0.5 W=640 nf=128 ad=92.8 as=94.25 pd=677.12 ps=687.7 nrd=0.000453125 nrs=0.000453125 sa=0 sb=0 sd=0 mult=1
XM2 net2 vin_p net5 gnd sky130_fd_pr__nfet_01v8 L=8 W=640 nf=128 ad=92.8 as=94.25 pd=677.12 ps=687.7 nrd=0.000453125 nrs=0.000453125 sa=0 sb=0 sd=0 mult=1
XM3 net3 vin_n net5 gnd sky130_fd_pr__nfet_01v8 L=8 W=640 nf=128 ad=92.8 as=94.25 pd=677.12 ps=687.7 nrd=0.000453125 nrs=0.000453125 sa=0 sb=0 sd=0 mult=1
XM6 net4 vctrl_p net2 gnd sky130_fd_pr__nfet_01v8 L=2 W=20 nf=4 ad=2.9 as=4.35 pd=21.16 ps=31.74 nrd=0.0145 nrs=0.0145 sa=0 sb=0 sd=0 mult=1
XM7 vdd vctrl_n net2 gnd sky130_fd_pr__nfet_01v8 L=2 W=20 nf=4 ad=2.9 as=4.35 pd=21.16 ps=31.74 nrd=0.0145 nrs=0.0145 sa=0 sb=0 sd=0 mult=1
XM8 vdd vctrl_n net3 gnd sky130_fd_pr__nfet_01v8 L=2 W=20 nf=4 ad=2.9 as=4.35 pd=21.16 ps=31.74 nrd=0.0145 nrs=0.0145 sa=0 sb=0 sd=0 mult=1
XM9 v_out vctrl_p net3 gnd sky130_fd_pr__nfet_01v8 L=2 W=20 nf=4 ad=2.9 as=4.35 pd=21.16 ps=31.74 nrd=0.0145 nrs=0.0145 sa=0 sb=0 sd=0 mult=1
XM5 net5 iref gnd gnd sky130_fd_pr__nfet_01v8 L=8 W=40 nf=8 ad=5.8 as=7.25 pd=42.32 ps=52.9 nrd=0.00725 nrs=0.00725 sa=0 sb=0 sd=0 mult=1 m=14
XM10 net4 iref gnd gnd sky130_fd_pr__nfet_01v8 L=8 W=40 nf=8 ad=5.8 as=7.25 pd=42.32 ps=52.9 nrd=0.00725 nrs=0.00725 sa=0 sb=0 sd=0 mult=1 m=2
XM11 v_out iref gnd gnd sky130_fd_pr__nfet_01v8 L=8 W=40 nf=8 ad=5.8 as=7.25 pd=42.32 ps=52.9 nrd=0.00725 nrs=0.00725 sa=0 sb=0 sd=0 mult=1 m=2
XM12 iref iref gnd gnd sky130_fd_pr__nfet_01v8 L=8 W=40 nf=8 ad=5.8 as=7.25 pd=42.32 ps=52.9 nrd=0.00725 nrs=0.00725 sa=0 sb=0 sd=0 mult=1
.ends
