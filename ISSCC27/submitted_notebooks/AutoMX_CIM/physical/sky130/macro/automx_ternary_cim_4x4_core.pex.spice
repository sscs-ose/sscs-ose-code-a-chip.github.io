* NGSPICE file created from automx_ternary_cim_4x4_core_pex.ext - technology: sky130A

.subckt automx_ternary_cim_4x4_core_pex_raw WPOS_0_0 WNEG_0_0 WPOS_0_1 WNEG_0_1 WPOS_0_2
+ WNEG_0_2 WPOS_0_3 WNEG_0_3 WPOS_1_0 WNEG_1_0 WPOS_1_1 WNEG_1_1 WPOS_1_2 WNEG_1_2
+ WPOS_1_3 WNEG_1_3 WPOS_2_0 WNEG_2_0 WPOS_2_1 WNEG_2_1 WPOS_2_2 WNEG_2_2 WPOS_2_3
+ WNEG_2_3 WPOS_3_0 WNEG_3_0 WPOS_3_1 WNEG_3_1 WPOS_3_2 WNEG_3_2 WPOS_3_3 WNEG_3_3
+ BLP0 BLN0 BLP1 BLN1 BLP2 BLN2 BLP3 BLN3 WLP0 WLN0 WLP1 WLN1 WLP2 WLN2 WLP3 WLN3
+ VGND VSUBS
X0 VSUBS.t61 WLN0.t6 a_1755_1216.t1 w_n20_50# sky130_fd_pr__nfet_01v8 ad=0.2436 pd=2.26 as=0.2436 ps=2.26 w=0.84 l=0.15
X1 a_255_6376.t0 WPOS_3_0.t0 BLP0.t1 w_n20_50# sky130_fd_pr__nfet_01v8 ad=0.2436 pd=2.26 as=0.2436 ps=2.26 w=0.84 l=0.15
X2 VSUBS.t60 WLN0.t5 a_3255_1216.t1 w_n20_50# sky130_fd_pr__nfet_01v8 ad=0.2436 pd=2.26 as=0.2436 ps=2.26 w=0.84 l=0.15
X3 a_4755_3316.t0 WPOS_1_3.t1 BLN3.t3 w_n20_50# sky130_fd_pr__nfet_01v8 ad=0.2436 pd=2.26 as=0.2436 ps=2.26 w=0.84 l=0.15
X4 VSUBS.t2 WLN3.t2 a_1755_6756.t0 w_n20_50# sky130_fd_pr__nfet_01v8 ad=0.2436 pd=2.26 as=0.2436 ps=2.26 w=0.84 l=0.15
X5 VSUBS.t23 WLP2.t2 a_1755_4276.t0 w_n20_50# sky130_fd_pr__nfet_01v8 ad=0.2436 pd=2.26 as=0.2436 ps=2.26 w=0.84 l=0.15
X6 a_4755_6376.t1 WPOS_3_3.t0 BLP3.t1 w_n20_50# sky130_fd_pr__nfet_01v8 ad=0.2436 pd=2.26 as=0.2436 ps=2.26 w=0.84 l=0.15
X7 VSUBS.t6 WLN3.t1 a_3255_6756.t0 w_n20_50# sky130_fd_pr__nfet_01v8 ad=0.2436 pd=2.26 as=0.2436 ps=2.26 w=0.84 l=0.15
X8 VSUBS.t22 WLP2.t1 a_3255_4276.t0 w_n20_50# sky130_fd_pr__nfet_01v8 ad=0.2436 pd=2.26 as=0.2436 ps=2.26 w=0.84 l=0.15
X9 VSUBS.t51 WLP0.t1 a_3255_76.t0 w_n20_50# sky130_fd_pr__nfet_01v8 ad=0.2436 pd=2.26 as=0.2436 ps=2.26 w=0.84 l=0.15
X10 VSUBS.t46 WLP1.t3 a_255_2176.t1 w_n20_50# sky130_fd_pr__nfet_01v8 ad=0.2436 pd=2.26 as=0.2436 ps=2.26 w=0.84 l=0.15
X11 VSUBS.t24 WLN2.t3 a_255_4656.t1 w_n20_50# sky130_fd_pr__nfet_01v8 ad=0.2436 pd=2.26 as=0.2436 ps=2.26 w=0.84 l=0.15
X12 a_1755_2176.t0 WPOS_1_1.t0 BLP1.t4 w_n20_50# sky130_fd_pr__nfet_01v8 ad=0.2436 pd=2.26 as=0.2436 ps=2.26 w=0.84 l=0.15
X13 a_1755_4656.t1 WNEG_2_1.t0 BLP1.t3 w_n20_50# sky130_fd_pr__nfet_01v8 ad=0.2436 pd=2.26 as=0.2436 ps=2.26 w=0.84 l=0.15
X14 VSUBS.t12 WLP3.t7 a_255_7136.t0 w_n20_50# sky130_fd_pr__nfet_01v8 ad=0.2436 pd=2.26 as=0.2436 ps=2.26 w=0.84 l=0.15
X15 a_3255_2176.t0 WPOS_1_2.t0 BLP2.t3 w_n20_50# sky130_fd_pr__nfet_01v8 ad=0.2436 pd=2.26 as=0.2436 ps=2.26 w=0.84 l=0.15
X16 a_3255_4656.t1 WNEG_2_2.t0 BLP2.t4 w_n20_50# sky130_fd_pr__nfet_01v8 ad=0.2436 pd=2.26 as=0.2436 ps=2.26 w=0.84 l=0.15
X17 a_255_76.t0 WPOS_0_0.t0 BLP0.t5 w_n20_50# sky130_fd_pr__nfet_01v8 ad=0.2436 pd=2.26 as=0.2436 ps=2.26 w=0.84 l=0.15
X18 VSUBS.t41 WLP1.t0 a_4755_2176.t1 w_n20_50# sky130_fd_pr__nfet_01v8 ad=0.2436 pd=2.26 as=0.2436 ps=2.26 w=0.84 l=0.15
X19 VSUBS.t29 WLN2.t0 a_4755_4656.t0 w_n20_50# sky130_fd_pr__nfet_01v8 ad=0.2436 pd=2.26 as=0.2436 ps=2.26 w=0.84 l=0.15
X20 a_1755_7136.t0 WNEG_3_1.t1 BLN1.t1 w_n20_50# sky130_fd_pr__nfet_01v8 ad=0.2436 pd=2.26 as=0.2436 ps=2.26 w=0.84 l=0.15
X21 a_255_2556.t1 WNEG_1_0.t0 BLP0.t6 w_n20_50# sky130_fd_pr__nfet_01v8 ad=0.2436 pd=2.26 as=0.2436 ps=2.26 w=0.84 l=0.15
R0 VSUBS VGND 0.000000
X22 VSUBS.t45 WLP1.t6 a_1755_2936.t1 w_n20_50# sky130_fd_pr__nfet_01v8 ad=0.2436 pd=2.26 as=0.2436 ps=2.26 w=0.84 l=0.15
X23 a_3255_7136.t0 WNEG_3_2.t1 BLN2.t1 w_n20_50# sky130_fd_pr__nfet_01v8 ad=0.2436 pd=2.26 as=0.2436 ps=2.26 w=0.84 l=0.15
X24 VSUBS.t58 WLN0.t0 a_4755_456.t1 w_n20_50# sky130_fd_pr__nfet_01v8 ad=0.2436 pd=2.26 as=0.2436 ps=2.26 w=0.84 l=0.15
X25 a_4755_836.t1 WNEG_0_3.t1 BLN3.t7 w_n20_50# sky130_fd_pr__nfet_01v8 ad=0.2436 pd=2.26 as=0.2436 ps=2.26 w=0.84 l=0.15
X26 VSUBS.t15 WLP3.t4 a_4755_7136.t1 w_n20_50# sky130_fd_pr__nfet_01v8 ad=0.2436 pd=2.26 as=0.2436 ps=2.26 w=0.84 l=0.15
X27 a_255_7516.t1 WPOS_3_0.t1 BLN0.t0 w_n20_50# sky130_fd_pr__nfet_01v8 ad=0.2436 pd=2.26 as=0.2436 ps=2.26 w=0.84 l=0.15
X28 a_255_5036.t0 WNEG_2_0.t1 BLN0.t1 w_n20_50# sky130_fd_pr__nfet_01v8 ad=0.2436 pd=2.26 as=0.2436 ps=2.26 w=0.84 l=0.15
X29 a_1755_76.t0 WPOS_0_1.t0 BLP1.t6 w_n20_50# sky130_fd_pr__nfet_01v8 ad=0.2436 pd=2.26 as=0.2436 ps=2.26 w=0.84 l=0.15
X30 a_4755_2556.t1 WNEG_1_3.t0 BLP3.t4 w_n20_50# sky130_fd_pr__nfet_01v8 ad=0.2436 pd=2.26 as=0.2436 ps=2.26 w=0.84 l=0.15
X31 VSUBS.t40 WLP1.t5 a_3255_2936.t1 w_n20_50# sky130_fd_pr__nfet_01v8 ad=0.2436 pd=2.26 as=0.2436 ps=2.26 w=0.84 l=0.15
X32 VSUBS.t27 WLN2.t6 a_1755_5416.t1 w_n20_50# sky130_fd_pr__nfet_01v8 ad=0.2436 pd=2.26 as=0.2436 ps=2.26 w=0.84 l=0.15
X33 a_4755_7516.t1 WPOS_3_3.t1 BLN3.t0 w_n20_50# sky130_fd_pr__nfet_01v8 ad=0.2436 pd=2.26 as=0.2436 ps=2.26 w=0.84 l=0.15
X34 a_4755_5036.t1 WNEG_2_3.t1 BLN3.t6 w_n20_50# sky130_fd_pr__nfet_01v8 ad=0.2436 pd=2.26 as=0.2436 ps=2.26 w=0.84 l=0.15
X35 VSUBS.t26 WLN2.t5 a_3255_5416.t1 w_n20_50# sky130_fd_pr__nfet_01v8 ad=0.2436 pd=2.26 as=0.2436 ps=2.26 w=0.84 l=0.15
X36 VSUBS.t39 WLN1.t7 a_255_3316.t1 w_n20_50# sky130_fd_pr__nfet_01v8 ad=0.2436 pd=2.26 as=0.2436 ps=2.26 w=0.84 l=0.15
X37 VSUBS.t53 WLP0.t6 a_1755_836.t0 w_n20_50# sky130_fd_pr__nfet_01v8 ad=0.2436 pd=2.26 as=0.2436 ps=2.26 w=0.84 l=0.15
X38 a_1755_3316.t0 WPOS_1_1.t1 BLN1.t4 w_n20_50# sky130_fd_pr__nfet_01v8 ad=0.2436 pd=2.26 as=0.2436 ps=2.26 w=0.84 l=0.15
X39 VSUBS.t48 WLP0.t5 a_3255_836.t1 w_n20_50# sky130_fd_pr__nfet_01v8 ad=0.2436 pd=2.26 as=0.2436 ps=2.26 w=0.84 l=0.15
X40 a_4755_76.t1 WPOS_0_3.t0 BLP3.t5 w_n20_50# sky130_fd_pr__nfet_01v8 ad=0.2436 pd=2.26 as=0.2436 ps=2.26 w=0.84 l=0.15
X41 VSUBS.t62 WLN0.t3 a_255_456.t0 w_n20_50# sky130_fd_pr__nfet_01v8 ad=0.2436 pd=2.26 as=0.2436 ps=2.26 w=0.84 l=0.15
X42 a_255_836.t1 WNEG_0_0.t1 BLN0.t7 w_n20_50# sky130_fd_pr__nfet_01v8 ad=0.2436 pd=2.26 as=0.2436 ps=2.26 w=0.84 l=0.15
X43 a_3255_3316.t0 WPOS_1_2.t1 BLN2.t3 w_n20_50# sky130_fd_pr__nfet_01v8 ad=0.2436 pd=2.26 as=0.2436 ps=2.26 w=0.84 l=0.15
X44 VSUBS.t14 WLP3.t3 a_255_6376.t1 w_n20_50# sky130_fd_pr__nfet_01v8 ad=0.2436 pd=2.26 as=0.2436 ps=2.26 w=0.84 l=0.15
X45 VSUBS.t36 WLN1.t4 a_4755_3316.t1 w_n20_50# sky130_fd_pr__nfet_01v8 ad=0.2436 pd=2.26 as=0.2436 ps=2.26 w=0.84 l=0.15
X46 a_1755_6376.t0 WPOS_3_1.t0 BLP1.t0 w_n20_50# sky130_fd_pr__nfet_01v8 ad=0.2436 pd=2.26 as=0.2436 ps=2.26 w=0.84 l=0.15
X47 a_255_1216.t0 WPOS_0_0.t1 BLN0.t5 w_n20_50# sky130_fd_pr__nfet_01v8 ad=0.2436 pd=2.26 as=0.2436 ps=2.26 w=0.84 l=0.15
X48 VSUBS.t49 WLP0.t3 a_255_76.t1 w_n20_50# sky130_fd_pr__nfet_01v8 ad=0.2436 pd=2.26 as=0.2436 ps=2.26 w=0.84 l=0.15
X49 a_3255_6376.t0 WPOS_3_2.t0 BLP2.t1 w_n20_50# sky130_fd_pr__nfet_01v8 ad=0.2436 pd=2.26 as=0.2436 ps=2.26 w=0.84 l=0.15
X50 VSUBS.t10 WLP3.t0 a_4755_6376.t0 w_n20_50# sky130_fd_pr__nfet_01v8 ad=0.2436 pd=2.26 as=0.2436 ps=2.26 w=0.84 l=0.15
X51 a_255_6756.t1 WNEG_3_0.t0 BLP0.t0 w_n20_50# sky130_fd_pr__nfet_01v8 ad=0.2436 pd=2.26 as=0.2436 ps=2.26 w=0.84 l=0.15
X52 a_4755_1216.t0 WPOS_0_3.t1 BLN3.t5 w_n20_50# sky130_fd_pr__nfet_01v8 ad=0.2436 pd=2.26 as=0.2436 ps=2.26 w=0.84 l=0.15
X53 a_255_4276.t1 WPOS_2_0.t0 BLP0.t3 w_n20_50# sky130_fd_pr__nfet_01v8 ad=0.2436 pd=2.26 as=0.2436 ps=2.26 w=0.84 l=0.15
X54 VSUBS.t55 WLP0.t2 a_1755_76.t1 w_n20_50# sky130_fd_pr__nfet_01v8 ad=0.2436 pd=2.26 as=0.2436 ps=2.26 w=0.84 l=0.15
X55 VSUBS.t44 WLP1.t2 a_1755_2176.t1 w_n20_50# sky130_fd_pr__nfet_01v8 ad=0.2436 pd=2.26 as=0.2436 ps=2.26 w=0.84 l=0.15
X56 VSUBS.t31 WLN2.t2 a_1755_4656.t0 w_n20_50# sky130_fd_pr__nfet_01v8 ad=0.2436 pd=2.26 as=0.2436 ps=2.26 w=0.84 l=0.15
X57 a_4755_6756.t1 WNEG_3_3.t0 BLP3.t0 w_n20_50# sky130_fd_pr__nfet_01v8 ad=0.2436 pd=2.26 as=0.2436 ps=2.26 w=0.84 l=0.15
X58 VSUBS.t42 WLP1.t1 a_3255_2176.t1 w_n20_50# sky130_fd_pr__nfet_01v8 ad=0.2436 pd=2.26 as=0.2436 ps=2.26 w=0.84 l=0.15
X59 a_4755_4276.t1 WPOS_2_3.t0 BLP3.t2 w_n20_50# sky130_fd_pr__nfet_01v8 ad=0.2436 pd=2.26 as=0.2436 ps=2.26 w=0.84 l=0.15
X60 VSUBS.t30 WLN2.t1 a_3255_4656.t0 w_n20_50# sky130_fd_pr__nfet_01v8 ad=0.2436 pd=2.26 as=0.2436 ps=2.26 w=0.84 l=0.15
X61 VSUBS.t8 WLP3.t6 a_1755_7136.t1 w_n20_50# sky130_fd_pr__nfet_01v8 ad=0.2436 pd=2.26 as=0.2436 ps=2.26 w=0.84 l=0.15
X62 VSUBS.t32 WLN1.t3 a_255_2556.t0 w_n20_50# sky130_fd_pr__nfet_01v8 ad=0.2436 pd=2.26 as=0.2436 ps=2.26 w=0.84 l=0.15
X63 a_1755_2556.t1 WNEG_1_1.t0 BLP1.t5 w_n20_50# sky130_fd_pr__nfet_01v8 ad=0.2436 pd=2.26 as=0.2436 ps=2.26 w=0.84 l=0.15
X64 VSUBS.t9 WLP3.t5 a_3255_7136.t1 w_n20_50# sky130_fd_pr__nfet_01v8 ad=0.2436 pd=2.26 as=0.2436 ps=2.26 w=0.84 l=0.15
X65 VSUBS.t54 WLP0.t0 a_4755_76.t0 w_n20_50# sky130_fd_pr__nfet_01v8 ad=0.2436 pd=2.26 as=0.2436 ps=2.26 w=0.84 l=0.15
X66 a_3255_2556.t1 WNEG_1_2.t0 BLP2.t6 w_n20_50# sky130_fd_pr__nfet_01v8 ad=0.2436 pd=2.26 as=0.2436 ps=2.26 w=0.84 l=0.15
X67 VSUBS.t1 WLN3.t7 a_255_7516.t0 w_n20_50# sky130_fd_pr__nfet_01v8 ad=0.2436 pd=2.26 as=0.2436 ps=2.26 w=0.84 l=0.15
X68 VSUBS.t20 WLP2.t7 a_255_5036.t1 w_n20_50# sky130_fd_pr__nfet_01v8 ad=0.2436 pd=2.26 as=0.2436 ps=2.26 w=0.84 l=0.15
X69 a_1755_7516.t0 WPOS_3_1.t1 BLN1.t0 w_n20_50# sky130_fd_pr__nfet_01v8 ad=0.2436 pd=2.26 as=0.2436 ps=2.26 w=0.84 l=0.15
X70 a_1755_456.t1 WNEG_0_1.t0 BLP1.t7 w_n20_50# sky130_fd_pr__nfet_01v8 ad=0.2436 pd=2.26 as=0.2436 ps=2.26 w=0.84 l=0.15
X71 VSUBS.t34 WLN1.t0 a_4755_2556.t0 w_n20_50# sky130_fd_pr__nfet_01v8 ad=0.2436 pd=2.26 as=0.2436 ps=2.26 w=0.84 l=0.15
X72 a_1755_5036.t1 WNEG_2_1.t1 BLN1.t3 w_n20_50# sky130_fd_pr__nfet_01v8 ad=0.2436 pd=2.26 as=0.2436 ps=2.26 w=0.84 l=0.15
X73 a_255_2936.t1 WNEG_1_0.t1 BLN0.t6 w_n20_50# sky130_fd_pr__nfet_01v8 ad=0.2436 pd=2.26 as=0.2436 ps=2.26 w=0.84 l=0.15
X74 a_3255_456.t0 WNEG_0_2.t0 BLP2.t5 w_n20_50# sky130_fd_pr__nfet_01v8 ad=0.2436 pd=2.26 as=0.2436 ps=2.26 w=0.84 l=0.15
X75 a_3255_7516.t1 WPOS_3_2.t1 BLN2.t0 w_n20_50# sky130_fd_pr__nfet_01v8 ad=0.2436 pd=2.26 as=0.2436 ps=2.26 w=0.84 l=0.15
X76 VSUBS.t50 WLP0.t4 a_4755_836.t0 w_n20_50# sky130_fd_pr__nfet_01v8 ad=0.2436 pd=2.26 as=0.2436 ps=2.26 w=0.84 l=0.15
X77 a_3255_5036.t1 WNEG_2_2.t1 BLN2.t4 w_n20_50# sky130_fd_pr__nfet_01v8 ad=0.2436 pd=2.26 as=0.2436 ps=2.26 w=0.84 l=0.15
X78 VSUBS.t5 WLN3.t4 a_4755_7516.t0 w_n20_50# sky130_fd_pr__nfet_01v8 ad=0.2436 pd=2.26 as=0.2436 ps=2.26 w=0.84 l=0.15
X79 VSUBS.t17 WLP2.t4 a_4755_5036.t0 w_n20_50# sky130_fd_pr__nfet_01v8 ad=0.2436 pd=2.26 as=0.2436 ps=2.26 w=0.84 l=0.15
X80 a_255_5416.t1 WPOS_2_0.t1 BLN0.t2 w_n20_50# sky130_fd_pr__nfet_01v8 ad=0.2436 pd=2.26 as=0.2436 ps=2.26 w=0.84 l=0.15
X81 a_4755_2936.t1 WNEG_1_3.t1 BLN3.t4 w_n20_50# sky130_fd_pr__nfet_01v8 ad=0.2436 pd=2.26 as=0.2436 ps=2.26 w=0.84 l=0.15
X82 VSUBS.t38 WLN1.t6 a_1755_3316.t1 w_n20_50# sky130_fd_pr__nfet_01v8 ad=0.2436 pd=2.26 as=0.2436 ps=2.26 w=0.84 l=0.15
X83 VSUBS.t37 WLN1.t5 a_3255_3316.t1 w_n20_50# sky130_fd_pr__nfet_01v8 ad=0.2436 pd=2.26 as=0.2436 ps=2.26 w=0.84 l=0.15
X84 a_4755_5416.t0 WPOS_2_3.t1 BLN3.t2 w_n20_50# sky130_fd_pr__nfet_01v8 ad=0.2436 pd=2.26 as=0.2436 ps=2.26 w=0.84 l=0.15
X85 VSUBS.t11 WLP3.t2 a_1755_6376.t1 w_n20_50# sky130_fd_pr__nfet_01v8 ad=0.2436 pd=2.26 as=0.2436 ps=2.26 w=0.84 l=0.15
X86 VSUBS.t63 WLN0.t7 a_255_1216.t1 w_n20_50# sky130_fd_pr__nfet_01v8 ad=0.2436 pd=2.26 as=0.2436 ps=2.26 w=0.84 l=0.15
X87 a_1755_1216.t0 WPOS_0_1.t1 BLN1.t6 w_n20_50# sky130_fd_pr__nfet_01v8 ad=0.2436 pd=2.26 as=0.2436 ps=2.26 w=0.84 l=0.15
X88 VSUBS.t13 WLP3.t1 a_3255_6376.t1 w_n20_50# sky130_fd_pr__nfet_01v8 ad=0.2436 pd=2.26 as=0.2436 ps=2.26 w=0.84 l=0.15
X89 VSUBS.t52 WLP0.t7 a_255_836.t0 w_n20_50# sky130_fd_pr__nfet_01v8 ad=0.2436 pd=2.26 as=0.2436 ps=2.26 w=0.84 l=0.15
X90 a_3255_1216.t0 WPOS_0_2.t1 BLN2.t7 w_n20_50# sky130_fd_pr__nfet_01v8 ad=0.2436 pd=2.26 as=0.2436 ps=2.26 w=0.84 l=0.15
X91 VSUBS.t3 WLN3.t3 a_255_6756.t0 w_n20_50# sky130_fd_pr__nfet_01v8 ad=0.2436 pd=2.26 as=0.2436 ps=2.26 w=0.84 l=0.15
X92 VSUBS.t16 WLP2.t3 a_255_4276.t0 w_n20_50# sky130_fd_pr__nfet_01v8 ad=0.2436 pd=2.26 as=0.2436 ps=2.26 w=0.84 l=0.15
X93 VSUBS.t59 WLN0.t4 a_4755_1216.t1 w_n20_50# sky130_fd_pr__nfet_01v8 ad=0.2436 pd=2.26 as=0.2436 ps=2.26 w=0.84 l=0.15
X94 a_1755_6756.t1 WNEG_3_1.t0 BLP1.t1 w_n20_50# sky130_fd_pr__nfet_01v8 ad=0.2436 pd=2.26 as=0.2436 ps=2.26 w=0.84 l=0.15
X95 a_1755_4276.t1 WPOS_2_1.t0 BLP1.t2 w_n20_50# sky130_fd_pr__nfet_01v8 ad=0.2436 pd=2.26 as=0.2436 ps=2.26 w=0.84 l=0.15
X96 a_3255_6756.t1 WNEG_3_2.t0 BLP2.t0 w_n20_50# sky130_fd_pr__nfet_01v8 ad=0.2436 pd=2.26 as=0.2436 ps=2.26 w=0.84 l=0.15
X97 a_3255_4276.t1 WPOS_2_2.t0 BLP2.t2 w_n20_50# sky130_fd_pr__nfet_01v8 ad=0.2436 pd=2.26 as=0.2436 ps=2.26 w=0.84 l=0.15
X98 VSUBS.t0 WLN3.t0 a_4755_6756.t0 w_n20_50# sky130_fd_pr__nfet_01v8 ad=0.2436 pd=2.26 as=0.2436 ps=2.26 w=0.84 l=0.15
X99 VSUBS.t21 WLP2.t0 a_4755_4276.t0 w_n20_50# sky130_fd_pr__nfet_01v8 ad=0.2436 pd=2.26 as=0.2436 ps=2.26 w=0.84 l=0.15
X100 a_255_2176.t0 WPOS_1_0.t0 BLP0.t4 w_n20_50# sky130_fd_pr__nfet_01v8 ad=0.2436 pd=2.26 as=0.2436 ps=2.26 w=0.84 l=0.15
X101 a_255_4656.t0 WNEG_2_0.t0 BLP0.t2 w_n20_50# sky130_fd_pr__nfet_01v8 ad=0.2436 pd=2.26 as=0.2436 ps=2.26 w=0.84 l=0.15
X102 a_4755_456.t0 WNEG_0_3.t0 BLP3.t7 w_n20_50# sky130_fd_pr__nfet_01v8 ad=0.2436 pd=2.26 as=0.2436 ps=2.26 w=0.84 l=0.15
X103 VSUBS.t33 WLN1.t2 a_1755_2556.t0 w_n20_50# sky130_fd_pr__nfet_01v8 ad=0.2436 pd=2.26 as=0.2436 ps=2.26 w=0.84 l=0.15
X104 a_255_7136.t1 WNEG_3_0.t1 BLN0.t3 w_n20_50# sky130_fd_pr__nfet_01v8 ad=0.2436 pd=2.26 as=0.2436 ps=2.26 w=0.84 l=0.15
X105 a_4755_2176.t0 WPOS_1_3.t0 BLP3.t3 w_n20_50# sky130_fd_pr__nfet_01v8 ad=0.2436 pd=2.26 as=0.2436 ps=2.26 w=0.84 l=0.15
X106 a_4755_4656.t1 WNEG_2_3.t0 BLP3.t6 w_n20_50# sky130_fd_pr__nfet_01v8 ad=0.2436 pd=2.26 as=0.2436 ps=2.26 w=0.84 l=0.15
X107 VSUBS.t35 WLN1.t1 a_3255_2556.t0 w_n20_50# sky130_fd_pr__nfet_01v8 ad=0.2436 pd=2.26 as=0.2436 ps=2.26 w=0.84 l=0.15
X108 VSUBS.t4 WLN3.t6 a_1755_7516.t1 w_n20_50# sky130_fd_pr__nfet_01v8 ad=0.2436 pd=2.26 as=0.2436 ps=2.26 w=0.84 l=0.15
X109 VSUBS.t47 WLP1.t7 a_255_2936.t0 w_n20_50# sky130_fd_pr__nfet_01v8 ad=0.2436 pd=2.26 as=0.2436 ps=2.26 w=0.84 l=0.15
X110 VSUBS.t19 WLP2.t6 a_1755_5036.t0 w_n20_50# sky130_fd_pr__nfet_01v8 ad=0.2436 pd=2.26 as=0.2436 ps=2.26 w=0.84 l=0.15
X111 a_1755_2936.t0 WNEG_1_1.t1 BLN1.t5 w_n20_50# sky130_fd_pr__nfet_01v8 ad=0.2436 pd=2.26 as=0.2436 ps=2.26 w=0.84 l=0.15
X112 VSUBS.t7 WLN3.t5 a_3255_7516.t0 w_n20_50# sky130_fd_pr__nfet_01v8 ad=0.2436 pd=2.26 as=0.2436 ps=2.26 w=0.84 l=0.15
X113 a_4755_7136.t0 WNEG_3_3.t1 BLN3.t1 w_n20_50# sky130_fd_pr__nfet_01v8 ad=0.2436 pd=2.26 as=0.2436 ps=2.26 w=0.84 l=0.15
X114 VSUBS.t18 WLP2.t5 a_3255_5036.t0 w_n20_50# sky130_fd_pr__nfet_01v8 ad=0.2436 pd=2.26 as=0.2436 ps=2.26 w=0.84 l=0.15
X115 a_3255_76.t1 WPOS_0_2.t0 BLP2.t7 w_n20_50# sky130_fd_pr__nfet_01v8 ad=0.2436 pd=2.26 as=0.2436 ps=2.26 w=0.84 l=0.15
X116 a_3255_2936.t0 WNEG_1_2.t1 BLN2.t6 w_n20_50# sky130_fd_pr__nfet_01v8 ad=0.2436 pd=2.26 as=0.2436 ps=2.26 w=0.84 l=0.15
X117 VSUBS.t28 WLN2.t7 a_255_5416.t0 w_n20_50# sky130_fd_pr__nfet_01v8 ad=0.2436 pd=2.26 as=0.2436 ps=2.26 w=0.84 l=0.15
X118 VSUBS.t43 WLP1.t4 a_4755_2936.t0 w_n20_50# sky130_fd_pr__nfet_01v8 ad=0.2436 pd=2.26 as=0.2436 ps=2.26 w=0.84 l=0.15
X119 VSUBS.t56 WLN0.t2 a_1755_456.t0 w_n20_50# sky130_fd_pr__nfet_01v8 ad=0.2436 pd=2.26 as=0.2436 ps=2.26 w=0.84 l=0.15
X120 a_1755_836.t1 WNEG_0_1.t1 BLN1.t7 w_n20_50# sky130_fd_pr__nfet_01v8 ad=0.2436 pd=2.26 as=0.2436 ps=2.26 w=0.84 l=0.15
X121 a_1755_5416.t0 WPOS_2_1.t1 BLN1.t2 w_n20_50# sky130_fd_pr__nfet_01v8 ad=0.2436 pd=2.26 as=0.2436 ps=2.26 w=0.84 l=0.15
X122 VSUBS.t57 WLN0.t1 a_3255_456.t1 w_n20_50# sky130_fd_pr__nfet_01v8 ad=0.2436 pd=2.26 as=0.2436 ps=2.26 w=0.84 l=0.15
X123 a_3255_836.t0 WNEG_0_2.t1 BLN2.t5 w_n20_50# sky130_fd_pr__nfet_01v8 ad=0.2436 pd=2.26 as=0.2436 ps=2.26 w=0.84 l=0.15
X124 a_255_456.t1 WNEG_0_0.t0 BLP0.t7 w_n20_50# sky130_fd_pr__nfet_01v8 ad=0.2436 pd=2.26 as=0.2436 ps=2.26 w=0.84 l=0.15
X125 a_3255_5416.t0 WPOS_2_2.t1 BLN2.t2 w_n20_50# sky130_fd_pr__nfet_01v8 ad=0.2436 pd=2.26 as=0.2436 ps=2.26 w=0.84 l=0.15
X126 a_255_3316.t0 WPOS_1_0.t1 BLN0.t4 w_n20_50# sky130_fd_pr__nfet_01v8 ad=0.2436 pd=2.26 as=0.2436 ps=2.26 w=0.84 l=0.15
X127 VSUBS.t25 WLN2.t4 a_4755_5416.t1 w_n20_50# sky130_fd_pr__nfet_01v8 ad=0.2436 pd=2.26 as=0.2436 ps=2.26 w=0.84 l=0.15
R1 WNEG_0_3.n0 WNEG_0_3.t0 380.207
R2 WNEG_0_3.n0 WNEG_0_3.t1 379.685
R3 WNEG_0_3 WNEG_0_3.n0 0.631182
R4 WNEG_0_2.n0 WNEG_0_2.t0 380.207
R5 WNEG_0_2.n0 WNEG_0_2.t1 379.685
R6 WNEG_0_2 WNEG_0_2.n0 0.631182
R7 WNEG_0_1.n0 WNEG_0_1.t0 380.207
R8 WNEG_0_1.n0 WNEG_0_1.t1 379.685
R9 WNEG_0_1 WNEG_0_1.n0 0.631182
R10 WLP0.n5 WLP0.t0 380.363
R11 WLP0.n3 WLP0.t1 380.363
R12 WLP0.n1 WLP0.t2 380.363
R13 WLP0.n0 WLP0.t3 380.363
R14 WLP0.n5 WLP0.t4 379.3
R15 WLP0.n3 WLP0.t5 379.3
R16 WLP0.n1 WLP0.t6 379.3
R17 WLP0.n0 WLP0.t7 379.3
R18 WLP0.n2 WLP0.n0 8.58232
R19 WLP0.n6 WLP0.n5 7.87732
R20 WLP0.n4 WLP0.n3 7.87732
R21 WLP0.n2 WLP0.n1 7.87732
R22 WLP0.n4 WLP0.n2 0.7055
R23 WLP0.n6 WLP0.n4 0.7055
R24 WLP0 WLP0.n6 0.0522
R25 WNEG_0_0.n0 WNEG_0_0.t0 380.207
R26 WNEG_0_0.n0 WNEG_0_0.t1 379.685
R27 WNEG_0_0 WNEG_0_0.n0 0.631182
R28 WPOS_0_3.n0 WPOS_0_3.t0 381.161
R29 WPOS_0_3.n0 WPOS_0_3.t1 379.56
R30 WPOS_0_3 WPOS_0_3.n0 0.113
R31 WPOS_0_2.n0 WPOS_0_2.t0 381.161
R32 WPOS_0_2.n0 WPOS_0_2.t1 379.56
R33 WPOS_0_2 WPOS_0_2.n0 0.113
R34 WPOS_0_1.n0 WPOS_0_1.t0 381.161
R35 WPOS_0_1.n0 WPOS_0_1.t1 379.56
R36 WPOS_0_1 WPOS_0_1.n0 0.113
R37 WLN0.n0 WLN0.t0 380.488
R38 WLN0.n4 WLN0.t1 380.488
R39 WLN0.n2 WLN0.t2 380.488
R40 WLN0.n1 WLN0.t3 380.488
R41 WLN0.n0 WLN0.t4 379.425
R42 WLN0.n4 WLN0.t5 379.425
R43 WLN0.n2 WLN0.t6 379.425
R44 WLN0.n1 WLN0.t7 379.425
R45 WLN0.n3 WLN0.n1 8.34084
R46 WLN0 WLN0.n0 7.65934
R47 WLN0.n5 WLN0.n4 7.63584
R48 WLN0.n3 WLN0.n2 7.63584
R49 WLN0.n5 WLN0.n3 0.7055
R50 WLN0 WLN0.n5 0.682
R51 WPOS_0_0.n0 WPOS_0_0.t0 381.161
R52 WPOS_0_0.n0 WPOS_0_0.t1 379.56
R53 WPOS_0_0 WPOS_0_0.n0 0.113
R54 WNEG_1_3.n0 WNEG_1_3.t0 380.207
R55 WNEG_1_3.n0 WNEG_1_3.t1 379.685
R56 WNEG_1_3 WNEG_1_3.n0 0.631182
R57 WNEG_1_2.n0 WNEG_1_2.t0 380.207
R58 WNEG_1_2.n0 WNEG_1_2.t1 379.685
R59 WNEG_1_2 WNEG_1_2.n0 0.631182
R60 WNEG_1_1.n0 WNEG_1_1.t0 380.207
R61 WNEG_1_1.n0 WNEG_1_1.t1 379.685
R62 WNEG_1_1 WNEG_1_1.n0 0.631182
R63 WLP1.n5 WLP1.t0 380.363
R64 WLP1.n3 WLP1.t1 380.363
R65 WLP1.n1 WLP1.t2 380.363
R66 WLP1.n0 WLP1.t3 380.363
R67 WLP1.n5 WLP1.t4 379.3
R68 WLP1.n3 WLP1.t5 379.3
R69 WLP1.n1 WLP1.t6 379.3
R70 WLP1.n0 WLP1.t7 379.3
R71 WLP1.n2 WLP1.n0 8.58232
R72 WLP1.n6 WLP1.n5 7.87732
R73 WLP1.n4 WLP1.n3 7.87732
R74 WLP1.n2 WLP1.n1 7.87732
R75 WLP1.n4 WLP1.n2 0.7055
R76 WLP1.n6 WLP1.n4 0.7055
R77 WLP1 WLP1.n6 0.0522
R78 WNEG_1_0.n0 WNEG_1_0.t0 380.207
R79 WNEG_1_0.n0 WNEG_1_0.t1 379.685
R80 WNEG_1_0 WNEG_1_0.n0 0.631182
R81 WPOS_1_3.n0 WPOS_1_3.t0 381.161
R82 WPOS_1_3.n0 WPOS_1_3.t1 379.56
R83 WPOS_1_3 WPOS_1_3.n0 0.113
R84 WPOS_1_2.n0 WPOS_1_2.t0 381.161
R85 WPOS_1_2.n0 WPOS_1_2.t1 379.56
R86 WPOS_1_2 WPOS_1_2.n0 0.113
R87 WPOS_1_1.n0 WPOS_1_1.t0 381.161
R88 WPOS_1_1.n0 WPOS_1_1.t1 379.56
R89 WPOS_1_1 WPOS_1_1.n0 0.113
R90 WLN1.n0 WLN1.t0 380.488
R91 WLN1.n4 WLN1.t1 380.488
R92 WLN1.n2 WLN1.t2 380.488
R93 WLN1.n1 WLN1.t3 380.488
R94 WLN1.n0 WLN1.t4 379.425
R95 WLN1.n4 WLN1.t5 379.425
R96 WLN1.n2 WLN1.t6 379.425
R97 WLN1.n1 WLN1.t7 379.425
R98 WLN1.n3 WLN1.n1 8.34084
R99 WLN1 WLN1.n0 7.65934
R100 WLN1.n5 WLN1.n4 7.63584
R101 WLN1.n3 WLN1.n2 7.63584
R102 WLN1.n5 WLN1.n3 0.7055
R103 WLN1 WLN1.n5 0.682
R104 WPOS_1_0.n0 WPOS_1_0.t0 381.161
R105 WPOS_1_0.n0 WPOS_1_0.t1 379.56
R106 WPOS_1_0 WPOS_1_0.n0 0.113
R107 WNEG_2_3.n0 WNEG_2_3.t0 380.207
R108 WNEG_2_3.n0 WNEG_2_3.t1 379.685
R109 WNEG_2_3 WNEG_2_3.n0 0.631182
R110 WNEG_2_2.n0 WNEG_2_2.t0 380.207
R111 WNEG_2_2.n0 WNEG_2_2.t1 379.685
R112 WNEG_2_2 WNEG_2_2.n0 0.631182
R113 WNEG_2_1.n0 WNEG_2_1.t0 380.207
R114 WNEG_2_1.n0 WNEG_2_1.t1 379.685
R115 WNEG_2_1 WNEG_2_1.n0 0.631182
R116 WLP2.n5 WLP2.t0 380.363
R117 WLP2.n3 WLP2.t1 380.363
R118 WLP2.n1 WLP2.t2 380.363
R119 WLP2.n0 WLP2.t3 380.363
R120 WLP2.n5 WLP2.t4 379.3
R121 WLP2.n3 WLP2.t5 379.3
R122 WLP2.n1 WLP2.t6 379.3
R123 WLP2.n0 WLP2.t7 379.3
R124 WLP2.n2 WLP2.n0 8.58232
R125 WLP2.n6 WLP2.n5 7.87732
R126 WLP2.n4 WLP2.n3 7.87732
R127 WLP2.n2 WLP2.n1 7.87732
R128 WLP2.n4 WLP2.n2 0.7055
R129 WLP2.n6 WLP2.n4 0.7055
R130 WLP2 WLP2.n6 0.0522
R131 WNEG_2_0.n0 WNEG_2_0.t0 380.207
R132 WNEG_2_0.n0 WNEG_2_0.t1 379.685
R133 WNEG_2_0 WNEG_2_0.n0 0.631182
R134 WPOS_2_3.n0 WPOS_2_3.t0 381.161
R135 WPOS_2_3.n0 WPOS_2_3.t1 379.56
R136 WPOS_2_3 WPOS_2_3.n0 0.113
R137 WPOS_2_2.n0 WPOS_2_2.t0 381.161
R138 WPOS_2_2.n0 WPOS_2_2.t1 379.56
R139 WPOS_2_2 WPOS_2_2.n0 0.113
R140 WPOS_2_1.n0 WPOS_2_1.t0 381.161
R141 WPOS_2_1.n0 WPOS_2_1.t1 379.56
R142 WPOS_2_1 WPOS_2_1.n0 0.113
R143 WLN2.n0 WLN2.t0 380.488
R144 WLN2.n4 WLN2.t1 380.488
R145 WLN2.n2 WLN2.t2 380.488
R146 WLN2.n1 WLN2.t3 380.488
R147 WLN2.n0 WLN2.t4 379.425
R148 WLN2.n4 WLN2.t5 379.425
R149 WLN2.n2 WLN2.t6 379.425
R150 WLN2.n1 WLN2.t7 379.425
R151 WLN2.n3 WLN2.n1 8.34084
R152 WLN2 WLN2.n0 7.65934
R153 WLN2.n5 WLN2.n4 7.63584
R154 WLN2.n3 WLN2.n2 7.63584
R155 WLN2.n5 WLN2.n3 0.7055
R156 WLN2 WLN2.n5 0.682
R157 WPOS_2_0.n0 WPOS_2_0.t0 381.161
R158 WPOS_2_0.n0 WPOS_2_0.t1 379.56
R159 WPOS_2_0 WPOS_2_0.n0 0.113
R160 BLP3.n1 BLP3.t5 123.175
R161 BLP3.n2 BLP3.t3 123.175
R162 BLP3.n4 BLP3.t2 123.175
R163 BLP3.n0 BLP3.t1 123.175
R164 BLP3.n1 BLP3.t7 122.635
R165 BLP3.n2 BLP3.t4 122.635
R166 BLP3.n4 BLP3.t6 122.635
R167 BLP3.n0 BLP3.t0 122.635
R168 BLP3.n3 BLP3.n1 5.94208
R169 BLP3 BLP3.n0 4.98014
R170 BLP3.n3 BLP3.n2 4.96448
R171 BLP3.n5 BLP3.n4 4.96448
R172 BLP3.n5 BLP3.n3 0.9781
R173 BLP3 BLP3.n5 0.962433
R174 BLP2.n1 BLP2.t7 123.175
R175 BLP2.n2 BLP2.t3 123.175
R176 BLP2.n4 BLP2.t2 123.175
R177 BLP2.n0 BLP2.t1 123.175
R178 BLP2.n1 BLP2.t5 122.635
R179 BLP2.n2 BLP2.t6 122.635
R180 BLP2.n4 BLP2.t4 122.635
R181 BLP2.n0 BLP2.t0 122.635
R182 BLP2.n3 BLP2.n1 5.94208
R183 BLP2 BLP2.n0 4.98014
R184 BLP2.n3 BLP2.n2 4.96448
R185 BLP2.n5 BLP2.n4 4.96448
R186 BLP2.n5 BLP2.n3 0.9781
R187 BLP2 BLP2.n5 0.962433
R188 BLP1.n1 BLP1.t6 123.175
R189 BLP1.n2 BLP1.t4 123.175
R190 BLP1.n4 BLP1.t2 123.175
R191 BLP1.n0 BLP1.t0 123.175
R192 BLP1.n1 BLP1.t7 122.635
R193 BLP1.n2 BLP1.t5 122.635
R194 BLP1.n4 BLP1.t3 122.635
R195 BLP1.n0 BLP1.t1 122.635
R196 BLP1.n3 BLP1.n1 5.94208
R197 BLP1 BLP1.n0 4.98014
R198 BLP1.n3 BLP1.n2 4.96448
R199 BLP1.n5 BLP1.n4 4.96448
R200 BLP1.n5 BLP1.n3 0.9781
R201 BLP1 BLP1.n5 0.962433
R202 BLP0.n1 BLP0.t5 123.175
R203 BLP0.n2 BLP0.t4 123.175
R204 BLP0.n4 BLP0.t3 123.175
R205 BLP0.n0 BLP0.t1 123.175
R206 BLP0.n1 BLP0.t7 122.635
R207 BLP0.n2 BLP0.t6 122.635
R208 BLP0.n4 BLP0.t2 122.635
R209 BLP0.n0 BLP0.t0 122.635
R210 BLP0.n3 BLP0.n1 5.94208
R211 BLP0 BLP0.n0 4.98014
R212 BLP0.n3 BLP0.n2 4.96448
R213 BLP0.n5 BLP0.n4 4.96448
R214 BLP0.n5 BLP0.n3 0.9781
R215 BLP0 BLP0.n5 0.962433
R216 WNEG_3_3.n0 WNEG_3_3.t0 380.207
R217 WNEG_3_3.n0 WNEG_3_3.t1 379.685
R218 WNEG_3_3 WNEG_3_3.n0 0.631182
R219 WNEG_3_2.n0 WNEG_3_2.t0 380.207
R220 WNEG_3_2.n0 WNEG_3_2.t1 379.685
R221 WNEG_3_2 WNEG_3_2.n0 0.631182
R222 WNEG_3_1.n0 WNEG_3_1.t0 380.207
R223 WNEG_3_1.n0 WNEG_3_1.t1 379.685
R224 WNEG_3_1 WNEG_3_1.n0 0.631182
R225 WLP3.n5 WLP3.t0 380.363
R226 WLP3.n3 WLP3.t1 380.363
R227 WLP3.n1 WLP3.t2 380.363
R228 WLP3.n0 WLP3.t3 380.363
R229 WLP3.n5 WLP3.t4 379.3
R230 WLP3.n3 WLP3.t5 379.3
R231 WLP3.n1 WLP3.t6 379.3
R232 WLP3.n0 WLP3.t7 379.3
R233 WLP3.n2 WLP3.n0 8.58232
R234 WLP3.n6 WLP3.n5 7.87732
R235 WLP3.n4 WLP3.n3 7.87732
R236 WLP3.n2 WLP3.n1 7.87732
R237 WLP3.n4 WLP3.n2 0.7055
R238 WLP3.n6 WLP3.n4 0.7055
R239 WLP3 WLP3.n6 0.0522
R240 WNEG_3_0.n0 WNEG_3_0.t0 380.207
R241 WNEG_3_0.n0 WNEG_3_0.t1 379.685
R242 WNEG_3_0 WNEG_3_0.n0 0.631182
R243 BLN3.n1 BLN3.t7 122.95
R244 BLN3.n2 BLN3.t4 122.95
R245 BLN3.n4 BLN3.t6 122.95
R246 BLN3.n0 BLN3.t1 122.95
R247 BLN3.n1 BLN3.t5 122.409
R248 BLN3.n2 BLN3.t3 122.409
R249 BLN3.n4 BLN3.t2 122.409
R250 BLN3.n0 BLN3.t0 122.409
R251 BLN3.n3 BLN3.n1 4.86253
R252 BLN3 BLN3.n0 3.9006
R253 BLN3.n3 BLN3.n2 3.88493
R254 BLN3.n5 BLN3.n4 3.88493
R255 BLN3.n5 BLN3.n3 0.9781
R256 BLN3 BLN3.n5 0.962433
R257 BLN2.n1 BLN2.t5 122.95
R258 BLN2.n2 BLN2.t6 122.95
R259 BLN2.n4 BLN2.t4 122.95
R260 BLN2.n0 BLN2.t1 122.95
R261 BLN2.n1 BLN2.t7 122.409
R262 BLN2.n2 BLN2.t3 122.409
R263 BLN2.n4 BLN2.t2 122.409
R264 BLN2.n0 BLN2.t0 122.409
R265 BLN2.n3 BLN2.n1 4.86253
R266 BLN2 BLN2.n0 3.9006
R267 BLN2.n3 BLN2.n2 3.88493
R268 BLN2.n5 BLN2.n4 3.88493
R269 BLN2.n5 BLN2.n3 0.9781
R270 BLN2 BLN2.n5 0.962433
R271 BLN1.n1 BLN1.t7 122.95
R272 BLN1.n2 BLN1.t5 122.95
R273 BLN1.n4 BLN1.t3 122.95
R274 BLN1.n0 BLN1.t1 122.95
R275 BLN1.n1 BLN1.t6 122.409
R276 BLN1.n2 BLN1.t4 122.409
R277 BLN1.n4 BLN1.t2 122.409
R278 BLN1.n0 BLN1.t0 122.409
R279 BLN1.n3 BLN1.n1 4.86253
R280 BLN1 BLN1.n0 3.9006
R281 BLN1.n3 BLN1.n2 3.88493
R282 BLN1.n5 BLN1.n4 3.88493
R283 BLN1.n5 BLN1.n3 0.9781
R284 BLN1 BLN1.n5 0.962433
R285 VSUBS.n11 VSUBS.t5 123.1
R286 VSUBS.n7 VSUBS.t7 123.1
R287 VSUBS.n3 VSUBS.t4 123.1
R288 VSUBS.n0 VSUBS.t1 123.1
R289 VSUBS.n26 VSUBS.t25 123.1
R290 VSUBS.n22 VSUBS.t26 123.1
R291 VSUBS.n18 VSUBS.t27 123.1
R292 VSUBS.n15 VSUBS.t28 123.1
R293 VSUBS.n59 VSUBS.t39 123.1
R294 VSUBS.n47 VSUBS.t36 123.1
R295 VSUBS.n51 VSUBS.t37 123.1
R296 VSUBS.n55 VSUBS.t38 123.1
R297 VSUBS.n42 VSUBS.t59 123.1
R298 VSUBS.n38 VSUBS.t60 123.1
R299 VSUBS.n34 VSUBS.t61 123.1
R300 VSUBS.n31 VSUBS.t63 123.1
R301 VSUBS.n12 VSUBS.t0 122.559
R302 VSUBS.n11 VSUBS.t15 122.559
R303 VSUBS.n13 VSUBS.t10 122.559
R304 VSUBS.n8 VSUBS.t6 122.559
R305 VSUBS.n7 VSUBS.t9 122.559
R306 VSUBS.n9 VSUBS.t13 122.559
R307 VSUBS.n4 VSUBS.t2 122.559
R308 VSUBS.n3 VSUBS.t8 122.559
R309 VSUBS.n5 VSUBS.t11 122.559
R310 VSUBS.n1 VSUBS.t3 122.559
R311 VSUBS.n0 VSUBS.t12 122.559
R312 VSUBS.n2 VSUBS.t14 122.559
R313 VSUBS.n27 VSUBS.t29 122.559
R314 VSUBS.n26 VSUBS.t17 122.559
R315 VSUBS.n28 VSUBS.t21 122.559
R316 VSUBS.n23 VSUBS.t30 122.559
R317 VSUBS.n22 VSUBS.t18 122.559
R318 VSUBS.n24 VSUBS.t22 122.559
R319 VSUBS.n19 VSUBS.t31 122.559
R320 VSUBS.n18 VSUBS.t19 122.559
R321 VSUBS.n20 VSUBS.t23 122.559
R322 VSUBS.n16 VSUBS.t24 122.559
R323 VSUBS.n15 VSUBS.t20 122.559
R324 VSUBS.n17 VSUBS.t16 122.559
R325 VSUBS.n60 VSUBS.t32 122.559
R326 VSUBS.n59 VSUBS.t47 122.559
R327 VSUBS.n61 VSUBS.t46 122.559
R328 VSUBS.n48 VSUBS.t34 122.559
R329 VSUBS.n47 VSUBS.t43 122.559
R330 VSUBS.n49 VSUBS.t41 122.559
R331 VSUBS.n52 VSUBS.t35 122.559
R332 VSUBS.n51 VSUBS.t40 122.559
R333 VSUBS.n53 VSUBS.t42 122.559
R334 VSUBS.n56 VSUBS.t33 122.559
R335 VSUBS.n55 VSUBS.t45 122.559
R336 VSUBS.n57 VSUBS.t44 122.559
R337 VSUBS.n43 VSUBS.t58 122.559
R338 VSUBS.n42 VSUBS.t50 122.559
R339 VSUBS.n44 VSUBS.t54 122.559
R340 VSUBS.n39 VSUBS.t57 122.559
R341 VSUBS.n38 VSUBS.t48 122.559
R342 VSUBS.n40 VSUBS.t51 122.559
R343 VSUBS.n35 VSUBS.t56 122.559
R344 VSUBS.n34 VSUBS.t53 122.559
R345 VSUBS.n36 VSUBS.t55 122.559
R346 VSUBS.n32 VSUBS.t62 122.559
R347 VSUBS.n31 VSUBS.t52 122.559
R348 VSUBS.n33 VSUBS.t49 122.559
R349 VSUBS.n6 VSUBS.n2 7.5505
R350 VSUBS.n21 VSUBS.n17 7.5505
R351 VSUBS.n37 VSUBS.n33 7.5505
R352 VSUBS.n14 VSUBS.n13 6.8455
R353 VSUBS.n10 VSUBS.n9 6.8455
R354 VSUBS.n6 VSUBS.n5 6.8455
R355 VSUBS.n29 VSUBS.n28 6.8455
R356 VSUBS.n25 VSUBS.n24 6.8455
R357 VSUBS.n21 VSUBS.n20 6.8455
R358 VGND VSUBS.n61 6.8455
R359 VSUBS.n50 VSUBS.n49 6.8455
R360 VSUBS.n54 VSUBS.n53 6.8455
R361 VSUBS.n58 VSUBS.n57 6.8455
R362 VSUBS.n45 VSUBS.n44 6.8455
R363 VSUBS.n41 VSUBS.n40 6.8455
R364 VSUBS.n37 VSUBS.n36 6.8455
R365 VSUBS.n46 VSUBS.n45 4.79418
R366 VSUBS.n30 VSUBS.n14 4.79418
R367 VSUBS.n30 VSUBS.n29 3.81658
R368 VSUBS.n50 VSUBS.n46 3.81658
R369 VSUBS.n46 VSUBS.n30 0.9781
R370 VSUBS.n41 VSUBS.n37 0.7055
R371 VSUBS.n10 VSUBS.n6 0.7055
R372 VSUBS.n14 VSUBS.n10 0.7055
R373 VSUBS.n25 VSUBS.n21 0.7055
R374 VSUBS.n29 VSUBS.n25 0.7055
R375 VSUBS.n58 VSUBS.n54 0.7055
R376 VSUBS.n54 VSUBS.n50 0.7055
R377 VSUBS VSUBS.n41 0.60398
R378 VGND VSUBS.n58 0.603801
R379 VSUBS.n12 VSUBS.n11 0.540273
R380 VSUBS.n8 VSUBS.n7 0.540273
R381 VSUBS.n4 VSUBS.n3 0.540273
R382 VSUBS.n1 VSUBS.n0 0.540273
R383 VSUBS.n27 VSUBS.n26 0.540273
R384 VSUBS.n23 VSUBS.n22 0.540273
R385 VSUBS.n19 VSUBS.n18 0.540273
R386 VSUBS.n16 VSUBS.n15 0.540273
R387 VSUBS.n60 VSUBS.n59 0.540273
R388 VSUBS.n48 VSUBS.n47 0.540273
R389 VSUBS.n52 VSUBS.n51 0.540273
R390 VSUBS.n56 VSUBS.n55 0.540273
R391 VSUBS.n43 VSUBS.n42 0.540273
R392 VSUBS.n39 VSUBS.n38 0.540273
R393 VSUBS.n35 VSUBS.n34 0.540273
R394 VSUBS.n32 VSUBS.n31 0.540273
R395 VSUBS.n13 VSUBS.n12 0.535159
R396 VSUBS.n9 VSUBS.n8 0.535159
R397 VSUBS.n5 VSUBS.n4 0.535159
R398 VSUBS.n2 VSUBS.n1 0.535159
R399 VSUBS.n28 VSUBS.n27 0.535159
R400 VSUBS.n24 VSUBS.n23 0.535159
R401 VSUBS.n20 VSUBS.n19 0.535159
R402 VSUBS.n17 VSUBS.n16 0.535159
R403 VSUBS.n61 VSUBS.n60 0.535159
R404 VSUBS.n49 VSUBS.n48 0.535159
R405 VSUBS.n53 VSUBS.n52 0.535159
R406 VSUBS.n57 VSUBS.n56 0.535159
R407 VSUBS.n44 VSUBS.n43 0.535159
R408 VSUBS.n40 VSUBS.n39 0.535159
R409 VSUBS.n36 VSUBS.n35 0.535159
R410 VSUBS.n33 VSUBS.n32 0.535159
R411 VSUBS.n45 VSUBS 0.10202
R412 BLN0.n1 BLN0.t7 122.95
R413 BLN0.n2 BLN0.t6 122.95
R414 BLN0.n4 BLN0.t1 122.95
R415 BLN0.n0 BLN0.t3 122.95
R416 BLN0.n1 BLN0.t5 122.409
R417 BLN0.n2 BLN0.t4 122.409
R418 BLN0.n4 BLN0.t2 122.409
R419 BLN0.n0 BLN0.t0 122.409
R420 BLN0.n3 BLN0.n1 4.86253
R421 BLN0 BLN0.n0 3.9006
R422 BLN0.n3 BLN0.n2 3.88493
R423 BLN0.n5 BLN0.n4 3.88493
R424 BLN0.n5 BLN0.n3 0.9781
R425 BLN0 BLN0.n5 0.962433
R426 WPOS_3_3.n0 WPOS_3_3.t0 381.161
R427 WPOS_3_3.n0 WPOS_3_3.t1 379.56
R428 WPOS_3_3 WPOS_3_3.n0 0.113
R429 WPOS_3_2.n0 WPOS_3_2.t0 381.161
R430 WPOS_3_2.n0 WPOS_3_2.t1 379.56
R431 WPOS_3_2 WPOS_3_2.n0 0.113
R432 WPOS_3_1.n0 WPOS_3_1.t0 381.161
R433 WPOS_3_1.n0 WPOS_3_1.t1 379.56
R434 WPOS_3_1 WPOS_3_1.n0 0.113
R435 WLN3.n0 WLN3.t0 380.488
R436 WLN3.n4 WLN3.t1 380.488
R437 WLN3.n2 WLN3.t2 380.488
R438 WLN3.n1 WLN3.t3 380.488
R439 WLN3.n0 WLN3.t4 379.425
R440 WLN3.n4 WLN3.t5 379.425
R441 WLN3.n2 WLN3.t6 379.425
R442 WLN3.n1 WLN3.t7 379.425
R443 WLN3.n3 WLN3.n1 8.34084
R444 WLN3 WLN3.n0 7.65934
R445 WLN3.n5 WLN3.n4 7.63584
R446 WLN3.n3 WLN3.n2 7.63584
R447 WLN3.n5 WLN3.n3 0.7055
R448 WLN3 WLN3.n5 0.682
R449 WPOS_3_0.n0 WPOS_3_0.t0 381.161
R450 WPOS_3_0.n0 WPOS_3_0.t1 379.56
R451 WPOS_3_0 WPOS_3_0.n0 0.113
R452 a_4755_76.t0 a_4755_76.t1 235.993
R453 a_3255_76.t0 a_3255_76.t1 235.993
R454 a_1755_76.t0 a_1755_76.t1 235.993
R455 a_255_76.t0 a_255_76.t1 235.993
R456 a_4755_456.t0 a_4755_456.t1 235.993
R457 a_3255_456.t0 a_3255_456.t1 235.993
R458 a_1755_456.t0 a_1755_456.t1 235.993
R459 a_255_456.t0 a_255_456.t1 235.993
R460 a_4755_836.t0 a_4755_836.t1 235.993
R461 a_3255_836.t0 a_3255_836.t1 235.993
R462 a_1755_836.t0 a_1755_836.t1 235.993
R463 a_255_836.t0 a_255_836.t1 235.993
R464 a_4755_1216.t0 a_4755_1216.t1 235.993
R465 a_3255_1216.t0 a_3255_1216.t1 235.993
R466 a_1755_1216.t0 a_1755_1216.t1 235.993
R467 a_255_1216.t0 a_255_1216.t1 235.993
R468 a_4755_2176.t0 a_4755_2176.t1 235.993
R469 a_3255_2176.t0 a_3255_2176.t1 235.993
R470 a_1755_2176.t0 a_1755_2176.t1 235.993
R471 a_255_2176.t0 a_255_2176.t1 235.993
R472 a_4755_2556.t0 a_4755_2556.t1 235.993
R473 a_3255_2556.t0 a_3255_2556.t1 235.993
R474 a_1755_2556.t0 a_1755_2556.t1 235.993
R475 a_255_2556.t0 a_255_2556.t1 235.993
R476 a_4755_2936.t0 a_4755_2936.t1 235.993
R477 a_3255_2936.t0 a_3255_2936.t1 235.993
R478 a_1755_2936.t0 a_1755_2936.t1 235.993
R479 a_255_2936.t0 a_255_2936.t1 235.993
R480 a_4755_3316.t0 a_4755_3316.t1 235.993
R481 a_3255_3316.t0 a_3255_3316.t1 235.993
R482 a_1755_3316.t0 a_1755_3316.t1 235.993
R483 a_255_3316.t0 a_255_3316.t1 235.993
R484 a_4755_4276.t0 a_4755_4276.t1 235.993
R485 a_3255_4276.t0 a_3255_4276.t1 235.993
R486 a_1755_4276.t0 a_1755_4276.t1 235.993
R487 a_255_4276.t0 a_255_4276.t1 235.993
R488 a_4755_4656.t0 a_4755_4656.t1 235.993
R489 a_3255_4656.t0 a_3255_4656.t1 235.993
R490 a_1755_4656.t0 a_1755_4656.t1 235.993
R491 a_255_4656.t0 a_255_4656.t1 235.993
R492 a_4755_5036.t0 a_4755_5036.t1 235.993
R493 a_3255_5036.t0 a_3255_5036.t1 235.993
R494 a_1755_5036.t0 a_1755_5036.t1 235.993
R495 a_255_5036.t0 a_255_5036.t1 235.993
R496 a_4755_5416.t0 a_4755_5416.t1 235.993
R497 a_3255_5416.t0 a_3255_5416.t1 235.993
R498 a_1755_5416.t0 a_1755_5416.t1 235.993
R499 a_255_5416.t0 a_255_5416.t1 235.993
R500 a_4755_6376.t0 a_4755_6376.t1 235.993
R501 a_3255_6376.t0 a_3255_6376.t1 235.993
R502 a_1755_6376.t0 a_1755_6376.t1 235.993
R503 a_255_6376.t0 a_255_6376.t1 235.993
R504 a_4755_6756.t0 a_4755_6756.t1 235.993
R505 a_3255_6756.t0 a_3255_6756.t1 235.993
R506 a_1755_6756.t0 a_1755_6756.t1 235.993
R507 a_255_6756.t0 a_255_6756.t1 235.993
R508 a_4755_7136.t0 a_4755_7136.t1 235.993
R509 a_3255_7136.t0 a_3255_7136.t1 235.993
R510 a_1755_7136.t0 a_1755_7136.t1 235.993
R511 a_255_7136.t0 a_255_7136.t1 235.993
R512 a_4755_7516.t0 a_4755_7516.t1 235.993
R513 a_3255_7516.t0 a_3255_7516.t1 235.993
R514 a_1755_7516.t0 a_1755_7516.t1 235.993
R515 a_255_7516.t0 a_255_7516.t1 235.993
C0 BLN1 WPOS_3_1 0.59779f
C1 WPOS_3_1 WLN3 0.64691f
C2 WLN1 VSUBS 3.92009f
C3 WNEG_0_2 VSUBS 0.30594f
C4 BLN3 WPOS_3_3 0.59779f
C5 BLP2 VSUBS 0.65951f
C6 WNEG_0_3 WLN0 0.76095f
C7 WNEG_2_3 WPOS_2_3 0.86289f
C8 WPOS_0_1 WNEG_0_1 0.86289f
C9 WPOS_2_2 WNEG_2_2 0.86289f
C10 WLP2 WPOS_2_0 0.42393f
C11 BLN1 WLN2 0.19827f
C12 WLN2 WLN3 0.13504f
C13 WPOS_3_2 WLP3 0.51307f
C14 WLP1 VSUBS 2.17301f
C15 WLN2 WNEG_2_2 0.76095f
C16 BLN1 BLP1 6.33714f
C17 BLP1 WLN3 0.44726f
C18 WNEG_0_3 WPOS_0_3 0.86289f
C19 BLN0 WLN1 0.10748f
C20 WLP0 WNEG_0_2 1.37894f
C21 BLP2 WLP0 0.18825f
C22 WNEG_1_2 BLN2 0.59948f
C23 WLN2 WPOS_2_2 0.64622f
C24 WPOS_2_0 WNEG_2_0 0.86289f
C25 WNEG_0_3 VSUBS 0.34815f
C26 WNEG_3_2 BLN2 0.59904f
C27 BLN3 WLN1 0.19827f
C28 WLP2 WLP3 0.11417f
C29 WLP0 WLP1 0.11417f
C30 BLN0 WLP1 0.11093f
C31 WLN0 WNEG_0_1 0.76095f
C32 WNEG_1_0 VSUBS 0.31219f
C33 WLP2 WNEG_2_0 1.34725f
C34 WLN2 BLP1 0.58176f
C35 BLN3 WLP1 0.21946f
C36 WNEG_0_3 WLP0 1.37894f
C37 WLN0 BLN2 0.19827f
C38 WPOS_2_3 VSUBS 0.8688f
C39 BLN1 WPOS_0_1 0.60509f
C40 WNEG_3_1 WLP3 1.37897f
C41 WPOS_1_3 WLN1 0.64621f
C42 WPOS_3_0 VSUBS 0.80557f
C43 WNEG_0_3 BLN3 0.59943f
C44 WLN3 WNEG_3_2 0.76095f
C45 BLN0 WNEG_1_0 0.59948f
C46 WNEG_0_1 VSUBS 0.30594f
C47 WPOS_2_1 WNEG_2_1 0.86289f
C48 WNEG_2_1 VSUBS 0.30594f
C49 WLP1 WPOS_1_3 0.51208f
C50 WNEG_3_3 WLN3 0.76095f
C51 BLN2 VSUBS 0.9253f
C52 WNEG_3_0 WPOS_3_0 0.86289f
C53 BLN0 WPOS_3_0 0.59779f
C54 WLP2 BLP3 0.18835f
C55 WPOS_1_2 WLN1 0.64622f
C56 WNEG_1_1 VSUBS 0.30611f
C57 BLN3 WPOS_2_3 0.61078f
C58 WLP0 WNEG_0_1 1.37894f
C59 BLN1 WLN0 0.19827f
C60 WNEG_2_3 WLN2 0.76095f
C61 WPOS_3_3 WLP3 0.51307f
C62 WPOS_1_2 WLP1 0.51208f
C63 WLP0 BLN2 0.2191f
C64 WPOS_0_2 WNEG_0_2 0.86289f
C65 WLN1 WPOS_1_0 0.62254f
C66 BLN1 WPOS_2_1 0.61078f
C67 BLN1 VSUBS 0.92647f
C68 WLN3 VSUBS 1.33234f
C69 WLP2 WLN1 0.13288f
C70 WLP2 BLP2 0.18835f
C71 WLP1 WPOS_1_0 0.42393f
C72 WNEG_2_2 VSUBS 0.30594f
C73 WLN0 BLP1 0.58176f
C74 WPOS_3_1 VSUBS 0.81812f
C75 WPOS_2_2 VSUBS 0.83918f
C76 WLN1 WPOS_1_1 0.64622f
C77 WLP2 WLP1 0.11417f
C78 BLN1 WLP0 0.2191f
C79 WLN3 WNEG_3_0 0.74998f
C80 WLN2 WPOS_2_1 0.64622f
C81 WLN2 VSUBS 3.91428f
C82 BLN3 WLN3 0.10598f
C83 WNEG_1_0 WPOS_1_0 0.86289f
C84 WLP1 WPOS_1_1 0.51208f
C85 BLP1 VSUBS 0.66486f
C86 WPOS_0_1 WLN0 0.64622f
C87 WPOS_1_2 BLN2 0.61078f
C88 WLN2 BLN0 0.10748f
C89 BLP3 WLN1 0.58176f
C90 WLN2 BLN3 0.19827f
C91 BLP1 WLP0 0.18825f
C92 BLN0 BLP1 0.16712f
C93 WLP2 WPOS_2_3 0.51208f
C94 WPOS_3_2 BLN2 0.59779f
C95 WPOS_3_0 WLP3 0.42393f
C96 WNEG_1_3 VSUBS 0.34815f
C97 WPOS_0_2 BLN2 0.60509f
C98 WPOS_0_1 VSUBS 0.83945f
C99 BLP3 WLP1 0.18835f
C100 WLP2 WNEG_2_1 1.37894f
C101 WNEG_1_2 VSUBS 0.30594f
C102 WNEG_3_2 VSUBS 0.30517f
C103 WNEG_2_3 VSUBS 0.34815f
C104 WLP2 BLN2 0.21946f
C105 BLN2 WLP3 0.13395f
C106 WNEG_3_3 VSUBS 0.30517f
C107 BLP2 WLN1 0.58176f
C108 WPOS_0_1 WLP0 0.51208f
C109 WLN0 WNEG_0_0 0.74998f
C110 WNEG_1_3 BLN3 0.59948f
C111 WLN0 WPOS_0_3 0.64621f
C112 WPOS_3_2 WLN3 0.64691f
C113 WNEG_1_1 WPOS_1_1 0.86289f
C114 WLN0 VSUBS 3.92395f
C115 WLP1 WLN1 6.49286f
C116 BLP2 WLP1 0.18835f
C117 WNEG_2_3 BLN3 0.59948f
C118 BLN1 WLP2 0.21946f
C119 WNEG_0_0 VSUBS 0.30843f
C120 WNEG_3_3 BLN3 0.59904f
C121 BLN1 WLP3 0.13395f
C122 WLN3 WLP3 6.49952f
C123 WLN2 WPOS_2_0 0.62254f
C124 WNEG_1_3 WPOS_1_3 0.86289f
C125 WPOS_0_3 VSUBS 0.86907f
C126 WLP2 WNEG_2_2 1.37894f
C127 WPOS_2_1 VSUBS 0.83918f
C128 WLN0 WLP0 6.49286f
C129 BLN0 WLN0 0.1074f
C130 WLP2 WPOS_2_2 0.51208f
C131 BLN1 WPOS_1_1 0.61078f
C132 WNEG_1_0 WLN1 0.74998f
C133 BLP3 BLN2 0.16712f
C134 BLN3 WLN0 0.19827f
C135 WPOS_3_1 WLP3 0.51307f
C136 BLN1 WNEG_3_1 0.59904f
C137 WLN3 WNEG_3_1 0.76095f
C138 WLP0 WNEG_0_0 1.34725f
C139 BLN0 WNEG_0_0 0.59943f
C140 WLN2 WLP2 6.49286f
C141 WLP0 WPOS_0_3 0.51208f
C142 WLN2 WLP3 0.13288f
C143 WNEG_1_0 WLP1 1.34725f
C144 WLP0 VSUBS 2.04494f
C145 WNEG_3_0 VSUBS 0.29987f
C146 WLP2 BLP1 0.18835f
C147 WPOS_3_1 WNEG_3_1 0.86289f
C148 BLN0 VSUBS 0.46054f
C149 BLN3 WPOS_0_3 0.60509f
C150 WPOS_1_2 WNEG_1_2 0.86289f
C151 WLN2 WNEG_2_0 0.74998f
C152 BLN3 VSUBS 1.06496f
C153 WLN1 BLN2 0.19827f
C154 BLP3 WLN3 0.44726f
C155 BLN2 WNEG_0_2 0.59943f
C156 BLP2 BLN2 6.33714f
C157 BLN0 WLP0 0.11058f
C158 BLN0 WNEG_3_0 0.59904f
C159 WLN3 WPOS_3_3 0.64691f
C160 WNEG_1_1 WLN1 0.76095f
C161 WPOS_3_2 WNEG_3_2 0.86289f
C162 WPOS_0_0 WLN0 0.62254f
C163 BLN3 WLP0 0.2191f
C164 WPOS_1_3 VSUBS 0.8688f
C165 WLP1 BLN2 0.21946f
C166 WNEG_1_1 WLP1 1.37894f
C167 WLN2 BLP3 0.58176f
C168 WPOS_0_0 WNEG_0_0 0.86289f
C169 WNEG_2_3 WLP2 1.37894f
C170 WNEG_3_2 WLP3 1.37897f
C171 BLN1 WLN1 0.19827f
C172 BLN1 BLP2 0.16712f
C173 WPOS_0_0 VSUBS 0.83844f
C174 WLN0 WPOS_0_2 0.64622f
C175 BLP2 WLN3 0.44726f
C176 WNEG_3_3 WLP3 1.37897f
C177 WPOS_1_2 VSUBS 0.83918f
C178 BLN3 WPOS_1_3 0.61078f
C179 BLN1 WLP1 0.21946f
C180 WPOS_2_0 VSUBS 0.83146f
C181 WPOS_3_2 VSUBS 0.81812f
C182 WPOS_0_0 WLP0 0.42393f
C183 WPOS_0_0 BLN0 0.60509f
C184 WLN2 WLN1 0.13504f
C185 WPOS_0_2 VSUBS 0.83945f
C186 WLN2 BLP2 0.58176f
C187 WPOS_1_0 VSUBS 0.86941f
C188 BLP1 WLN1 0.58176f
C189 WLP2 WPOS_2_1 0.51208f
C190 WLP2 VSUBS 2.04487f
C191 WPOS_2_0 BLN0 0.61078f
C192 WLP3 VSUBS 1.91512f
C193 WPOS_0_2 WLP0 0.51208f
C194 BLP1 WLP1 0.18835f
C195 BLN0 WPOS_1_0 0.61078f
C196 WPOS_1_1 VSUBS 0.84038f
C197 WLN3 WPOS_3_0 0.62254f
C198 WNEG_2_0 VSUBS 0.30801f
C199 WNEG_3_3 WPOS_3_3 0.86289f
C200 WNEG_3_1 VSUBS 0.30517f
C201 WLP2 BLN0 0.11093f
C202 WNEG_1_3 WLN1 0.76095f
C203 BLN1 WNEG_0_1 0.59943f
C204 BLP0 BLN0 6.33714f
C205 WNEG_3_0 WLP3 1.34725f
C206 WLN0 BLP3 0.58176f
C207 BLN1 WNEG_2_1 0.59948f
C208 WLP2 BLN3 0.21946f
C209 WNEG_1_2 WLN1 0.76095f
C210 BLN3 WLP3 0.13395f
C211 WLN3 BLN2 0.10598f
C212 BLN0 WNEG_2_0 0.59948f
C213 WLN2 WPOS_2_3 0.64621f
C214 WNEG_1_3 WLP1 1.37894f
C215 BLN1 WNEG_1_1 0.59948f
C216 BLN2 WNEG_2_2 0.59948f
C217 WNEG_1_2 WLP1 1.37894f
C218 WPOS_2_2 BLN2 0.61078f
C219 BLP3 VSUBS 0.65951f
C220 WLN2 WNEG_2_1 0.76095f
C221 WPOS_3_3 VSUBS 0.81812f
C222 WLN2 BLN2 0.19827f
C223 WLN0 WLN1 0.13504f
C224 WLN0 WNEG_0_2 0.76095f
C225 BLP2 WLN0 0.58176f
C226 BLN1 WLN3 0.10598f
C227 BLP3 WLP0 0.18825f
C228 WLN0 WLP1 0.13288f
C229 BLN3 BLP3 6.33714f
C230 WNEG_0_3 w_n20_50# 0.82572f
C231 WNEG_0_2 w_n20_50# 0.82718f
C232 WNEG_0_1 w_n20_50# 0.82718f
C233 WLP0 w_n20_50# 3.51645f
C234 WNEG_0_0 w_n20_50# 0.83705f
C235 WPOS_0_3 w_n20_50# 0.71111f
C236 WPOS_0_2 w_n20_50# 0.71204f
C237 WPOS_0_1 w_n20_50# 0.71204f
C238 WLN0 w_n20_50# 4.18257f
C239 WPOS_0_0 w_n20_50# 0.72917f
C240 WNEG_1_3 w_n20_50# 0.81805f
C241 WNEG_1_2 w_n20_50# 0.81951f
C242 WNEG_1_1 w_n20_50# 0.81953f
C243 WLP1 w_n20_50# 3.12709f
C244 WNEG_1_0 w_n20_50# 0.82956f
C245 WPOS_1_3 w_n20_50# 0.68293f
C246 WPOS_1_2 w_n20_50# 0.68385f
C247 WPOS_1_1 w_n20_50# 0.68388f
C248 WLN1 w_n20_50# 4.07151f
C249 WPOS_1_0 w_n20_50# 0.70159f
C250 WNEG_2_3 w_n20_50# 0.81805f
C251 WNEG_2_2 w_n20_50# 0.81951f
C252 WNEG_2_1 w_n20_50# 0.81951f
C253 WLP2 w_n20_50# 3.12601f
C254 WNEG_2_0 w_n20_50# 0.82924f
C255 WPOS_2_3 w_n20_50# 0.68293f
C256 WPOS_2_2 w_n20_50# 0.68385f
C257 WPOS_2_1 w_n20_50# 0.68385f
C258 WLN2 w_n20_50# 4.07123f
C259 WPOS_2_0 w_n20_50# 0.70075f
C260 BLP3 w_n20_50# 3.28394f
C261 BLP2 w_n20_50# 3.28394f
C262 BLP1 w_n20_50# 3.28436f
C263 BLP0 w_n20_50# 5.18906f
C264 WNEG_3_3 w_n20_50# 0.85634f
C265 WNEG_3_2 w_n20_50# 0.82707f
C266 WNEG_3_1 w_n20_50# 0.82707f
C267 WLP3 w_n20_50# 3.36765f
C268 WNEG_3_0 w_n20_50# 0.83624f
C269 BLN3 w_n20_50# 2.92308f
C270 BLN2 w_n20_50# 2.88729f
C271 BLN1 w_n20_50# 2.88737f
C272 VSUBS w_n20_50# 16.22019f
C273 VGND w_n20_50# 1.43795f
C274 BLN0 w_n20_50# 2.92702f
C275 WPOS_3_3 w_n20_50# 0.81175f
C276 WPOS_3_2 w_n20_50# 0.78417f
C277 WPOS_3_1 w_n20_50# 0.78417f
C278 WLN3 w_n20_50# 5.16338f
C279 WPOS_3_0 w_n20_50# 0.80203f
C280 a_255_7516.t1 w_n20_50# 0.35227f
C281 a_255_7516.t0 w_n20_50# 0.33659f
C282 a_1755_7516.t1 w_n20_50# 0.33785f
C283 a_1755_7516.t0 w_n20_50# 0.35533f
C284 a_3255_7516.t1 w_n20_50# 0.35533f
C285 a_3255_7516.t0 w_n20_50# 0.33785f
C286 a_4755_7516.t1 w_n20_50# 0.35479f
C287 a_4755_7516.t0 w_n20_50# 0.33774f
C288 a_255_7136.t1 w_n20_50# 0.36469f
C289 a_255_7136.t0 w_n20_50# 0.34904f
C290 a_1755_7136.t1 w_n20_50# 0.34984f
C291 a_1755_7136.t0 w_n20_50# 0.36616f
C292 a_3255_7136.t1 w_n20_50# 0.34984f
C293 a_3255_7136.t0 w_n20_50# 0.36616f
C294 a_4755_7136.t1 w_n20_50# 0.34973f
C295 a_4755_7136.t0 w_n20_50# 0.36546f
C296 a_255_6756.t1 w_n20_50# 0.36609f
C297 a_255_6756.t0 w_n20_50# 0.34422f
C298 a_1755_6756.t1 w_n20_50# 0.36772f
C299 a_1755_6756.t0 w_n20_50# 0.34517f
C300 a_3255_6756.t1 w_n20_50# 0.36772f
C301 a_3255_6756.t0 w_n20_50# 0.34517f
C302 a_4755_6756.t1 w_n20_50# 0.36701f
C303 a_4755_6756.t0 w_n20_50# 0.34506f
C304 a_255_6376.t1 w_n20_50# 0.29811f
C305 a_255_6376.t0 w_n20_50# 0.30938f
C306 a_1755_6376.t1 w_n20_50# 0.30275f
C307 a_1755_6376.t0 w_n20_50# 0.31595f
C308 a_3255_6376.t1 w_n20_50# 0.30275f
C309 a_3255_6376.t0 w_n20_50# 0.31595f
C310 a_4755_6376.t1 w_n20_50# 0.31541f
C311 a_4755_6376.t0 w_n20_50# 0.30267f
C312 a_255_5416.t1 w_n20_50# 0.35611f
C313 a_255_5416.t0 w_n20_50# 0.34674f
C314 a_1755_5416.t1 w_n20_50# 0.34796f
C315 a_1755_5416.t0 w_n20_50# 0.35903f
C316 a_3255_5416.t1 w_n20_50# 0.34796f
C317 a_3255_5416.t0 w_n20_50# 0.35903f
C318 a_4755_5416.t1 w_n20_50# 0.34797f
C319 a_4755_5416.t0 w_n20_50# 0.35901f
C320 a_255_5036.t1 w_n20_50# 0.35094f
C321 a_255_5036.t0 w_n20_50# 0.36492f
C322 a_1755_5036.t1 w_n20_50# 0.36629f
C323 a_1755_5036.t0 w_n20_50# 0.35174f
C324 a_3255_5036.t1 w_n20_50# 0.36629f
C325 a_3255_5036.t0 w_n20_50# 0.35174f
C326 a_4755_5036.t1 w_n20_50# 0.36625f
C327 a_4755_5036.t0 w_n20_50# 0.35175f
C328 a_255_4656.t1 w_n20_50# 0.35249f
C329 a_255_4656.t0 w_n20_50# 0.36633f
C330 a_1755_4656.t1 w_n20_50# 0.36786f
C331 a_1755_4656.t0 w_n20_50# 0.35344f
C332 a_3255_4656.t1 w_n20_50# 0.36786f
C333 a_3255_4656.t0 w_n20_50# 0.35344f
C334 a_4755_4656.t1 w_n20_50# 0.36782f
C335 a_4755_4656.t0 w_n20_50# 0.35344f
C336 a_255_4276.t1 w_n20_50# 0.31104f
C337 a_255_4276.t0 w_n20_50# 0.30008f
C338 a_1755_4276.t1 w_n20_50# 0.31751f
C339 a_1755_4276.t0 w_n20_50# 0.30472f
C340 a_3255_4276.t1 w_n20_50# 0.31751f
C341 a_3255_4276.t0 w_n20_50# 0.30472f
C342 a_4755_4276.t1 w_n20_50# 0.31749f
C343 a_4755_4276.t0 w_n20_50# 0.30473f
C344 a_255_3316.t1 w_n20_50# 0.34675f
C345 a_255_3316.t0 w_n20_50# 0.35663f
C346 a_1755_3316.t1 w_n20_50# 0.34797f
C347 a_1755_3316.t0 w_n20_50# 0.35905f
C348 a_3255_3316.t1 w_n20_50# 0.34797f
C349 a_3255_3316.t0 w_n20_50# 0.35903f
C350 a_4755_3316.t1 w_n20_50# 0.34798f
C351 a_4755_3316.t0 w_n20_50# 0.35901f
C352 a_255_2936.t1 w_n20_50# 0.36497f
C353 a_255_2936.t0 w_n20_50# 0.35124f
C354 a_1755_2936.t1 w_n20_50# 0.35204f
C355 a_1755_2936.t0 w_n20_50# 0.36629f
C356 a_3255_2936.t1 w_n20_50# 0.35204f
C357 a_3255_2936.t0 w_n20_50# 0.36629f
C358 a_4755_2936.t1 w_n20_50# 0.36625f
C359 a_4755_2936.t0 w_n20_50# 0.35205f
C360 a_255_2556.t1 w_n20_50# 0.36638f
C361 a_255_2556.t0 w_n20_50# 0.3525f
C362 a_1755_2556.t1 w_n20_50# 0.36786f
C363 a_1755_2556.t0 w_n20_50# 0.35345f
C364 a_3255_2556.t1 w_n20_50# 0.36786f
C365 a_3255_2556.t0 w_n20_50# 0.35345f
C366 a_4755_2556.t1 w_n20_50# 0.36782f
C367 a_4755_2556.t0 w_n20_50# 0.35346f
C368 a_255_2176.t1 w_n20_50# 0.30094f
C369 a_255_2176.t0 w_n20_50# 0.31214f
C370 a_1755_2176.t1 w_n20_50# 0.30524f
C371 a_1755_2176.t0 w_n20_50# 0.31774f
C372 a_3255_2176.t1 w_n20_50# 0.30503f
C373 a_3255_2176.t0 w_n20_50# 0.31751f
C374 a_4755_2176.t1 w_n20_50# 0.30504f
C375 a_4755_2176.t0 w_n20_50# 0.31749f
C376 a_255_1216.t1 w_n20_50# 0.34646f
C377 a_255_1216.t0 w_n20_50# 0.35579f
C378 a_1755_1216.t1 w_n20_50# 0.34768f
C379 a_1755_1216.t0 w_n20_50# 0.35857f
C380 a_3255_1216.t1 w_n20_50# 0.34768f
C381 a_3255_1216.t0 w_n20_50# 0.35857f
C382 a_4755_1216.t1 w_n20_50# 0.34769f
C383 a_4755_1216.t0 w_n20_50# 0.35854f
C384 a_255_836.t1 w_n20_50# 0.3648f
C385 a_255_836.t0 w_n20_50# 0.34997f
C386 a_1755_836.t1 w_n20_50# 0.36615f
C387 a_1755_836.t0 w_n20_50# 0.35077f
C388 a_3255_836.t1 w_n20_50# 0.35077f
C389 a_3255_836.t0 w_n20_50# 0.36615f
C390 a_4755_836.t1 w_n20_50# 0.36611f
C391 a_4755_836.t0 w_n20_50# 0.35077f
C392 a_255_456.t1 w_n20_50# 0.36618f
C393 a_255_456.t0 w_n20_50# 0.35214f
C394 a_1755_456.t1 w_n20_50# 0.36768f
C395 a_1755_456.t0 w_n20_50# 0.35308f
C396 a_3255_456.t1 w_n20_50# 0.35308f
C397 a_3255_456.t0 w_n20_50# 0.36768f
C398 a_4755_456.t1 w_n20_50# 0.35309f
C399 a_4755_456.t0 w_n20_50# 0.36764f
C400 a_255_76.t1 w_n20_50# 0.2877f
C401 a_255_76.t0 w_n20_50# 0.2993f
C402 a_1755_76.t1 w_n20_50# 0.291f
C403 a_1755_76.t0 w_n20_50# 0.30428f
C404 a_3255_76.t1 w_n20_50# 0.30428f
C405 a_3255_76.t0 w_n20_50# 0.291f
C406 a_4755_76.t1 w_n20_50# 0.30425f
C407 a_4755_76.t0 w_n20_50# 0.29101f
C408 WPOS_3_0.n0 w_n20_50# 3.3901f
C409 WLN3.n0 w_n20_50# 2.73525f
C410 WLN3.n1 w_n20_50# 2.80667f
C411 WLN3.n2 w_n20_50# 2.73479f
C412 WLN3.n3 w_n20_50# 2.0448f
C413 WLN3.n4 w_n20_50# 2.73479f
C414 WLN3.n5 w_n20_50# 1.24674f
C415 WPOS_3_1.n0 w_n20_50# 3.51172f
C416 WPOS_3_2.n0 w_n20_50# 3.51172f
C417 WPOS_3_3.n0 w_n20_50# 3.48299f
C418 BLN0.t0 w_n20_50# 0.13527f
C419 BLN0.t3 w_n20_50# 0.14635f
C420 BLN0.n0 w_n20_50# 1.71286f
C421 BLN0.t5 w_n20_50# 0.1365f
C422 BLN0.t7 w_n20_50# 0.14649f
C423 BLN0.n1 w_n20_50# 2.18859f
C424 BLN0.t4 w_n20_50# 0.13734f
C425 BLN0.t6 w_n20_50# 0.14663f
C426 BLN0.n2 w_n20_50# 1.71242f
C427 BLN0.n3 w_n20_50# 3.81347f
C428 BLN0.t2 w_n20_50# 0.13682f
C429 BLN0.t1 w_n20_50# 0.14658f
C430 BLN0.n4 w_n20_50# 1.71242f
C431 BLN0.n5 w_n20_50# 1.90634f
C432 VSUBS.t1 w_n20_50# 0.10651f
C433 VSUBS.t12 w_n20_50# 0.11071f
C434 VSUBS.n0 w_n20_50# 0.94707f
C435 VSUBS.t3 w_n20_50# 0.10593f
C436 VSUBS.n1 w_n20_50# 0.40668f
C437 VSUBS.t14 w_n20_50# 0.1123f
C438 VSUBS.n2 w_n20_50# 0.45215f
C439 VSUBS.t4 w_n20_50# 0.10651f
C440 VSUBS.t8 w_n20_50# 0.11071f
C441 VSUBS.n3 w_n20_50# 0.94707f
C442 VSUBS.t2 w_n20_50# 0.10593f
C443 VSUBS.n4 w_n20_50# 0.40668f
C444 VSUBS.t11 w_n20_50# 0.1123f
C445 VSUBS.n5 w_n20_50# 0.3926f
C446 VSUBS.n6 w_n20_50# 1.71951f
C447 VSUBS.t7 w_n20_50# 0.10651f
C448 VSUBS.t9 w_n20_50# 0.11071f
C449 VSUBS.n7 w_n20_50# 0.94707f
C450 VSUBS.t6 w_n20_50# 0.10593f
C451 VSUBS.n8 w_n20_50# 0.40668f
C452 VSUBS.t13 w_n20_50# 0.1123f
C453 VSUBS.n9 w_n20_50# 0.3926f
C454 VSUBS.n10 w_n20_50# 1.1414f
C455 VSUBS.t5 w_n20_50# 0.10651f
C456 VSUBS.t15 w_n20_50# 0.11071f
C457 VSUBS.n11 w_n20_50# 0.94707f
C458 VSUBS.t0 w_n20_50# 0.10593f
C459 VSUBS.n12 w_n20_50# 0.40668f
C460 VSUBS.t10 w_n20_50# 0.1123f
C461 VSUBS.n13 w_n20_50# 0.3926f
C462 VSUBS.n14 w_n20_50# 1.39866f
C463 VSUBS.t28 w_n20_50# 0.11437f
C464 VSUBS.t20 w_n20_50# 0.1126f
C465 VSUBS.n15 w_n20_50# 0.94707f
C466 VSUBS.t24 w_n20_50# 0.1142f
C467 VSUBS.n16 w_n20_50# 0.40668f
C468 VSUBS.t16 w_n20_50# 0.11427f
C469 VSUBS.n17 w_n20_50# 0.45215f
C470 VSUBS.t27 w_n20_50# 0.11437f
C471 VSUBS.t19 w_n20_50# 0.1126f
C472 VSUBS.n18 w_n20_50# 0.94707f
C473 VSUBS.t31 w_n20_50# 0.1142f
C474 VSUBS.n19 w_n20_50# 0.40668f
C475 VSUBS.t23 w_n20_50# 0.11427f
C476 VSUBS.n20 w_n20_50# 0.3926f
C477 VSUBS.n21 w_n20_50# 1.71951f
C478 VSUBS.t26 w_n20_50# 0.11437f
C479 VSUBS.t18 w_n20_50# 0.1126f
C480 VSUBS.n22 w_n20_50# 0.94707f
C481 VSUBS.t30 w_n20_50# 0.1142f
C482 VSUBS.n23 w_n20_50# 0.40668f
C483 VSUBS.t22 w_n20_50# 0.11427f
C484 VSUBS.n24 w_n20_50# 0.3926f
C485 VSUBS.n25 w_n20_50# 1.1414f
C486 VSUBS.t25 w_n20_50# 0.11437f
C487 VSUBS.t17 w_n20_50# 0.1126f
C488 VSUBS.n26 w_n20_50# 0.94707f
C489 VSUBS.t29 w_n20_50# 0.1142f
C490 VSUBS.n27 w_n20_50# 0.40668f
C491 VSUBS.t21 w_n20_50# 0.11427f
C492 VSUBS.n28 w_n20_50# 0.3926f
C493 VSUBS.n29 w_n20_50# 1.22321f
C494 VSUBS.n30 w_n20_50# 2.26384f
C495 VSUBS.t63 w_n20_50# 0.1141f
C496 VSUBS.t52 w_n20_50# 0.11166f
C497 VSUBS.n31 w_n20_50# 0.94707f
C498 VSUBS.t62 w_n20_50# 0.1139f
C499 VSUBS.n32 w_n20_50# 0.40668f
C500 VSUBS.t49 w_n20_50# 0.11329f
C501 VSUBS.n33 w_n20_50# 0.45215f
C502 VSUBS.t61 w_n20_50# 0.1141f
C503 VSUBS.t53 w_n20_50# 0.11166f
C504 VSUBS.n34 w_n20_50# 0.94707f
C505 VSUBS.t56 w_n20_50# 0.1139f
C506 VSUBS.n35 w_n20_50# 0.40668f
C507 VSUBS.t55 w_n20_50# 0.11329f
C508 VSUBS.n36 w_n20_50# 0.3926f
C509 VSUBS.n37 w_n20_50# 1.71951f
C510 VSUBS.t60 w_n20_50# 0.1141f
C511 VSUBS.t48 w_n20_50# 0.11166f
C512 VSUBS.n38 w_n20_50# 0.94707f
C513 VSUBS.t57 w_n20_50# 0.1139f
C514 VSUBS.n39 w_n20_50# 0.40668f
C515 VSUBS.t51 w_n20_50# 0.11329f
C516 VSUBS.n40 w_n20_50# 0.3926f
C517 VSUBS.n41 w_n20_50# 1.063f
C518 VSUBS.t59 w_n20_50# 0.1141f
C519 VSUBS.t50 w_n20_50# 0.11166f
C520 VSUBS.n42 w_n20_50# 0.94707f
C521 VSUBS.t58 w_n20_50# 0.1139f
C522 VSUBS.n43 w_n20_50# 0.40668f
C523 VSUBS.t54 w_n20_50# 0.11329f
C524 VSUBS.n44 w_n20_50# 0.3926f
C525 VSUBS.n45 w_n20_50# 0.93266f
C526 VSUBS.n46 w_n20_50# 2.26384f
C527 VSUBS.t36 w_n20_50# 0.11439f
C528 VSUBS.t43 w_n20_50# 0.1129f
C529 VSUBS.n47 w_n20_50# 0.94707f
C530 VSUBS.t34 w_n20_50# 0.11421f
C531 VSUBS.n48 w_n20_50# 0.40668f
C532 VSUBS.t41 w_n20_50# 0.11458f
C533 VSUBS.n49 w_n20_50# 0.3926f
C534 VSUBS.n50 w_n20_50# 1.22321f
C535 VSUBS.t37 w_n20_50# 0.11439f
C536 VSUBS.t40 w_n20_50# 0.1129f
C537 VSUBS.n51 w_n20_50# 0.94707f
C538 VSUBS.t35 w_n20_50# 0.11421f
C539 VSUBS.n52 w_n20_50# 0.40668f
C540 VSUBS.t42 w_n20_50# 0.11458f
C541 VSUBS.n53 w_n20_50# 0.3926f
C542 VSUBS.n54 w_n20_50# 1.1414f
C543 VSUBS.t38 w_n20_50# 0.11439f
C544 VSUBS.t45 w_n20_50# 0.1129f
C545 VSUBS.n55 w_n20_50# 0.94707f
C546 VSUBS.t33 w_n20_50# 0.11421f
C547 VSUBS.n56 w_n20_50# 0.40668f
C548 VSUBS.t44 w_n20_50# 0.11458f
C549 VSUBS.n57 w_n20_50# 0.3926f
C550 VSUBS.n58 w_n20_50# 1.08438f
C551 VSUBS.t39 w_n20_50# 0.11439f
C552 VSUBS.t47 w_n20_50# 0.1129f
C553 VSUBS.n59 w_n20_50# 0.94707f
C554 VSUBS.t32 w_n20_50# 0.11421f
C555 VSUBS.n60 w_n20_50# 0.40668f
C556 VSUBS.t46 w_n20_50# 0.11458f
C557 VSUBS.n61 w_n20_50# 0.3926f
C558 BLN1.t0 w_n20_50# 0.14357f
C559 BLN1.t1 w_n20_50# 0.15385f
C560 BLN1.n0 w_n20_50# 1.84357f
C561 BLN1.t6 w_n20_50# 0.14456f
C562 BLN1.t7 w_n20_50# 0.15387f
C563 BLN1.n1 w_n20_50# 2.3556f
C564 BLN1.t4 w_n20_50# 0.14503f
C565 BLN1.t5 w_n20_50# 0.15399f
C566 BLN1.n2 w_n20_50# 1.84309f
C567 BLN1.n3 w_n20_50# 4.10447f
C568 BLN1.t2 w_n20_50# 0.14502f
C569 BLN1.t3 w_n20_50# 0.15399f
C570 BLN1.n4 w_n20_50# 1.84309f
C571 BLN1.n5 w_n20_50# 2.0518f
C572 BLN2.t0 w_n20_50# 0.14356f
C573 BLN2.t1 w_n20_50# 0.15385f
C574 BLN2.n0 w_n20_50# 1.84343f
C575 BLN2.t7 w_n20_50# 0.14455f
C576 BLN2.t5 w_n20_50# 0.15387f
C577 BLN2.n1 w_n20_50# 2.35543f
C578 BLN2.t3 w_n20_50# 0.14501f
C579 BLN2.t6 w_n20_50# 0.15398f
C580 BLN2.n2 w_n20_50# 1.84296f
C581 BLN2.n3 w_n20_50# 4.10417f
C582 BLN2.t2 w_n20_50# 0.14501f
C583 BLN2.t4 w_n20_50# 0.15398f
C584 BLN2.n4 w_n20_50# 1.84296f
C585 BLN2.n5 w_n20_50# 2.05165f
C586 BLN3.t0 w_n20_50# 0.14298f
C587 BLN3.t1 w_n20_50# 0.15309f
C588 BLN3.n0 w_n20_50# 1.84025f
C589 BLN3.t5 w_n20_50# 0.14436f
C590 BLN3.t7 w_n20_50# 0.15365f
C591 BLN3.n1 w_n20_50# 2.35136f
C592 BLN3.t3 w_n20_50# 0.14482f
C593 BLN3.t4 w_n20_50# 0.15376f
C594 BLN3.n2 w_n20_50# 1.83978f
C595 BLN3.n3 w_n20_50# 4.09709f
C596 BLN3.t2 w_n20_50# 0.14482f
C597 BLN3.t6 w_n20_50# 0.15376f
C598 BLN3.n4 w_n20_50# 1.83978f
C599 BLN3.n5 w_n20_50# 2.04811f
C600 WNEG_3_0.n0 w_n20_50# 3.7858f
C601 WLP3.n0 w_n20_50# 2.99705f
C602 WLP3.n1 w_n20_50# 2.92369f
C603 WLP3.n2 w_n20_50# 2.36564f
C604 WLP3.n3 w_n20_50# 2.92369f
C605 WLP3.n4 w_n20_50# 1.54595f
C606 WLP3.n5 w_n20_50# 2.92369f
C607 WLP3.n6 w_n20_50# 0.88832f
C608 WNEG_3_1.n0 w_n20_50# 3.83041f
C609 WNEG_3_2.n0 w_n20_50# 3.83041f
C610 WNEG_3_3.n0 w_n20_50# 3.79096f
C611 BLP0.t1 w_n20_50# 0.10037f
C612 BLP0.t0 w_n20_50# 0.1036f
C613 BLP0.n0 w_n20_50# 0.82955f
C614 BLP0.t5 w_n20_50# 0.10169f
C615 BLP0.t7 w_n20_50# 0.10375f
C616 BLP0.n1 w_n20_50# 1.04378f
C617 BLP0.t4 w_n20_50# 0.10259f
C618 BLP0.t6 w_n20_50# 0.10389f
C619 BLP0.n2 w_n20_50# 0.82916f
C620 BLP0.n3 w_n20_50# 2.16102f
C621 BLP0.t3 w_n20_50# 0.10204f
C622 BLP0.t2 w_n20_50# 0.10383f
C623 BLP0.n4 w_n20_50# 0.82916f
C624 BLP0.n5 w_n20_50# 1.06333f
C625 BLP1.t0 w_n20_50# 0.12596f
C626 BLP1.t1 w_n20_50# 0.12743f
C627 BLP1.n0 w_n20_50# 1.25235f
C628 BLP1.t6 w_n20_50# 0.12702f
C629 BLP1.t7 w_n20_50# 0.12745f
C630 BLP1.n1 w_n20_50# 1.57577f
C631 BLP1.t4 w_n20_50# 0.12754f
C632 BLP1.t5 w_n20_50# 0.12757f
C633 BLP1.n2 w_n20_50# 1.25175f
C634 BLP1.n3 w_n20_50# 3.26243f
C635 BLP1.t2 w_n20_50# 0.12752f
C636 BLP1.t3 w_n20_50# 0.12757f
C637 BLP1.n4 w_n20_50# 1.25175f
C638 BLP1.n5 w_n20_50# 1.60527f
C639 BLP2.t1 w_n20_50# 0.12593f
C640 BLP2.t0 w_n20_50# 0.1274f
C641 BLP2.n0 w_n20_50# 1.25177f
C642 BLP2.t7 w_n20_50# 0.12699f
C643 BLP2.t5 w_n20_50# 0.12742f
C644 BLP2.n1 w_n20_50# 1.57505f
C645 BLP2.t3 w_n20_50# 0.12749f
C646 BLP2.t6 w_n20_50# 0.12753f
C647 BLP2.n2 w_n20_50# 1.25118f
C648 BLP2.n3 w_n20_50# 3.26094f
C649 BLP2.t2 w_n20_50# 0.12749f
C650 BLP2.t4 w_n20_50# 0.12753f
C651 BLP2.n4 w_n20_50# 1.25118f
C652 BLP2.n5 w_n20_50# 1.60454f
C653 BLP3.t1 w_n20_50# 0.12547f
C654 BLP3.t0 w_n20_50# 0.12679f
C655 BLP3.n0 w_n20_50# 1.25177f
C656 BLP3.t5 w_n20_50# 0.12696f
C657 BLP3.t7 w_n20_50# 0.12737f
C658 BLP3.n1 w_n20_50# 1.57505f
C659 BLP3.t3 w_n20_50# 0.12746f
C660 BLP3.t4 w_n20_50# 0.12749f
C661 BLP3.n2 w_n20_50# 1.25118f
C662 BLP3.n3 w_n20_50# 3.26094f
C663 BLP3.t2 w_n20_50# 0.12746f
C664 BLP3.t6 w_n20_50# 0.12749f
C665 BLP3.n4 w_n20_50# 1.25118f
C666 BLP3.n5 w_n20_50# 1.60454f
C667 WPOS_2_0.n0 w_n20_50# 3.49482f
C668 WLN2.n0 w_n20_50# 3.35801f
C669 WLN2.n1 w_n20_50# 3.44569f
C670 WLN2.n2 w_n20_50# 3.35745f
C671 WLN2.n3 w_n20_50# 2.51035f
C672 WLN2.n4 w_n20_50# 3.35745f
C673 WLN2.n5 w_n20_50# 1.53059f
C674 WPOS_2_1.n0 w_n20_50# 3.60978f
C675 WPOS_2_2.n0 w_n20_50# 3.60978f
C676 WPOS_2_3.n0 w_n20_50# 3.6077f
C677 WNEG_2_0.n0 w_n20_50# 3.801f
C678 WLP2.n0 w_n20_50# 3.1352f
C679 WLP2.n1 w_n20_50# 3.05845f
C680 WLP2.n2 w_n20_50# 2.47469f
C681 WLP2.n3 w_n20_50# 3.05845f
C682 WLP2.n4 w_n20_50# 1.61721f
C683 WLP2.n5 w_n20_50# 3.05845f
C684 WLP2.n6 w_n20_50# 0.92927f
C685 WNEG_2_1.n0 w_n20_50# 3.83916f
C686 WNEG_2_2.n0 w_n20_50# 3.83916f
C687 WNEG_2_3.n0 w_n20_50# 3.83597f
C688 WPOS_1_0.n0 w_n20_50# 3.52978f
C689 WLN1.n0 w_n20_50# 3.35902f
C690 WLN1.n1 w_n20_50# 3.44673f
C691 WLN1.n2 w_n20_50# 3.35847f
C692 WLN1.n3 w_n20_50# 2.51112f
C693 WLN1.n4 w_n20_50# 3.35847f
C694 WLN1.n5 w_n20_50# 1.53106f
C695 WPOS_1_1.n0 w_n20_50# 3.61089f
C696 WPOS_1_2.n0 w_n20_50# 3.60978f
C697 WPOS_1_3.n0 w_n20_50# 3.6077f
C698 WNEG_1_0.n0 w_n20_50# 3.80465f
C699 WLP1.n0 w_n20_50# 3.15729f
C700 WLP1.n1 w_n20_50# 3.08f
C701 WLP1.n2 w_n20_50# 2.49213f
C702 WLP1.n3 w_n20_50# 3.08f
C703 WLP1.n4 w_n20_50# 1.62861f
C704 WLP1.n5 w_n20_50# 3.08f
C705 WLP1.n6 w_n20_50# 0.93582f
C706 WNEG_1_1.n0 w_n20_50# 3.83931f
C707 WNEG_1_2.n0 w_n20_50# 3.83916f
C708 WNEG_1_3.n0 w_n20_50# 3.83597f
C709 WPOS_0_0.n0 w_n20_50# 3.47318f
C710 WLN0.n0 w_n20_50# 3.33595f
C711 WLN0.n1 w_n20_50# 3.42306f
C712 WLN0.n2 w_n20_50# 3.3354f
C713 WLN0.n3 w_n20_50# 2.49387f
C714 WLN0.n4 w_n20_50# 3.3354f
C715 WLN0.n5 w_n20_50# 1.52054f
C716 WPOS_0_1.n0 w_n20_50# 3.57857f
C717 WPOS_0_2.n0 w_n20_50# 3.57857f
C718 WPOS_0_3.n0 w_n20_50# 3.57649f
C719 WNEG_0_0.n0 w_n20_50# 3.79518f
C720 WLP0.n0 w_n20_50# 3.06644f
C721 WLP0.n1 w_n20_50# 2.99138f
C722 WLP0.n2 w_n20_50# 2.42042f
C723 WLP0.n3 w_n20_50# 2.99138f
C724 WLP0.n4 w_n20_50# 1.58175f
C725 WLP0.n5 w_n20_50# 2.99138f
C726 WLP0.n6 w_n20_50# 0.90889f
C727 WNEG_0_1.n0 w_n20_50# 3.83166f
C728 WNEG_0_2.n0 w_n20_50# 3.83166f
C729 WNEG_0_3.n0 w_n20_50# 3.82847f
.ends

* Stage-4 ordered interface to Magic's extracted pin order
.subckt automx_ternary_cim_4x4_core_pex BLP0 BLN0 BLP1 BLN1 BLP2 BLN2 BLP3 BLN3 WLP0 WLN0 WLP1 WLN1 WLP2 WLN2 WLP3 WLN3 WPOS_0_0 WNEG_0_0 WPOS_0_1 WNEG_0_1 WPOS_0_2 WNEG_0_2 WPOS_0_3 WNEG_0_3 WPOS_1_0 WNEG_1_0 WPOS_1_1 WNEG_1_1 WPOS_1_2 WNEG_1_2 WPOS_1_3 WNEG_1_3 WPOS_2_0 WNEG_2_0 WPOS_2_1 WNEG_2_1 WPOS_2_2 WNEG_2_2 WPOS_2_3 WNEG_2_3 WPOS_3_0 WNEG_3_0 WPOS_3_1 WNEG_3_1 WPOS_3_2 WNEG_3_2 WPOS_3_3 WNEG_3_3 VGND VSUBS
XPEX_RAW WPOS_0_0 WNEG_0_0 WPOS_0_1 WNEG_0_1 WPOS_0_2 WNEG_0_2 WPOS_0_3 WNEG_0_3 WPOS_1_0 WNEG_1_0 WPOS_1_1 WNEG_1_1 WPOS_1_2 WNEG_1_2 WPOS_1_3 WNEG_1_3 WPOS_2_0 WNEG_2_0 WPOS_2_1 WNEG_2_1 WPOS_2_2 WNEG_2_2 WPOS_2_3 WNEG_2_3 WPOS_3_0 WNEG_3_0 WPOS_3_1 WNEG_3_1 WPOS_3_2 WNEG_3_2 WPOS_3_3 WNEG_3_3 BLP0 BLN0 BLP1 BLN1 BLP2 BLN2 BLP3 BLN3 WLP0 WLN0 WLP1 WLN1 WLP2 WLN2 WLP3 WLN3 VGND VSUBS automx_ternary_cim_4x4_core_pex_raw
.ends automx_ternary_cim_4x4_core_pex
