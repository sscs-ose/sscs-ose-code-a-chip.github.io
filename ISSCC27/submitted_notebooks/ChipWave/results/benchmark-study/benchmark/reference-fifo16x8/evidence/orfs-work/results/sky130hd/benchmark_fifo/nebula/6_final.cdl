* CDL Netlist generated by OpenROAD

*.BUSDELIMITER [

.SUBCKT benchmark_fifo clk empty full rd_data[0] rd_data[10]
+ rd_data[11] rd_data[12] rd_data[13] rd_data[14] rd_data[15]
+ rd_data[1] rd_data[2] rd_data[3] rd_data[4] rd_data[5] rd_data[6]
+ rd_data[7] rd_data[8] rd_data[9] rd_en rst_n wr_data[0] wr_data[10]
+ wr_data[11] wr_data[12] wr_data[13] wr_data[14] wr_data[15]
+ wr_data[1] wr_data[2] wr_data[3] wr_data[4] wr_data[5] wr_data[6]
+ wr_data[7] wr_data[8] wr_data[9] wr_en VDD VSS
X_482_ used\[0\] used\[1\] VSS VSS VDD VDD _035_ sky130_fd_sc_hd__nor2_2
X_483_ used\[2\] VSS VSS VDD VDD _036_ sky130_fd_sc_hd__inv_1
X_484_ _041_ net1 VSS VSS VDD VDD _042_ sky130_fd_sc_hd__nand2_2
X_485_ _016_ _111_ _112_ VSS VSS VDD VDD _019_ sky130_fd_sc_hd__o21ai_0
X_486_ _014_ wptr\[0\] VSS VSS VDD VDD _113_ sky130_fd_sc_hd__nand2_1
X_487_ _039_ _113_ VSS VSS VDD VDD _018_ sky130_fd_sc_hd__nand2_1
X_488_ _007_ _014_ VSS VSS VDD VDD _114_ sky130_fd_sc_hd__nor2_1
X_489_ _104_ _014_ _114_ VSS VSS VDD VDD _017_ sky130_fd_sc_hd__a21oi_1
X_490_ used\[1\] VSS VSS VDD VDD _001_ sky130_fd_sc_hd__inv_1
X_491_ storage\[0\]\[0\] VSS VSS VDD VDD _115_ sky130_fd_sc_hd__inv_1
X_492_ _060_ _115_ VSS VSS VDD VDD _116_ sky130_fd_sc_hd__nand2_1
X_493_ storage\[1\]\[0\] VSS VSS VDD VDD _117_ sky130_fd_sc_hd__inv_1
X_494_ _117_ rptr\[0\] VSS VSS VDD VDD _118_ sky130_fd_sc_hd__nand2_1
X_495_ _042_ VSS VSS VDD VDD _015_ sky130_fd_sc_hd__inv_2
X_496_ _116_ _118_ _070_ VSS VSS VDD VDD _119_ sky130_fd_sc_hd__nand3_1
X_497_ storage\[2\]\[0\] VSS VSS VDD VDD _120_ sky130_fd_sc_hd__inv_1
X_498_ _060_ _120_ VSS VSS VDD VDD _121_ sky130_fd_sc_hd__nand2_1
X_499_ storage\[3\]\[0\] VSS VSS VDD VDD _122_ sky130_fd_sc_hd__inv_1
X_500_ _122_ rptr\[0\] VSS VSS VDD VDD _123_ sky130_fd_sc_hd__nand2_1
X_501_ _121_ _123_ net60 VSS VSS VDD VDD _124_ sky130_fd_sc_hd__nand3_1
X_502_ _119_ _124_ VSS VSS VDD VDD _125_ sky130_fd_sc_hd__nand2_1
X_503_ rptr\[2\] _125_ VSS VSS VDD VDD _126_ sky130_fd_sc_hd__nor2_1
X_504_ storage\[4\]\[0\] VSS VSS VDD VDD _127_ sky130_fd_sc_hd__inv_1
X_505_ _060_ _127_ VSS VSS VDD VDD _128_ sky130_fd_sc_hd__nand2_1
Xoutput26 net26 VSS VSS VDD VDD rd_data[13] sky130_fd_sc_hd__clkdlybuf4s50_1
X_507_ storage\[5\]\[0\] VSS VSS VDD VDD _129_ sky130_fd_sc_hd__inv_1
X_508_ _129_ rptr\[0\] VSS VSS VDD VDD _130_ sky130_fd_sc_hd__nand2_1
X_509_ _128_ _130_ _070_ VSS VSS VDD VDD _131_ sky130_fd_sc_hd__nand3_1
X_510_ storage\[6\]\[0\] VSS VSS VDD VDD _132_ sky130_fd_sc_hd__inv_1
X_511_ _060_ _132_ VSS VSS VDD VDD _133_ sky130_fd_sc_hd__nand2_1
X_512_ storage\[7\]\[0\] VSS VSS VDD VDD _134_ sky130_fd_sc_hd__inv_1
X_513_ _134_ rptr\[0\] VSS VSS VDD VDD _135_ sky130_fd_sc_hd__nand2_1
X_514_ _133_ _135_ net60 VSS VSS VDD VDD _136_ sky130_fd_sc_hd__nand3_1
X_515_ _131_ _136_ rptr\[2\] VSS VSS VDD VDD _137_ sky130_fd_sc_hd__nand3_1
X_516_ _137_ _041_ VSS VSS VDD VDD _138_ sky130_fd_sc_hd__nand2_1
X_517_ rptr\[2\] _008_ VSS VSS VDD VDD _044_ sky130_fd_sc_hd__xnor2_1
X_518_ _126_ _138_ VSS VSS VDD VDD net22 sky130_fd_sc_hd__nor2_1
X_519_ storage\[0\]\[1\] VSS VSS VDD VDD _139_ sky130_fd_sc_hd__inv_1
X_520_ _060_ _139_ VSS VSS VDD VDD _140_ sky130_fd_sc_hd__nand2_1
X_521_ storage\[1\]\[1\] VSS VSS VDD VDD _141_ sky130_fd_sc_hd__inv_1
X_522_ _141_ rptr\[0\] VSS VSS VDD VDD _142_ sky130_fd_sc_hd__nand2_1
X_523_ _140_ _142_ _070_ VSS VSS VDD VDD _143_ sky130_fd_sc_hd__nand3_1
Xoutput25 net25 VSS VSS VDD VDD rd_data[12] sky130_fd_sc_hd__clkdlybuf4s50_1
X_525_ storage\[2\]\[1\] VSS VSS VDD VDD _145_ sky130_fd_sc_hd__inv_1
X_526_ _060_ _145_ VSS VSS VDD VDD _146_ sky130_fd_sc_hd__nand2_1
X_527_ storage\[3\]\[1\] VSS VSS VDD VDD _147_ sky130_fd_sc_hd__inv_1
Xoutput24 net24 VSS VSS VDD VDD rd_data[11] sky130_fd_sc_hd__clkdlybuf4s50_1
Xoutput23 net23 VSS VSS VDD VDD rd_data[10] sky130_fd_sc_hd__clkdlybuf4s50_1
X_530_ _147_ rptr\[0\] VSS VSS VDD VDD _149_ sky130_fd_sc_hd__nand2_1
X_531_ _146_ _149_ net60 VSS VSS VDD VDD _150_ sky130_fd_sc_hd__nand3_1
X_532_ _143_ _150_ VSS VSS VDD VDD _151_ sky130_fd_sc_hd__nand2_1
X_533_ rptr\[2\] _151_ VSS VSS VDD VDD _152_ sky130_fd_sc_hd__nor2_1
X_534_ storage\[4\]\[1\] VSS VSS VDD VDD _153_ sky130_fd_sc_hd__inv_1
X_535_ _060_ _153_ VSS VSS VDD VDD _154_ sky130_fd_sc_hd__nand2_1
X_536_ storage\[5\]\[1\] VSS VSS VDD VDD _155_ sky130_fd_sc_hd__inv_1
X_537_ _155_ rptr\[0\] VSS VSS VDD VDD _156_ sky130_fd_sc_hd__nand2_1
X_538_ _154_ _156_ _070_ VSS VSS VDD VDD _157_ sky130_fd_sc_hd__nand3_1
X_539_ _042_ rptr\[2\] VSS VSS VDD VDD _046_ sky130_fd_sc_hd__nand2_1
X_540_ storage\[6\]\[1\] VSS VSS VDD VDD _158_ sky130_fd_sc_hd__inv_1
X_541_ _060_ _158_ VSS VSS VDD VDD _159_ sky130_fd_sc_hd__nand2_1
X_542_ storage\[7\]\[1\] VSS VSS VDD VDD _160_ sky130_fd_sc_hd__inv_1
X_543_ _160_ rptr\[0\] VSS VSS VDD VDD _161_ sky130_fd_sc_hd__nand2_1
X_544_ _159_ _161_ net60 VSS VSS VDD VDD _162_ sky130_fd_sc_hd__nand3_1
X_545_ _157_ _162_ rptr\[2\] VSS VSS VDD VDD _163_ sky130_fd_sc_hd__nand3_1
X_546_ _163_ _041_ VSS VSS VDD VDD _164_ sky130_fd_sc_hd__nand2_1
X_547_ _152_ _164_ VSS VSS VDD VDD net29 sky130_fd_sc_hd__nor2_1
Xoutput22 net22 VSS VSS VDD VDD rd_data[0] sky130_fd_sc_hd__clkdlybuf4s50_1
X_549_ storage\[0\]\[2\] VSS VSS VDD VDD _166_ sky130_fd_sc_hd__inv_1
X_550_ _044_ _042_ _046_ VSS VSS VDD VDD _026_ sky130_fd_sc_hd__o21ai_0
X_551_ _060_ _166_ VSS VSS VDD VDD _167_ sky130_fd_sc_hd__nand2_1
X_552_ storage\[1\]\[2\] VSS VSS VDD VDD _168_ sky130_fd_sc_hd__inv_1
X_553_ _168_ rptr\[0\] VSS VSS VDD VDD _169_ sky130_fd_sc_hd__nand2_1
Xoutput21 net21 VSS VSS VDD VDD full sky130_fd_sc_hd__clkdlybuf4s50_1
X_555_ _167_ _169_ _070_ VSS VSS VDD VDD _171_ sky130_fd_sc_hd__nand3_1
X_556_ storage\[2\]\[2\] VSS VSS VDD VDD _172_ sky130_fd_sc_hd__inv_1
X_557_ _060_ _172_ VSS VSS VDD VDD _173_ sky130_fd_sc_hd__nand2_1
X_558_ storage\[3\]\[2\] VSS VSS VDD VDD _174_ sky130_fd_sc_hd__inv_1
X_559_ _174_ rptr\[0\] VSS VSS VDD VDD _175_ sky130_fd_sc_hd__nand2_1
X_560_ _173_ _175_ net60 VSS VSS VDD VDD _176_ sky130_fd_sc_hd__nand3_1
X_561_ _013_ _010_ _012_ VSS VSS VDD VDD _047_ sky130_fd_sc_hd__a21oi_1
X_562_ _171_ _176_ VSS VSS VDD VDD _177_ sky130_fd_sc_hd__nand2_1
X_563_ rptr\[2\] _177_ VSS VSS VDD VDD _178_ sky130_fd_sc_hd__nor2_1
X_564_ storage\[4\]\[2\] VSS VSS VDD VDD _179_ sky130_fd_sc_hd__inv_1
X_565_ _060_ _179_ VSS VSS VDD VDD _180_ sky130_fd_sc_hd__nand2_1
X_566_ storage\[5\]\[2\] VSS VSS VDD VDD _181_ sky130_fd_sc_hd__inv_1
X_567_ _181_ rptr\[0\] VSS VSS VDD VDD _182_ sky130_fd_sc_hd__nand2_1
X_568_ _180_ _182_ _070_ VSS VSS VDD VDD _183_ sky130_fd_sc_hd__nand3_1
X_569_ storage\[6\]\[2\] VSS VSS VDD VDD _184_ sky130_fd_sc_hd__inv_1
X_570_ _060_ _184_ VSS VSS VDD VDD _185_ sky130_fd_sc_hd__nand2_1
X_571_ storage\[7\]\[2\] VSS VSS VDD VDD _186_ sky130_fd_sc_hd__inv_1
X_572_ _013_ _011_ used\[0\] VSS VSS VDD VDD _048_ sky130_fd_sc_hd__nand3_1
X_573_ _186_ rptr\[0\] VSS VSS VDD VDD _187_ sky130_fd_sc_hd__nand2_1
X_574_ _185_ _187_ net60 VSS VSS VDD VDD _188_ sky130_fd_sc_hd__nand3_1
Xoutput20 net20 VSS VSS VDD VDD empty sky130_fd_sc_hd__clkdlybuf4s50_1
X_576_ _183_ _188_ rptr\[2\] VSS VSS VDD VDD _190_ sky130_fd_sc_hd__nand3_1
X_577_ _190_ _041_ VSS VSS VDD VDD _191_ sky130_fd_sc_hd__nand2_1
X_578_ _178_ _191_ VSS VSS VDD VDD net30 sky130_fd_sc_hd__nor2_1
X_579_ storage\[0\]\[3\] VSS VSS VDD VDD _192_ sky130_fd_sc_hd__inv_1
X_580_ _060_ _192_ VSS VSS VDD VDD _193_ sky130_fd_sc_hd__nand2_1
X_581_ storage\[1\]\[3\] VSS VSS VDD VDD _194_ sky130_fd_sc_hd__inv_1
Xinput19 wr_en VSS VSS VDD VDD net19 sky130_fd_sc_hd__clkdlybuf4s50_1
X_583_ _047_ _048_ VSS VSS VDD VDD _049_ sky130_fd_sc_hd__nand2_1
X_584_ _194_ rptr\[0\] VSS VSS VDD VDD _196_ sky130_fd_sc_hd__nand2_1
X_585_ _193_ _196_ _070_ VSS VSS VDD VDD _197_ sky130_fd_sc_hd__nand3_1
X_586_ storage\[2\]\[3\] VSS VSS VDD VDD _198_ sky130_fd_sc_hd__inv_1
X_587_ _060_ _198_ VSS VSS VDD VDD _199_ sky130_fd_sc_hd__nand2_1
X_588_ storage\[3\]\[3\] VSS VSS VDD VDD _200_ sky130_fd_sc_hd__inv_1
X_589_ _200_ rptr\[0\] VSS VSS VDD VDD _201_ sky130_fd_sc_hd__nand2_1
Xinput18 wr_data[9] VSS VSS VDD VDD net18 sky130_fd_sc_hd__clkdlybuf4s50_1
X_591_ _199_ _201_ net60 VSS VSS VDD VDD _203_ sky130_fd_sc_hd__nand3_1
X_592_ _197_ _203_ VSS VSS VDD VDD _204_ sky130_fd_sc_hd__nand2_1
X_593_ rptr\[2\] _204_ VSS VSS VDD VDD _205_ sky130_fd_sc_hd__nor2_1
X_594_ _035_ used\[3\] _036_ VSS VSS VDD VDD _037_ sky130_fd_sc_hd__nand3_2
X_595_ _005_ VSS VSS VDD VDD _002_ sky130_fd_sc_hd__inv_1
X_596_ storage\[4\]\[3\] VSS VSS VDD VDD _206_ sky130_fd_sc_hd__inv_1
X_597_ _060_ _206_ VSS VSS VDD VDD _207_ sky130_fd_sc_hd__nand2_1
X_598_ storage\[5\]\[3\] VSS VSS VDD VDD _208_ sky130_fd_sc_hd__inv_1
X_599_ _208_ rptr\[0\] VSS VSS VDD VDD _209_ sky130_fd_sc_hd__nand2_1
X_600_ _207_ _209_ _070_ VSS VSS VDD VDD _210_ sky130_fd_sc_hd__nand3_1
X_601_ storage\[6\]\[3\] VSS VSS VDD VDD _211_ sky130_fd_sc_hd__inv_1
X_602_ _060_ _211_ VSS VSS VDD VDD _212_ sky130_fd_sc_hd__nand2_1
X_603_ storage\[7\]\[3\] VSS VSS VDD VDD _213_ sky130_fd_sc_hd__inv_1
X_604_ _213_ rptr\[0\] VSS VSS VDD VDD _214_ sky130_fd_sc_hd__nand2_1
X_605_ _212_ _214_ net60 VSS VSS VDD VDD _215_ sky130_fd_sc_hd__nand3_1
X_606_ _040_ _002_ VSS VSS VDD VDD _050_ sky130_fd_sc_hd__nand2_1
X_607_ _210_ _215_ rptr\[2\] VSS VSS VDD VDD _216_ sky130_fd_sc_hd__nand3_1
X_608_ _216_ _041_ VSS VSS VDD VDD _217_ sky130_fd_sc_hd__nand2_1
X_609_ _205_ _217_ VSS VSS VDD VDD net31 sky130_fd_sc_hd__nor2_1
X_610_ storage\[0\]\[4\] VSS VSS VDD VDD _218_ sky130_fd_sc_hd__inv_1
X_611_ _060_ _218_ VSS VSS VDD VDD _219_ sky130_fd_sc_hd__nand2_1
X_612_ storage\[1\]\[4\] VSS VSS VDD VDD _220_ sky130_fd_sc_hd__inv_1
X_613_ _220_ rptr\[0\] VSS VSS VDD VDD _221_ sky130_fd_sc_hd__nand2_1
X_614_ _219_ _221_ _070_ VSS VSS VDD VDD _222_ sky130_fd_sc_hd__nand3_1
X_615_ storage\[2\]\[4\] VSS VSS VDD VDD _223_ sky130_fd_sc_hd__inv_1
X_616_ _060_ _223_ VSS VSS VDD VDD _224_ sky130_fd_sc_hd__nand2_1
X_617_ used\[3\] _005_ VSS VSS VDD VDD _051_ sky130_fd_sc_hd__nand2_1
X_618_ storage\[3\]\[4\] VSS VSS VDD VDD _225_ sky130_fd_sc_hd__inv_1
X_619_ _225_ rptr\[0\] VSS VSS VDD VDD _226_ sky130_fd_sc_hd__nand2_1
X_620_ _224_ _226_ net60 VSS VSS VDD VDD _227_ sky130_fd_sc_hd__nand3_1
X_621_ _222_ _227_ VSS VSS VDD VDD _228_ sky130_fd_sc_hd__nand2_1
X_622_ rptr\[2\] _228_ VSS VSS VDD VDD _229_ sky130_fd_sc_hd__nor2_1
X_623_ storage\[4\]\[4\] VSS VSS VDD VDD _230_ sky130_fd_sc_hd__inv_1
X_624_ _060_ _230_ VSS VSS VDD VDD _231_ sky130_fd_sc_hd__nand2_1
X_625_ storage\[5\]\[4\] VSS VSS VDD VDD _232_ sky130_fd_sc_hd__inv_1
X_626_ _232_ rptr\[0\] VSS VSS VDD VDD _233_ sky130_fd_sc_hd__nand2_1
X_627_ _231_ _233_ _070_ VSS VSS VDD VDD _234_ sky130_fd_sc_hd__nand3_1
X_628_ _050_ _051_ VSS VSS VDD VDD _052_ sky130_fd_sc_hd__nand2_1
X_629_ storage\[6\]\[4\] VSS VSS VDD VDD _235_ sky130_fd_sc_hd__inv_1
X_630_ _060_ _235_ VSS VSS VDD VDD _236_ sky130_fd_sc_hd__nand2_1
X_631_ storage\[7\]\[4\] VSS VSS VDD VDD _237_ sky130_fd_sc_hd__inv_1
X_632_ _237_ rptr\[0\] VSS VSS VDD VDD _238_ sky130_fd_sc_hd__nand2_1
X_633_ _236_ _238_ net60 VSS VSS VDD VDD _239_ sky130_fd_sc_hd__nand3_1
X_634_ _234_ _239_ rptr\[2\] VSS VSS VDD VDD _240_ sky130_fd_sc_hd__nand3_1
X_635_ _240_ _041_ VSS VSS VDD VDD _241_ sky130_fd_sc_hd__nand2_1
X_636_ _229_ _241_ VSS VSS VDD VDD net32 sky130_fd_sc_hd__nor2_1
X_637_ storage\[0\]\[5\] VSS VSS VDD VDD _242_ sky130_fd_sc_hd__inv_1
X_638_ net58 _242_ VSS VSS VDD VDD _243_ sky130_fd_sc_hd__nand2_1
X_639_ _052_ VSS VSS VDD VDD _053_ sky130_fd_sc_hd__inv_1
X_640_ storage\[1\]\[5\] VSS VSS VDD VDD _244_ sky130_fd_sc_hd__inv_1
X_641_ _244_ net61 VSS VSS VDD VDD _245_ sky130_fd_sc_hd__nand2_1
X_642_ _243_ _245_ _070_ VSS VSS VDD VDD _246_ sky130_fd_sc_hd__nand3_1
X_643_ storage\[2\]\[5\] VSS VSS VDD VDD _247_ sky130_fd_sc_hd__inv_1
X_644_ net58 _247_ VSS VSS VDD VDD _248_ sky130_fd_sc_hd__nand2_1
X_645_ storage\[3\]\[5\] VSS VSS VDD VDD _249_ sky130_fd_sc_hd__inv_1
X_646_ _249_ net61 VSS VSS VDD VDD _250_ sky130_fd_sc_hd__nand2_1
X_647_ _248_ _250_ net60 VSS VSS VDD VDD _251_ sky130_fd_sc_hd__nand3_1
X_648_ _246_ _251_ VSS VSS VDD VDD _252_ sky130_fd_sc_hd__nand2_1
X_649_ net59 _252_ VSS VSS VDD VDD _253_ sky130_fd_sc_hd__nor2_1
X_650_ _049_ _053_ VSS VSS VDD VDD _054_ sky130_fd_sc_hd__nand2_1
X_651_ storage\[4\]\[5\] VSS VSS VDD VDD _254_ sky130_fd_sc_hd__inv_1
X_652_ net58 _254_ VSS VSS VDD VDD _255_ sky130_fd_sc_hd__nand2_1
X_653_ storage\[5\]\[5\] VSS VSS VDD VDD _256_ sky130_fd_sc_hd__inv_1
X_654_ _256_ net61 VSS VSS VDD VDD _257_ sky130_fd_sc_hd__nand2_1
X_655_ _255_ _257_ _070_ VSS VSS VDD VDD _258_ sky130_fd_sc_hd__nand3_1
X_656_ storage\[6\]\[5\] VSS VSS VDD VDD _259_ sky130_fd_sc_hd__inv_1
X_657_ net58 _259_ VSS VSS VDD VDD _260_ sky130_fd_sc_hd__nand2_1
X_658_ storage\[7\]\[5\] VSS VSS VDD VDD _261_ sky130_fd_sc_hd__inv_1
X_659_ _261_ net61 VSS VSS VDD VDD _262_ sky130_fd_sc_hd__nand2_1
X_660_ _260_ _262_ net60 VSS VSS VDD VDD _263_ sky130_fd_sc_hd__nand3_1
X_661_ _052_ _047_ _048_ VSS VSS VDD VDD _055_ sky130_fd_sc_hd__nand3_1
X_662_ _258_ _263_ net59 VSS VSS VDD VDD _264_ sky130_fd_sc_hd__nand3_1
X_663_ _264_ _041_ VSS VSS VDD VDD _265_ sky130_fd_sc_hd__nand2_1
X_664_ _253_ _265_ VSS VSS VDD VDD net33 sky130_fd_sc_hd__nor2_1
X_665_ storage\[0\]\[6\] VSS VSS VDD VDD _266_ sky130_fd_sc_hd__inv_1
X_666_ net58 _266_ VSS VSS VDD VDD _267_ sky130_fd_sc_hd__nand2_1
X_667_ storage\[1\]\[6\] VSS VSS VDD VDD _268_ sky130_fd_sc_hd__inv_1
X_668_ _268_ net61 VSS VSS VDD VDD _269_ sky130_fd_sc_hd__nand2_1
X_669_ _267_ _269_ _070_ VSS VSS VDD VDD _270_ sky130_fd_sc_hd__nand3_1
X_670_ storage\[2\]\[6\] VSS VSS VDD VDD _271_ sky130_fd_sc_hd__inv_1
X_671_ net58 _271_ VSS VSS VDD VDD _272_ sky130_fd_sc_hd__nand2_1
X_672_ _016_ _054_ _055_ VSS VSS VDD VDD _056_ sky130_fd_sc_hd__nand3b_1
X_673_ storage\[3\]\[6\] VSS VSS VDD VDD _273_ sky130_fd_sc_hd__inv_1
X_674_ _273_ net61 VSS VSS VDD VDD _274_ sky130_fd_sc_hd__nand2_1
X_675_ _272_ _274_ net60 VSS VSS VDD VDD _275_ sky130_fd_sc_hd__nand3_1
X_676_ _270_ _275_ VSS VSS VDD VDD _276_ sky130_fd_sc_hd__nand2_1
X_677_ net59 _276_ VSS VSS VDD VDD _277_ sky130_fd_sc_hd__nor2_1
X_678_ storage\[4\]\[6\] VSS VSS VDD VDD _278_ sky130_fd_sc_hd__inv_1
X_679_ net58 _278_ VSS VSS VDD VDD _279_ sky130_fd_sc_hd__nand2_1
X_680_ storage\[5\]\[6\] VSS VSS VDD VDD _280_ sky130_fd_sc_hd__inv_1
X_681_ _280_ net61 VSS VSS VDD VDD _281_ sky130_fd_sc_hd__nand2_1
X_682_ _279_ _281_ _070_ VSS VSS VDD VDD _282_ sky130_fd_sc_hd__nand3_1
X_683_ used\[3\] _016_ VSS VSS VDD VDD _057_ sky130_fd_sc_hd__nand2_1
X_684_ storage\[6\]\[6\] VSS VSS VDD VDD _283_ sky130_fd_sc_hd__inv_1
X_685_ _283_ net58 VSS VSS VDD VDD _284_ sky130_fd_sc_hd__nand2_1
X_686_ storage\[7\]\[6\] VSS VSS VDD VDD _285_ sky130_fd_sc_hd__inv_1
X_687_ _285_ net61 VSS VSS VDD VDD _286_ sky130_fd_sc_hd__nand2_1
X_688_ _284_ _286_ net60 VSS VSS VDD VDD _287_ sky130_fd_sc_hd__nand3_1
X_689_ _282_ _287_ net59 VSS VSS VDD VDD _288_ sky130_fd_sc_hd__nand3_1
X_690_ _288_ _041_ VSS VSS VDD VDD _289_ sky130_fd_sc_hd__nand2_1
X_691_ _277_ _289_ VSS VSS VDD VDD net34 sky130_fd_sc_hd__nor2_1
X_692_ storage\[0\]\[7\] VSS VSS VDD VDD _290_ sky130_fd_sc_hd__inv_1
X_693_ net58 _290_ VSS VSS VDD VDD _291_ sky130_fd_sc_hd__nand2_1
X_694_ _056_ _057_ VSS VSS VDD VDD _025_ sky130_fd_sc_hd__nand2_1
X_695_ storage\[1\]\[7\] VSS VSS VDD VDD _292_ sky130_fd_sc_hd__inv_1
X_696_ _292_ net61 VSS VSS VDD VDD _293_ sky130_fd_sc_hd__nand2_1
X_697_ _291_ _293_ _070_ VSS VSS VDD VDD _294_ sky130_fd_sc_hd__nand3_1
X_698_ storage\[2\]\[7\] VSS VSS VDD VDD _295_ sky130_fd_sc_hd__inv_1
X_699_ net58 _295_ VSS VSS VDD VDD _296_ sky130_fd_sc_hd__nand2_1
X_700_ storage\[3\]\[7\] VSS VSS VDD VDD _297_ sky130_fd_sc_hd__inv_1
X_701_ _297_ net61 VSS VSS VDD VDD _298_ sky130_fd_sc_hd__nand2_1
X_702_ _296_ _298_ net60 VSS VSS VDD VDD _299_ sky130_fd_sc_hd__nand3_1
X_703_ _294_ _299_ VSS VSS VDD VDD _300_ sky130_fd_sc_hd__nand2_1
X_704_ net59 _300_ VSS VSS VDD VDD _301_ sky130_fd_sc_hd__nor2_1
X_705_ _037_ VSS VSS VDD VDD net21 sky130_fd_sc_hd__inv_1
X_706_ wptr\[2\] _006_ VSS VSS VDD VDD _058_ sky130_fd_sc_hd__xnor2_1
X_707_ storage\[4\]\[7\] VSS VSS VDD VDD _302_ sky130_fd_sc_hd__inv_1
X_708_ net58 _302_ VSS VSS VDD VDD _303_ sky130_fd_sc_hd__nand2_1
X_709_ storage\[5\]\[7\] VSS VSS VDD VDD _304_ sky130_fd_sc_hd__inv_1
X_710_ _304_ net61 VSS VSS VDD VDD _305_ sky130_fd_sc_hd__nand2_1
X_711_ _303_ _305_ _070_ VSS VSS VDD VDD _306_ sky130_fd_sc_hd__nand3_1
X_712_ storage\[6\]\[7\] VSS VSS VDD VDD _307_ sky130_fd_sc_hd__inv_1
X_713_ net58 _307_ VSS VSS VDD VDD _308_ sky130_fd_sc_hd__nand2_1
X_714_ storage\[7\]\[7\] VSS VSS VDD VDD _309_ sky130_fd_sc_hd__inv_1
X_715_ _309_ net61 VSS VSS VDD VDD _310_ sky130_fd_sc_hd__nand2_1
X_716_ _308_ _310_ net60 VSS VSS VDD VDD _311_ sky130_fd_sc_hd__nand3_1
X_717_ _014_ wptr\[2\] VSS VSS VDD VDD _059_ sky130_fd_sc_hd__nand2_1
X_718_ _306_ _311_ net59 VSS VSS VDD VDD _312_ sky130_fd_sc_hd__nand3_1
X_719_ _312_ _041_ VSS VSS VDD VDD _313_ sky130_fd_sc_hd__nand2_1
X_720_ _301_ _313_ VSS VSS VDD VDD net35 sky130_fd_sc_hd__nor2_1
X_721_ storage\[0\]\[8\] VSS VSS VDD VDD _314_ sky130_fd_sc_hd__inv_1
X_722_ net58 _314_ VSS VSS VDD VDD _315_ sky130_fd_sc_hd__nand2_1
X_723_ storage\[1\]\[8\] VSS VSS VDD VDD _316_ sky130_fd_sc_hd__inv_1
X_724_ _316_ net61 VSS VSS VDD VDD _317_ sky130_fd_sc_hd__nand2_1
X_725_ _315_ _317_ _070_ VSS VSS VDD VDD _318_ sky130_fd_sc_hd__nand3_1
X_726_ storage\[2\]\[8\] VSS VSS VDD VDD _319_ sky130_fd_sc_hd__inv_1
X_727_ net58 _319_ VSS VSS VDD VDD _320_ sky130_fd_sc_hd__nand2_1
X_728_ _058_ _014_ _059_ VSS VSS VDD VDD _024_ sky130_fd_sc_hd__o21ai_0
X_729_ storage\[3\]\[8\] VSS VSS VDD VDD _321_ sky130_fd_sc_hd__inv_1
X_730_ _321_ net61 VSS VSS VDD VDD _322_ sky130_fd_sc_hd__nand2_1
X_731_ _320_ _322_ net60 VSS VSS VDD VDD _323_ sky130_fd_sc_hd__nand3_1
X_732_ _318_ _323_ VSS VSS VDD VDD _324_ sky130_fd_sc_hd__nand2_1
X_733_ net59 _324_ VSS VSS VDD VDD _325_ sky130_fd_sc_hd__nor2_1
X_734_ storage\[4\]\[8\] VSS VSS VDD VDD _326_ sky130_fd_sc_hd__inv_1
X_735_ net58 _326_ VSS VSS VDD VDD _327_ sky130_fd_sc_hd__nand2_1
X_736_ storage\[5\]\[8\] VSS VSS VDD VDD _328_ sky130_fd_sc_hd__inv_1
X_737_ _328_ net61 VSS VSS VDD VDD _329_ sky130_fd_sc_hd__nand2_1
X_738_ _327_ _329_ _070_ VSS VSS VDD VDD _330_ sky130_fd_sc_hd__nand3_1
X_739_ rptr\[0\] VSS VSS VDD VDD _060_ sky130_fd_sc_hd__inv_2
X_740_ storage\[6\]\[8\] VSS VSS VDD VDD _331_ sky130_fd_sc_hd__inv_1
X_741_ net58 _331_ VSS VSS VDD VDD _332_ sky130_fd_sc_hd__nand2_1
X_742_ storage\[7\]\[8\] VSS VSS VDD VDD _333_ sky130_fd_sc_hd__inv_1
X_743_ _333_ net61 VSS VSS VDD VDD _334_ sky130_fd_sc_hd__nand2_1
X_744_ _332_ _334_ net60 VSS VSS VDD VDD _335_ sky130_fd_sc_hd__nand3_1
X_745_ _330_ _335_ net59 VSS VSS VDD VDD _336_ sky130_fd_sc_hd__nand3_1
X_746_ _336_ _041_ VSS VSS VDD VDD _337_ sky130_fd_sc_hd__nand2_1
X_747_ _325_ _337_ VSS VSS VDD VDD net36 sky130_fd_sc_hd__nor2_1
X_748_ storage\[0\]\[9\] VSS VSS VDD VDD _338_ sky130_fd_sc_hd__inv_1
X_749_ net58 _338_ VSS VSS VDD VDD _339_ sky130_fd_sc_hd__nand2_1
Xinput17 wr_data[8] VSS VSS VDD VDD net17 sky130_fd_sc_hd__clkdlybuf4s50_1
X_751_ storage\[1\]\[9\] VSS VSS VDD VDD _340_ sky130_fd_sc_hd__inv_1
X_752_ _340_ net61 VSS VSS VDD VDD _341_ sky130_fd_sc_hd__nand2_1
X_753_ _339_ _341_ _070_ VSS VSS VDD VDD _342_ sky130_fd_sc_hd__nand3_1
X_754_ storage\[2\]\[9\] VSS VSS VDD VDD _343_ sky130_fd_sc_hd__inv_1
X_755_ net58 _343_ VSS VSS VDD VDD _344_ sky130_fd_sc_hd__nand2_1
X_756_ storage\[3\]\[9\] VSS VSS VDD VDD _345_ sky130_fd_sc_hd__inv_1
X_757_ _345_ net61 VSS VSS VDD VDD _346_ sky130_fd_sc_hd__nand2_1
X_758_ _344_ _346_ net60 VSS VSS VDD VDD _347_ sky130_fd_sc_hd__nand3_1
X_759_ _342_ _347_ VSS VSS VDD VDD _348_ sky130_fd_sc_hd__nand2_1
X_760_ net59 _348_ VSS VSS VDD VDD _349_ sky130_fd_sc_hd__nor2_1
Xinput16 wr_data[7] VSS VSS VDD VDD net16 sky130_fd_sc_hd__clkdlybuf4s50_1
X_762_ storage\[4\]\[9\] VSS VSS VDD VDD _350_ sky130_fd_sc_hd__inv_1
X_763_ net58 _350_ VSS VSS VDD VDD _351_ sky130_fd_sc_hd__nand2_1
X_764_ storage\[5\]\[9\] VSS VSS VDD VDD _352_ sky130_fd_sc_hd__inv_1
X_765_ _352_ net61 VSS VSS VDD VDD _353_ sky130_fd_sc_hd__nand2_1
X_766_ _351_ _353_ _070_ VSS VSS VDD VDD _354_ sky130_fd_sc_hd__nand3_1
X_767_ storage\[6\]\[9\] VSS VSS VDD VDD _355_ sky130_fd_sc_hd__inv_1
X_768_ net58 _355_ VSS VSS VDD VDD _356_ sky130_fd_sc_hd__nand2_1
X_769_ storage\[7\]\[9\] VSS VSS VDD VDD _357_ sky130_fd_sc_hd__inv_1
X_770_ _357_ net61 VSS VSS VDD VDD _358_ sky130_fd_sc_hd__nand2_1
X_771_ _356_ _358_ net60 VSS VSS VDD VDD _359_ sky130_fd_sc_hd__nand3_1
X_772_ storage\[0\]\[15\] VSS VSS VDD VDD _063_ sky130_fd_sc_hd__inv_1
X_773_ _354_ _359_ net59 VSS VSS VDD VDD _360_ sky130_fd_sc_hd__nand3_1
X_774_ _360_ _041_ VSS VSS VDD VDD _361_ sky130_fd_sc_hd__nand2_1
X_775_ _349_ _361_ VSS VSS VDD VDD net37 sky130_fd_sc_hd__nor2_1
X_776_ storage\[0\]\[10\] VSS VSS VDD VDD _362_ sky130_fd_sc_hd__inv_1
X_777_ net58 _362_ VSS VSS VDD VDD _363_ sky130_fd_sc_hd__nand2_1
X_778_ storage\[1\]\[10\] VSS VSS VDD VDD _364_ sky130_fd_sc_hd__inv_1
X_779_ _364_ net61 VSS VSS VDD VDD _365_ sky130_fd_sc_hd__nand2_1
X_780_ _363_ _365_ _070_ VSS VSS VDD VDD _366_ sky130_fd_sc_hd__nand3_1
X_781_ storage\[2\]\[10\] VSS VSS VDD VDD _367_ sky130_fd_sc_hd__inv_1
X_782_ net58 _367_ VSS VSS VDD VDD _368_ sky130_fd_sc_hd__nand2_1
X_783_ _060_ _063_ VSS VSS VDD VDD _064_ sky130_fd_sc_hd__nand2_1
X_784_ storage\[3\]\[10\] VSS VSS VDD VDD _369_ sky130_fd_sc_hd__inv_1
X_785_ _369_ net61 VSS VSS VDD VDD _370_ sky130_fd_sc_hd__nand2_1
X_786_ _368_ _370_ net60 VSS VSS VDD VDD _371_ sky130_fd_sc_hd__nand3_1
X_787_ _366_ _371_ VSS VSS VDD VDD _372_ sky130_fd_sc_hd__nand2_1
X_788_ net59 _372_ VSS VSS VDD VDD _373_ sky130_fd_sc_hd__nor2_1
X_789_ storage\[4\]\[10\] VSS VSS VDD VDD _374_ sky130_fd_sc_hd__inv_1
X_790_ net58 _374_ VSS VSS VDD VDD _375_ sky130_fd_sc_hd__nand2_1
X_791_ storage\[5\]\[10\] VSS VSS VDD VDD _376_ sky130_fd_sc_hd__inv_1
X_792_ _376_ net61 VSS VSS VDD VDD _377_ sky130_fd_sc_hd__nand2_1
X_793_ _375_ _377_ _070_ VSS VSS VDD VDD _378_ sky130_fd_sc_hd__nand3_1
X_794_ storage\[1\]\[15\] VSS VSS VDD VDD _065_ sky130_fd_sc_hd__inv_1
X_795_ storage\[6\]\[10\] VSS VSS VDD VDD _379_ sky130_fd_sc_hd__inv_1
X_796_ net58 _379_ VSS VSS VDD VDD _380_ sky130_fd_sc_hd__nand2_1
X_797_ storage\[7\]\[10\] VSS VSS VDD VDD _381_ sky130_fd_sc_hd__inv_1
X_798_ _381_ net61 VSS VSS VDD VDD _382_ sky130_fd_sc_hd__nand2_1
X_799_ _380_ _382_ net60 VSS VSS VDD VDD _383_ sky130_fd_sc_hd__nand3_1
X_800_ _378_ _383_ net59 VSS VSS VDD VDD _384_ sky130_fd_sc_hd__nand3_1
X_801_ _384_ _041_ VSS VSS VDD VDD _385_ sky130_fd_sc_hd__nand2_1
X_802_ _373_ _385_ VSS VSS VDD VDD net23 sky130_fd_sc_hd__nor2_1
X_803_ storage\[0\]\[11\] VSS VSS VDD VDD _386_ sky130_fd_sc_hd__inv_1
X_804_ net58 _386_ VSS VSS VDD VDD _387_ sky130_fd_sc_hd__nand2_1
Xinput15 wr_data[6] VSS VSS VDD VDD net15 sky130_fd_sc_hd__clkdlybuf4s50_1
X_806_ storage\[1\]\[11\] VSS VSS VDD VDD _388_ sky130_fd_sc_hd__inv_1
X_807_ _388_ net61 VSS VSS VDD VDD _389_ sky130_fd_sc_hd__nand2_1
X_808_ _387_ _389_ _070_ VSS VSS VDD VDD _390_ sky130_fd_sc_hd__nand3_1
X_809_ storage\[2\]\[11\] VSS VSS VDD VDD _391_ sky130_fd_sc_hd__inv_1
X_810_ net58 _391_ VSS VSS VDD VDD _392_ sky130_fd_sc_hd__nand2_1
X_811_ storage\[3\]\[11\] VSS VSS VDD VDD _393_ sky130_fd_sc_hd__inv_1
X_812_ _393_ net61 VSS VSS VDD VDD _394_ sky130_fd_sc_hd__nand2_1
X_813_ _392_ _394_ net60 VSS VSS VDD VDD _395_ sky130_fd_sc_hd__nand3_1
X_814_ _390_ _395_ VSS VSS VDD VDD _396_ sky130_fd_sc_hd__nand2_1
X_815_ net59 _396_ VSS VSS VDD VDD _397_ sky130_fd_sc_hd__nor2_1
X_816_ wptr\[2\] net2 wptr\[1\] VSS VSS VDD VDD _038_ sky130_fd_sc_hd__nand3_1
Xinput14 wr_data[5] VSS VSS VDD VDD net14 sky130_fd_sc_hd__clkdlybuf4s50_1
X_818_ storage\[4\]\[11\] VSS VSS VDD VDD _398_ sky130_fd_sc_hd__inv_1
X_819_ net58 _398_ VSS VSS VDD VDD _399_ sky130_fd_sc_hd__nand2_1
X_820_ storage\[5\]\[11\] VSS VSS VDD VDD _400_ sky130_fd_sc_hd__inv_1
X_821_ _400_ net61 VSS VSS VDD VDD _401_ sky130_fd_sc_hd__nand2_1
X_822_ _399_ _401_ _070_ VSS VSS VDD VDD _402_ sky130_fd_sc_hd__nand3_1
X_823_ storage\[6\]\[11\] VSS VSS VDD VDD _403_ sky130_fd_sc_hd__inv_1
X_824_ net58 _403_ VSS VSS VDD VDD _404_ sky130_fd_sc_hd__nand2_1
X_825_ storage\[7\]\[11\] VSS VSS VDD VDD _405_ sky130_fd_sc_hd__inv_1
X_826_ _405_ net61 VSS VSS VDD VDD _406_ sky130_fd_sc_hd__nand2_1
X_827_ _404_ _406_ net60 VSS VSS VDD VDD _407_ sky130_fd_sc_hd__nand3_1
X_828_ _065_ rptr\[0\] VSS VSS VDD VDD _068_ sky130_fd_sc_hd__nand2_1
X_829_ _402_ _407_ net59 VSS VSS VDD VDD _408_ sky130_fd_sc_hd__nand3_1
X_830_ _408_ _041_ VSS VSS VDD VDD _409_ sky130_fd_sc_hd__nand2_1
X_831_ _397_ _409_ VSS VSS VDD VDD net24 sky130_fd_sc_hd__nor2_1
X_832_ storage\[0\]\[12\] VSS VSS VDD VDD _410_ sky130_fd_sc_hd__inv_1
X_833_ net58 _410_ VSS VSS VDD VDD _411_ sky130_fd_sc_hd__nand2_1
X_834_ storage\[1\]\[12\] VSS VSS VDD VDD _412_ sky130_fd_sc_hd__inv_1
X_835_ _412_ net61 VSS VSS VDD VDD _413_ sky130_fd_sc_hd__nand2_1
X_836_ _411_ _413_ _070_ VSS VSS VDD VDD _414_ sky130_fd_sc_hd__nand3_1
X_837_ storage\[2\]\[12\] VSS VSS VDD VDD _415_ sky130_fd_sc_hd__inv_1
X_838_ net58 _415_ VSS VSS VDD VDD _416_ sky130_fd_sc_hd__nand2_1
Xinput13 wr_data[4] VSS VSS VDD VDD net13 sky130_fd_sc_hd__clkdlybuf4s50_1
X_840_ storage\[3\]\[12\] VSS VSS VDD VDD _417_ sky130_fd_sc_hd__inv_1
X_841_ _417_ net61 VSS VSS VDD VDD _418_ sky130_fd_sc_hd__nand2_1
X_842_ _416_ _418_ net60 VSS VSS VDD VDD _419_ sky130_fd_sc_hd__nand3_1
X_843_ _414_ _419_ VSS VSS VDD VDD _420_ sky130_fd_sc_hd__nand2_1
X_844_ net59 _420_ VSS VSS VDD VDD _421_ sky130_fd_sc_hd__nor2_1
X_845_ storage\[4\]\[12\] VSS VSS VDD VDD _422_ sky130_fd_sc_hd__inv_1
X_846_ net58 _422_ VSS VSS VDD VDD _423_ sky130_fd_sc_hd__nand2_1
X_847_ storage\[5\]\[12\] VSS VSS VDD VDD _424_ sky130_fd_sc_hd__inv_1
X_848_ _424_ net61 VSS VSS VDD VDD _425_ sky130_fd_sc_hd__nand2_1
X_849_ _423_ _425_ _070_ VSS VSS VDD VDD _426_ sky130_fd_sc_hd__nand3_1
X_850_ rptr\[1\] VSS VSS VDD VDD _070_ sky130_fd_sc_hd__inv_2
X_851_ storage\[6\]\[12\] VSS VSS VDD VDD _427_ sky130_fd_sc_hd__inv_1
X_852_ net58 _427_ VSS VSS VDD VDD _428_ sky130_fd_sc_hd__nand2_1
X_853_ storage\[7\]\[12\] VSS VSS VDD VDD _429_ sky130_fd_sc_hd__inv_1
X_854_ _429_ net61 VSS VSS VDD VDD _430_ sky130_fd_sc_hd__nand2_1
X_855_ _428_ _430_ net60 VSS VSS VDD VDD _431_ sky130_fd_sc_hd__nand3_1
X_856_ _426_ _431_ net59 VSS VSS VDD VDD _432_ sky130_fd_sc_hd__nand3_1
X_857_ _432_ _041_ VSS VSS VDD VDD _433_ sky130_fd_sc_hd__nand2_1
X_858_ _421_ _433_ VSS VSS VDD VDD net25 sky130_fd_sc_hd__nor2_1
X_859_ storage\[0\]\[13\] VSS VSS VDD VDD _434_ sky130_fd_sc_hd__inv_1
X_860_ net58 _434_ VSS VSS VDD VDD _435_ sky130_fd_sc_hd__nand2_1
Xinput12 wr_data[3] VSS VSS VDD VDD net12 sky130_fd_sc_hd__clkdlybuf4s50_1
X_862_ storage\[1\]\[13\] VSS VSS VDD VDD _436_ sky130_fd_sc_hd__inv_1
X_863_ _436_ net61 VSS VSS VDD VDD _437_ sky130_fd_sc_hd__nand2_1
X_864_ _435_ _437_ _070_ VSS VSS VDD VDD _438_ sky130_fd_sc_hd__nand3_1
X_865_ storage\[2\]\[13\] VSS VSS VDD VDD _439_ sky130_fd_sc_hd__inv_1
X_866_ net58 _439_ VSS VSS VDD VDD _440_ sky130_fd_sc_hd__nand2_1
X_867_ storage\[3\]\[13\] VSS VSS VDD VDD _441_ sky130_fd_sc_hd__inv_1
X_868_ _441_ net61 VSS VSS VDD VDD _442_ sky130_fd_sc_hd__nand2_1
X_869_ _440_ _442_ net60 VSS VSS VDD VDD _443_ sky130_fd_sc_hd__nand3_1
X_870_ _438_ _443_ VSS VSS VDD VDD _444_ sky130_fd_sc_hd__nand2_1
X_871_ net59 _444_ VSS VSS VDD VDD _445_ sky130_fd_sc_hd__nor2_1
X_872_ _064_ _068_ _070_ VSS VSS VDD VDD _072_ sky130_fd_sc_hd__nand3_1
X_873_ storage\[4\]\[13\] VSS VSS VDD VDD _446_ sky130_fd_sc_hd__inv_1
X_874_ net58 _446_ VSS VSS VDD VDD _447_ sky130_fd_sc_hd__nand2_1
X_875_ storage\[5\]\[13\] VSS VSS VDD VDD _448_ sky130_fd_sc_hd__inv_1
X_876_ _448_ net61 VSS VSS VDD VDD _449_ sky130_fd_sc_hd__nand2_1
X_877_ _447_ _449_ _070_ VSS VSS VDD VDD _450_ sky130_fd_sc_hd__nand3_1
X_878_ storage\[6\]\[13\] VSS VSS VDD VDD _451_ sky130_fd_sc_hd__inv_1
X_879_ net58 _451_ VSS VSS VDD VDD _452_ sky130_fd_sc_hd__nand2_1
X_880_ storage\[7\]\[13\] VSS VSS VDD VDD _453_ sky130_fd_sc_hd__inv_1
X_881_ _453_ net61 VSS VSS VDD VDD _454_ sky130_fd_sc_hd__nand2_1
X_882_ _452_ _454_ net60 VSS VSS VDD VDD _455_ sky130_fd_sc_hd__nand3_1
Xinput11 wr_data[2] VSS VSS VDD VDD net11 sky130_fd_sc_hd__clkdlybuf4s50_1
X_884_ _450_ _455_ net59 VSS VSS VDD VDD _456_ sky130_fd_sc_hd__nand3_1
X_885_ _456_ _041_ VSS VSS VDD VDD _457_ sky130_fd_sc_hd__nand2_1
X_886_ _445_ _457_ VSS VSS VDD VDD net26 sky130_fd_sc_hd__nor2_1
X_887_ storage\[0\]\[14\] VSS VSS VDD VDD _458_ sky130_fd_sc_hd__inv_1
X_888_ net58 _458_ VSS VSS VDD VDD _459_ sky130_fd_sc_hd__nand2_1
X_889_ storage\[1\]\[14\] VSS VSS VDD VDD _460_ sky130_fd_sc_hd__inv_1
X_890_ _460_ net61 VSS VSS VDD VDD _461_ sky130_fd_sc_hd__nand2_1
X_891_ _459_ _461_ _070_ VSS VSS VDD VDD _462_ sky130_fd_sc_hd__nand3_1
X_892_ storage\[2\]\[14\] VSS VSS VDD VDD _463_ sky130_fd_sc_hd__inv_1
X_893_ net58 _463_ VSS VSS VDD VDD _464_ sky130_fd_sc_hd__nand2_1
X_894_ storage\[2\]\[15\] VSS VSS VDD VDD _074_ sky130_fd_sc_hd__inv_1
X_895_ storage\[3\]\[14\] VSS VSS VDD VDD _465_ sky130_fd_sc_hd__inv_1
X_896_ _465_ net61 VSS VSS VDD VDD _466_ sky130_fd_sc_hd__nand2_1
X_897_ _464_ _466_ net60 VSS VSS VDD VDD _467_ sky130_fd_sc_hd__nand3_1
X_898_ _462_ _467_ VSS VSS VDD VDD _468_ sky130_fd_sc_hd__nand2_1
X_899_ net59 _468_ VSS VSS VDD VDD _469_ sky130_fd_sc_hd__nor2_1
X_900_ storage\[4\]\[14\] VSS VSS VDD VDD _470_ sky130_fd_sc_hd__inv_1
X_901_ net58 _470_ VSS VSS VDD VDD _471_ sky130_fd_sc_hd__nand2_1
X_902_ storage\[5\]\[14\] VSS VSS VDD VDD _472_ sky130_fd_sc_hd__inv_1
X_903_ _472_ net61 VSS VSS VDD VDD _473_ sky130_fd_sc_hd__nand2_1
X_904_ _471_ _473_ _070_ VSS VSS VDD VDD _474_ sky130_fd_sc_hd__nand3_1
X_905_ _060_ _074_ VSS VSS VDD VDD _075_ sky130_fd_sc_hd__nand2_1
X_906_ storage\[6\]\[14\] VSS VSS VDD VDD _475_ sky130_fd_sc_hd__inv_1
X_907_ net58 _475_ VSS VSS VDD VDD _476_ sky130_fd_sc_hd__nand2_1
X_908_ storage\[7\]\[14\] VSS VSS VDD VDD _477_ sky130_fd_sc_hd__inv_1
X_909_ _477_ net61 VSS VSS VDD VDD _478_ sky130_fd_sc_hd__nand2_1
X_910_ _476_ _478_ net60 VSS VSS VDD VDD _479_ sky130_fd_sc_hd__nand3_1
X_911_ _474_ _479_ net59 VSS VSS VDD VDD _480_ sky130_fd_sc_hd__nand3_1
X_912_ _480_ _041_ VSS VSS VDD VDD _481_ sky130_fd_sc_hd__nand2_1
X_913_ _469_ _481_ VSS VSS VDD VDD net27 sky130_fd_sc_hd__nor2_1
X_914_ storage\[3\]\[15\] VSS VSS VDD VDD _076_ sky130_fd_sc_hd__inv_1
X_915_ _037_ net19 VSS VSS VDD VDD _014_ sky130_fd_sc_hd__nand2_2
Xinput10 wr_data[1] VSS VSS VDD VDD net10 sky130_fd_sc_hd__clkdlybuf4s50_1
X_917_ _076_ rptr\[0\] VSS VSS VDD VDD _078_ sky130_fd_sc_hd__nand2_1
Xinput9 wr_data[15] VSS VSS VDD VDD net9 sky130_fd_sc_hd__clkdlybuf4s50_1
X_919_ _075_ _078_ net60 VSS VSS VDD VDD _080_ sky130_fd_sc_hd__nand3_1
X_920_ _072_ _080_ VSS VSS VDD VDD _081_ sky130_fd_sc_hd__nand2_1
X_921_ rptr\[2\] _081_ VSS VSS VDD VDD _082_ sky130_fd_sc_hd__nor2_1
Xinput8 wr_data[14] VSS VSS VDD VDD net8 sky130_fd_sc_hd__clkdlybuf4s50_1
X_923_ storage\[4\]\[15\] VSS VSS VDD VDD _084_ sky130_fd_sc_hd__inv_1
X_924_ _060_ _084_ VSS VSS VDD VDD _085_ sky130_fd_sc_hd__nand2_1
X_925_ storage\[5\]\[15\] VSS VSS VDD VDD _086_ sky130_fd_sc_hd__inv_1
X_926_ wptr\[0\] _014_ VSS VSS VDD VDD _039_ sky130_fd_sc_hd__or2_4
Xinput7 wr_data[13] VSS VSS VDD VDD net7 sky130_fd_sc_hd__clkdlybuf4s50_1
X_928_ _086_ rptr\[0\] VSS VSS VDD VDD _088_ sky130_fd_sc_hd__nand2_1
Xinput6 wr_data[12] VSS VSS VDD VDD net6 sky130_fd_sc_hd__clkdlybuf4s50_1
X_930_ _085_ _088_ _070_ VSS VSS VDD VDD _090_ sky130_fd_sc_hd__nand3_1
Xinput5 wr_data[11] VSS VSS VDD VDD net5 sky130_fd_sc_hd__clkdlybuf4s50_1
X_932_ storage\[6\]\[15\] VSS VSS VDD VDD _092_ sky130_fd_sc_hd__inv_1
X_933_ _060_ _092_ VSS VSS VDD VDD _093_ sky130_fd_sc_hd__nand2_1
X_934_ storage\[7\]\[15\] VSS VSS VDD VDD _094_ sky130_fd_sc_hd__inv_1
Xinput4 wr_data[10] VSS VSS VDD VDD net4 sky130_fd_sc_hd__clkdlybuf4s50_1
X_936_ _094_ rptr\[0\] VSS VSS VDD VDD _096_ sky130_fd_sc_hd__nand2_1
X_937_ _038_ _039_ VSS VSS VDD VDD _033_ sky130_fd_sc_hd__nor2_1
Xinput3 wr_data[0] VSS VSS VDD VDD net3 sky130_fd_sc_hd__clkdlybuf4s50_1
X_939_ _093_ _096_ net60 VSS VSS VDD VDD _098_ sky130_fd_sc_hd__nand3_1
Xinput2 rst_n VSS VSS VDD VDD net2 sky130_fd_sc_hd__clkdlybuf4s50_1
X_941_ _090_ _098_ rptr\[2\] VSS VSS VDD VDD _100_ sky130_fd_sc_hd__nand3_1
Xinput1 rd_en VSS VSS VDD VDD net1 sky130_fd_sc_hd__clkdlybuf4s50_1
X_943_ _100_ _041_ VSS VSS VDD VDD _102_ sky130_fd_sc_hd__nand2_1
X_944_ _082_ _102_ VSS VSS VDD VDD net28 sky130_fd_sc_hd__nor2_1
X_945_ _041_ VSS VSS VDD VDD net20 sky130_fd_sc_hd__inv_1
X_946_ wptr\[2\] VSS VSS VDD VDD _103_ sky130_fd_sc_hd__inv_1
X_947_ wptr\[1\] VSS VSS VDD VDD _104_ sky130_fd_sc_hd__inv_1
X_948_ used\[3\] VSS VSS VDD VDD _040_ sky130_fd_sc_hd__inv_1
X_949_ _103_ _104_ net2 VSS VSS VDD VDD _105_ sky130_fd_sc_hd__nand3_1
X_950_ _105_ _039_ VSS VSS VDD VDD _027_ sky130_fd_sc_hd__nor2_1
X_951_ _104_ wptr\[2\] net2 VSS VSS VDD VDD _106_ sky130_fd_sc_hd__nand3_1
X_952_ _106_ _039_ VSS VSS VDD VDD _031_ sky130_fd_sc_hd__nor2_1
X_953_ _037_ net19 wptr\[0\] VSS VSS VDD VDD _107_ sky130_fd_sc_hd__nand3_1
X_954_ _105_ _107_ VSS VSS VDD VDD _028_ sky130_fd_sc_hd__nor2_1
X_955_ _103_ net2 wptr\[1\] VSS VSS VDD VDD _108_ sky130_fd_sc_hd__nand3_1
X_956_ _108_ _039_ VSS VSS VDD VDD _029_ sky130_fd_sc_hd__nor2_1
X_957_ _108_ _107_ VSS VSS VDD VDD _030_ sky130_fd_sc_hd__nor2_1
X_958_ _106_ _107_ VSS VSS VDD VDD _032_ sky130_fd_sc_hd__nor2_1
X_959_ _035_ _040_ _036_ VSS VSS VDD VDD _041_ sky130_fd_sc_hd__nand3_2
X_960_ _038_ _107_ VSS VSS VDD VDD _034_ sky130_fd_sc_hd__nor2_1
X_961_ _060_ _042_ VSS VSS VDD VDD _023_ sky130_fd_sc_hd__xor2_1
X_962_ _015_ _009_ VSS VSS VDD VDD _109_ sky130_fd_sc_hd__nand2_1
X_963_ _070_ _015_ _109_ VSS VSS VDD VDD _022_ sky130_fd_sc_hd__o21ai_1
X_964_ used\[0\] VSS VSS VDD VDD _000_ sky130_fd_sc_hd__inv_1
X_965_ _016_ used\[0\] VSS VSS VDD VDD _021_ sky130_fd_sc_hd__xnor2_1
X_966_ _016_ used\[1\] VSS VSS VDD VDD _110_ sky130_fd_sc_hd__nand2_1
X_967_ _016_ _004_ _110_ VSS VSS VDD VDD _020_ sky130_fd_sc_hd__o21ai_0
X_968_ _013_ _003_ VSS VSS VDD VDD _111_ sky130_fd_sc_hd__xor2_1
X_969_ _016_ used\[2\] VSS VSS VDD VDD _112_ sky130_fd_sc_hd__nand2_1
X_970_ _000_ _001_ _002_ VSS VSS VDD VDD _003_ _004_ sky130_fd_sc_hd__fa_1
X_971_ wptr\[0\] wptr\[1\] VSS VSS VDD VDD _006_ _007_ sky130_fd_sc_hd__ha_1
X_972_ rptr\[0\] net60 VSS VSS VDD VDD _008_ _009_ sky130_fd_sc_hd__ha_1
X_973_ used\[1\] _005_ VSS VSS VDD VDD _010_ _011_ sky130_fd_sc_hd__ha_1
X_974_ used\[2\] _005_ VSS VSS VDD VDD _012_ _013_ sky130_fd_sc_hd__ha_1
X_975_ _014_ _015_ VSS VSS VDD VDD _005_ _016_ sky130_fd_sc_hd__ha_1
Xrptr\[0\]$_DFFE_PN0P_ clknet_4_6_0_clk _023_ net2 VSS VSS
+ VDD VDD rptr\[0\] sky130_fd_sc_hd__dfrtp_1
Xrptr\[1\]$_DFFE_PN0P_ clknet_4_6_0_clk _022_ net2 VSS VSS
+ VDD VDD rptr\[1\] sky130_fd_sc_hd__dfrtp_1
Xrptr\[2\]$_DFFE_PN0P_ clknet_4_6_0_clk _026_ net2 VSS VSS
+ VDD VDD rptr\[2\] sky130_fd_sc_hd__dfrtp_1
Xstorage\[0\]\[0\]$_DFFE_PP_ clknet_4_5_0_clk net3 _027_ VSS
+ VSS VDD VDD storage\[0\]\[0\] sky130_fd_sc_hd__edfxtp_1
Xstorage\[0\]\[10\]$_DFFE_PP_ clknet_4_10_0_clk net4 net52
+ VSS VSS VDD VDD storage\[0\]\[10\] sky130_fd_sc_hd__edfxtp_1
Xstorage\[0\]\[11\]$_DFFE_PP_ clknet_4_8_0_clk net5 net52
+ VSS VSS VDD VDD storage\[0\]\[11\] sky130_fd_sc_hd__edfxtp_1
Xstorage\[0\]\[12\]$_DFFE_PP_ clknet_4_2_0_clk net6 net52
+ VSS VSS VDD VDD storage\[0\]\[12\] sky130_fd_sc_hd__edfxtp_1
Xstorage\[0\]\[13\]$_DFFE_PP_ clknet_4_3_0_clk net7 net52
+ VSS VSS VDD VDD storage\[0\]\[13\] sky130_fd_sc_hd__edfxtp_1
Xstorage\[0\]\[14\]$_DFFE_PP_ clknet_4_0_0_clk net8 net52
+ VSS VSS VDD VDD storage\[0\]\[14\] sky130_fd_sc_hd__edfxtp_1
Xstorage\[0\]\[15\]$_DFFE_PP_ clknet_4_4_0_clk net9 _027_
+ VSS VSS VDD VDD storage\[0\]\[15\] sky130_fd_sc_hd__edfxtp_1
Xstorage\[0\]\[1\]$_DFFE_PP_ clknet_4_6_0_clk net10 net52
+ VSS VSS VDD VDD storage\[0\]\[1\] sky130_fd_sc_hd__edfxtp_1
Xstorage\[0\]\[2\]$_DFFE_PP_ clknet_4_12_0_clk net11 net52
+ VSS VSS VDD VDD storage\[0\]\[2\] sky130_fd_sc_hd__edfxtp_1
Xstorage\[0\]\[3\]$_DFFE_PP_ clknet_4_12_0_clk net12 net52
+ VSS VSS VDD VDD storage\[0\]\[3\] sky130_fd_sc_hd__edfxtp_1
Xstorage\[0\]\[4\]$_DFFE_PP_ clknet_4_12_0_clk net13 net52
+ VSS VSS VDD VDD storage\[0\]\[4\] sky130_fd_sc_hd__edfxtp_1
Xstorage\[0\]\[5\]$_DFFE_PP_ clknet_4_14_0_clk net14 net52
+ VSS VSS VDD VDD storage\[0\]\[5\] sky130_fd_sc_hd__edfxtp_1
Xstorage\[0\]\[6\]$_DFFE_PP_ clknet_4_14_0_clk net15 net52
+ VSS VSS VDD VDD storage\[0\]\[6\] sky130_fd_sc_hd__edfxtp_1
Xstorage\[0\]\[7\]$_DFFE_PP_ clknet_4_9_0_clk net16 net52
+ VSS VSS VDD VDD storage\[0\]\[7\] sky130_fd_sc_hd__edfxtp_1
Xstorage\[0\]\[8\]$_DFFE_PP_ clknet_4_11_0_clk net17 net52
+ VSS VSS VDD VDD storage\[0\]\[8\] sky130_fd_sc_hd__edfxtp_1
Xstorage\[0\]\[9\]$_DFFE_PP_ clknet_4_8_0_clk net18 net52
+ VSS VSS VDD VDD storage\[0\]\[9\] sky130_fd_sc_hd__edfxtp_1
Xstorage\[1\]\[0\]$_DFFE_PP_ clknet_4_5_0_clk net3 net57 VSS
+ VSS VDD VDD storage\[1\]\[0\] sky130_fd_sc_hd__edfxtp_1
Xstorage\[1\]\[10\]$_DFFE_PP_ clknet_4_10_0_clk net4 net57
+ VSS VSS VDD VDD storage\[1\]\[10\] sky130_fd_sc_hd__edfxtp_1
Xstorage\[1\]\[11\]$_DFFE_PP_ clknet_4_8_0_clk net5 net57
+ VSS VSS VDD VDD storage\[1\]\[11\] sky130_fd_sc_hd__edfxtp_1
Xstorage\[1\]\[12\]$_DFFE_PP_ clknet_4_2_0_clk net6 net57
+ VSS VSS VDD VDD storage\[1\]\[12\] sky130_fd_sc_hd__edfxtp_1
Xstorage\[1\]\[13\]$_DFFE_PP_ clknet_4_3_0_clk net7 net57
+ VSS VSS VDD VDD storage\[1\]\[13\] sky130_fd_sc_hd__edfxtp_1
Xstorage\[1\]\[14\]$_DFFE_PP_ clknet_4_0_0_clk net8 net57
+ VSS VSS VDD VDD storage\[1\]\[14\] sky130_fd_sc_hd__edfxtp_1
Xstorage\[1\]\[15\]$_DFFE_PP_ clknet_4_4_0_clk net9 net57
+ VSS VSS VDD VDD storage\[1\]\[15\] sky130_fd_sc_hd__edfxtp_1
Xstorage\[1\]\[1\]$_DFFE_PP_ clknet_4_7_0_clk net10 net57
+ VSS VSS VDD VDD storage\[1\]\[1\] sky130_fd_sc_hd__edfxtp_1
Xstorage\[1\]\[2\]$_DFFE_PP_ clknet_4_6_0_clk net11 net57
+ VSS VSS VDD VDD storage\[1\]\[2\] sky130_fd_sc_hd__edfxtp_1
Xstorage\[1\]\[3\]$_DFFE_PP_ clknet_4_12_0_clk net12 net57
+ VSS VSS VDD VDD storage\[1\]\[3\] sky130_fd_sc_hd__edfxtp_1
Xstorage\[1\]\[4\]$_DFFE_PP_ clknet_4_13_0_clk net13 net57
+ VSS VSS VDD VDD storage\[1\]\[4\] sky130_fd_sc_hd__edfxtp_1
Xstorage\[1\]\[5\]$_DFFE_PP_ clknet_4_15_0_clk net14 net57
+ VSS VSS VDD VDD storage\[1\]\[5\] sky130_fd_sc_hd__edfxtp_1
Xstorage\[1\]\[6\]$_DFFE_PP_ clknet_4_11_0_clk net15 net57
+ VSS VSS VDD VDD storage\[1\]\[6\] sky130_fd_sc_hd__edfxtp_1
Xstorage\[1\]\[7\]$_DFFE_PP_ clknet_4_9_0_clk net16 net57
+ VSS VSS VDD VDD storage\[1\]\[7\] sky130_fd_sc_hd__edfxtp_1
Xstorage\[1\]\[8\]$_DFFE_PP_ clknet_4_11_0_clk net17 net57
+ VSS VSS VDD VDD storage\[1\]\[8\] sky130_fd_sc_hd__edfxtp_1
Xstorage\[1\]\[9\]$_DFFE_PP_ clknet_4_8_0_clk net18 net57
+ VSS VSS VDD VDD storage\[1\]\[9\] sky130_fd_sc_hd__edfxtp_1
Xstorage\[2\]\[0\]$_DFFE_PP_ clknet_4_5_0_clk net3 _029_ VSS
+ VSS VDD VDD storage\[2\]\[0\] sky130_fd_sc_hd__edfxtp_1
Xstorage\[2\]\[10\]$_DFFE_PP_ clknet_4_10_0_clk net4 net50
+ VSS VSS VDD VDD storage\[2\]\[10\] sky130_fd_sc_hd__edfxtp_1
Xstorage\[2\]\[11\]$_DFFE_PP_ clknet_4_8_0_clk net5 net50
+ VSS VSS VDD VDD storage\[2\]\[11\] sky130_fd_sc_hd__edfxtp_1
Xstorage\[2\]\[12\]$_DFFE_PP_ clknet_4_2_0_clk net6 net50
+ VSS VSS VDD VDD storage\[2\]\[12\] sky130_fd_sc_hd__edfxtp_1
Xstorage\[2\]\[13\]$_DFFE_PP_ clknet_4_3_0_clk net7 net50
+ VSS VSS VDD VDD storage\[2\]\[13\] sky130_fd_sc_hd__edfxtp_1
Xstorage\[2\]\[14\]$_DFFE_PP_ clknet_4_0_0_clk net8 net50
+ VSS VSS VDD VDD storage\[2\]\[14\] sky130_fd_sc_hd__edfxtp_1
Xstorage\[2\]\[15\]$_DFFE_PP_ clknet_4_4_0_clk net9 _029_
+ VSS VSS VDD VDD storage\[2\]\[15\] sky130_fd_sc_hd__edfxtp_1
Xstorage\[2\]\[1\]$_DFFE_PP_ clknet_4_6_0_clk net10 net50
+ VSS VSS VDD VDD storage\[2\]\[1\] sky130_fd_sc_hd__edfxtp_1
Xstorage\[2\]\[2\]$_DFFE_PP_ clknet_4_12_0_clk net11 net50
+ VSS VSS VDD VDD storage\[2\]\[2\] sky130_fd_sc_hd__edfxtp_1
Xstorage\[2\]\[3\]$_DFFE_PP_ clknet_4_12_0_clk net12 net50
+ VSS VSS VDD VDD storage\[2\]\[3\] sky130_fd_sc_hd__edfxtp_1
Xstorage\[2\]\[4\]$_DFFE_PP_ clknet_4_15_0_clk net13 net50
+ VSS VSS VDD VDD storage\[2\]\[4\] sky130_fd_sc_hd__edfxtp_1
Xstorage\[2\]\[5\]$_DFFE_PP_ clknet_4_15_0_clk net14 net50
+ VSS VSS VDD VDD storage\[2\]\[5\] sky130_fd_sc_hd__edfxtp_1
Xstorage\[2\]\[6\]$_DFFE_PP_ clknet_4_11_0_clk net15 net50
+ VSS VSS VDD VDD storage\[2\]\[6\] sky130_fd_sc_hd__edfxtp_1
Xstorage\[2\]\[7\]$_DFFE_PP_ clknet_4_12_0_clk net16 net50
+ VSS VSS VDD VDD storage\[2\]\[7\] sky130_fd_sc_hd__edfxtp_1
Xstorage\[2\]\[8\]$_DFFE_PP_ clknet_4_11_0_clk net17 net50
+ VSS VSS VDD VDD storage\[2\]\[8\] sky130_fd_sc_hd__edfxtp_1
Xstorage\[2\]\[9\]$_DFFE_PP_ clknet_4_8_0_clk net18 net50
+ VSS VSS VDD VDD storage\[2\]\[9\] sky130_fd_sc_hd__edfxtp_1
Xstorage\[3\]\[0\]$_DFFE_PP_ clknet_4_5_0_clk net3 net56 VSS
+ VSS VDD VDD storage\[3\]\[0\] sky130_fd_sc_hd__edfxtp_1
Xstorage\[3\]\[10\]$_DFFE_PP_ clknet_4_10_0_clk net4 net56
+ VSS VSS VDD VDD storage\[3\]\[10\] sky130_fd_sc_hd__edfxtp_1
Xstorage\[3\]\[11\]$_DFFE_PP_ clknet_4_8_0_clk net5 net56
+ VSS VSS VDD VDD storage\[3\]\[11\] sky130_fd_sc_hd__edfxtp_1
Xstorage\[3\]\[12\]$_DFFE_PP_ clknet_4_2_0_clk net6 net56
+ VSS VSS VDD VDD storage\[3\]\[12\] sky130_fd_sc_hd__edfxtp_1
Xstorage\[3\]\[13\]$_DFFE_PP_ clknet_4_1_0_clk net7 net56
+ VSS VSS VDD VDD storage\[3\]\[13\] sky130_fd_sc_hd__edfxtp_1
Xstorage\[3\]\[14\]$_DFFE_PP_ clknet_4_0_0_clk net8 net56
+ VSS VSS VDD VDD storage\[3\]\[14\] sky130_fd_sc_hd__edfxtp_1
Xstorage\[3\]\[15\]$_DFFE_PP_ clknet_4_4_0_clk net9 net56
+ VSS VSS VDD VDD storage\[3\]\[15\] sky130_fd_sc_hd__edfxtp_1
Xstorage\[3\]\[1\]$_DFFE_PP_ clknet_4_7_0_clk net10 net56
+ VSS VSS VDD VDD storage\[3\]\[1\] sky130_fd_sc_hd__edfxtp_1
Xstorage\[3\]\[2\]$_DFFE_PP_ clknet_4_12_0_clk net11 net56
+ VSS VSS VDD VDD storage\[3\]\[2\] sky130_fd_sc_hd__edfxtp_1
Xstorage\[3\]\[3\]$_DFFE_PP_ clknet_4_12_0_clk net12 net56
+ VSS VSS VDD VDD storage\[3\]\[3\] sky130_fd_sc_hd__edfxtp_1
Xstorage\[3\]\[4\]$_DFFE_PP_ clknet_4_13_0_clk net13 net56
+ VSS VSS VDD VDD storage\[3\]\[4\] sky130_fd_sc_hd__edfxtp_1
Xstorage\[3\]\[5\]$_DFFE_PP_ clknet_4_15_0_clk net14 net56
+ VSS VSS VDD VDD storage\[3\]\[5\] sky130_fd_sc_hd__edfxtp_1
Xstorage\[3\]\[6\]$_DFFE_PP_ clknet_4_11_0_clk net15 net56
+ VSS VSS VDD VDD storage\[3\]\[6\] sky130_fd_sc_hd__edfxtp_1
Xstorage\[3\]\[7\]$_DFFE_PP_ clknet_4_9_0_clk net16 net56
+ VSS VSS VDD VDD storage\[3\]\[7\] sky130_fd_sc_hd__edfxtp_1
Xstorage\[3\]\[8\]$_DFFE_PP_ clknet_4_11_0_clk net17 net56
+ VSS VSS VDD VDD storage\[3\]\[8\] sky130_fd_sc_hd__edfxtp_1
Xstorage\[3\]\[9\]$_DFFE_PP_ clknet_4_8_0_clk net18 net56
+ VSS VSS VDD VDD storage\[3\]\[9\] sky130_fd_sc_hd__edfxtp_1
Xstorage\[4\]\[0\]$_DFFE_PP_ clknet_4_5_0_clk net3 _031_ VSS
+ VSS VDD VDD storage\[4\]\[0\] sky130_fd_sc_hd__edfxtp_1
Xstorage\[4\]\[10\]$_DFFE_PP_ clknet_4_10_0_clk net4 net51
+ VSS VSS VDD VDD storage\[4\]\[10\] sky130_fd_sc_hd__edfxtp_1
Xstorage\[4\]\[11\]$_DFFE_PP_ clknet_4_8_0_clk net5 net51
+ VSS VSS VDD VDD storage\[4\]\[11\] sky130_fd_sc_hd__edfxtp_1
Xstorage\[4\]\[12\]$_DFFE_PP_ clknet_4_3_0_clk net6 net51
+ VSS VSS VDD VDD storage\[4\]\[12\] sky130_fd_sc_hd__edfxtp_1
Xstorage\[4\]\[13\]$_DFFE_PP_ clknet_4_1_0_clk net7 net51
+ VSS VSS VDD VDD storage\[4\]\[13\] sky130_fd_sc_hd__edfxtp_1
Xstorage\[4\]\[14\]$_DFFE_PP_ clknet_4_2_0_clk net8 net51
+ VSS VSS VDD VDD storage\[4\]\[14\] sky130_fd_sc_hd__edfxtp_1
Xstorage\[4\]\[15\]$_DFFE_PP_ clknet_4_4_0_clk net9 _031_
+ VSS VSS VDD VDD storage\[4\]\[15\] sky130_fd_sc_hd__edfxtp_1
Xstorage\[4\]\[1\]$_DFFE_PP_ clknet_4_7_0_clk net10 _031_
+ VSS VSS VDD VDD storage\[4\]\[1\] sky130_fd_sc_hd__edfxtp_1
Xstorage\[4\]\[2\]$_DFFE_PP_ clknet_4_6_0_clk net11 net51
+ VSS VSS VDD VDD storage\[4\]\[2\] sky130_fd_sc_hd__edfxtp_1
Xstorage\[4\]\[3\]$_DFFE_PP_ clknet_4_13_0_clk net12 _031_
+ VSS VSS VDD VDD storage\[4\]\[3\] sky130_fd_sc_hd__edfxtp_1
Xstorage\[4\]\[4\]$_DFFE_PP_ clknet_4_15_0_clk net13 net51
+ VSS VSS VDD VDD storage\[4\]\[4\] sky130_fd_sc_hd__edfxtp_1
Xstorage\[4\]\[5\]$_DFFE_PP_ clknet_4_14_0_clk net14 net51
+ VSS VSS VDD VDD storage\[4\]\[5\] sky130_fd_sc_hd__edfxtp_1
Xstorage\[4\]\[6\]$_DFFE_PP_ clknet_4_14_0_clk net15 net51
+ VSS VSS VDD VDD storage\[4\]\[6\] sky130_fd_sc_hd__edfxtp_1
Xstorage\[4\]\[7\]$_DFFE_PP_ clknet_4_9_0_clk net16 net51
+ VSS VSS VDD VDD storage\[4\]\[7\] sky130_fd_sc_hd__edfxtp_1
Xstorage\[4\]\[8\]$_DFFE_PP_ clknet_4_11_0_clk net17 net51
+ VSS VSS VDD VDD storage\[4\]\[8\] sky130_fd_sc_hd__edfxtp_1
Xstorage\[4\]\[9\]$_DFFE_PP_ clknet_4_8_0_clk net18 net51
+ VSS VSS VDD VDD storage\[4\]\[9\] sky130_fd_sc_hd__edfxtp_1
Xstorage\[5\]\[0\]$_DFFE_PP_ clknet_4_5_0_clk net3 net55 VSS
+ VSS VDD VDD storage\[5\]\[0\] sky130_fd_sc_hd__edfxtp_1
Xstorage\[5\]\[10\]$_DFFE_PP_ clknet_4_10_0_clk net4 net55
+ VSS VSS VDD VDD storage\[5\]\[10\] sky130_fd_sc_hd__edfxtp_1
Xstorage\[5\]\[11\]$_DFFE_PP_ clknet_4_9_0_clk net5 net55
+ VSS VSS VDD VDD storage\[5\]\[11\] sky130_fd_sc_hd__edfxtp_1
Xstorage\[5\]\[12\]$_DFFE_PP_ clknet_4_3_0_clk net6 net55
+ VSS VSS VDD VDD storage\[5\]\[12\] sky130_fd_sc_hd__edfxtp_1
Xstorage\[5\]\[13\]$_DFFE_PP_ clknet_4_1_0_clk net7 net55
+ VSS VSS VDD VDD storage\[5\]\[13\] sky130_fd_sc_hd__edfxtp_1
Xstorage\[5\]\[14\]$_DFFE_PP_ clknet_4_1_0_clk net8 net55
+ VSS VSS VDD VDD storage\[5\]\[14\] sky130_fd_sc_hd__edfxtp_1
Xstorage\[5\]\[15\]$_DFFE_PP_ clknet_4_4_0_clk net9 net55
+ VSS VSS VDD VDD storage\[5\]\[15\] sky130_fd_sc_hd__edfxtp_1
Xstorage\[5\]\[1\]$_DFFE_PP_ clknet_4_7_0_clk net10 net55
+ VSS VSS VDD VDD storage\[5\]\[1\] sky130_fd_sc_hd__edfxtp_1
Xstorage\[5\]\[2\]$_DFFE_PP_ clknet_4_12_0_clk net11 net55
+ VSS VSS VDD VDD storage\[5\]\[2\] sky130_fd_sc_hd__edfxtp_1
Xstorage\[5\]\[3\]$_DFFE_PP_ clknet_4_13_0_clk net12 net55
+ VSS VSS VDD VDD storage\[5\]\[3\] sky130_fd_sc_hd__edfxtp_1
Xstorage\[5\]\[4\]$_DFFE_PP_ clknet_4_15_0_clk net13 net55
+ VSS VSS VDD VDD storage\[5\]\[4\] sky130_fd_sc_hd__edfxtp_1
Xstorage\[5\]\[5\]$_DFFE_PP_ clknet_4_15_0_clk net14 net55
+ VSS VSS VDD VDD storage\[5\]\[5\] sky130_fd_sc_hd__edfxtp_1
Xstorage\[5\]\[6\]$_DFFE_PP_ clknet_4_14_0_clk net15 net55
+ VSS VSS VDD VDD storage\[5\]\[6\] sky130_fd_sc_hd__edfxtp_1
Xstorage\[5\]\[7\]$_DFFE_PP_ clknet_4_9_0_clk net16 net55
+ VSS VSS VDD VDD storage\[5\]\[7\] sky130_fd_sc_hd__edfxtp_1
Xstorage\[5\]\[8\]$_DFFE_PP_ clknet_4_11_0_clk net17 net55
+ VSS VSS VDD VDD storage\[5\]\[8\] sky130_fd_sc_hd__edfxtp_1
Xstorage\[5\]\[9\]$_DFFE_PP_ clknet_4_8_0_clk net18 net55
+ VSS VSS VDD VDD storage\[5\]\[9\] sky130_fd_sc_hd__edfxtp_1
Xstorage\[6\]\[0\]$_DFFE_PP_ clknet_4_5_0_clk net3 _033_ VSS
+ VSS VDD VDD storage\[6\]\[0\] sky130_fd_sc_hd__edfxtp_1
Xstorage\[6\]\[10\]$_DFFE_PP_ clknet_4_10_0_clk net4 net53
+ VSS VSS VDD VDD storage\[6\]\[10\] sky130_fd_sc_hd__edfxtp_1
Xstorage\[6\]\[11\]$_DFFE_PP_ clknet_4_9_0_clk net5 net53
+ VSS VSS VDD VDD storage\[6\]\[11\] sky130_fd_sc_hd__edfxtp_1
Xstorage\[6\]\[12\]$_DFFE_PP_ clknet_4_2_0_clk net6 net53
+ VSS VSS VDD VDD storage\[6\]\[12\] sky130_fd_sc_hd__edfxtp_1
Xstorage\[6\]\[13\]$_DFFE_PP_ clknet_4_1_0_clk net7 net53
+ VSS VSS VDD VDD storage\[6\]\[13\] sky130_fd_sc_hd__edfxtp_1
Xstorage\[6\]\[14\]$_DFFE_PP_ clknet_4_0_0_clk net8 net53
+ VSS VSS VDD VDD storage\[6\]\[14\] sky130_fd_sc_hd__edfxtp_1
Xstorage\[6\]\[15\]$_DFFE_PP_ clknet_4_7_0_clk net9 _033_
+ VSS VSS VDD VDD storage\[6\]\[15\] sky130_fd_sc_hd__edfxtp_1
Xstorage\[6\]\[1\]$_DFFE_PP_ clknet_4_7_0_clk net10 _033_
+ VSS VSS VDD VDD storage\[6\]\[1\] sky130_fd_sc_hd__edfxtp_1
Xstorage\[6\]\[2\]$_DFFE_PP_ clknet_4_13_0_clk net11 _033_
+ VSS VSS VDD VDD storage\[6\]\[2\] sky130_fd_sc_hd__edfxtp_1
Xstorage\[6\]\[3\]$_DFFE_PP_ clknet_4_13_0_clk net12 _033_
+ VSS VSS VDD VDD storage\[6\]\[3\] sky130_fd_sc_hd__edfxtp_1
Xstorage\[6\]\[4\]$_DFFE_PP_ clknet_4_15_0_clk net13 _033_
+ VSS VSS VDD VDD storage\[6\]\[4\] sky130_fd_sc_hd__edfxtp_1
Xstorage\[6\]\[5\]$_DFFE_PP_ clknet_4_14_0_clk net14 net53
+ VSS VSS VDD VDD storage\[6\]\[5\] sky130_fd_sc_hd__edfxtp_1
Xstorage\[6\]\[6\]$_DFFE_PP_ clknet_4_14_0_clk net15 net53
+ VSS VSS VDD VDD storage\[6\]\[6\] sky130_fd_sc_hd__edfxtp_1
Xstorage\[6\]\[7\]$_DFFE_PP_ clknet_4_12_0_clk net16 net53
+ VSS VSS VDD VDD storage\[6\]\[7\] sky130_fd_sc_hd__edfxtp_1
Xstorage\[6\]\[8\]$_DFFE_PP_ clknet_4_9_0_clk net17 net53
+ VSS VSS VDD VDD storage\[6\]\[8\] sky130_fd_sc_hd__edfxtp_1
Xstorage\[6\]\[9\]$_DFFE_PP_ clknet_4_9_0_clk net18 net53
+ VSS VSS VDD VDD storage\[6\]\[9\] sky130_fd_sc_hd__edfxtp_1
Xstorage\[7\]\[0\]$_DFFE_PP_ clknet_4_5_0_clk net3 net54 VSS
+ VSS VDD VDD storage\[7\]\[0\] sky130_fd_sc_hd__edfxtp_1
Xstorage\[7\]\[10\]$_DFFE_PP_ clknet_4_10_0_clk net4 net54
+ VSS VSS VDD VDD storage\[7\]\[10\] sky130_fd_sc_hd__edfxtp_1
Xstorage\[7\]\[11\]$_DFFE_PP_ clknet_4_9_0_clk net5 net54
+ VSS VSS VDD VDD storage\[7\]\[11\] sky130_fd_sc_hd__edfxtp_1
Xstorage\[7\]\[12\]$_DFFE_PP_ clknet_4_3_0_clk net6 net54
+ VSS VSS VDD VDD storage\[7\]\[12\] sky130_fd_sc_hd__edfxtp_1
Xstorage\[7\]\[13\]$_DFFE_PP_ clknet_4_1_0_clk net7 net54
+ VSS VSS VDD VDD storage\[7\]\[13\] sky130_fd_sc_hd__edfxtp_1
Xstorage\[7\]\[14\]$_DFFE_PP_ clknet_4_0_0_clk net8 net54
+ VSS VSS VDD VDD storage\[7\]\[14\] sky130_fd_sc_hd__edfxtp_1
Xstorage\[7\]\[15\]$_DFFE_PP_ clknet_4_4_0_clk net9 net54
+ VSS VSS VDD VDD storage\[7\]\[15\] sky130_fd_sc_hd__edfxtp_1
Xstorage\[7\]\[1\]$_DFFE_PP_ clknet_4_7_0_clk net10 net54
+ VSS VSS VDD VDD storage\[7\]\[1\] sky130_fd_sc_hd__edfxtp_1
Xstorage\[7\]\[2\]$_DFFE_PP_ clknet_4_13_0_clk net11 net54
+ VSS VSS VDD VDD storage\[7\]\[2\] sky130_fd_sc_hd__edfxtp_1
Xstorage\[7\]\[3\]$_DFFE_PP_ clknet_4_13_0_clk net12 net54
+ VSS VSS VDD VDD storage\[7\]\[3\] sky130_fd_sc_hd__edfxtp_1
Xstorage\[7\]\[4\]$_DFFE_PP_ clknet_4_15_0_clk net13 net54
+ VSS VSS VDD VDD storage\[7\]\[4\] sky130_fd_sc_hd__edfxtp_1
Xstorage\[7\]\[5\]$_DFFE_PP_ clknet_4_15_0_clk net14 net54
+ VSS VSS VDD VDD storage\[7\]\[5\] sky130_fd_sc_hd__edfxtp_1
Xstorage\[7\]\[6\]$_DFFE_PP_ clknet_4_14_0_clk net15 net54
+ VSS VSS VDD VDD storage\[7\]\[6\] sky130_fd_sc_hd__edfxtp_1
Xstorage\[7\]\[7\]$_DFFE_PP_ clknet_4_9_0_clk net16 net54
+ VSS VSS VDD VDD storage\[7\]\[7\] sky130_fd_sc_hd__edfxtp_1
Xstorage\[7\]\[8\]$_DFFE_PP_ clknet_4_9_0_clk net17 net54
+ VSS VSS VDD VDD storage\[7\]\[8\] sky130_fd_sc_hd__edfxtp_1
Xstorage\[7\]\[9\]$_DFFE_PP_ clknet_4_8_0_clk net18 net54
+ VSS VSS VDD VDD storage\[7\]\[9\] sky130_fd_sc_hd__edfxtp_1
Xused\[0\]$_DFFE_PN0P_ clknet_4_0_0_clk _021_ net2 VSS VSS
+ VDD VDD used\[0\] sky130_fd_sc_hd__dfrtp_1
Xused\[1\]$_DFFE_PN0P_ clknet_4_0_0_clk _020_ net2 VSS VSS
+ VDD VDD used\[1\] sky130_fd_sc_hd__dfrtp_1
Xused\[2\]$_DFFE_PN0P_ clknet_4_1_0_clk _019_ net2 VSS VSS
+ VDD VDD used\[2\] sky130_fd_sc_hd__dfrtp_1
Xused\[3\]$_DFFE_PN0P_ clknet_4_1_0_clk _025_ net2 VSS VSS
+ VDD VDD used\[3\] sky130_fd_sc_hd__dfrtp_1
Xwptr\[0\]$_DFFE_PN0P_ clknet_4_4_0_clk _018_ net2 VSS VSS
+ VDD VDD wptr\[0\] sky130_fd_sc_hd__dfrtp_1
Xwptr\[1\]$_DFFE_PN0P_ clknet_4_4_0_clk _017_ net2 VSS VSS
+ VDD VDD wptr\[1\] sky130_fd_sc_hd__dfrtp_1
Xwptr\[2\]$_DFFE_PN0P_ clknet_4_1_0_clk _024_ net2 VSS VSS
+ VDD VDD wptr\[2\] sky130_fd_sc_hd__dfrtp_1
XTAP_TAPCELL_ROW_0_0 VSS VDD sky130_fd_sc_hd__tapvpwrvgnd_1
XTAP_TAPCELL_ROW_0_1 VSS VDD sky130_fd_sc_hd__tapvpwrvgnd_1
XTAP_TAPCELL_ROW_0_2 VSS VDD sky130_fd_sc_hd__tapvpwrvgnd_1
XTAP_TAPCELL_ROW_0_3 VSS VDD sky130_fd_sc_hd__tapvpwrvgnd_1
XTAP_TAPCELL_ROW_0_4 VSS VDD sky130_fd_sc_hd__tapvpwrvgnd_1
XTAP_TAPCELL_ROW_0_5 VSS VDD sky130_fd_sc_hd__tapvpwrvgnd_1
XTAP_TAPCELL_ROW_0_6 VSS VDD sky130_fd_sc_hd__tapvpwrvgnd_1
XTAP_TAPCELL_ROW_0_7 VSS VDD sky130_fd_sc_hd__tapvpwrvgnd_1
XTAP_TAPCELL_ROW_0_8 VSS VDD sky130_fd_sc_hd__tapvpwrvgnd_1
XTAP_TAPCELL_ROW_1_9 VSS VDD sky130_fd_sc_hd__tapvpwrvgnd_1
XTAP_TAPCELL_ROW_1_10 VSS VDD sky130_fd_sc_hd__tapvpwrvgnd_1
XTAP_TAPCELL_ROW_1_11 VSS VDD sky130_fd_sc_hd__tapvpwrvgnd_1
XTAP_TAPCELL_ROW_1_12 VSS VDD sky130_fd_sc_hd__tapvpwrvgnd_1
XTAP_TAPCELL_ROW_2_13 VSS VDD sky130_fd_sc_hd__tapvpwrvgnd_1
XTAP_TAPCELL_ROW_2_14 VSS VDD sky130_fd_sc_hd__tapvpwrvgnd_1
XTAP_TAPCELL_ROW_2_15 VSS VDD sky130_fd_sc_hd__tapvpwrvgnd_1
XTAP_TAPCELL_ROW_2_16 VSS VDD sky130_fd_sc_hd__tapvpwrvgnd_1
XTAP_TAPCELL_ROW_2_17 VSS VDD sky130_fd_sc_hd__tapvpwrvgnd_1
XTAP_TAPCELL_ROW_3_18 VSS VDD sky130_fd_sc_hd__tapvpwrvgnd_1
XTAP_TAPCELL_ROW_3_19 VSS VDD sky130_fd_sc_hd__tapvpwrvgnd_1
XTAP_TAPCELL_ROW_3_20 VSS VDD sky130_fd_sc_hd__tapvpwrvgnd_1
XTAP_TAPCELL_ROW_3_21 VSS VDD sky130_fd_sc_hd__tapvpwrvgnd_1
XTAP_TAPCELL_ROW_4_22 VSS VDD sky130_fd_sc_hd__tapvpwrvgnd_1
XTAP_TAPCELL_ROW_4_23 VSS VDD sky130_fd_sc_hd__tapvpwrvgnd_1
XTAP_TAPCELL_ROW_4_24 VSS VDD sky130_fd_sc_hd__tapvpwrvgnd_1
XTAP_TAPCELL_ROW_4_25 VSS VDD sky130_fd_sc_hd__tapvpwrvgnd_1
XTAP_TAPCELL_ROW_4_26 VSS VDD sky130_fd_sc_hd__tapvpwrvgnd_1
XTAP_TAPCELL_ROW_5_27 VSS VDD sky130_fd_sc_hd__tapvpwrvgnd_1
XTAP_TAPCELL_ROW_5_28 VSS VDD sky130_fd_sc_hd__tapvpwrvgnd_1
XTAP_TAPCELL_ROW_5_29 VSS VDD sky130_fd_sc_hd__tapvpwrvgnd_1
XTAP_TAPCELL_ROW_5_30 VSS VDD sky130_fd_sc_hd__tapvpwrvgnd_1
XTAP_TAPCELL_ROW_6_31 VSS VDD sky130_fd_sc_hd__tapvpwrvgnd_1
XTAP_TAPCELL_ROW_6_32 VSS VDD sky130_fd_sc_hd__tapvpwrvgnd_1
XTAP_TAPCELL_ROW_6_33 VSS VDD sky130_fd_sc_hd__tapvpwrvgnd_1
XTAP_TAPCELL_ROW_6_34 VSS VDD sky130_fd_sc_hd__tapvpwrvgnd_1
XTAP_TAPCELL_ROW_6_35 VSS VDD sky130_fd_sc_hd__tapvpwrvgnd_1
XTAP_TAPCELL_ROW_7_36 VSS VDD sky130_fd_sc_hd__tapvpwrvgnd_1
XTAP_TAPCELL_ROW_7_37 VSS VDD sky130_fd_sc_hd__tapvpwrvgnd_1
XTAP_TAPCELL_ROW_7_38 VSS VDD sky130_fd_sc_hd__tapvpwrvgnd_1
XTAP_TAPCELL_ROW_7_39 VSS VDD sky130_fd_sc_hd__tapvpwrvgnd_1
XTAP_TAPCELL_ROW_8_40 VSS VDD sky130_fd_sc_hd__tapvpwrvgnd_1
XTAP_TAPCELL_ROW_8_41 VSS VDD sky130_fd_sc_hd__tapvpwrvgnd_1
XTAP_TAPCELL_ROW_8_42 VSS VDD sky130_fd_sc_hd__tapvpwrvgnd_1
XTAP_TAPCELL_ROW_8_43 VSS VDD sky130_fd_sc_hd__tapvpwrvgnd_1
XTAP_TAPCELL_ROW_8_44 VSS VDD sky130_fd_sc_hd__tapvpwrvgnd_1
XTAP_TAPCELL_ROW_9_45 VSS VDD sky130_fd_sc_hd__tapvpwrvgnd_1
XTAP_TAPCELL_ROW_9_46 VSS VDD sky130_fd_sc_hd__tapvpwrvgnd_1
XTAP_TAPCELL_ROW_9_47 VSS VDD sky130_fd_sc_hd__tapvpwrvgnd_1
XTAP_TAPCELL_ROW_9_48 VSS VDD sky130_fd_sc_hd__tapvpwrvgnd_1
XTAP_TAPCELL_ROW_10_49 VSS VDD sky130_fd_sc_hd__tapvpwrvgnd_1
XTAP_TAPCELL_ROW_10_50 VSS VDD sky130_fd_sc_hd__tapvpwrvgnd_1
XTAP_TAPCELL_ROW_10_51 VSS VDD sky130_fd_sc_hd__tapvpwrvgnd_1
XTAP_TAPCELL_ROW_10_52 VSS VDD sky130_fd_sc_hd__tapvpwrvgnd_1
XTAP_TAPCELL_ROW_10_53 VSS VDD sky130_fd_sc_hd__tapvpwrvgnd_1
XTAP_TAPCELL_ROW_11_54 VSS VDD sky130_fd_sc_hd__tapvpwrvgnd_1
XTAP_TAPCELL_ROW_11_55 VSS VDD sky130_fd_sc_hd__tapvpwrvgnd_1
XTAP_TAPCELL_ROW_11_56 VSS VDD sky130_fd_sc_hd__tapvpwrvgnd_1
XTAP_TAPCELL_ROW_11_57 VSS VDD sky130_fd_sc_hd__tapvpwrvgnd_1
XTAP_TAPCELL_ROW_12_58 VSS VDD sky130_fd_sc_hd__tapvpwrvgnd_1
XTAP_TAPCELL_ROW_12_59 VSS VDD sky130_fd_sc_hd__tapvpwrvgnd_1
XTAP_TAPCELL_ROW_12_60 VSS VDD sky130_fd_sc_hd__tapvpwrvgnd_1
XTAP_TAPCELL_ROW_12_61 VSS VDD sky130_fd_sc_hd__tapvpwrvgnd_1
XTAP_TAPCELL_ROW_12_62 VSS VDD sky130_fd_sc_hd__tapvpwrvgnd_1
XTAP_TAPCELL_ROW_13_63 VSS VDD sky130_fd_sc_hd__tapvpwrvgnd_1
XTAP_TAPCELL_ROW_13_64 VSS VDD sky130_fd_sc_hd__tapvpwrvgnd_1
XTAP_TAPCELL_ROW_13_65 VSS VDD sky130_fd_sc_hd__tapvpwrvgnd_1
XTAP_TAPCELL_ROW_13_66 VSS VDD sky130_fd_sc_hd__tapvpwrvgnd_1
XTAP_TAPCELL_ROW_14_67 VSS VDD sky130_fd_sc_hd__tapvpwrvgnd_1
XTAP_TAPCELL_ROW_14_68 VSS VDD sky130_fd_sc_hd__tapvpwrvgnd_1
XTAP_TAPCELL_ROW_14_69 VSS VDD sky130_fd_sc_hd__tapvpwrvgnd_1
XTAP_TAPCELL_ROW_14_70 VSS VDD sky130_fd_sc_hd__tapvpwrvgnd_1
XTAP_TAPCELL_ROW_14_71 VSS VDD sky130_fd_sc_hd__tapvpwrvgnd_1
XTAP_TAPCELL_ROW_15_72 VSS VDD sky130_fd_sc_hd__tapvpwrvgnd_1
XTAP_TAPCELL_ROW_15_73 VSS VDD sky130_fd_sc_hd__tapvpwrvgnd_1
XTAP_TAPCELL_ROW_15_74 VSS VDD sky130_fd_sc_hd__tapvpwrvgnd_1
XTAP_TAPCELL_ROW_15_75 VSS VDD sky130_fd_sc_hd__tapvpwrvgnd_1
XTAP_TAPCELL_ROW_16_76 VSS VDD sky130_fd_sc_hd__tapvpwrvgnd_1
XTAP_TAPCELL_ROW_16_77 VSS VDD sky130_fd_sc_hd__tapvpwrvgnd_1
XTAP_TAPCELL_ROW_16_78 VSS VDD sky130_fd_sc_hd__tapvpwrvgnd_1
XTAP_TAPCELL_ROW_16_79 VSS VDD sky130_fd_sc_hd__tapvpwrvgnd_1
XTAP_TAPCELL_ROW_16_80 VSS VDD sky130_fd_sc_hd__tapvpwrvgnd_1
XTAP_TAPCELL_ROW_17_81 VSS VDD sky130_fd_sc_hd__tapvpwrvgnd_1
XTAP_TAPCELL_ROW_17_82 VSS VDD sky130_fd_sc_hd__tapvpwrvgnd_1
XTAP_TAPCELL_ROW_17_83 VSS VDD sky130_fd_sc_hd__tapvpwrvgnd_1
XTAP_TAPCELL_ROW_17_84 VSS VDD sky130_fd_sc_hd__tapvpwrvgnd_1
XTAP_TAPCELL_ROW_18_85 VSS VDD sky130_fd_sc_hd__tapvpwrvgnd_1
XTAP_TAPCELL_ROW_18_86 VSS VDD sky130_fd_sc_hd__tapvpwrvgnd_1
XTAP_TAPCELL_ROW_18_87 VSS VDD sky130_fd_sc_hd__tapvpwrvgnd_1
XTAP_TAPCELL_ROW_18_88 VSS VDD sky130_fd_sc_hd__tapvpwrvgnd_1
XTAP_TAPCELL_ROW_18_89 VSS VDD sky130_fd_sc_hd__tapvpwrvgnd_1
XTAP_TAPCELL_ROW_19_90 VSS VDD sky130_fd_sc_hd__tapvpwrvgnd_1
XTAP_TAPCELL_ROW_19_91 VSS VDD sky130_fd_sc_hd__tapvpwrvgnd_1
XTAP_TAPCELL_ROW_19_92 VSS VDD sky130_fd_sc_hd__tapvpwrvgnd_1
XTAP_TAPCELL_ROW_19_93 VSS VDD sky130_fd_sc_hd__tapvpwrvgnd_1
XTAP_TAPCELL_ROW_20_94 VSS VDD sky130_fd_sc_hd__tapvpwrvgnd_1
XTAP_TAPCELL_ROW_20_95 VSS VDD sky130_fd_sc_hd__tapvpwrvgnd_1
XTAP_TAPCELL_ROW_20_96 VSS VDD sky130_fd_sc_hd__tapvpwrvgnd_1
XTAP_TAPCELL_ROW_20_97 VSS VDD sky130_fd_sc_hd__tapvpwrvgnd_1
XTAP_TAPCELL_ROW_20_98 VSS VDD sky130_fd_sc_hd__tapvpwrvgnd_1
XTAP_TAPCELL_ROW_21_99 VSS VDD sky130_fd_sc_hd__tapvpwrvgnd_1
XTAP_TAPCELL_ROW_21_100 VSS VDD sky130_fd_sc_hd__tapvpwrvgnd_1
XTAP_TAPCELL_ROW_21_101 VSS VDD sky130_fd_sc_hd__tapvpwrvgnd_1
XTAP_TAPCELL_ROW_21_102 VSS VDD sky130_fd_sc_hd__tapvpwrvgnd_1
XTAP_TAPCELL_ROW_22_103 VSS VDD sky130_fd_sc_hd__tapvpwrvgnd_1
XTAP_TAPCELL_ROW_22_104 VSS VDD sky130_fd_sc_hd__tapvpwrvgnd_1
XTAP_TAPCELL_ROW_22_105 VSS VDD sky130_fd_sc_hd__tapvpwrvgnd_1
XTAP_TAPCELL_ROW_22_106 VSS VDD sky130_fd_sc_hd__tapvpwrvgnd_1
XTAP_TAPCELL_ROW_22_107 VSS VDD sky130_fd_sc_hd__tapvpwrvgnd_1
XTAP_TAPCELL_ROW_23_108 VSS VDD sky130_fd_sc_hd__tapvpwrvgnd_1
XTAP_TAPCELL_ROW_23_109 VSS VDD sky130_fd_sc_hd__tapvpwrvgnd_1
XTAP_TAPCELL_ROW_23_110 VSS VDD sky130_fd_sc_hd__tapvpwrvgnd_1
XTAP_TAPCELL_ROW_23_111 VSS VDD sky130_fd_sc_hd__tapvpwrvgnd_1
XTAP_TAPCELL_ROW_24_112 VSS VDD sky130_fd_sc_hd__tapvpwrvgnd_1
XTAP_TAPCELL_ROW_24_113 VSS VDD sky130_fd_sc_hd__tapvpwrvgnd_1
XTAP_TAPCELL_ROW_24_114 VSS VDD sky130_fd_sc_hd__tapvpwrvgnd_1
XTAP_TAPCELL_ROW_24_115 VSS VDD sky130_fd_sc_hd__tapvpwrvgnd_1
XTAP_TAPCELL_ROW_24_116 VSS VDD sky130_fd_sc_hd__tapvpwrvgnd_1
XTAP_TAPCELL_ROW_25_117 VSS VDD sky130_fd_sc_hd__tapvpwrvgnd_1
XTAP_TAPCELL_ROW_25_118 VSS VDD sky130_fd_sc_hd__tapvpwrvgnd_1
XTAP_TAPCELL_ROW_25_119 VSS VDD sky130_fd_sc_hd__tapvpwrvgnd_1
XTAP_TAPCELL_ROW_25_120 VSS VDD sky130_fd_sc_hd__tapvpwrvgnd_1
XTAP_TAPCELL_ROW_26_121 VSS VDD sky130_fd_sc_hd__tapvpwrvgnd_1
XTAP_TAPCELL_ROW_26_122 VSS VDD sky130_fd_sc_hd__tapvpwrvgnd_1
XTAP_TAPCELL_ROW_26_123 VSS VDD sky130_fd_sc_hd__tapvpwrvgnd_1
XTAP_TAPCELL_ROW_26_124 VSS VDD sky130_fd_sc_hd__tapvpwrvgnd_1
XTAP_TAPCELL_ROW_26_125 VSS VDD sky130_fd_sc_hd__tapvpwrvgnd_1
XTAP_TAPCELL_ROW_27_126 VSS VDD sky130_fd_sc_hd__tapvpwrvgnd_1
XTAP_TAPCELL_ROW_27_127 VSS VDD sky130_fd_sc_hd__tapvpwrvgnd_1
XTAP_TAPCELL_ROW_27_128 VSS VDD sky130_fd_sc_hd__tapvpwrvgnd_1
XTAP_TAPCELL_ROW_27_129 VSS VDD sky130_fd_sc_hd__tapvpwrvgnd_1
XTAP_TAPCELL_ROW_28_130 VSS VDD sky130_fd_sc_hd__tapvpwrvgnd_1
XTAP_TAPCELL_ROW_28_131 VSS VDD sky130_fd_sc_hd__tapvpwrvgnd_1
XTAP_TAPCELL_ROW_28_132 VSS VDD sky130_fd_sc_hd__tapvpwrvgnd_1
XTAP_TAPCELL_ROW_28_133 VSS VDD sky130_fd_sc_hd__tapvpwrvgnd_1
XTAP_TAPCELL_ROW_28_134 VSS VDD sky130_fd_sc_hd__tapvpwrvgnd_1
XTAP_TAPCELL_ROW_29_135 VSS VDD sky130_fd_sc_hd__tapvpwrvgnd_1
XTAP_TAPCELL_ROW_29_136 VSS VDD sky130_fd_sc_hd__tapvpwrvgnd_1
XTAP_TAPCELL_ROW_29_137 VSS VDD sky130_fd_sc_hd__tapvpwrvgnd_1
XTAP_TAPCELL_ROW_29_138 VSS VDD sky130_fd_sc_hd__tapvpwrvgnd_1
XTAP_TAPCELL_ROW_30_139 VSS VDD sky130_fd_sc_hd__tapvpwrvgnd_1
XTAP_TAPCELL_ROW_30_140 VSS VDD sky130_fd_sc_hd__tapvpwrvgnd_1
XTAP_TAPCELL_ROW_30_141 VSS VDD sky130_fd_sc_hd__tapvpwrvgnd_1
XTAP_TAPCELL_ROW_30_142 VSS VDD sky130_fd_sc_hd__tapvpwrvgnd_1
XTAP_TAPCELL_ROW_30_143 VSS VDD sky130_fd_sc_hd__tapvpwrvgnd_1
XTAP_TAPCELL_ROW_31_144 VSS VDD sky130_fd_sc_hd__tapvpwrvgnd_1
XTAP_TAPCELL_ROW_31_145 VSS VDD sky130_fd_sc_hd__tapvpwrvgnd_1
XTAP_TAPCELL_ROW_31_146 VSS VDD sky130_fd_sc_hd__tapvpwrvgnd_1
XTAP_TAPCELL_ROW_31_147 VSS VDD sky130_fd_sc_hd__tapvpwrvgnd_1
XTAP_TAPCELL_ROW_32_148 VSS VDD sky130_fd_sc_hd__tapvpwrvgnd_1
XTAP_TAPCELL_ROW_32_149 VSS VDD sky130_fd_sc_hd__tapvpwrvgnd_1
XTAP_TAPCELL_ROW_32_150 VSS VDD sky130_fd_sc_hd__tapvpwrvgnd_1
XTAP_TAPCELL_ROW_32_151 VSS VDD sky130_fd_sc_hd__tapvpwrvgnd_1
XTAP_TAPCELL_ROW_32_152 VSS VDD sky130_fd_sc_hd__tapvpwrvgnd_1
XTAP_TAPCELL_ROW_33_153 VSS VDD sky130_fd_sc_hd__tapvpwrvgnd_1
XTAP_TAPCELL_ROW_33_154 VSS VDD sky130_fd_sc_hd__tapvpwrvgnd_1
XTAP_TAPCELL_ROW_33_155 VSS VDD sky130_fd_sc_hd__tapvpwrvgnd_1
XTAP_TAPCELL_ROW_33_156 VSS VDD sky130_fd_sc_hd__tapvpwrvgnd_1
XTAP_TAPCELL_ROW_34_157 VSS VDD sky130_fd_sc_hd__tapvpwrvgnd_1
XTAP_TAPCELL_ROW_34_158 VSS VDD sky130_fd_sc_hd__tapvpwrvgnd_1
XTAP_TAPCELL_ROW_34_159 VSS VDD sky130_fd_sc_hd__tapvpwrvgnd_1
XTAP_TAPCELL_ROW_34_160 VSS VDD sky130_fd_sc_hd__tapvpwrvgnd_1
XTAP_TAPCELL_ROW_34_161 VSS VDD sky130_fd_sc_hd__tapvpwrvgnd_1
XTAP_TAPCELL_ROW_35_162 VSS VDD sky130_fd_sc_hd__tapvpwrvgnd_1
XTAP_TAPCELL_ROW_35_163 VSS VDD sky130_fd_sc_hd__tapvpwrvgnd_1
XTAP_TAPCELL_ROW_35_164 VSS VDD sky130_fd_sc_hd__tapvpwrvgnd_1
XTAP_TAPCELL_ROW_35_165 VSS VDD sky130_fd_sc_hd__tapvpwrvgnd_1
XTAP_TAPCELL_ROW_36_166 VSS VDD sky130_fd_sc_hd__tapvpwrvgnd_1
XTAP_TAPCELL_ROW_36_167 VSS VDD sky130_fd_sc_hd__tapvpwrvgnd_1
XTAP_TAPCELL_ROW_36_168 VSS VDD sky130_fd_sc_hd__tapvpwrvgnd_1
XTAP_TAPCELL_ROW_36_169 VSS VDD sky130_fd_sc_hd__tapvpwrvgnd_1
XTAP_TAPCELL_ROW_36_170 VSS VDD sky130_fd_sc_hd__tapvpwrvgnd_1
XTAP_TAPCELL_ROW_37_171 VSS VDD sky130_fd_sc_hd__tapvpwrvgnd_1
XTAP_TAPCELL_ROW_37_172 VSS VDD sky130_fd_sc_hd__tapvpwrvgnd_1
XTAP_TAPCELL_ROW_37_173 VSS VDD sky130_fd_sc_hd__tapvpwrvgnd_1
XTAP_TAPCELL_ROW_37_174 VSS VDD sky130_fd_sc_hd__tapvpwrvgnd_1
XTAP_TAPCELL_ROW_38_175 VSS VDD sky130_fd_sc_hd__tapvpwrvgnd_1
XTAP_TAPCELL_ROW_38_176 VSS VDD sky130_fd_sc_hd__tapvpwrvgnd_1
XTAP_TAPCELL_ROW_38_177 VSS VDD sky130_fd_sc_hd__tapvpwrvgnd_1
XTAP_TAPCELL_ROW_38_178 VSS VDD sky130_fd_sc_hd__tapvpwrvgnd_1
XTAP_TAPCELL_ROW_38_179 VSS VDD sky130_fd_sc_hd__tapvpwrvgnd_1
XTAP_TAPCELL_ROW_39_180 VSS VDD sky130_fd_sc_hd__tapvpwrvgnd_1
XTAP_TAPCELL_ROW_39_181 VSS VDD sky130_fd_sc_hd__tapvpwrvgnd_1
XTAP_TAPCELL_ROW_39_182 VSS VDD sky130_fd_sc_hd__tapvpwrvgnd_1
XTAP_TAPCELL_ROW_39_183 VSS VDD sky130_fd_sc_hd__tapvpwrvgnd_1
XTAP_TAPCELL_ROW_40_184 VSS VDD sky130_fd_sc_hd__tapvpwrvgnd_1
XTAP_TAPCELL_ROW_40_185 VSS VDD sky130_fd_sc_hd__tapvpwrvgnd_1
XTAP_TAPCELL_ROW_40_186 VSS VDD sky130_fd_sc_hd__tapvpwrvgnd_1
XTAP_TAPCELL_ROW_40_187 VSS VDD sky130_fd_sc_hd__tapvpwrvgnd_1
XTAP_TAPCELL_ROW_40_188 VSS VDD sky130_fd_sc_hd__tapvpwrvgnd_1
XTAP_TAPCELL_ROW_41_189 VSS VDD sky130_fd_sc_hd__tapvpwrvgnd_1
XTAP_TAPCELL_ROW_41_190 VSS VDD sky130_fd_sc_hd__tapvpwrvgnd_1
XTAP_TAPCELL_ROW_41_191 VSS VDD sky130_fd_sc_hd__tapvpwrvgnd_1
XTAP_TAPCELL_ROW_41_192 VSS VDD sky130_fd_sc_hd__tapvpwrvgnd_1
XTAP_TAPCELL_ROW_42_193 VSS VDD sky130_fd_sc_hd__tapvpwrvgnd_1
XTAP_TAPCELL_ROW_42_194 VSS VDD sky130_fd_sc_hd__tapvpwrvgnd_1
XTAP_TAPCELL_ROW_42_195 VSS VDD sky130_fd_sc_hd__tapvpwrvgnd_1
XTAP_TAPCELL_ROW_42_196 VSS VDD sky130_fd_sc_hd__tapvpwrvgnd_1
XTAP_TAPCELL_ROW_42_197 VSS VDD sky130_fd_sc_hd__tapvpwrvgnd_1
XTAP_TAPCELL_ROW_43_198 VSS VDD sky130_fd_sc_hd__tapvpwrvgnd_1
XTAP_TAPCELL_ROW_43_199 VSS VDD sky130_fd_sc_hd__tapvpwrvgnd_1
XTAP_TAPCELL_ROW_43_200 VSS VDD sky130_fd_sc_hd__tapvpwrvgnd_1
XTAP_TAPCELL_ROW_43_201 VSS VDD sky130_fd_sc_hd__tapvpwrvgnd_1
XTAP_TAPCELL_ROW_44_202 VSS VDD sky130_fd_sc_hd__tapvpwrvgnd_1
XTAP_TAPCELL_ROW_44_203 VSS VDD sky130_fd_sc_hd__tapvpwrvgnd_1
XTAP_TAPCELL_ROW_44_204 VSS VDD sky130_fd_sc_hd__tapvpwrvgnd_1
XTAP_TAPCELL_ROW_44_205 VSS VDD sky130_fd_sc_hd__tapvpwrvgnd_1
XTAP_TAPCELL_ROW_44_206 VSS VDD sky130_fd_sc_hd__tapvpwrvgnd_1
XTAP_TAPCELL_ROW_44_207 VSS VDD sky130_fd_sc_hd__tapvpwrvgnd_1
XTAP_TAPCELL_ROW_44_208 VSS VDD sky130_fd_sc_hd__tapvpwrvgnd_1
XTAP_TAPCELL_ROW_44_209 VSS VDD sky130_fd_sc_hd__tapvpwrvgnd_1
XTAP_TAPCELL_ROW_44_210 VSS VDD sky130_fd_sc_hd__tapvpwrvgnd_1
Xoutput27 net27 VSS VSS VDD VDD rd_data[14] sky130_fd_sc_hd__clkdlybuf4s50_1
Xoutput28 net28 VSS VSS VDD VDD rd_data[15] sky130_fd_sc_hd__clkdlybuf4s50_1
Xoutput29 net29 VSS VSS VDD VDD rd_data[1] sky130_fd_sc_hd__clkdlybuf4s50_1
Xoutput30 net30 VSS VSS VDD VDD rd_data[2] sky130_fd_sc_hd__clkdlybuf4s50_1
Xoutput31 net31 VSS VSS VDD VDD rd_data[3] sky130_fd_sc_hd__clkdlybuf4s50_1
Xoutput32 net32 VSS VSS VDD VDD rd_data[4] sky130_fd_sc_hd__clkdlybuf4s50_1
Xoutput33 net33 VSS VSS VDD VDD rd_data[5] sky130_fd_sc_hd__clkdlybuf4s50_1
Xoutput34 net34 VSS VSS VDD VDD rd_data[6] sky130_fd_sc_hd__clkdlybuf4s50_1
Xoutput35 net35 VSS VSS VDD VDD rd_data[7] sky130_fd_sc_hd__clkdlybuf4s50_1
Xoutput36 net36 VSS VSS VDD VDD rd_data[8] sky130_fd_sc_hd__clkdlybuf4s50_1
Xoutput37 net37 VSS VSS VDD VDD rd_data[9] sky130_fd_sc_hd__clkdlybuf4s50_1
Xclkbuf_0_clk clk VSS VSS VDD VDD clknet_0_clk sky130_fd_sc_hd__clkbuf_16
Xplace50 _029_ VSS VSS VDD VDD net50 sky130_fd_sc_hd__buf_4
Xplace51 _031_ VSS VSS VDD VDD net51 sky130_fd_sc_hd__buf_4
Xplace52 _027_ VSS VSS VDD VDD net52 sky130_fd_sc_hd__buf_4
Xplace53 _033_ VSS VSS VDD VDD net53 sky130_fd_sc_hd__buf_4
Xplace54 _034_ VSS VSS VDD VDD net54 sky130_fd_sc_hd__buf_4
Xplace55 _032_ VSS VSS VDD VDD net55 sky130_fd_sc_hd__buf_4
Xplace56 _030_ VSS VSS VDD VDD net56 sky130_fd_sc_hd__buf_4
Xplace57 _028_ VSS VSS VDD VDD net57 sky130_fd_sc_hd__buf_4
Xplace58 _060_ VSS VSS VDD VDD net58 sky130_fd_sc_hd__buf_4
Xplace59 rptr\[2\] VSS VSS VDD VDD net59 sky130_fd_sc_hd__buf_4
Xplace60 rptr\[1\] VSS VSS VDD VDD net60 sky130_fd_sc_hd__buf_4
Xplace61 rptr\[0\] VSS VSS VDD VDD net61 sky130_fd_sc_hd__buf_4
Xclkbuf_4_0_0_clk clknet_0_clk VSS VSS VDD VDD clknet_4_0_0_clk
+ sky130_fd_sc_hd__clkbuf_16
Xclkbuf_4_1_0_clk clknet_0_clk VSS VSS VDD VDD clknet_4_1_0_clk
+ sky130_fd_sc_hd__clkbuf_16
Xclkbuf_4_2_0_clk clknet_0_clk VSS VSS VDD VDD clknet_4_2_0_clk
+ sky130_fd_sc_hd__clkbuf_16
Xclkbuf_4_3_0_clk clknet_0_clk VSS VSS VDD VDD clknet_4_3_0_clk
+ sky130_fd_sc_hd__clkbuf_16
Xclkbuf_4_4_0_clk clknet_0_clk VSS VSS VDD VDD clknet_4_4_0_clk
+ sky130_fd_sc_hd__clkbuf_16
Xclkbuf_4_5_0_clk clknet_0_clk VSS VSS VDD VDD clknet_4_5_0_clk
+ sky130_fd_sc_hd__clkbuf_16
Xclkbuf_4_6_0_clk clknet_0_clk VSS VSS VDD VDD clknet_4_6_0_clk
+ sky130_fd_sc_hd__clkbuf_16
Xclkbuf_4_7_0_clk clknet_0_clk VSS VSS VDD VDD clknet_4_7_0_clk
+ sky130_fd_sc_hd__clkbuf_16
Xclkbuf_4_8_0_clk clknet_0_clk VSS VSS VDD VDD clknet_4_8_0_clk
+ sky130_fd_sc_hd__clkbuf_16
Xclkbuf_4_9_0_clk clknet_0_clk VSS VSS VDD VDD clknet_4_9_0_clk
+ sky130_fd_sc_hd__clkbuf_16
Xclkbuf_4_10_0_clk clknet_0_clk VSS VSS VDD VDD clknet_4_10_0_clk
+ sky130_fd_sc_hd__clkbuf_16
Xclkbuf_4_11_0_clk clknet_0_clk VSS VSS VDD VDD clknet_4_11_0_clk
+ sky130_fd_sc_hd__clkbuf_16
Xclkbuf_4_12_0_clk clknet_0_clk VSS VSS VDD VDD clknet_4_12_0_clk
+ sky130_fd_sc_hd__clkbuf_16
Xclkbuf_4_13_0_clk clknet_0_clk VSS VSS VDD VDD clknet_4_13_0_clk
+ sky130_fd_sc_hd__clkbuf_16
Xclkbuf_4_14_0_clk clknet_0_clk VSS VSS VDD VDD clknet_4_14_0_clk
+ sky130_fd_sc_hd__clkbuf_16
Xclkbuf_4_15_0_clk clknet_0_clk VSS VSS VDD VDD clknet_4_15_0_clk
+ sky130_fd_sc_hd__clkbuf_16
Xclkload0 clknet_4_0_0_clk VSS VSS VDD VDD _unconnected_0
+ sky130_fd_sc_hd__bufinv_16
Xclkload1 clknet_4_1_0_clk VSS VSS VDD VDD _unconnected_1
+ sky130_fd_sc_hd__clkinv_2
Xclkload2 clknet_4_2_0_clk VSS VSS VDD VDD _unconnected_2
+ sky130_fd_sc_hd__clkinv_4
Xclkload3 clknet_4_3_0_clk VSS VSS VDD VDD _unconnected_3
+ sky130_fd_sc_hd__clkinv_4
Xclkload4 clknet_4_4_0_clk VSS VSS VDD VDD _unconnected_4
+ sky130_fd_sc_hd__clkinv_2
Xclkload5 clknet_4_5_0_clk VSS VSS VDD VDD _unconnected_5
+ sky130_fd_sc_hd__bufinv_16
Xclkload6 clknet_4_6_0_clk VSS VSS VDD VDD _unconnected_6
+ sky130_fd_sc_hd__clkinvlp_4
Xclkload7 clknet_4_7_0_clk VSS VSS VDD VDD _unconnected_7
+ sky130_fd_sc_hd__clkinvlp_4
Xclkload8 clknet_4_10_0_clk VSS VSS VDD VDD _unconnected_8
+ sky130_fd_sc_hd__bufinv_16
Xclkload9 clknet_4_11_0_clk VSS VSS VDD VDD _unconnected_9
+ sky130_fd_sc_hd__clkinv_2
Xclkload10 clknet_4_12_0_clk VSS VSS VDD VDD _unconnected_10
+ sky130_fd_sc_hd__clkbuf_1
Xclkload11 clknet_4_13_0_clk VSS VSS VDD VDD _unconnected_11
+ sky130_fd_sc_hd__bufinv_16
Xclkload12 clknet_4_14_0_clk VSS VSS VDD VDD _unconnected_12
+ sky130_fd_sc_hd__bufinv_16
Xclkload13 clknet_4_15_0_clk VSS VSS VDD VDD _unconnected_13
+ sky130_fd_sc_hd__clkinv_1
.ENDS benchmark_fifo
