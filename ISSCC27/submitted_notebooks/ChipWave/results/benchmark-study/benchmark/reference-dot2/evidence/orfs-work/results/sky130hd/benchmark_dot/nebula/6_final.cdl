* CDL Netlist generated by OpenROAD

*.BUSDELIMITER [

.SUBCKT benchmark_dot clk kill req_a[0] req_a[10] req_a[11]
+ req_a[12] req_a[13] req_a[14] req_a[15] req_a[1] req_a[2]
+ req_a[3] req_a[4] req_a[5] req_a[6] req_a[7] req_a[8] req_a[9]
+ req_b[0] req_b[10] req_b[11] req_b[12] req_b[13] req_b[14]
+ req_b[15] req_b[1] req_b[2] req_b[3] req_b[4] req_b[5] req_b[6]
+ req_b[7] req_b[8] req_b[9] req_ready req_valid rsp_data[0]
+ rsp_data[10] rsp_data[11] rsp_data[12] rsp_data[13] rsp_data[14]
+ rsp_data[15] rsp_data[16] rsp_data[17] rsp_data[18] rsp_data[19]
+ rsp_data[1] rsp_data[20] rsp_data[21] rsp_data[22] rsp_data[23]
+ rsp_data[24] rsp_data[25] rsp_data[26] rsp_data[27] rsp_data[28]
+ rsp_data[29] rsp_data[2] rsp_data[30] rsp_data[31] rsp_data[3]
+ rsp_data[4] rsp_data[5] rsp_data[6] rsp_data[7] rsp_data[8]
+ rsp_data[9] rsp_ready rsp_valid rst_n VDD VSS
X_1137_ net61 VSS VSS VDD VDD _0358_ sky130_fd_sc_hd__inv_1
X_1138_ phase\[0\] VSS VSS VDD VDD _0359_ sky130_fd_sc_hd__inv_1
X_1139_ net34 _0359_ _0360_ _0365_ VSS VSS VDD VDD _0232_
+ sky130_fd_sc_hd__o211ai_1
X_1140_ _0096_ VSS VSS VDD VDD _0452_ sky130_fd_sc_hd__inv_1
X_1141_ _0011_ VSS VSS VDD VDD _0453_ sky130_fd_sc_hd__inv_1
X_1142_ _0452_ _0453_ VSS VSS VDD VDD _0454_ sky130_fd_sc_hd__nand2_1
X_1143_ _0096_ _0011_ VSS VSS VDD VDD _0455_ sky130_fd_sc_hd__nand2_1
X_1144_ _0454_ _0455_ VSS VSS VDD VDD _0456_ sky130_fd_sc_hd__nand2_1
X_1145_ _0456_ _0111_ VSS VSS VDD VDD _0457_ sky130_fd_sc_hd__nand2_1
X_1146_ _0111_ _0454_ _0455_ VSS VSS VDD VDD _0458_ sky130_fd_sc_hd__nand3b_1
X_1147_ _0457_ _0458_ VSS VSS VDD VDD _0459_ sky130_fd_sc_hd__nand2_1
X_1148_ _0451_ _0459_ VSS VSS VDD VDD _0460_ sky130_fd_sc_hd__nand2_1
X_1149_ _0459_ VSS VSS VDD VDD _0461_ sky130_fd_sc_hd__inv_1
X_1150_ phase\[0\] net34 VSS VSS VDD VDD _0366_ sky130_fd_sc_hd__nand2_1
X_1151_ _0449_ _0461_ _0450_ VSS VSS VDD VDD _0462_ sky130_fd_sc_hd__nand3_1
X_1152_ _0460_ _0462_ VSS VSS VDD VDD _0463_ sky130_fd_sc_hd__nand2_1
X_1153_ _0146_ _0148_ VSS VSS VDD VDD _0464_ sky130_fd_sc_hd__nand2_1
X_1154_ _0464_ VSS VSS VDD VDD _0465_ sky130_fd_sc_hd__inv_1
X_1155_ _0465_ _0014_ VSS VSS VDD VDD _0466_ sky130_fd_sc_hd__nand2_1
X_1156_ _0146_ _0147_ _0145_ VSS VSS VDD VDD _0467_ sky130_fd_sc_hd__a21oi_1
X_1157_ _0466_ _0467_ VSS VSS VDD VDD _0468_ sky130_fd_sc_hd__nand2_1
X_1158_ _0150_ _0137_ VSS VSS VDD VDD _0469_ sky130_fd_sc_hd__nand2_1
X_1159_ _0144_ _0173_ VSS VSS VDD VDD _0470_ sky130_fd_sc_hd__nand2_1
X_1160_ _0469_ _0470_ VSS VSS VDD VDD _0471_ sky130_fd_sc_hd__nor2_1
X_1161_ net1 _0366_ VSS VSS VDD VDD _0367_ sky130_fd_sc_hd__nor2_2
X_1162_ _0155_ _0160_ VSS VSS VDD VDD _0472_ sky130_fd_sc_hd__nand2_1
X_1163_ _0210_ _0142_ VSS VSS VDD VDD _0473_ sky130_fd_sc_hd__nand2_1
X_1164_ _0472_ _0473_ VSS VSS VDD VDD _0474_ sky130_fd_sc_hd__nor2_1
X_1165_ _0468_ _0471_ _0474_ VSS VSS VDD VDD _0475_ sky130_fd_sc_hd__nand3_1
X_1166_ _0173_ _0143_ VSS VSS VDD VDD _0476_ sky130_fd_sc_hd__nand2_1
X_1167_ _0172_ VSS VSS VDD VDD _0477_ sky130_fd_sc_hd__inv_1
X_1168_ _0476_ _0477_ VSS VSS VDD VDD _0478_ sky130_fd_sc_hd__nand2_1
X_1169_ _0469_ VSS VSS VDD VDD _0479_ sky130_fd_sc_hd__inv_1
X_1170_ _0478_ _0479_ VSS VSS VDD VDD _0480_ sky130_fd_sc_hd__nand2_1
X_1171_ _0137_ _0149_ VSS VSS VDD VDD _0481_ sky130_fd_sc_hd__nand2_1
Xoutput53 net45 VSS VSS VDD VDD rsp_data[23] sky130_fd_sc_hd__clkdlybuf4s50_1
X_1173_ _0136_ VSS VSS VDD VDD _0482_ sky130_fd_sc_hd__inv_1
X_1174_ _0481_ _0482_ VSS VSS VDD VDD _0483_ sky130_fd_sc_hd__nand2_1
X_1175_ _0483_ VSS VSS VDD VDD _0484_ sky130_fd_sc_hd__inv_1
X_1176_ _0480_ _0484_ VSS VSS VDD VDD _0485_ sky130_fd_sc_hd__nand2_1
X_1177_ _0485_ _0474_ VSS VSS VDD VDD _0486_ sky130_fd_sc_hd__nand2_1
X_1178_ _0209_ _0142_ _0141_ VSS VSS VDD VDD _0487_ sky130_fd_sc_hd__a21o_1
X_1179_ _0155_ _0159_ VSS VSS VDD VDD _0488_ sky130_fd_sc_hd__nand2_1
X_1180_ _0154_ VSS VSS VDD VDD _0489_ sky130_fd_sc_hd__inv_1
X_1181_ _0488_ _0489_ _0473_ VSS VSS VDD VDD _0490_ sky130_fd_sc_hd__a21oi_1
X_1182_ _0487_ _0490_ VSS VSS VDD VDD _0491_ sky130_fd_sc_hd__nor2_1
Xoutput52 net45 VSS VSS VDD VDD rsp_data[22] sky130_fd_sc_hd__clkdlybuf4s50_1
X_1184_ _0475_ _0486_ _0491_ VSS VSS VDD VDD _0492_ sky130_fd_sc_hd__nand3_1
X_1185_ _0492_ VSS VSS VDD VDD _0493_ sky130_fd_sc_hd__inv_1
X_1186_ _0463_ _0493_ VSS VSS VDD VDD _0494_ sky130_fd_sc_hd__nand2_1
X_1187_ _0460_ _0462_ _0492_ VSS VSS VDD VDD _0495_ sky130_fd_sc_hd__nand3_1
X_1188_ _0494_ _0495_ net59 VSS VSS VDD VDD _0496_ sky130_fd_sc_hd__nand3_1
X_1189_ _0430_ product\[31\] VSS VSS VDD VDD _0497_ sky130_fd_sc_hd__nand2_1
X_1190_ _0496_ _0497_ VSS VSS VDD VDD _0281_ sky130_fd_sc_hd__nand2_1
X_1191_ _0358_ _0361_ VSS VSS VDD VDD net55 sky130_fd_sc_hd__nor2_1
Xoutput51 net45 VSS VSS VDD VDD rsp_data[21] sky130_fd_sc_hd__clkdlybuf4s50_1
X_1193_ net38 _0362_ _0363_ _0158_ VSS VSS VDD VDD _0280_
+ sky130_fd_sc_hd__a22o_1
X_1194_ phase\[2\] VSS VSS VDD VDD _0369_ sky130_fd_sc_hd__inv_1
X_1195_ net46 _0362_ _0363_ _0105_ VSS VSS VDD VDD _0279_
+ sky130_fd_sc_hd__a22o_1
X_1196_ _0204_ _0104_ VSS VSS VDD VDD _0499_ sky130_fd_sc_hd__nor2_1
X_1197_ _0204_ _0104_ VSS VSS VDD VDD _0500_ sky130_fd_sc_hd__nand2_1
X_1198_ _0363_ _0500_ VSS VSS VDD VDD _0501_ sky130_fd_sc_hd__nand2_1
Xoutput50 net45 VSS VSS VDD VDD rsp_data[20] sky130_fd_sc_hd__clkdlybuf4s50_1
X_1200_ _0362_ net47 VSS VSS VDD VDD _0503_ sky130_fd_sc_hd__nand2_1
X_1201_ _0499_ _0501_ _0503_ VSS VSS VDD VDD _0278_ sky130_fd_sc_hd__o21ai_2
X_1202_ _0204_ _0103_ _0138_ VSS VSS VDD VDD _0504_ sky130_fd_sc_hd__nand3_1
X_1203_ _0203_ VSS VSS VDD VDD _0505_ sky130_fd_sc_hd__inv_1
X_1204_ _0204_ _0153_ VSS VSS VDD VDD _0506_ sky130_fd_sc_hd__nand2_1
X_1205_ net1 _0369_ VSS VSS VDD VDD _0230_ sky130_fd_sc_hd__nor2_1
X_1206_ _0504_ _0505_ _0506_ VSS VSS VDD VDD _0507_ sky130_fd_sc_hd__nand3_2
X_1207_ _0135_ _0507_ VSS VSS VDD VDD _0508_ sky130_fd_sc_hd__xnor2_1
X_1208_ _0362_ net48 VSS VSS VDD VDD _0509_ sky130_fd_sc_hd__nand2_1
X_1209_ _0364_ _0508_ _0509_ VSS VSS VDD VDD _0277_ sky130_fd_sc_hd__o21ai_1
X_1210_ _0135_ _0203_ _0134_ VSS VSS VDD VDD _0510_ sky130_fd_sc_hd__a21oi_1
X_1211_ _0204_ _0104_ _0135_ VSS VSS VDD VDD _0511_ sky130_fd_sc_hd__nand3_1
X_1212_ _0510_ _0511_ VSS VSS VDD VDD _0512_ sky130_fd_sc_hd__nand2_1
X_1213_ _0181_ _0512_ VSS VSS VDD VDD _0513_ sky130_fd_sc_hd__xnor2_1
X_1214_ _0362_ net49 VSS VSS VDD VDD _0514_ sky130_fd_sc_hd__nand2_1
X_1215_ _0364_ _0513_ _0514_ VSS VSS VDD VDD _0276_ sky130_fd_sc_hd__o21ai_1
X_1216_ _0018_ VSS VSS VDD VDD _0370_ sky130_fd_sc_hd__inv_1
X_1217_ _0506_ _0505_ VSS VSS VDD VDD _0515_ sky130_fd_sc_hd__nand2_1
X_1218_ _0135_ _0181_ VSS VSS VDD VDD _0516_ sky130_fd_sc_hd__nand2_1
X_1219_ _0516_ VSS VSS VDD VDD _0517_ sky130_fd_sc_hd__inv_1
X_1220_ _0181_ _0134_ VSS VSS VDD VDD _0518_ sky130_fd_sc_hd__nand2_1
X_1221_ _0180_ VSS VSS VDD VDD _0519_ sky130_fd_sc_hd__inv_1
X_1222_ _0518_ _0519_ VSS VSS VDD VDD _0520_ sky130_fd_sc_hd__nand2_1
X_1223_ _0515_ _0517_ _0520_ VSS VSS VDD VDD _0521_ sky130_fd_sc_hd__a21oi_1
X_1224_ _0517_ _0204_ _0103_ _0138_ VSS VSS VDD VDD _0522_
+ sky130_fd_sc_hd__nand4_1
X_1225_ _0521_ _0522_ VSS VSS VDD VDD _0523_ sky130_fd_sc_hd__nand2_1
X_1226_ _0179_ _0523_ VSS VSS VDD VDD _0524_ sky130_fd_sc_hd__xnor2_1
X_1227_ _0370_ _0025_ VSS VSS VDD VDD _0371_ sky130_fd_sc_hd__nand2_1
X_1228_ _0362_ net50 VSS VSS VDD VDD _0525_ sky130_fd_sc_hd__nand2_1
X_1229_ _0364_ _0524_ _0525_ VSS VSS VDD VDD _0275_ sky130_fd_sc_hd__o21ai_0
X_1230_ _0181_ _0179_ VSS VSS VDD VDD _0526_ sky130_fd_sc_hd__nand2_1
X_1231_ _0526_ VSS VSS VDD VDD _0527_ sky130_fd_sc_hd__inv_1
X_1232_ _0512_ _0527_ VSS VSS VDD VDD _0528_ sky130_fd_sc_hd__nand2_1
X_1233_ _0179_ _0180_ _0178_ VSS VSS VDD VDD _0529_ sky130_fd_sc_hd__a21oi_1
X_1234_ _0528_ _0529_ VSS VSS VDD VDD _0530_ sky130_fd_sc_hd__nand2_1
X_1235_ _0168_ _0530_ VSS VSS VDD VDD _0531_ sky130_fd_sc_hd__xnor2_1
X_1236_ _0362_ net51 VSS VSS VDD VDD _0532_ sky130_fd_sc_hd__nand2_1
X_1237_ _0364_ _0531_ _0532_ VSS VSS VDD VDD _0274_ sky130_fd_sc_hd__o21ai_0
X_1238_ _0025_ VSS VSS VDD VDD _0372_ sky130_fd_sc_hd__inv_1
X_1239_ _0179_ _0168_ VSS VSS VDD VDD _0533_ sky130_fd_sc_hd__nand2_1
X_1240_ _0516_ _0533_ VSS VSS VDD VDD _0534_ sky130_fd_sc_hd__nor2_1
X_1241_ _0507_ _0534_ VSS VSS VDD VDD _0535_ sky130_fd_sc_hd__nand2_1
X_1242_ _0533_ VSS VSS VDD VDD _0536_ sky130_fd_sc_hd__inv_1
X_1243_ _0168_ _0178_ VSS VSS VDD VDD _0537_ sky130_fd_sc_hd__nand2_1
X_1244_ _0167_ VSS VSS VDD VDD _0538_ sky130_fd_sc_hd__inv_1
X_1245_ _0537_ _0538_ VSS VSS VDD VDD _0539_ sky130_fd_sc_hd__nand2_1
X_1246_ _0520_ _0536_ _0539_ VSS VSS VDD VDD _0540_ sky130_fd_sc_hd__a21oi_1
X_1247_ _0535_ _0540_ VSS VSS VDD VDD _0541_ sky130_fd_sc_hd__nand2_1
X_1248_ _0183_ _0541_ VSS VSS VDD VDD _0542_ sky130_fd_sc_hd__xnor2_1
X_1249_ net1 _0358_ _0359_ VSS VSS VDD VDD net37 sky130_fd_sc_hd__nor3_1
X_1250_ _0372_ _0018_ VSS VSS VDD VDD _0373_ sky130_fd_sc_hd__nand2_1
X_1251_ _0362_ net52 VSS VSS VDD VDD _0543_ sky130_fd_sc_hd__nand2_1
X_1252_ _0364_ _0542_ _0543_ VSS VSS VDD VDD _0273_ sky130_fd_sc_hd__o21ai_1
X_1253_ _0183_ _0167_ VSS VSS VDD VDD _0544_ sky130_fd_sc_hd__nand2_1
X_1254_ _0182_ VSS VSS VDD VDD _0545_ sky130_fd_sc_hd__inv_1
X_1255_ _0544_ _0545_ VSS VSS VDD VDD _0546_ sky130_fd_sc_hd__nand2_1
X_1256_ _0168_ _0183_ VSS VSS VDD VDD _0547_ sky130_fd_sc_hd__nand2_1
X_1257_ _0547_ _0529_ VSS VSS VDD VDD _0548_ sky130_fd_sc_hd__nor2_1
X_1258_ _0546_ _0548_ VSS VSS VDD VDD _0549_ sky130_fd_sc_hd__nor2_1
X_1259_ _0526_ _0547_ VSS VSS VDD VDD _0550_ sky130_fd_sc_hd__nor2_1
X_1260_ _0512_ _0550_ VSS VSS VDD VDD _0551_ sky130_fd_sc_hd__nand2_1
X_1261_ _0007_ VSS VSS VDD VDD _0374_ sky130_fd_sc_hd__inv_1
X_1262_ _0549_ _0551_ VSS VSS VDD VDD _0552_ sky130_fd_sc_hd__nand2_1
X_1263_ _0133_ _0552_ VSS VSS VDD VDD _0553_ sky130_fd_sc_hd__xnor2_1
X_1264_ _0362_ net53 VSS VSS VDD VDD _0554_ sky130_fd_sc_hd__nand2_1
X_1265_ _0364_ _0553_ _0554_ VSS VSS VDD VDD _0272_ sky130_fd_sc_hd__o21ai_1
X_1266_ _0183_ _0133_ VSS VSS VDD VDD _0555_ sky130_fd_sc_hd__nand2_1
X_1267_ _0555_ VSS VSS VDD VDD _0556_ sky130_fd_sc_hd__inv_1
X_1268_ _0541_ _0556_ VSS VSS VDD VDD _0557_ sky130_fd_sc_hd__nand2_1
X_1269_ _0133_ _0182_ VSS VSS VDD VDD _0558_ sky130_fd_sc_hd__nand2_1
X_1270_ _0132_ VSS VSS VDD VDD _0559_ sky130_fd_sc_hd__inv_1
X_1271_ _0558_ _0559_ VSS VSS VDD VDD _0560_ sky130_fd_sc_hd__nand2_1
X_1272_ _0371_ _0373_ _0374_ VSS VSS VDD VDD _0375_ sky130_fd_sc_hd__nand3_1
X_1273_ _0560_ VSS VSS VDD VDD _0561_ sky130_fd_sc_hd__inv_1
X_1274_ _0557_ _0561_ VSS VSS VDD VDD _0562_ sky130_fd_sc_hd__nand2_1
X_1275_ _0218_ _0562_ VSS VSS VDD VDD _0563_ sky130_fd_sc_hd__nor2_1
X_1276_ _0562_ _0218_ VSS VSS VDD VDD _0564_ sky130_fd_sc_hd__nand2_1
X_1277_ _0564_ _0363_ VSS VSS VDD VDD _0565_ sky130_fd_sc_hd__nand2_1
X_1278_ _0362_ net54 VSS VSS VDD VDD _0566_ sky130_fd_sc_hd__nand2_1
X_1279_ _0563_ _0565_ _0566_ VSS VSS VDD VDD _0271_ sky130_fd_sc_hd__o21ai_2
X_1280_ _0133_ _0218_ VSS VSS VDD VDD _0567_ sky130_fd_sc_hd__nand2_1
X_1281_ _0567_ VSS VSS VDD VDD _0568_ sky130_fd_sc_hd__inv_1
X_1282_ _0552_ _0568_ VSS VSS VDD VDD _0569_ sky130_fd_sc_hd__nand2_1
X_1283_ _0370_ _0372_ VSS VSS VDD VDD _0376_ sky130_fd_sc_hd__nand2_1
X_1284_ _0218_ _0132_ VSS VSS VDD VDD _0570_ sky130_fd_sc_hd__nand2_1
X_1285_ _0217_ VSS VSS VDD VDD _0571_ sky130_fd_sc_hd__inv_1
X_1286_ _0570_ _0571_ VSS VSS VDD VDD _0572_ sky130_fd_sc_hd__nand2_1
X_1287_ _0572_ VSS VSS VDD VDD _0573_ sky130_fd_sc_hd__inv_1
X_1288_ _0569_ _0573_ VSS VSS VDD VDD _0574_ sky130_fd_sc_hd__nand2_1
X_1289_ _0574_ _0162_ VSS VSS VDD VDD _0575_ sky130_fd_sc_hd__nand2_1
X_1290_ _0162_ _0569_ _0573_ VSS VSS VDD VDD _0576_ sky130_fd_sc_hd__nand3b_1
X_1291_ _0575_ _0576_ _0363_ VSS VSS VDD VDD _0577_ sky130_fd_sc_hd__nand3_1
X_1292_ _0362_ net39 VSS VSS VDD VDD _0578_ sky130_fd_sc_hd__nand2_1
X_1293_ _0577_ _0578_ VSS VSS VDD VDD _0270_ sky130_fd_sc_hd__nand2_1
X_1294_ _0018_ _0025_ VSS VSS VDD VDD _0377_ sky130_fd_sc_hd__nand2_1
X_1295_ _0218_ _0162_ VSS VSS VDD VDD _0579_ sky130_fd_sc_hd__nand2_1
X_1296_ _0555_ _0579_ VSS VSS VDD VDD _0580_ sky130_fd_sc_hd__nor2_1
X_1297_ _0540_ _0580_ VSS VSS VDD VDD _0581_ sky130_fd_sc_hd__nand2b_1
X_1298_ _0507_ _0534_ _0580_ VSS VSS VDD VDD _0582_ sky130_fd_sc_hd__nand3_1
X_1299_ _0579_ VSS VSS VDD VDD _0583_ sky130_fd_sc_hd__inv_1
X_1300_ _0560_ _0583_ VSS VSS VDD VDD _0584_ sky130_fd_sc_hd__nand2_1
X_1301_ _0162_ _0217_ _0161_ VSS VSS VDD VDD _0585_ sky130_fd_sc_hd__a21oi_1
X_1302_ _0584_ _0585_ VSS VSS VDD VDD _0586_ sky130_fd_sc_hd__nand2_1
X_1303_ _0586_ VSS VSS VDD VDD _0587_ sky130_fd_sc_hd__inv_1
X_1304_ _0581_ _0582_ _0587_ VSS VSS VDD VDD _0588_ sky130_fd_sc_hd__nand3_1
X_1305_ _0376_ _0007_ _0377_ VSS VSS VDD VDD _0378_ sky130_fd_sc_hd__nand3_1
X_1306_ _0588_ _0164_ VSS VSS VDD VDD _0589_ sky130_fd_sc_hd__nand2_1
X_1307_ _0164_ VSS VSS VDD VDD _0590_ sky130_fd_sc_hd__inv_1
X_1308_ _0581_ _0582_ _0590_ _0587_ VSS VSS VDD VDD _0591_
+ sky130_fd_sc_hd__nand4_1
X_1309_ _0589_ _0591_ _0363_ VSS VSS VDD VDD _0592_ sky130_fd_sc_hd__nand3_1
X_1310_ _0362_ net40 VSS VSS VDD VDD _0593_ sky130_fd_sc_hd__nand2_1
X_1311_ _0592_ _0593_ VSS VSS VDD VDD _0269_ sky130_fd_sc_hd__nand2_1
X_1312_ _0162_ _0164_ VSS VSS VDD VDD _0594_ sky130_fd_sc_hd__nand2_1
X_1313_ _0567_ _0594_ VSS VSS VDD VDD _0595_ sky130_fd_sc_hd__nor2_1
X_1314_ _0546_ _0548_ _0595_ VSS VSS VDD VDD _0596_ sky130_fd_sc_hd__o21ai_0
X_1315_ _0512_ _0550_ _0595_ VSS VSS VDD VDD _0597_ sky130_fd_sc_hd__nand3_1
X_1316_ _0375_ _0378_ VSS VSS VDD VDD _0379_ sky130_fd_sc_hd__nand2_1
X_1317_ _0594_ VSS VSS VDD VDD _0598_ sky130_fd_sc_hd__inv_1
X_1318_ _0572_ _0598_ VSS VSS VDD VDD _0599_ sky130_fd_sc_hd__nand2_1
X_1319_ _0164_ _0161_ _0163_ VSS VSS VDD VDD _0600_ sky130_fd_sc_hd__a21oi_1
X_1320_ _0599_ _0600_ VSS VSS VDD VDD _0601_ sky130_fd_sc_hd__nand2_1
X_1321_ _0601_ VSS VSS VDD VDD _0602_ sky130_fd_sc_hd__inv_1
X_1322_ _0596_ _0597_ _0602_ VSS VSS VDD VDD _0603_ sky130_fd_sc_hd__nand3_1
X_1323_ _0603_ _0186_ VSS VSS VDD VDD _0604_ sky130_fd_sc_hd__nand2_1
X_1324_ _0186_ VSS VSS VDD VDD _0605_ sky130_fd_sc_hd__inv_1
X_1325_ _0596_ _0597_ _0605_ _0602_ VSS VSS VDD VDD _0606_
+ sky130_fd_sc_hd__nand4_1
X_1326_ _0604_ _0606_ _0363_ VSS VSS VDD VDD _0607_ sky130_fd_sc_hd__nand3_1
X_1327_ _0013_ _0012_ VSS VSS VDD VDD _0380_ sky130_fd_sc_hd__xnor2_1
X_1328_ _0362_ net41 VSS VSS VDD VDD _0608_ sky130_fd_sc_hd__nand2_1
X_1329_ _0607_ _0608_ VSS VSS VDD VDD _0268_ sky130_fd_sc_hd__nand2_1
X_1330_ _0164_ _0186_ VSS VSS VDD VDD _0609_ sky130_fd_sc_hd__nand2_1
X_1331_ _0186_ _0163_ VSS VSS VDD VDD _0610_ sky130_fd_sc_hd__nand2_1
X_1332_ _0185_ VSS VSS VDD VDD _0611_ sky130_fd_sc_hd__inv_1
X_1333_ _0610_ _0611_ VSS VSS VDD VDD _0612_ sky130_fd_sc_hd__nand2_1
X_1334_ _0609_ _0585_ _0612_ VSS VSS VDD VDD _0613_ sky130_fd_sc_hd__o21bai_1
X_1335_ _0539_ _0556_ VSS VSS VDD VDD _0614_ sky130_fd_sc_hd__nand2_1
X_1336_ _0218_ _0162_ _0164_ _0186_ VSS VSS VDD VDD _0615_
+ sky130_fd_sc_hd__nand4_1
X_1337_ _0614_ _0561_ _0615_ VSS VSS VDD VDD _0616_ sky130_fd_sc_hd__a21oi_1
X_1338_ _0380_ VSS VSS VDD VDD _0381_ sky130_fd_sc_hd__inv_1
X_1339_ _0613_ _0616_ VSS VSS VDD VDD _0617_ sky130_fd_sc_hd__nor2_1
X_1340_ _0533_ _0555_ _0615_ VSS VSS VDD VDD _0618_ sky130_fd_sc_hd__nor3_1
X_1341_ _0618_ _0523_ VSS VSS VDD VDD _0619_ sky130_fd_sc_hd__nand2_1
X_1342_ _0191_ VSS VSS VDD VDD _0620_ sky130_fd_sc_hd__inv_1
X_1343_ _0617_ _0619_ _0620_ VSS VSS VDD VDD _0621_ sky130_fd_sc_hd__a21oi_1
X_1344_ _0617_ _0619_ _0620_ VSS VSS VDD VDD _0622_ sky130_fd_sc_hd__nand3_1
X_1345_ _0622_ _0363_ VSS VSS VDD VDD _0623_ sky130_fd_sc_hd__nand2_1
X_1346_ _0362_ net42 VSS VSS VDD VDD _0624_ sky130_fd_sc_hd__nand2_1
X_1347_ _0621_ _0623_ _0624_ VSS VSS VDD VDD _0267_ sky130_fd_sc_hd__o21ai_2
X_1348_ _0186_ _0191_ VSS VSS VDD VDD _0625_ sky130_fd_sc_hd__nand2_1
X_1349_ _0379_ _0381_ VSS VSS VDD VDD _0382_ sky130_fd_sc_hd__nand2_1
X_1350_ _0191_ _0185_ VSS VSS VDD VDD _0626_ sky130_fd_sc_hd__nand2_1
X_1351_ _0190_ VSS VSS VDD VDD _0627_ sky130_fd_sc_hd__inv_1
X_1352_ _0626_ _0627_ VSS VSS VDD VDD _0628_ sky130_fd_sc_hd__nand2_1
X_1353_ _0625_ _0600_ _0628_ VSS VSS VDD VDD _0629_ sky130_fd_sc_hd__o21bai_1
X_1354_ _0546_ _0568_ VSS VSS VDD VDD _0630_ sky130_fd_sc_hd__nand2_1
X_1355_ _0162_ _0164_ _0186_ _0191_ VSS VSS VDD VDD _0631_
+ sky130_fd_sc_hd__nand4_1
X_1356_ _0630_ _0573_ _0631_ VSS VSS VDD VDD _0632_ sky130_fd_sc_hd__a21oi_1
X_1357_ _0629_ _0632_ VSS VSS VDD VDD _0633_ sky130_fd_sc_hd__nor2_1
X_1358_ _0547_ _0567_ _0631_ VSS VSS VDD VDD _0634_ sky130_fd_sc_hd__nor3_1
X_1359_ _0530_ _0634_ VSS VSS VDD VDD _0635_ sky130_fd_sc_hd__nand2_1
X_1360_ net1 VSS VSS VDD VDD _0360_ sky130_fd_sc_hd__inv_2
X_1361_ _0375_ _0378_ _0380_ VSS VSS VDD VDD _0383_ sky130_fd_sc_hd__nand3_1
X_1362_ _0208_ VSS VSS VDD VDD _0636_ sky130_fd_sc_hd__inv_1
X_1363_ _0633_ _0635_ _0636_ VSS VSS VDD VDD _0637_ sky130_fd_sc_hd__a21oi_1
X_1364_ _0633_ _0635_ _0636_ VSS VSS VDD VDD _0638_ sky130_fd_sc_hd__nand3_1
X_1365_ _0638_ _0363_ VSS VSS VDD VDD _0639_ sky130_fd_sc_hd__nand2_1
X_1366_ _0362_ net43 VSS VSS VDD VDD _0640_ sky130_fd_sc_hd__nand2_1
X_1367_ _0637_ _0639_ _0640_ VSS VSS VDD VDD _0266_ sky130_fd_sc_hd__o21ai_1
X_1368_ _0620_ _0636_ _0609_ VSS VSS VDD VDD _0641_ sky130_fd_sc_hd__nor3_1
X_1369_ _0541_ _0580_ _0641_ VSS VSS VDD VDD _0642_ sky130_fd_sc_hd__nand3_1
X_1370_ _0612_ _0191_ _0208_ VSS VSS VDD VDD _0643_ sky130_fd_sc_hd__nand3_1
X_1371_ _0208_ _0190_ _0207_ VSS VSS VDD VDD _0644_ sky130_fd_sc_hd__a21oi_1
X_1372_ _0382_ _0383_ VSS VSS VDD VDD _0384_ sky130_fd_sc_hd__nand2_1
X_1373_ _0643_ _0644_ VSS VSS VDD VDD _0645_ sky130_fd_sc_hd__nand2_1
X_1374_ _0586_ _0641_ _0645_ VSS VSS VDD VDD _0646_ sky130_fd_sc_hd__a21oi_1
X_1375_ _0642_ _0646_ VSS VSS VDD VDD _0647_ sky130_fd_sc_hd__nand2_1
X_1376_ _0647_ _0131_ VSS VSS VDD VDD _0648_ sky130_fd_sc_hd__nand2_1
X_1377_ _0131_ VSS VSS VDD VDD _0649_ sky130_fd_sc_hd__inv_1
X_1378_ _0642_ _0649_ _0646_ VSS VSS VDD VDD _0650_ sky130_fd_sc_hd__nand3_1
X_1379_ _0648_ _0363_ _0650_ VSS VSS VDD VDD _0651_ sky130_fd_sc_hd__nand3_1
X_1380_ _0362_ net44 VSS VSS VDD VDD _0652_ sky130_fd_sc_hd__nand2_1
X_1381_ _0651_ _0652_ VSS VSS VDD VDD _0265_ sky130_fd_sc_hd__nand2_1
X_1382_ _0636_ _0649_ _0625_ VSS VSS VDD VDD _0653_ sky130_fd_sc_hd__nor3_2
X_1383_ _0019_ VSS VSS VDD VDD _0385_ sky130_fd_sc_hd__inv_1
X_1384_ _0653_ _0595_ VSS VSS VDD VDD _0654_ sky130_fd_sc_hd__and2_1
X_1385_ _0552_ _0654_ VSS VSS VDD VDD _0655_ sky130_fd_sc_hd__nand2_1
X_1386_ _0628_ _0208_ _0131_ VSS VSS VDD VDD _0656_ sky130_fd_sc_hd__nand3_1
X_1387_ _0131_ _0207_ _0130_ VSS VSS VDD VDD _0657_ sky130_fd_sc_hd__a21oi_1
X_1388_ _0656_ _0657_ VSS VSS VDD VDD _0658_ sky130_fd_sc_hd__nand2_1
X_1389_ _0601_ _0653_ _0658_ VSS VSS VDD VDD _0659_ sky130_fd_sc_hd__a21oi_1
X_1390_ _0655_ _0659_ VSS VSS VDD VDD _0660_ sky130_fd_sc_hd__nand2_1
X_1391_ _0660_ _0131_ VSS VSS VDD VDD _0661_ sky130_fd_sc_hd__nand2_1
X_1392_ _0655_ _0649_ _0659_ VSS VSS VDD VDD _0662_ sky130_fd_sc_hd__nand3_1
X_1393_ _0661_ _0363_ _0662_ VSS VSS VDD VDD _0663_ sky130_fd_sc_hd__nand3_1
X_1394_ _0017_ VSS VSS VDD VDD _0386_ sky130_fd_sc_hd__inv_1
X_1395_ _0362_ net45 VSS VSS VDD VDD _0664_ sky130_fd_sc_hd__nand2_1
X_1396_ _0663_ _0664_ VSS VSS VDD VDD _0264_ sky130_fd_sc_hd__nand2_1
Xoutput49 net46 VSS VSS VDD VDD rsp_data[1] sky130_fd_sc_hd__clkdlybuf4s50_1
Xoutput48 net45 VSS VSS VDD VDD rsp_data[19] sky130_fd_sc_hd__clkdlybuf4s50_1
Xoutput47 net45 VSS VSS VDD VDD rsp_data[18] sky130_fd_sc_hd__clkdlybuf4s50_1
X_1400_ net59 net16 net32 product\[0\] _0430_ VSS VSS VDD
+ VDD _0263_ sky130_fd_sc_hd__a32o_1
Xoutput46 net45 VSS VSS VDD VDD rsp_data[17] sky130_fd_sc_hd__clkdlybuf4s50_1
X_1402_ net59 _0127_ _0430_ product\[1\] VSS VSS VDD VDD _0262_
+ sky130_fd_sc_hd__a22o_1
X_1403_ net59 _0199_ _0430_ product\[2\] VSS VSS VDD VDD _0261_
+ sky130_fd_sc_hd__a22o_1
X_1404_ net59 _0008_ _0430_ product\[3\] VSS VSS VDD VDD _0260_
+ sky130_fd_sc_hd__a22o_1
X_1405_ _0385_ _0386_ VSS VSS VDD VDD _0387_ sky130_fd_sc_hd__nand2_1
X_1406_ net59 _0192_ _0430_ product\[4\] VSS VSS VDD VDD _0259_
+ sky130_fd_sc_hd__a22o_1
X_1407_ net59 _0005_ _0430_ product\[5\] VSS VSS VDD VDD _0258_
+ sky130_fd_sc_hd__a22o_1
X_1408_ net59 VSS VSS VDD VDD _0669_ sky130_fd_sc_hd__inv_1
X_1409_ _0189_ _0004_ VSS VSS VDD VDD _0670_ sky130_fd_sc_hd__xnor2_1
X_1410_ _0430_ product\[6\] VSS VSS VDD VDD _0671_ sky130_fd_sc_hd__nand2_1
X_1411_ _0669_ _0670_ _0671_ VSS VSS VDD VDD _0257_ sky130_fd_sc_hd__o21ai_0
X_1412_ _0400_ _0197_ _0669_ VSS VSS VDD VDD _0672_ sky130_fd_sc_hd__a21oi_1
X_1413_ _0197_ _0400_ _0672_ VSS VSS VDD VDD _0673_ sky130_fd_sc_hd__o21ai_0
X_1414_ _0430_ product\[7\] VSS VSS VDD VDD _0674_ sky130_fd_sc_hd__nand2_1
X_1415_ _0673_ _0674_ VSS VSS VDD VDD _0256_ sky130_fd_sc_hd__nand2_1
X_1416_ _0019_ _0017_ VSS VSS VDD VDD _0388_ sky130_fd_sc_hd__nand2_1
X_1417_ _0197_ _0188_ _0196_ VSS VSS VDD VDD _0675_ sky130_fd_sc_hd__a21oi_1
X_1418_ _0189_ _0004_ _0197_ VSS VSS VDD VDD _0676_ sky130_fd_sc_hd__nand3_1
X_1419_ _0675_ _0676_ VSS VSS VDD VDD _0677_ sky130_fd_sc_hd__nand2_1
X_1420_ _0677_ _0157_ _0669_ VSS VSS VDD VDD _0678_ sky130_fd_sc_hd__a21oi_1
X_1421_ _0157_ _0677_ _0678_ VSS VSS VDD VDD _0679_ sky130_fd_sc_hd__o21ai_0
X_1422_ _0430_ product\[8\] VSS VSS VDD VDD _0680_ sky130_fd_sc_hd__nand2_1
X_1423_ _0679_ _0680_ VSS VSS VDD VDD _0255_ sky130_fd_sc_hd__nand2_1
X_1424_ _0400_ _0197_ _0157_ VSS VSS VDD VDD _0681_ sky130_fd_sc_hd__nand3_1
X_1425_ _0410_ VSS VSS VDD VDD _0682_ sky130_fd_sc_hd__inv_1
X_1426_ _0152_ VSS VSS VDD VDD _0683_ sky130_fd_sc_hd__inv_1
X_1427_ _0387_ _0388_ VSS VSS VDD VDD _0389_ sky130_fd_sc_hd__nand2_1
X_1428_ _0681_ _0682_ _0683_ VSS VSS VDD VDD _0684_ sky130_fd_sc_hd__a21oi_1
X_1429_ _0681_ _0683_ _0682_ VSS VSS VDD VDD _0685_ sky130_fd_sc_hd__nand3_1
Xoutput45 net45 VSS VSS VDD VDD rsp_data[16] sky130_fd_sc_hd__clkdlybuf4s50_1
X_1431_ _0685_ net59 VSS VSS VDD VDD _0687_ sky130_fd_sc_hd__nand2_1
X_1432_ _0430_ product\[9\] VSS VSS VDD VDD _0688_ sky130_fd_sc_hd__nand2_1
X_1433_ _0684_ _0687_ _0688_ VSS VSS VDD VDD _0254_ sky130_fd_sc_hd__o21ai_0
X_1434_ _0189_ _0197_ VSS VSS VDD VDD _0689_ sky130_fd_sc_hd__nand2_1
X_1435_ _0157_ _0152_ VSS VSS VDD VDD _0690_ sky130_fd_sc_hd__nand2_1
X_1436_ _0689_ _0690_ VSS VSS VDD VDD _0691_ sky130_fd_sc_hd__nor2_1
X_1437_ _0156_ _0152_ _0151_ VSS VSS VDD VDD _0692_ sky130_fd_sc_hd__a21oi_1
X_1438_ _0389_ _0006_ VSS VSS VDD VDD _0390_ sky130_fd_sc_hd__nand2_1
X_1439_ _0690_ _0675_ _0692_ VSS VSS VDD VDD _0693_ sky130_fd_sc_hd__o21ai_1
X_1440_ _0004_ _0691_ _0693_ VSS VSS VDD VDD _0694_ sky130_fd_sc_hd__a21o_1
X_1441_ _0177_ _0694_ VSS VSS VDD VDD _0695_ sky130_fd_sc_hd__nor2_1
X_1442_ _0694_ _0177_ VSS VSS VDD VDD _0696_ sky130_fd_sc_hd__nand2_1
X_1443_ _0696_ net59 VSS VSS VDD VDD _0697_ sky130_fd_sc_hd__nand2_1
X_1444_ _0430_ product\[10\] VSS VSS VDD VDD _0698_ sky130_fd_sc_hd__nand2_1
X_1445_ _0695_ _0697_ _0698_ VSS VSS VDD VDD _0253_ sky130_fd_sc_hd__o21ai_0
X_1446_ _0400_ _0403_ VSS VSS VDD VDD _0699_ sky130_fd_sc_hd__nand2_1
X_1447_ _0699_ _0413_ _0412_ VSS VSS VDD VDD _0700_ sky130_fd_sc_hd__nand3_1
X_1448_ _0700_ _0214_ _0669_ VSS VSS VDD VDD _0701_ sky130_fd_sc_hd__a21oi_1
X_1449_ _0006_ _0387_ _0388_ VSS VSS VDD VDD _0391_ sky130_fd_sc_hd__nand3b_1
X_1450_ _0214_ _0700_ _0701_ VSS VSS VDD VDD _0702_ sky130_fd_sc_hd__o21ai_0
X_1451_ _0430_ product\[11\] VSS VSS VDD VDD _0703_ sky130_fd_sc_hd__nand2_1
X_1452_ _0702_ _0703_ VSS VSS VDD VDD _0252_ sky130_fd_sc_hd__nand2_1
X_1453_ _0214_ _0176_ _0213_ VSS VSS VDD VDD _0704_ sky130_fd_sc_hd__a21o_1
X_1454_ _0214_ _0177_ VSS VSS VDD VDD _0705_ sky130_fd_sc_hd__nand2_1
X_1455_ _0705_ _0692_ VSS VSS VDD VDD _0706_ sky130_fd_sc_hd__nor2_1
X_1456_ _0704_ _0706_ VSS VSS VDD VDD _0707_ sky130_fd_sc_hd__nor2_1
X_1457_ _0690_ _0705_ VSS VSS VDD VDD _0708_ sky130_fd_sc_hd__nor2_1
X_1458_ _0677_ _0708_ VSS VSS VDD VDD _0709_ sky130_fd_sc_hd__nand2_1
X_1459_ _0707_ _0709_ _0175_ VSS VSS VDD VDD _0710_ sky130_fd_sc_hd__a21boi_0
X_1460_ _0390_ _0391_ VSS VSS VDD VDD _0392_ sky130_fd_sc_hd__nand2_1
X_1461_ _0707_ _0709_ VSS VSS VDD VDD _0711_ sky130_fd_sc_hd__nand2_1
X_1462_ _0175_ _0711_ net59 VSS VSS VDD VDD _0712_ sky130_fd_sc_hd__o21ai_0
X_1463_ _0430_ product\[12\] VSS VSS VDD VDD _0713_ sky130_fd_sc_hd__nand2_1
X_1464_ _0710_ _0712_ _0713_ VSS VSS VDD VDD _0251_ sky130_fd_sc_hd__o21ai_0
X_1465_ _0399_ _0398_ _0402_ VSS VSS VDD VDD _0714_ sky130_fd_sc_hd__a21oi_1
X_1466_ _0404_ _0401_ VSS VSS VDD VDD _0715_ sky130_fd_sc_hd__nor2_1
X_1467_ _0410_ _0714_ _0715_ VSS VSS VDD VDD _0716_ sky130_fd_sc_hd__o21ai_0
X_1468_ _0404_ _0413_ VSS VSS VDD VDD _0717_ sky130_fd_sc_hd__nor2_1
X_1469_ _0418_ _0717_ VSS VSS VDD VDD _0718_ sky130_fd_sc_hd__nor2_1
X_1470_ _0189_ _0140_ VSS VSS VDD VDD _0719_ sky130_fd_sc_hd__nand2_1
X_1471_ _0360_ phase\[3\] VSS VSS VDD VDD _0361_ sky130_fd_sc_hd__nand2_1
X_1472_ _0384_ _0392_ VSS VSS VDD VDD _0393_ sky130_fd_sc_hd__nand2_1
X_1473_ _0719_ _0402_ VSS VSS VDD VDD _0720_ sky130_fd_sc_hd__nor2_1
X_1474_ _0720_ _0715_ _0003_ VSS VSS VDD VDD _0721_ sky130_fd_sc_hd__nand3_1
X_1475_ _0716_ _0718_ _0721_ VSS VSS VDD VDD _0722_ sky130_fd_sc_hd__nand3_1
X_1476_ _0201_ _0722_ VSS VSS VDD VDD _0723_ sky130_fd_sc_hd__nor2_1
X_1477_ _0722_ _0201_ VSS VSS VDD VDD _0724_ sky130_fd_sc_hd__nand2_1
X_1478_ _0724_ net59 VSS VSS VDD VDD _0725_ sky130_fd_sc_hd__nand2_1
X_1479_ _0430_ product\[13\] VSS VSS VDD VDD _0726_ sky130_fd_sc_hd__nand2_1
X_1480_ _0723_ _0725_ _0726_ VSS VSS VDD VDD _0250_ sky130_fd_sc_hd__o21ai_0
X_1481_ _0201_ _0175_ VSS VSS VDD VDD _0727_ sky130_fd_sc_hd__nand2_1
X_1482_ _0705_ _0727_ VSS VSS VDD VDD _0728_ sky130_fd_sc_hd__nor2_1
X_1483_ _0392_ VSS VSS VDD VDD _0394_ sky130_fd_sc_hd__inv_1
X_1484_ _0693_ _0728_ VSS VSS VDD VDD _0729_ sky130_fd_sc_hd__nand2_1
X_1485_ _0727_ VSS VSS VDD VDD _0730_ sky130_fd_sc_hd__inv_1
X_1486_ _0201_ _0174_ _0200_ VSS VSS VDD VDD _0731_ sky130_fd_sc_hd__a21oi_1
X_1487_ _0704_ _0730_ _0731_ VSS VSS VDD VDD _0732_ sky130_fd_sc_hd__a21boi_0
X_1488_ _0691_ _0728_ _0004_ VSS VSS VDD VDD _0733_ sky130_fd_sc_hd__nand3_1
X_1489_ _0729_ _0732_ _0733_ VSS VSS VDD VDD _0734_ sky130_fd_sc_hd__nand3_1
X_1490_ _0216_ _0734_ VSS VSS VDD VDD _0735_ sky130_fd_sc_hd__nor2_1
X_1491_ _0734_ _0216_ VSS VSS VDD VDD _0736_ sky130_fd_sc_hd__nand2_1
X_1492_ _0736_ net59 VSS VSS VDD VDD _0737_ sky130_fd_sc_hd__nand2_1
X_1493_ _0430_ product\[14\] VSS VSS VDD VDD _0738_ sky130_fd_sc_hd__nand2_1
X_1494_ _0382_ _0394_ _0383_ VSS VSS VDD VDD _0395_ sky130_fd_sc_hd__nand3_1
X_1495_ _0735_ _0737_ _0738_ VSS VSS VDD VDD _0249_ sky130_fd_sc_hd__o21ai_0
Xoutput44 net44 VSS VSS VDD VDD rsp_data[15] sky130_fd_sc_hd__clkdlybuf4s50_1
Xoutput43 net43 VSS VSS VDD VDD rsp_data[14] sky130_fd_sc_hd__clkdlybuf4s50_1
X_1498_ net59 net2 net18 product\[16\] _0430_ VSS VSS VDD
+ VDD _0248_ sky130_fd_sc_hd__a32o_1
X_1499_ net59 _0171_ _0430_ product\[17\] VSS VSS VDD VDD
+ _0247_ sky130_fd_sc_hd__a22o_1
X_1500_ net59 _0206_ _0430_ product\[18\] VSS VSS VDD VDD
+ _0246_ sky130_fd_sc_hd__a22o_1
X_1501_ net59 _0020_ _0430_ product\[19\] VSS VSS VDD VDD
+ _0245_ sky130_fd_sc_hd__a22o_1
X_1502_ net59 _0184_ _0430_ product\[20\] VSS VSS VDD VDD
+ _0244_ sky130_fd_sc_hd__a22o_1
X_1503_ net59 _0016_ _0430_ product\[21\] VSS VSS VDD VDD
+ _0243_ sky130_fd_sc_hd__a22o_1
X_1504_ _0015_ _0146_ VSS VSS VDD VDD _0741_ sky130_fd_sc_hd__or2_2
X_1505_ _0393_ _0395_ VSS VSS VDD VDD _0396_ sky130_fd_sc_hd__nand2_1
X_1506_ _0015_ _0146_ VSS VSS VDD VDD _0742_ sky130_fd_sc_hd__nand2_1
X_1507_ net59 _0741_ _0742_ product\[22\] _0430_ VSS VSS VDD
+ VDD _0242_ sky130_fd_sc_hd__a32o_1
X_1508_ _0144_ VSS VSS VDD VDD _0743_ sky130_fd_sc_hd__inv_1
X_1509_ _0467_ _0466_ _0743_ VSS VSS VDD VDD _0744_ sky130_fd_sc_hd__a21oi_1
X_1510_ _0144_ _0468_ net59 VSS VSS VDD VDD _0745_ sky130_fd_sc_hd__o21ai_0
X_1511_ _0430_ product\[23\] VSS VSS VDD VDD _0746_ sky130_fd_sc_hd__nand2_1
X_1512_ _0744_ _0745_ _0746_ VSS VSS VDD VDD _0241_ sky130_fd_sc_hd__o21ai_0
X_1513_ _0144_ _0145_ _0143_ VSS VSS VDD VDD _0747_ sky130_fd_sc_hd__a21oi_1
X_1514_ _0743_ _0742_ _0747_ VSS VSS VDD VDD _0748_ sky130_fd_sc_hd__o21ai_1
X_1515_ _0173_ _0748_ VSS VSS VDD VDD _0749_ sky130_fd_sc_hd__nor2_1
X_1516_ _0189_ _0140_ _0003_ VSS VSS VDD VDD _0397_ sky130_fd_sc_hd__nand3_1
X_1517_ _0748_ _0173_ VSS VSS VDD VDD _0750_ sky130_fd_sc_hd__nand2_1
X_1518_ _0750_ net59 VSS VSS VDD VDD _0751_ sky130_fd_sc_hd__nand2_1
X_1519_ _0430_ product\[24\] VSS VSS VDD VDD _0752_ sky130_fd_sc_hd__nand2_1
X_1520_ _0749_ _0751_ _0752_ VSS VSS VDD VDD _0240_ sky130_fd_sc_hd__o21ai_0
X_1521_ _0470_ VSS VSS VDD VDD _0753_ sky130_fd_sc_hd__inv_1
X_1522_ _0468_ _0753_ _0478_ VSS VSS VDD VDD _0754_ sky130_fd_sc_hd__a21oi_1
X_1523_ _0754_ VSS VSS VDD VDD _0755_ sky130_fd_sc_hd__inv_1
X_1524_ _0755_ _0150_ _0669_ VSS VSS VDD VDD _0756_ sky130_fd_sc_hd__a21oi_1
X_1525_ _0150_ _0755_ _0756_ VSS VSS VDD VDD _0757_ sky130_fd_sc_hd__o21ai_0
X_1526_ _0430_ product\[25\] VSS VSS VDD VDD _0758_ sky130_fd_sc_hd__nand2_1
X_1527_ _0188_ VSS VSS VDD VDD _0398_ sky130_fd_sc_hd__inv_1
X_1528_ _0757_ _0758_ VSS VSS VDD VDD _0239_ sky130_fd_sc_hd__nand2_1
X_1529_ _0144_ _0146_ VSS VSS VDD VDD _0759_ sky130_fd_sc_hd__nand2_1
X_1530_ _0150_ _0173_ VSS VSS VDD VDD _0760_ sky130_fd_sc_hd__nand2_1
X_1531_ _0759_ _0760_ VSS VSS VDD VDD _0761_ sky130_fd_sc_hd__nor2_1
X_1532_ _0150_ _0172_ _0149_ VSS VSS VDD VDD _0762_ sky130_fd_sc_hd__a21oi_1
X_1533_ _0760_ _0747_ _0762_ VSS VSS VDD VDD _0763_ sky130_fd_sc_hd__o21ai_1
X_1534_ _0015_ _0761_ _0763_ VSS VSS VDD VDD _0764_ sky130_fd_sc_hd__a21o_1
X_1535_ _0137_ _0764_ VSS VSS VDD VDD _0765_ sky130_fd_sc_hd__nor2_1
X_1536_ _0764_ _0137_ VSS VSS VDD VDD _0766_ sky130_fd_sc_hd__nand2_1
X_1537_ _0766_ net59 VSS VSS VDD VDD _0767_ sky130_fd_sc_hd__nand2_1
X_1538_ _0189_ _0139_ VSS VSS VDD VDD _0399_ sky130_fd_sc_hd__nand2_1
X_1539_ _0430_ product\[26\] VSS VSS VDD VDD _0768_ sky130_fd_sc_hd__nand2_1
X_1540_ _0765_ _0767_ _0768_ VSS VSS VDD VDD _0238_ sky130_fd_sc_hd__o21ai_1
X_1541_ _0468_ _0471_ _0485_ VSS VSS VDD VDD _0769_ sky130_fd_sc_hd__a21oi_1
X_1542_ _0160_ VSS VSS VDD VDD _0770_ sky130_fd_sc_hd__inv_1
X_1543_ _0769_ _0770_ VSS VSS VDD VDD _0771_ sky130_fd_sc_hd__and2_1
X_1544_ _0770_ _0769_ net59 VSS VSS VDD VDD _0772_ sky130_fd_sc_hd__o21ai_0
X_1545_ _0430_ product\[27\] VSS VSS VDD VDD _0773_ sky130_fd_sc_hd__nand2_1
X_1546_ _0771_ _0772_ _0773_ VSS VSS VDD VDD _0237_ sky130_fd_sc_hd__o21ai_0
X_1547_ _0137_ _0160_ VSS VSS VDD VDD _0774_ sky130_fd_sc_hd__nand2_1
X_1548_ _0760_ _0774_ VSS VSS VDD VDD _0775_ sky130_fd_sc_hd__nor2_1
X_1549_ _0397_ _0398_ _0399_ VSS VSS VDD VDD _0400_ sky130_fd_sc_hd__nand3_1
X_1550_ _0748_ _0775_ VSS VSS VDD VDD _0776_ sky130_fd_sc_hd__nand2_1
X_1551_ _0482_ _0770_ _0159_ VSS VSS VDD VDD _0777_ sky130_fd_sc_hd__o21bai_1
X_1552_ _0774_ _0762_ VSS VSS VDD VDD _0778_ sky130_fd_sc_hd__nor2_1
X_1553_ _0777_ _0778_ VSS VSS VDD VDD _0779_ sky130_fd_sc_hd__nor2_1
X_1554_ _0776_ _0779_ _0155_ VSS VSS VDD VDD _0780_ sky130_fd_sc_hd__a21boi_0
X_1555_ _0776_ _0779_ VSS VSS VDD VDD _0781_ sky130_fd_sc_hd__nand2_1
X_1556_ _0155_ _0781_ net59 VSS VSS VDD VDD _0782_ sky130_fd_sc_hd__o21ai_0
X_1557_ _0430_ product\[28\] VSS VSS VDD VDD _0783_ sky130_fd_sc_hd__nand2_1
X_1558_ _0780_ _0782_ _0783_ VSS VSS VDD VDD _0236_ sky130_fd_sc_hd__o21ai_1
X_1559_ _0478_ VSS VSS VDD VDD _0784_ sky130_fd_sc_hd__inv_1
X_1560_ _0177_ _0152_ VSS VSS VDD VDD _0401_ sky130_fd_sc_hd__nand2_1
X_1561_ _0470_ _0467_ _0784_ VSS VSS VDD VDD _0785_ sky130_fd_sc_hd__o21ai_0
X_1562_ _0472_ _0469_ VSS VSS VDD VDD _0786_ sky130_fd_sc_hd__nor2_1
X_1563_ _0785_ _0786_ VSS VSS VDD VDD _0787_ sky130_fd_sc_hd__nand2_1
X_1564_ _0488_ _0489_ VSS VSS VDD VDD _0788_ sky130_fd_sc_hd__nand2_1
X_1565_ _0483_ _0155_ _0160_ _0788_ VSS VSS VDD VDD _0789_
+ sky130_fd_sc_hd__a31oi_1
X_1566_ _0786_ _0014_ _0465_ _0753_ VSS VSS VDD VDD _0790_
+ sky130_fd_sc_hd__nand4_1
X_1567_ _0787_ _0789_ _0790_ VSS VSS VDD VDD _0791_ sky130_fd_sc_hd__nand3_1
X_1568_ _0210_ _0791_ VSS VSS VDD VDD _0792_ sky130_fd_sc_hd__nor2_1
X_1569_ _0791_ _0210_ VSS VSS VDD VDD _0793_ sky130_fd_sc_hd__nand2_1
X_1570_ _0793_ net59 VSS VSS VDD VDD _0794_ sky130_fd_sc_hd__nand2_1
X_1571_ _0197_ _0157_ VSS VSS VDD VDD _0402_ sky130_fd_sc_hd__nand2_1
X_1572_ _0430_ product\[29\] VSS VSS VDD VDD _0795_ sky130_fd_sc_hd__nand2_1
X_1573_ _0792_ _0794_ _0795_ VSS VSS VDD VDD _0235_ sky130_fd_sc_hd__o21ai_0
X_1574_ _0210_ _0155_ VSS VSS VDD VDD _0796_ sky130_fd_sc_hd__nand2_1
X_1575_ _0774_ _0796_ VSS VSS VDD VDD _0797_ sky130_fd_sc_hd__nor2_1
X_1576_ _0763_ _0797_ VSS VSS VDD VDD _0798_ sky130_fd_sc_hd__nand2_1
X_1577_ _0796_ VSS VSS VDD VDD _0799_ sky130_fd_sc_hd__inv_1
X_1578_ _0210_ _0154_ _0209_ VSS VSS VDD VDD _0800_ sky130_fd_sc_hd__a21oi_1
X_1579_ _0777_ _0799_ _0800_ VSS VSS VDD VDD _0801_ sky130_fd_sc_hd__a21boi_0
X_1580_ _0761_ _0797_ _0015_ VSS VSS VDD VDD _0802_ sky130_fd_sc_hd__nand3_1
X_1581_ _0798_ _0801_ _0802_ VSS VSS VDD VDD _0803_ sky130_fd_sc_hd__nand3_1
X_1582_ net1 phase\[1\] VSS VSS VDD VDD _0362_ sky130_fd_sc_hd__nor2_4
X_1583_ _0401_ _0402_ VSS VSS VDD VDD _0403_ sky130_fd_sc_hd__nor2_1
X_1584_ _0142_ _0803_ VSS VSS VDD VDD _0804_ sky130_fd_sc_hd__nor2_1
X_1585_ _0803_ _0142_ VSS VSS VDD VDD _0805_ sky130_fd_sc_hd__nand2_1
X_1586_ _0805_ net59 VSS VSS VDD VDD _0806_ sky130_fd_sc_hd__nand2_1
X_1587_ _0430_ product\[30\] VSS VSS VDD VDD _0807_ sky130_fd_sc_hd__nand2_1
X_1588_ _0804_ _0806_ _0807_ VSS VSS VDD VDD _0234_ sky130_fd_sc_hd__o21ai_0
X_1589_ net24 VSS VSS VDD VDD _0808_ sky130_fd_sc_hd__inv_1
X_1590_ net16 _0808_ VSS VSS VDD VDD _0043_ sky130_fd_sc_hd__nor2_1
Xoutput42 net42 VSS VSS VDD VDD rsp_data[13] sky130_fd_sc_hd__clkdlybuf4s50_1
X_1592_ net17 _0808_ VSS VSS VDD VDD _0040_ sky130_fd_sc_hd__nor2_1
Xoutput41 net41 VSS VSS VDD VDD rsp_data[12] sky130_fd_sc_hd__clkdlybuf4s50_1
X_1594_ _0175_ _0214_ VSS VSS VDD VDD _0404_ sky130_fd_sc_hd__nand2_1
X_1595_ net3 _0808_ VSS VSS VDD VDD _0037_ sky130_fd_sc_hd__nor2_1
Xoutput40 net40 VSS VSS VDD VDD rsp_data[11] sky130_fd_sc_hd__clkdlybuf4s50_1
X_1597_ net4 _0808_ VSS VSS VDD VDD _0034_ sky130_fd_sc_hd__nor2_1
Xoutput39 net39 VSS VSS VDD VDD rsp_data[10] sky130_fd_sc_hd__clkdlybuf4s50_1
X_1599_ net5 _0808_ VSS VSS VDD VDD _0031_ sky130_fd_sc_hd__nor2_1
Xoutput38 net38 VSS VSS VDD VDD rsp_data[0] sky130_fd_sc_hd__clkdlybuf4s50_1
X_1601_ net6 _0808_ VSS VSS VDD VDD _0028_ sky130_fd_sc_hd__nor2_1
Xoutput37 net37 VSS VSS VDD VDD req_ready sky130_fd_sc_hd__clkdlybuf4s50_1
X_1603_ net7 _0808_ VSS VSS VDD VDD _0026_ sky130_fd_sc_hd__nor2_1
Xinput36 rst_n VSS VSS VDD VDD net36 sky130_fd_sc_hd__clkdlybuf4s50_1
X_1605_ _0201_ _0216_ VSS VSS VDD VDD _0405_ sky130_fd_sc_hd__nand2_1
X_1606_ net8 _0808_ VSS VSS VDD VDD _0024_ sky130_fd_sc_hd__nor2_1
Xinput35 rsp_ready VSS VSS VDD VDD net35 sky130_fd_sc_hd__clkdlybuf4s50_1
X_1608_ net16 net23 VSS VSS VDD VDD _0817_ sky130_fd_sc_hd__nand2_1
X_1609_ _0817_ VSS VSS VDD VDD _0212_ sky130_fd_sc_hd__inv_1
X_1610_ net17 net23 VSS VSS VDD VDD _0818_ sky130_fd_sc_hd__nand2_1
X_1611_ _0818_ VSS VSS VDD VDD _0042_ sky130_fd_sc_hd__inv_1
X_1612_ net3 net23 VSS VSS VDD VDD _0819_ sky130_fd_sc_hd__nand2_1
X_1613_ _0819_ VSS VSS VDD VDD _0039_ sky130_fd_sc_hd__inv_1
X_1614_ net4 net23 VSS VSS VDD VDD _0820_ sky130_fd_sc_hd__nand2_1
X_1615_ _0820_ VSS VSS VDD VDD _0036_ sky130_fd_sc_hd__inv_1
X_1616_ _0404_ _0405_ VSS VSS VDD VDD _0406_ sky130_fd_sc_hd__nor2_1
X_1617_ net5 net23 VSS VSS VDD VDD _0821_ sky130_fd_sc_hd__nand2_1
X_1618_ _0821_ VSS VSS VDD VDD _0033_ sky130_fd_sc_hd__inv_1
X_1619_ net6 net23 VSS VSS VDD VDD _0822_ sky130_fd_sc_hd__nand2_1
X_1620_ _0822_ VSS VSS VDD VDD _0030_ sky130_fd_sc_hd__inv_1
X_1621_ net7 net23 VSS VSS VDD VDD _0823_ sky130_fd_sc_hd__nand2_1
X_1622_ _0823_ VSS VSS VDD VDD _0027_ sky130_fd_sc_hd__inv_1
X_1623_ net8 net23 VSS VSS VDD VDD _0824_ sky130_fd_sc_hd__nand2_1
X_1624_ _0824_ VSS VSS VDD VDD _0023_ sky130_fd_sc_hd__inv_1
Xinput34 req_valid VSS VSS VDD VDD net34 sky130_fd_sc_hd__clkdlybuf4s50_1
X_1626_ net16 net22 VSS VSS VDD VDD _0826_ sky130_fd_sc_hd__nand2_1
X_1627_ _0400_ _0403_ _0406_ VSS VSS VDD VDD _0407_ sky130_fd_sc_hd__nand3_1
X_1628_ _0826_ VSS VSS VDD VDD _0202_ sky130_fd_sc_hd__inv_1
X_1629_ net17 net22 VSS VSS VDD VDD _0827_ sky130_fd_sc_hd__nand2_1
X_1630_ _0827_ VSS VSS VDD VDD _0211_ sky130_fd_sc_hd__inv_1
X_1631_ net3 net22 VSS VSS VDD VDD _0828_ sky130_fd_sc_hd__nand2_1
X_1632_ _0828_ VSS VSS VDD VDD _0041_ sky130_fd_sc_hd__inv_1
X_1633_ net4 net22 VSS VSS VDD VDD _0829_ sky130_fd_sc_hd__nand2_1
X_1634_ _0829_ VSS VSS VDD VDD _0038_ sky130_fd_sc_hd__inv_1
X_1635_ net5 net22 VSS VSS VDD VDD _0830_ sky130_fd_sc_hd__nand2_1
X_1636_ _0830_ VSS VSS VDD VDD _0035_ sky130_fd_sc_hd__inv_1
X_1637_ net6 net22 VSS VSS VDD VDD _0831_ sky130_fd_sc_hd__nand2_1
X_1638_ _0196_ _0157_ VSS VSS VDD VDD _0408_ sky130_fd_sc_hd__nand2_1
X_1639_ _0831_ VSS VSS VDD VDD _0032_ sky130_fd_sc_hd__inv_1
X_1640_ net7 net22 VSS VSS VDD VDD _0832_ sky130_fd_sc_hd__nand2_1
X_1641_ _0832_ VSS VSS VDD VDD _0029_ sky130_fd_sc_hd__inv_1
X_1642_ net8 net22 VSS VSS VDD VDD _0833_ sky130_fd_sc_hd__nand2_1
X_1643_ _0833_ VSS VSS VDD VDD _0022_ sky130_fd_sc_hd__inv_1
Xinput33 req_b[9] VSS VSS VDD VDD net33 sky130_fd_sc_hd__clkdlybuf4s50_1
X_1645_ net16 net21 VSS VSS VDD VDD _0835_ sky130_fd_sc_hd__nand2_1
X_1646_ _0835_ VSS VSS VDD VDD _0074_ sky130_fd_sc_hd__inv_1
X_1647_ net17 net21 VSS VSS VDD VDD _0836_ sky130_fd_sc_hd__nand2_1
X_1648_ _0836_ VSS VSS VDD VDD _0071_ sky130_fd_sc_hd__inv_1
X_1649_ _0156_ VSS VSS VDD VDD _0409_ sky130_fd_sc_hd__inv_1
X_1650_ net3 net21 VSS VSS VDD VDD _0837_ sky130_fd_sc_hd__nand2_1
X_1651_ _0837_ VSS VSS VDD VDD _0068_ sky130_fd_sc_hd__inv_1
X_1652_ net4 net21 VSS VSS VDD VDD _0838_ sky130_fd_sc_hd__nand2_1
X_1653_ _0838_ VSS VSS VDD VDD _0065_ sky130_fd_sc_hd__inv_1
X_1654_ net5 net21 VSS VSS VDD VDD _0839_ sky130_fd_sc_hd__nand2_1
X_1655_ _0839_ VSS VSS VDD VDD _0062_ sky130_fd_sc_hd__inv_1
X_1656_ net6 net21 VSS VSS VDD VDD _0840_ sky130_fd_sc_hd__nand2_1
X_1657_ _0840_ VSS VSS VDD VDD _0059_ sky130_fd_sc_hd__inv_1
X_1658_ net7 net21 VSS VSS VDD VDD _0841_ sky130_fd_sc_hd__nand2_1
X_1659_ _0841_ VSS VSS VDD VDD _0057_ sky130_fd_sc_hd__inv_1
X_1660_ _0408_ _0409_ VSS VSS VDD VDD _0410_ sky130_fd_sc_hd__nand2_1
X_1661_ net8 net21 VSS VSS VDD VDD _0842_ sky130_fd_sc_hd__nand2_1
X_1662_ _0842_ VSS VSS VDD VDD _0056_ sky130_fd_sc_hd__inv_1
Xinput32 req_b[8] VSS VSS VDD VDD net32 sky130_fd_sc_hd__clkdlybuf4s50_1
X_1664_ net16 net20 VSS VSS VDD VDD _0844_ sky130_fd_sc_hd__nand2_1
X_1665_ _0844_ VSS VSS VDD VDD _0228_ sky130_fd_sc_hd__inv_1
X_1666_ net17 net20 VSS VSS VDD VDD _0845_ sky130_fd_sc_hd__nand2_1
X_1667_ _0845_ VSS VSS VDD VDD _0073_ sky130_fd_sc_hd__inv_1
X_1668_ net3 net20 VSS VSS VDD VDD _0846_ sky130_fd_sc_hd__nand2_1
X_1669_ _0846_ VSS VSS VDD VDD _0070_ sky130_fd_sc_hd__inv_1
X_1670_ net4 net20 VSS VSS VDD VDD _0847_ sky130_fd_sc_hd__nand2_1
X_1671_ _0401_ VSS VSS VDD VDD _0411_ sky130_fd_sc_hd__inv_1
X_1672_ _0847_ VSS VSS VDD VDD _0067_ sky130_fd_sc_hd__inv_1
X_1673_ net5 net20 VSS VSS VDD VDD _0848_ sky130_fd_sc_hd__nand2_1
X_1674_ _0848_ VSS VSS VDD VDD _0064_ sky130_fd_sc_hd__inv_1
X_1675_ net6 net20 VSS VSS VDD VDD _0849_ sky130_fd_sc_hd__nand2_1
X_1676_ _0849_ VSS VSS VDD VDD _0061_ sky130_fd_sc_hd__inv_1
X_1677_ net7 net20 VSS VSS VDD VDD _0850_ sky130_fd_sc_hd__nand2_1
X_1678_ _0850_ VSS VSS VDD VDD _0058_ sky130_fd_sc_hd__inv_1
X_1679_ net8 net20 VSS VSS VDD VDD _0851_ sky130_fd_sc_hd__nand2_1
X_1680_ _0851_ VSS VSS VDD VDD _0055_ sky130_fd_sc_hd__inv_1
Xinput31 req_b[7] VSS VSS VDD VDD net31 sky130_fd_sc_hd__clkdlybuf4s50_1
X_1682_ _0410_ _0411_ VSS VSS VDD VDD _0412_ sky130_fd_sc_hd__nand2_1
X_1683_ net16 net19 VSS VSS VDD VDD _0853_ sky130_fd_sc_hd__nand2_1
X_1684_ _0853_ VSS VSS VDD VDD _0198_ sky130_fd_sc_hd__inv_1
X_1685_ net17 net19 VSS VSS VDD VDD _0854_ sky130_fd_sc_hd__nand2_1
X_1686_ _0854_ VSS VSS VDD VDD _0227_ sky130_fd_sc_hd__inv_1
X_1687_ net3 net19 VSS VSS VDD VDD _0855_ sky130_fd_sc_hd__nand2_1
X_1688_ _0855_ VSS VSS VDD VDD _0072_ sky130_fd_sc_hd__inv_1
X_1689_ net4 net19 VSS VSS VDD VDD _0856_ sky130_fd_sc_hd__nand2_1
X_1690_ _0856_ VSS VSS VDD VDD _0069_ sky130_fd_sc_hd__inv_1
X_1691_ net5 net19 VSS VSS VDD VDD _0857_ sky130_fd_sc_hd__nand2_1
X_1692_ _0857_ VSS VSS VDD VDD _0066_ sky130_fd_sc_hd__inv_1
X_1693_ net1 _0362_ VSS VSS VDD VDD _0363_ sky130_fd_sc_hd__nor2_2
X_1694_ _0177_ _0151_ _0176_ VSS VSS VDD VDD _0413_ sky130_fd_sc_hd__a21oi_1
X_1695_ net6 net19 VSS VSS VDD VDD _0858_ sky130_fd_sc_hd__nand2_1
X_1696_ _0858_ VSS VSS VDD VDD _0063_ sky130_fd_sc_hd__inv_1
X_1697_ net7 net19 VSS VSS VDD VDD _0859_ sky130_fd_sc_hd__nand2_1
X_1698_ _0859_ VSS VSS VDD VDD _0060_ sky130_fd_sc_hd__inv_1
X_1699_ net8 net19 VSS VSS VDD VDD _0860_ sky130_fd_sc_hd__nand2_1
X_1700_ _0860_ VSS VSS VDD VDD _0054_ sky130_fd_sc_hd__inv_1
Xinput30 req_b[6] VSS VSS VDD VDD net30 sky130_fd_sc_hd__clkdlybuf4s50_1
X_1702_ net16 net33 VSS VSS VDD VDD _0862_ sky130_fd_sc_hd__nand2_1
X_1703_ _0862_ VSS VSS VDD VDD _0126_ sky130_fd_sc_hd__inv_1
X_1704_ net17 net33 VSS VSS VDD VDD _0863_ sky130_fd_sc_hd__nand2_1
X_1705_ _0412_ _0413_ VSS VSS VDD VDD _0414_ sky130_fd_sc_hd__nand2_1
X_1706_ _0863_ VSS VSS VDD VDD _0124_ sky130_fd_sc_hd__inv_1
X_1707_ net3 net33 VSS VSS VDD VDD _0864_ sky130_fd_sc_hd__nand2_1
X_1708_ _0864_ VSS VSS VDD VDD _0122_ sky130_fd_sc_hd__inv_1
X_1709_ net4 net33 VSS VSS VDD VDD _0865_ sky130_fd_sc_hd__nand2_1
X_1710_ _0865_ VSS VSS VDD VDD _0120_ sky130_fd_sc_hd__inv_1
X_1711_ net5 net33 VSS VSS VDD VDD _0866_ sky130_fd_sc_hd__nand2_1
X_1712_ _0866_ VSS VSS VDD VDD _0118_ sky130_fd_sc_hd__inv_1
X_1713_ net6 net33 VSS VSS VDD VDD _0867_ sky130_fd_sc_hd__nand2_1
X_1714_ _0867_ VSS VSS VDD VDD _0116_ sky130_fd_sc_hd__inv_1
X_1715_ net7 net33 VSS VSS VDD VDD _0868_ sky130_fd_sc_hd__nand2_1
X_1716_ _0414_ _0406_ VSS VSS VDD VDD _0415_ sky130_fd_sc_hd__nand2_1
X_1717_ _0868_ VSS VSS VDD VDD _0098_ sky130_fd_sc_hd__inv_1
X_1718_ net8 net33 VSS VSS VDD VDD _0869_ sky130_fd_sc_hd__nand2_1
X_1719_ _0869_ VSS VSS VDD VDD _0229_ sky130_fd_sc_hd__inv_1
X_1720_ net17 net32 VSS VSS VDD VDD _0870_ sky130_fd_sc_hd__nand2_1
X_1721_ _0870_ VSS VSS VDD VDD _0125_ sky130_fd_sc_hd__inv_1
X_1722_ net3 net32 VSS VSS VDD VDD _0283_ sky130_fd_sc_hd__nand2_1
X_1723_ _0283_ VSS VSS VDD VDD _0123_ sky130_fd_sc_hd__inv_1
X_1724_ net4 net32 VSS VSS VDD VDD _0284_ sky130_fd_sc_hd__nand2_1
X_1725_ _0284_ VSS VSS VDD VDD _0121_ sky130_fd_sc_hd__inv_1
X_1726_ net5 net32 VSS VSS VDD VDD _0285_ sky130_fd_sc_hd__nand2_1
X_1727_ _0175_ _0213_ VSS VSS VDD VDD _0416_ sky130_fd_sc_hd__nand2_1
X_1728_ _0285_ VSS VSS VDD VDD _0119_ sky130_fd_sc_hd__inv_1
X_1729_ net6 net32 VSS VSS VDD VDD _0286_ sky130_fd_sc_hd__nand2_1
X_1730_ _0286_ VSS VSS VDD VDD _0117_ sky130_fd_sc_hd__inv_1
X_1731_ net7 net32 VSS VSS VDD VDD _0287_ sky130_fd_sc_hd__nand2_1
X_1732_ _0287_ VSS VSS VDD VDD _0115_ sky130_fd_sc_hd__inv_1
X_1733_ net8 net32 VSS VSS VDD VDD _0288_ sky130_fd_sc_hd__nand2_1
X_1734_ _0288_ VSS VSS VDD VDD _0097_ sky130_fd_sc_hd__inv_1
X_1735_ net31 VSS VSS VDD VDD _0289_ sky130_fd_sc_hd__inv_1
X_1736_ net2 _0289_ VSS VSS VDD VDD _0049_ sky130_fd_sc_hd__nor2_1
Xinput29 req_b[5] VSS VSS VDD VDD net29 sky130_fd_sc_hd__clkdlybuf4s50_1
X_1738_ _0174_ VSS VSS VDD VDD _0417_ sky130_fd_sc_hd__inv_1
X_1739_ net9 _0289_ VSS VSS VDD VDD _0114_ sky130_fd_sc_hd__nor2_1
Xinput28 req_b[4] VSS VSS VDD VDD net28 sky130_fd_sc_hd__clkdlybuf4s50_1
X_1741_ net10 _0289_ VSS VSS VDD VDD _0102_ sky130_fd_sc_hd__nor2_1
Xinput27 req_b[3] VSS VSS VDD VDD net27 sky130_fd_sc_hd__clkdlybuf4s50_1
X_1743_ net11 _0289_ VSS VSS VDD VDD _0002_ sky130_fd_sc_hd__nor2_1
Xinput26 req_b[2] VSS VSS VDD VDD net26 sky130_fd_sc_hd__clkdlybuf4s50_1
X_1745_ net12 _0289_ VSS VSS VDD VDD _0110_ sky130_fd_sc_hd__nor2_1
Xinput25 req_b[1] VSS VSS VDD VDD net25 sky130_fd_sc_hd__clkdlybuf4s50_1
X_1747_ net13 _0289_ VSS VSS VDD VDD _0107_ sky130_fd_sc_hd__nor2_1
Xinput24 req_b[15] VSS VSS VDD VDD net24 sky130_fd_sc_hd__clkdlybuf4s50_1
X_1749_ _0416_ _0417_ VSS VSS VDD VDD _0418_ sky130_fd_sc_hd__nand2_1
X_1750_ net14 _0289_ VSS VSS VDD VDD _0099_ sky130_fd_sc_hd__nor2_1
Xinput23 req_b[14] VSS VSS VDD VDD net23 sky130_fd_sc_hd__clkdlybuf4s50_1
X_1752_ net15 _0289_ VSS VSS VDD VDD _0095_ sky130_fd_sc_hd__nor2_1
Xinput22 req_b[13] VSS VSS VDD VDD net22 sky130_fd_sc_hd__clkdlybuf4s50_1
X_1754_ net2 net30 VSS VSS VDD VDD _0298_ sky130_fd_sc_hd__nand2_1
X_1755_ _0298_ VSS VSS VDD VDD _0195_ sky130_fd_sc_hd__inv_1
X_1756_ net9 net30 VSS VSS VDD VDD _0299_ sky130_fd_sc_hd__nand2_1
X_1757_ _0299_ VSS VSS VDD VDD _0048_ sky130_fd_sc_hd__inv_1
X_1758_ net10 net30 VSS VSS VDD VDD _0300_ sky130_fd_sc_hd__nand2_1
X_1759_ _0300_ VSS VSS VDD VDD _0113_ sky130_fd_sc_hd__inv_1
X_1760_ _0405_ VSS VSS VDD VDD _0419_ sky130_fd_sc_hd__inv_1
X_1761_ net11 net30 VSS VSS VDD VDD _0301_ sky130_fd_sc_hd__nand2_1
X_1762_ _0301_ VSS VSS VDD VDD _0101_ sky130_fd_sc_hd__inv_1
X_1763_ net12 net30 VSS VSS VDD VDD _0302_ sky130_fd_sc_hd__nand2_1
X_1764_ _0302_ VSS VSS VDD VDD _0001_ sky130_fd_sc_hd__inv_1
X_1765_ net13 net30 VSS VSS VDD VDD _0303_ sky130_fd_sc_hd__nand2_1
X_1766_ _0303_ VSS VSS VDD VDD _0109_ sky130_fd_sc_hd__inv_1
X_1767_ net14 net30 VSS VSS VDD VDD _0304_ sky130_fd_sc_hd__nand2_1
X_1768_ _0304_ VSS VSS VDD VDD _0106_ sky130_fd_sc_hd__inv_1
X_1769_ net15 net30 VSS VSS VDD VDD _0305_ sky130_fd_sc_hd__nand2_1
X_1770_ _0305_ VSS VSS VDD VDD _0094_ sky130_fd_sc_hd__inv_1
X_1771_ _0216_ _0200_ VSS VSS VDD VDD _0420_ sky130_fd_sc_hd__nand2_1
Xinput21 req_b[12] VSS VSS VDD VDD net21 sky130_fd_sc_hd__clkdlybuf4s50_1
X_1773_ net2 net29 VSS VSS VDD VDD _0307_ sky130_fd_sc_hd__nand2_1
X_1774_ _0307_ VSS VSS VDD VDD _0193_ sky130_fd_sc_hd__inv_1
X_1775_ net9 net29 VSS VSS VDD VDD _0308_ sky130_fd_sc_hd__nand2_1
X_1776_ _0308_ VSS VSS VDD VDD _0194_ sky130_fd_sc_hd__inv_1
X_1777_ net10 net29 VSS VSS VDD VDD _0309_ sky130_fd_sc_hd__nand2_1
X_1778_ _0309_ VSS VSS VDD VDD _0047_ sky130_fd_sc_hd__inv_1
X_1779_ net11 net29 VSS VSS VDD VDD _0310_ sky130_fd_sc_hd__nand2_1
X_1780_ _0310_ VSS VSS VDD VDD _0112_ sky130_fd_sc_hd__inv_1
X_1781_ net12 net29 VSS VSS VDD VDD _0311_ sky130_fd_sc_hd__nand2_1
X_1782_ _0215_ VSS VSS VDD VDD _0421_ sky130_fd_sc_hd__inv_1
X_1783_ _0311_ VSS VSS VDD VDD _0100_ sky130_fd_sc_hd__inv_1
X_1784_ net13 net29 VSS VSS VDD VDD _0312_ sky130_fd_sc_hd__nand2_1
X_1785_ _0312_ VSS VSS VDD VDD _0000_ sky130_fd_sc_hd__inv_1
X_1786_ net14 net29 VSS VSS VDD VDD _0313_ sky130_fd_sc_hd__nand2_1
X_1787_ _0313_ VSS VSS VDD VDD _0108_ sky130_fd_sc_hd__inv_1
X_1788_ net15 net29 VSS VSS VDD VDD _0314_ sky130_fd_sc_hd__nand2_1
X_1789_ _0314_ VSS VSS VDD VDD _0093_ sky130_fd_sc_hd__inv_1
Xinput20 req_b[11] VSS VSS VDD VDD net20 sky130_fd_sc_hd__clkdlybuf4s50_1
X_1791_ net2 net28 VSS VSS VDD VDD _0316_ sky130_fd_sc_hd__nand2_1
X_1792_ _0316_ VSS VSS VDD VDD _0092_ sky130_fd_sc_hd__inv_1
X_1793_ _0420_ _0421_ VSS VSS VDD VDD _0422_ sky130_fd_sc_hd__nand2_1
X_1794_ net9 net28 VSS VSS VDD VDD _0317_ sky130_fd_sc_hd__nand2_1
X_1795_ _0317_ VSS VSS VDD VDD _0089_ sky130_fd_sc_hd__inv_1
X_1796_ net10 net28 VSS VSS VDD VDD _0318_ sky130_fd_sc_hd__nand2_1
X_1797_ _0318_ VSS VSS VDD VDD _0086_ sky130_fd_sc_hd__inv_1
X_1798_ net11 net28 VSS VSS VDD VDD _0319_ sky130_fd_sc_hd__nand2_1
X_1799_ _0319_ VSS VSS VDD VDD _0083_ sky130_fd_sc_hd__inv_1
X_1800_ net12 net28 VSS VSS VDD VDD _0320_ sky130_fd_sc_hd__nand2_1
X_1801_ _0320_ VSS VSS VDD VDD _0080_ sky130_fd_sc_hd__inv_1
X_1802_ net13 net28 VSS VSS VDD VDD _0321_ sky130_fd_sc_hd__nand2_1
X_1803_ _0321_ VSS VSS VDD VDD _0077_ sky130_fd_sc_hd__inv_1
X_1804_ _0363_ VSS VSS VDD VDD _0364_ sky130_fd_sc_hd__inv_2
X_1805_ _0418_ _0419_ _0422_ VSS VSS VDD VDD _0423_ sky130_fd_sc_hd__a21oi_1
X_1806_ net14 net28 VSS VSS VDD VDD _0322_ sky130_fd_sc_hd__nand2_1
X_1807_ _0322_ VSS VSS VDD VDD _0053_ sky130_fd_sc_hd__inv_1
X_1808_ net15 net28 VSS VSS VDD VDD _0323_ sky130_fd_sc_hd__nand2_1
X_1809_ _0323_ VSS VSS VDD VDD _0052_ sky130_fd_sc_hd__inv_1
Xinput19 req_b[10] VSS VSS VDD VDD net19 sky130_fd_sc_hd__clkdlybuf4s50_1
X_1811_ net2 net27 VSS VSS VDD VDD _0325_ sky130_fd_sc_hd__nand2_1
X_1812_ _0325_ VSS VSS VDD VDD _0129_ sky130_fd_sc_hd__inv_1
X_1813_ net9 net27 VSS VSS VDD VDD _0326_ sky130_fd_sc_hd__nand2_1
X_1814_ _0326_ VSS VSS VDD VDD _0091_ sky130_fd_sc_hd__inv_1
X_1815_ net10 net27 VSS VSS VDD VDD _0327_ sky130_fd_sc_hd__nand2_1
X_1816_ _0407_ _0415_ _0423_ VSS VSS VDD VDD _0424_ sky130_fd_sc_hd__nand3_1
X_1817_ _0327_ VSS VSS VDD VDD _0088_ sky130_fd_sc_hd__inv_1
X_1818_ net11 net27 VSS VSS VDD VDD _0328_ sky130_fd_sc_hd__nand2_1
X_1819_ _0328_ VSS VSS VDD VDD _0085_ sky130_fd_sc_hd__inv_1
X_1820_ net12 net27 VSS VSS VDD VDD _0329_ sky130_fd_sc_hd__nand2_1
X_1821_ _0329_ VSS VSS VDD VDD _0082_ sky130_fd_sc_hd__inv_1
X_1822_ net13 net27 VSS VSS VDD VDD _0330_ sky130_fd_sc_hd__nand2_1
X_1823_ _0330_ VSS VSS VDD VDD _0079_ sky130_fd_sc_hd__inv_1
X_1824_ net14 net27 VSS VSS VDD VDD _0331_ sky130_fd_sc_hd__nand2_1
X_1825_ _0331_ VSS VSS VDD VDD _0076_ sky130_fd_sc_hd__inv_1
X_1826_ net15 net27 VSS VSS VDD VDD _0332_ sky130_fd_sc_hd__nand2_1
X_1827_ _0424_ VSS VSS VDD VDD _0425_ sky130_fd_sc_hd__inv_1
X_1828_ _0332_ VSS VSS VDD VDD _0051_ sky130_fd_sc_hd__inv_1
Xinput18 req_b[0] VSS VSS VDD VDD net18 sky130_fd_sc_hd__clkdlybuf4s50_1
X_1830_ net2 net26 VSS VSS VDD VDD _0334_ sky130_fd_sc_hd__nand2_1
X_1831_ _0334_ VSS VSS VDD VDD _0205_ sky130_fd_sc_hd__inv_1
X_1832_ net9 net26 VSS VSS VDD VDD _0335_ sky130_fd_sc_hd__nand2_1
X_1833_ _0335_ VSS VSS VDD VDD _0128_ sky130_fd_sc_hd__inv_1
X_1834_ net10 net26 VSS VSS VDD VDD _0336_ sky130_fd_sc_hd__nand2_1
X_1835_ _0336_ VSS VSS VDD VDD _0090_ sky130_fd_sc_hd__inv_1
X_1836_ net11 net26 VSS VSS VDD VDD _0337_ sky130_fd_sc_hd__nand2_1
X_1837_ _0337_ VSS VSS VDD VDD _0087_ sky130_fd_sc_hd__inv_1
X_1838_ _0396_ _0425_ VSS VSS VDD VDD _0426_ sky130_fd_sc_hd__nand2_1
X_1839_ net12 net26 VSS VSS VDD VDD _0338_ sky130_fd_sc_hd__nand2_1
X_1840_ _0338_ VSS VSS VDD VDD _0084_ sky130_fd_sc_hd__inv_1
X_1841_ net13 net26 VSS VSS VDD VDD _0339_ sky130_fd_sc_hd__nand2_1
X_1842_ _0339_ VSS VSS VDD VDD _0081_ sky130_fd_sc_hd__inv_1
X_1843_ net14 net26 VSS VSS VDD VDD _0340_ sky130_fd_sc_hd__nand2_1
X_1844_ _0340_ VSS VSS VDD VDD _0078_ sky130_fd_sc_hd__inv_1
X_1845_ net15 net26 VSS VSS VDD VDD _0341_ sky130_fd_sc_hd__nand2_1
X_1846_ _0341_ VSS VSS VDD VDD _0050_ sky130_fd_sc_hd__inv_1
Xinput17 req_a[9] VSS VSS VDD VDD net17 sky130_fd_sc_hd__clkdlybuf4s50_1
X_1848_ net2 net25 VSS VSS VDD VDD _0343_ sky130_fd_sc_hd__nand2_1
X_1849_ _0393_ _0395_ _0424_ VSS VSS VDD VDD _0427_ sky130_fd_sc_hd__nand3_1
X_1850_ _0343_ VSS VSS VDD VDD _0170_ sky130_fd_sc_hd__inv_1
X_1851_ net9 net25 VSS VSS VDD VDD _0344_ sky130_fd_sc_hd__nand2_1
X_1852_ _0344_ VSS VSS VDD VDD _0166_ sky130_fd_sc_hd__inv_1
X_1853_ net10 net25 VSS VSS VDD VDD _0345_ sky130_fd_sc_hd__nand2_1
X_1854_ _0345_ VSS VSS VDD VDD _0226_ sky130_fd_sc_hd__inv_1
X_1855_ net11 net25 VSS VSS VDD VDD _0346_ sky130_fd_sc_hd__nand2_1
X_1856_ _0346_ VSS VSS VDD VDD _0224_ sky130_fd_sc_hd__inv_1
X_1857_ net12 net25 VSS VSS VDD VDD _0347_ sky130_fd_sc_hd__nand2_1
X_1858_ _0347_ VSS VSS VDD VDD _0222_ sky130_fd_sc_hd__inv_1
X_1859_ net13 net25 VSS VSS VDD VDD _0348_ sky130_fd_sc_hd__nand2_1
X_1860_ _0426_ _0427_ net59 VSS VSS VDD VDD _0428_ sky130_fd_sc_hd__nand3_1
X_1861_ _0348_ VSS VSS VDD VDD _0220_ sky130_fd_sc_hd__inv_1
X_1862_ net14 net25 VSS VSS VDD VDD _0349_ sky130_fd_sc_hd__nand2_1
X_1863_ _0349_ VSS VSS VDD VDD _0046_ sky130_fd_sc_hd__inv_1
X_1864_ net15 net25 VSS VSS VDD VDD _0350_ sky130_fd_sc_hd__nand2_1
X_1865_ _0350_ VSS VSS VDD VDD _0187_ sky130_fd_sc_hd__inv_1
X_1866_ net9 net18 VSS VSS VDD VDD _0351_ sky130_fd_sc_hd__nand2_1
X_1867_ _0351_ VSS VSS VDD VDD _0169_ sky130_fd_sc_hd__inv_1
X_1868_ net10 net18 VSS VSS VDD VDD _0352_ sky130_fd_sc_hd__nand2_1
X_1869_ _0352_ VSS VSS VDD VDD _0165_ sky130_fd_sc_hd__inv_1
X_1870_ net11 net18 VSS VSS VDD VDD _0353_ sky130_fd_sc_hd__nand2_1
X_1871_ _0366_ _0360_ VSS VSS VDD VDD _0429_ sky130_fd_sc_hd__nand2_1
X_1872_ _0353_ VSS VSS VDD VDD _0225_ sky130_fd_sc_hd__inv_1
X_1873_ net12 net18 VSS VSS VDD VDD _0354_ sky130_fd_sc_hd__nand2_1
X_1874_ _0354_ VSS VSS VDD VDD _0223_ sky130_fd_sc_hd__inv_1
X_1875_ net13 net18 VSS VSS VDD VDD _0355_ sky130_fd_sc_hd__nand2_1
X_1876_ _0355_ VSS VSS VDD VDD _0221_ sky130_fd_sc_hd__inv_1
X_1877_ net14 net18 VSS VSS VDD VDD _0356_ sky130_fd_sc_hd__nand2_1
X_1878_ _0356_ VSS VSS VDD VDD _0219_ sky130_fd_sc_hd__inv_1
X_1879_ net15 net18 VSS VSS VDD VDD _0357_ sky130_fd_sc_hd__nand2_1
X_1880_ _0357_ VSS VSS VDD VDD _0045_ sky130_fd_sc_hd__inv_1
X_1881_ _0429_ VSS VSS VDD VDD _0430_ sky130_fd_sc_hd__inv_2
Xinput16 req_a[8] VSS VSS VDD VDD net16 sky130_fd_sc_hd__clkdlybuf4s50_1
X_1883_ _0430_ product\[15\] VSS VSS VDD VDD _0432_ sky130_fd_sc_hd__nand2_1
X_1884_ net35 _0361_ _0364_ VSS VSS VDD VDD _0233_ sky130_fd_sc_hd__o21ai_0
X_1885_ _0428_ _0432_ VSS VSS VDD VDD _0282_ sky130_fd_sc_hd__nand2_1
X_1886_ _0075_ VSS VSS VDD VDD _0433_ sky130_fd_sc_hd__inv_1
X_1887_ _0433_ _0044_ VSS VSS VDD VDD _0434_ sky130_fd_sc_hd__nand2_1
X_1888_ _0044_ VSS VSS VDD VDD _0435_ sky130_fd_sc_hd__inv_1
X_1889_ _0435_ _0075_ VSS VSS VDD VDD _0436_ sky130_fd_sc_hd__nand2_1
X_1890_ _0434_ _0436_ _0010_ VSS VSS VDD VDD _0437_ sky130_fd_sc_hd__nand3_1
X_1891_ _0433_ _0435_ VSS VSS VDD VDD _0438_ sky130_fd_sc_hd__nand2_1
X_1892_ _0010_ VSS VSS VDD VDD _0439_ sky130_fd_sc_hd__inv_1
X_1893_ _0075_ _0044_ VSS VSS VDD VDD _0440_ sky130_fd_sc_hd__nand2_1
X_1894_ _0438_ _0439_ _0440_ VSS VSS VDD VDD _0441_ sky130_fd_sc_hd__nand3_1
X_1895_ _0360_ phase\[3\] net35 VSS VSS VDD VDD _0365_ sky130_fd_sc_hd__nand3_1
X_1896_ _0437_ _0441_ VSS VSS VDD VDD _0442_ sky130_fd_sc_hd__nand2_1
X_1897_ _0009_ VSS VSS VDD VDD _0443_ sky130_fd_sc_hd__inv_1
X_1898_ _0443_ _0021_ VSS VSS VDD VDD _0444_ sky130_fd_sc_hd__nand2_1
X_1899_ _0021_ VSS VSS VDD VDD _0445_ sky130_fd_sc_hd__inv_1
X_1900_ _0445_ _0009_ VSS VSS VDD VDD _0446_ sky130_fd_sc_hd__nand2_1
X_1901_ _0444_ _0446_ VSS VSS VDD VDD _0447_ sky130_fd_sc_hd__nand2_1
X_1902_ _0447_ VSS VSS VDD VDD _0448_ sky130_fd_sc_hd__inv_1
X_1903_ _0442_ _0448_ VSS VSS VDD VDD _0449_ sky130_fd_sc_hd__nand2_1
X_1904_ _0437_ _0441_ _0447_ VSS VSS VDD VDD _0450_ sky130_fd_sc_hd__nand3_1
X_1905_ _0449_ _0450_ VSS VSS VDD VDD _0451_ sky130_fd_sc_hd__nand2_1
X_1906_ _0000_ _0001_ _0002_ VSS VSS VDD VDD _0871_ _0872_
+ sky130_fd_sc_hd__fa_1
X_1907_ _0873_ _0874_ _0003_ VSS VSS VDD VDD _0004_ _0005_
+ sky130_fd_sc_hd__fa_1
X_1908_ _0006_ _0875_ _0876_ VSS VSS VDD VDD _0007_ _0877_
+ sky130_fd_sc_hd__fa_1
X_1909_ _0006_ _0878_ _0879_ VSS VSS VDD VDD _0880_ _0881_
+ sky130_fd_sc_hd__fa_1
X_1910_ _0882_ _0883_ _0884_ VSS VSS VDD VDD _0885_ _0886_
+ sky130_fd_sc_hd__fa_1
X_1911_ _0887_ _0888_ _0889_ VSS VSS VDD VDD _0890_ _0891_
+ sky130_fd_sc_hd__fa_1
X_1912_ _0892_ _0893_ _0894_ VSS VSS VDD VDD _0895_ _0896_
+ sky130_fd_sc_hd__fa_1
X_1913_ _0897_ _0898_ _0899_ VSS VSS VDD VDD _0900_ _0901_
+ sky130_fd_sc_hd__fa_1
X_1914_ _0902_ _0903_ _0904_ VSS VSS VDD VDD _0905_ _0906_
+ sky130_fd_sc_hd__fa_1
X_1915_ _0907_ _0908_ _0909_ VSS VSS VDD VDD _0910_ _0911_
+ sky130_fd_sc_hd__fa_1
X_1916_ _0912_ _0913_ _0914_ VSS VSS VDD VDD _0915_ _0916_
+ sky130_fd_sc_hd__fa_1
X_1917_ _0917_ _0918_ _0919_ VSS VSS VDD VDD _0920_ _0873_
+ sky130_fd_sc_hd__fa_1
X_1918_ _0921_ _0922_ _0923_ VSS VSS VDD VDD _0874_ _0924_
+ sky130_fd_sc_hd__fa_1
X_1919_ _0925_ _0926_ _0927_ VSS VSS VDD VDD _0928_ _0008_
+ sky130_fd_sc_hd__fa_1
X_1920_ _0009_ _0010_ _0929_ VSS VSS VDD VDD _0011_ _0930_
+ sky130_fd_sc_hd__fa_1
X_1921_ _0012_ _0931_ _0932_ VSS VSS VDD VDD _0013_ _0875_
+ sky130_fd_sc_hd__fa_1
X_1922_ _0012_ _0933_ _0934_ VSS VSS VDD VDD _0876_ _0878_
+ sky130_fd_sc_hd__fa_1
X_1923_ _0012_ _0935_ _0936_ VSS VSS VDD VDD _0879_ _0883_
+ sky130_fd_sc_hd__fa_1
X_1924_ _0937_ _0938_ _0939_ VSS VSS VDD VDD _0884_ _0888_
+ sky130_fd_sc_hd__fa_1
X_1925_ _0940_ _0941_ _0942_ VSS VSS VDD VDD _0889_ _0893_
+ sky130_fd_sc_hd__fa_1
X_1926_ _0943_ _0944_ _0945_ VSS VSS VDD VDD _0894_ _0898_
+ sky130_fd_sc_hd__fa_1
X_1927_ _0946_ _0947_ _0948_ VSS VSS VDD VDD _0899_ _0903_
+ sky130_fd_sc_hd__fa_1
X_1928_ _0949_ _0950_ _0951_ VSS VSS VDD VDD _0904_ _0908_
+ sky130_fd_sc_hd__fa_1
X_1929_ _0952_ _0953_ _0954_ VSS VSS VDD VDD _0909_ _0913_
+ sky130_fd_sc_hd__fa_1
X_1930_ _0955_ _0956_ _0957_ VSS VSS VDD VDD _0958_ _0959_
+ sky130_fd_sc_hd__fa_1
X_1931_ _0960_ _0961_ _0014_ VSS VSS VDD VDD _0015_ _0016_
+ sky130_fd_sc_hd__fa_1
X_1932_ _0962_ _0963_ _0964_ VSS VSS VDD VDD _0965_ _0966_
+ sky130_fd_sc_hd__fa_1
X_1933_ _0967_ _0968_ _0969_ VSS VSS VDD VDD _0970_ _0971_
+ sky130_fd_sc_hd__fa_1
X_1934_ _0972_ _0973_ _0974_ VSS VSS VDD VDD _0961_ _0975_
+ sky130_fd_sc_hd__fa_1
X_1935_ _0017_ _0018_ _0976_ VSS VSS VDD VDD _0019_ _0931_
+ sky130_fd_sc_hd__fa_1
X_1936_ _0017_ _0977_ _0978_ VSS VSS VDD VDD _0932_ _0933_
+ sky130_fd_sc_hd__fa_1
X_1937_ _0017_ _0979_ _0980_ VSS VSS VDD VDD _0934_ _0935_
+ sky130_fd_sc_hd__fa_1
X_1938_ _0017_ _0981_ _0982_ VSS VSS VDD VDD _0936_ _0938_
+ sky130_fd_sc_hd__fa_1
X_1939_ _0983_ _0984_ _0985_ VSS VSS VDD VDD _0939_ _0941_
+ sky130_fd_sc_hd__fa_1
X_1940_ _0986_ _0987_ _0988_ VSS VSS VDD VDD _0942_ _0944_
+ sky130_fd_sc_hd__fa_1
X_1941_ _0989_ _0990_ _0991_ VSS VSS VDD VDD _0945_ _0947_
+ sky130_fd_sc_hd__fa_1
X_1942_ _0992_ _0993_ _0994_ VSS VSS VDD VDD _0948_ _0950_
+ sky130_fd_sc_hd__fa_1
X_1943_ _0995_ _0996_ _0997_ VSS VSS VDD VDD _0998_ _0020_
+ sky130_fd_sc_hd__fa_1
X_1944_ _0999_ _1000_ _1001_ VSS VSS VDD VDD _1002_ _1003_
+ sky130_fd_sc_hd__fa_1
X_1945_ _0021_ _1004_ _1005_ VSS VSS VDD VDD _1006_ _1007_
+ sky130_fd_sc_hd__fa_1
X_1946_ _1008_ _1009_ _0958_ VSS VSS VDD VDD _1010_ _1011_
+ sky130_fd_sc_hd__fa_1
X_1947_ _0022_ _0023_ _0024_ VSS VSS VDD VDD _0025_ _0018_
+ sky130_fd_sc_hd__fa_1
X_1948_ _0022_ _0023_ _0026_ VSS VSS VDD VDD _0976_ _0977_
+ sky130_fd_sc_hd__fa_1
X_1949_ _0022_ _0027_ _0028_ VSS VSS VDD VDD _0978_ _0979_
+ sky130_fd_sc_hd__fa_1
X_1950_ _0029_ _0030_ _0031_ VSS VSS VDD VDD _0980_ _0981_
+ sky130_fd_sc_hd__fa_1
X_1951_ _0032_ _0033_ _0034_ VSS VSS VDD VDD _0982_ _0984_
+ sky130_fd_sc_hd__fa_1
X_1952_ _0035_ _0036_ _0037_ VSS VSS VDD VDD _0985_ _0987_
+ sky130_fd_sc_hd__fa_1
X_1953_ _0038_ _0039_ _0040_ VSS VSS VDD VDD _0988_ _0990_
+ sky130_fd_sc_hd__fa_1
X_1954_ _0041_ _0042_ _0043_ VSS VSS VDD VDD _0991_ _0993_
+ sky130_fd_sc_hd__fa_1
X_1955_ _1012_ _0959_ _1013_ VSS VSS VDD VDD _1014_ _1015_
+ sky130_fd_sc_hd__fa_1
X_1956_ _0044_ _1016_ _1017_ VSS VSS VDD VDD _1005_ _1000_
+ sky130_fd_sc_hd__fa_1
X_1957_ _1018_ _1019_ _1020_ VSS VSS VDD VDD _1013_ _0968_
+ sky130_fd_sc_hd__fa_1
X_1958_ _1021_ _1022_ _1023_ VSS VSS VDD VDD _0006_ _0012_
+ sky130_fd_sc_hd__fa_1
X_1959_ net31 _0045_ _0046_ VSS VSS VDD VDD _1024_ _1025_
+ sky130_fd_sc_hd__fa_1
X_1960_ _1021_ _1022_ _1026_ VSS VSS VDD VDD _0882_ _0937_
+ sky130_fd_sc_hd__fa_1
X_1961_ _1021_ _1022_ _1027_ VSS VSS VDD VDD _0887_ _0940_
+ sky130_fd_sc_hd__fa_1
X_1962_ _1021_ _1022_ _1028_ VSS VSS VDD VDD _0892_ _0943_
+ sky130_fd_sc_hd__fa_1
X_1963_ _1021_ _1029_ _1030_ VSS VSS VDD VDD _0897_ _0946_
+ sky130_fd_sc_hd__fa_1
X_1964_ _1031_ _1032_ _1033_ VSS VSS VDD VDD _0902_ _0949_
+ sky130_fd_sc_hd__fa_1
X_1965_ _1034_ _1035_ _1036_ VSS VSS VDD VDD _0907_ _0952_
+ sky130_fd_sc_hd__fa_1
X_1966_ _1037_ _1038_ _1039_ VSS VSS VDD VDD _0912_ _1040_
+ sky130_fd_sc_hd__fa_1
X_1967_ _1041_ _1042_ _1043_ VSS VSS VDD VDD _0917_ _1044_
+ sky130_fd_sc_hd__fa_1
X_1968_ _0047_ _0048_ _0049_ VSS VSS VDD VDD _1045_ _1046_
+ sky130_fd_sc_hd__fa_1
X_1969_ _1047_ _1048_ _1049_ VSS VSS VDD VDD _0969_ _0963_
+ sky130_fd_sc_hd__fa_1
X_1970_ _1050_ _1051_ _1052_ VSS VSS VDD VDD _0964_ _1053_
+ sky130_fd_sc_hd__fa_1
X_1971_ _0050_ _0051_ _0052_ VSS VSS VDD VDD _1054_ _0009_
+ sky130_fd_sc_hd__fa_1
X_1972_ _1055_ _1056_ _1057_ VSS VSS VDD VDD _1058_ _0960_
+ sky130_fd_sc_hd__fa_1
X_1973_ _0050_ _0051_ _0053_ VSS VSS VDD VDD _1059_ _1060_
+ sky130_fd_sc_hd__fa_1
X_1974_ _0054_ _0055_ _0056_ VSS VSS VDD VDD _1023_ _0017_
+ sky130_fd_sc_hd__fa_1
X_1975_ _0054_ _0055_ _0057_ VSS VSS VDD VDD _1026_ _0983_
+ sky130_fd_sc_hd__fa_1
X_1976_ _0054_ _0058_ _0059_ VSS VSS VDD VDD _1027_ _0986_
+ sky130_fd_sc_hd__fa_1
X_1977_ _0060_ _0061_ _0062_ VSS VSS VDD VDD _1028_ _0989_
+ sky130_fd_sc_hd__fa_1
X_1978_ _0063_ _0064_ _0065_ VSS VSS VDD VDD _1030_ _0992_
+ sky130_fd_sc_hd__fa_1
X_1979_ _0066_ _0067_ _0068_ VSS VSS VDD VDD _1033_ _1061_
+ sky130_fd_sc_hd__fa_1
X_1980_ _0069_ _0070_ _0071_ VSS VSS VDD VDD _1036_ _1062_
+ sky130_fd_sc_hd__fa_1
X_1981_ _0072_ _0073_ _0074_ VSS VSS VDD VDD _1039_ _1063_
+ sky130_fd_sc_hd__fa_1
X_1982_ _0044_ _0930_ _1064_ VSS VSS VDD VDD _0075_ _1065_
+ sky130_fd_sc_hd__fa_1
X_1983_ _0050_ _0076_ _0077_ VSS VSS VDD VDD _1066_ _1067_
+ sky130_fd_sc_hd__fa_1
X_1984_ _0078_ _0079_ _0080_ VSS VSS VDD VDD _1068_ _1069_
+ sky130_fd_sc_hd__fa_1
X_1985_ _0081_ _0082_ _0083_ VSS VSS VDD VDD _1070_ _1071_
+ sky130_fd_sc_hd__fa_1
X_1986_ _0084_ _0085_ _0086_ VSS VSS VDD VDD _1072_ _1073_
+ sky130_fd_sc_hd__fa_1
X_1987_ _0087_ _0088_ _0089_ VSS VSS VDD VDD _1074_ _1075_
+ sky130_fd_sc_hd__fa_1
X_1988_ _0090_ _0091_ _0092_ VSS VSS VDD VDD _1076_ _1077_
+ sky130_fd_sc_hd__fa_1
X_1989_ _0093_ _0094_ _0095_ VSS VSS VDD VDD _0096_ _0010_
+ sky130_fd_sc_hd__fa_1
X_1990_ _1078_ _1079_ _1080_ VSS VSS VDD VDD _1001_ _1081_
+ sky130_fd_sc_hd__fa_1
X_1991_ net24 _0097_ _0098_ VSS VSS VDD VDD _1029_ _1031_
+ sky130_fd_sc_hd__fa_1
X_1992_ _0044_ _1082_ _1083_ VSS VSS VDD VDD _1084_ _1004_
+ sky130_fd_sc_hd__fa_1
X_1993_ _1085_ _1086_ _1087_ VSS VSS VDD VDD _1088_ _1009_
+ sky130_fd_sc_hd__fa_1
X_1994_ _1069_ _1089_ _1045_ VSS VSS VDD VDD _0957_ _1019_
+ sky130_fd_sc_hd__fa_1
X_1995_ _1071_ _1046_ _1090_ VSS VSS VDD VDD _1020_ _1048_
+ sky130_fd_sc_hd__fa_1
X_1996_ _0093_ _0094_ _0099_ VSS VSS VDD VDD _0929_ _1091_
+ sky130_fd_sc_hd__fa_1
X_1997_ _0100_ _0101_ _0102_ VSS VSS VDD VDD _1092_ _1093_
+ sky130_fd_sc_hd__fa_1
X_1998_ product\[1\] product\[17\] _0103_ VSS VSS VDD VDD
+ _0104_ _0105_ sky130_fd_sc_hd__fa_1
X_1999_ _0093_ _0106_ _0107_ VSS VSS VDD VDD _1094_ _1095_
+ sky130_fd_sc_hd__fa_1
X_2000_ _0009_ _1091_ _1094_ VSS VSS VDD VDD _1064_ _1082_
+ sky130_fd_sc_hd__fa_1
X_2001_ _0009_ _1095_ _1096_ VSS VSS VDD VDD _1083_ _1016_
+ sky130_fd_sc_hd__fa_1
X_2002_ _1060_ _0872_ _1092_ VSS VSS VDD VDD _1080_ _1086_
+ sky130_fd_sc_hd__fa_1
X_2003_ _1067_ _1093_ _1097_ VSS VSS VDD VDD _1087_ _0956_
+ sky130_fd_sc_hd__fa_1
X_2004_ _1098_ _1099_ _1054_ VSS VSS VDD VDD _0021_ _0044_
+ sky130_fd_sc_hd__fa_1
X_2005_ _0108_ _0109_ _0110_ VSS VSS VDD VDD _1096_ _1100_
+ sky130_fd_sc_hd__fa_1
X_2006_ _1098_ _1099_ _1059_ VSS VSS VDD VDD _0999_ _1078_
+ sky130_fd_sc_hd__fa_1
X_2007_ _1098_ _1099_ _1066_ VSS VSS VDD VDD _1101_ _1085_
+ sky130_fd_sc_hd__fa_1
X_2008_ _1098_ _1099_ _1068_ VSS VSS VDD VDD _1008_ _0955_
+ sky130_fd_sc_hd__fa_1
X_2009_ _1098_ _1024_ _1070_ VSS VSS VDD VDD _1012_ _1018_
+ sky130_fd_sc_hd__fa_1
X_2010_ _1025_ _1102_ _1072_ VSS VSS VDD VDD _0967_ _1047_
+ sky130_fd_sc_hd__fa_1
X_2011_ _1103_ _1104_ _1074_ VSS VSS VDD VDD _0962_ _1050_
+ sky130_fd_sc_hd__fa_1
X_2012_ _1105_ _1106_ _1076_ VSS VSS VDD VDD _1107_ _1108_
+ sky130_fd_sc_hd__fa_1
X_2013_ _1109_ _1110_ _1111_ VSS VSS VDD VDD _1055_ _1112_
+ sky130_fd_sc_hd__fa_1
X_2014_ _1107_ _1053_ _1113_ VSS VSS VDD VDD _1114_ _1115_
+ sky130_fd_sc_hd__fa_1
X_2015_ _1101_ _1081_ _1088_ VSS VSS VDD VDD _1116_ _1117_
+ sky130_fd_sc_hd__fa_1
X_2016_ _0021_ _1065_ _1084_ VSS VSS VDD VDD _0111_ _1118_
+ sky130_fd_sc_hd__fa_1
X_2017_ _0009_ _1100_ _0871_ VSS VSS VDD VDD _1017_ _1079_
+ sky130_fd_sc_hd__fa_1
X_2018_ _0112_ _0113_ _0114_ VSS VSS VDD VDD _1097_ _1089_
+ sky130_fd_sc_hd__fa_1
X_2019_ _0115_ _0116_ VSS VSS VDD VDD _1032_ _1034_ sky130_fd_sc_hd__ha_1
X_2020_ _0117_ _0118_ VSS VSS VDD VDD _1035_ _1037_ sky130_fd_sc_hd__ha_1
X_2021_ _0119_ _0120_ VSS VSS VDD VDD _1038_ _1041_ sky130_fd_sc_hd__ha_1
X_2022_ _0121_ _0122_ VSS VSS VDD VDD _1042_ _1119_ sky130_fd_sc_hd__ha_1
X_2023_ _0123_ _0124_ VSS VSS VDD VDD _1120_ _1121_ sky130_fd_sc_hd__ha_1
X_2024_ _0125_ _0126_ VSS VSS VDD VDD _1122_ _0127_ sky130_fd_sc_hd__ha_1
X_2025_ _0128_ _0129_ VSS VSS VDD VDD _1111_ _1123_ sky130_fd_sc_hd__ha_1
X_2026_ product\[15\] product\[31\] VSS VSS VDD VDD _0130_
+ _0131_ sky130_fd_sc_hd__ha_1
X_2027_ _1123_ _1124_ VSS VSS VDD VDD _0974_ _0996_ sky130_fd_sc_hd__ha_1
X_2028_ product\[8\] product\[24\] VSS VSS VDD VDD _0132_
+ _0133_ sky130_fd_sc_hd__ha_1
X_2029_ product\[3\] product\[19\] VSS VSS VDD VDD _0134_
+ _0135_ sky130_fd_sc_hd__ha_1
X_2030_ _1011_ _1014_ VSS VSS VDD VDD _0136_ _0137_ sky130_fd_sc_hd__ha_1
X_2031_ _0873_ _0874_ VSS VSS VDD VDD _0139_ _0140_ sky130_fd_sc_hd__ha_1
X_2032_ _1118_ _1006_ VSS VSS VDD VDD _0141_ _0142_ sky130_fd_sc_hd__ha_1
X_2033_ _0966_ _1114_ VSS VSS VDD VDD _0143_ _0144_ sky130_fd_sc_hd__ha_1
X_2034_ _1115_ _1058_ VSS VSS VDD VDD _0145_ _0146_ sky130_fd_sc_hd__ha_1
X_2035_ _1077_ _1112_ VSS VSS VDD VDD _1057_ _0973_ sky130_fd_sc_hd__ha_1
X_2036_ _0960_ _0961_ VSS VSS VDD VDD _0147_ _0148_ sky130_fd_sc_hd__ha_1
X_2037_ _1015_ _0970_ VSS VSS VDD VDD _0149_ _0150_ sky130_fd_sc_hd__ha_1
X_2038_ _0901_ _0905_ VSS VSS VDD VDD _0151_ _0152_ sky130_fd_sc_hd__ha_1
X_2039_ product\[1\] product\[17\] VSS VSS VDD VDD _0153_
+ _0138_ sky130_fd_sc_hd__ha_1
X_2040_ _1003_ _1116_ VSS VSS VDD VDD _0154_ _0155_ sky130_fd_sc_hd__ha_1
X_2041_ _0906_ _0910_ VSS VSS VDD VDD _0156_ _0157_ sky130_fd_sc_hd__ha_1
X_2042_ _1108_ _1125_ VSS VSS VDD VDD _1113_ _1056_ sky130_fd_sc_hd__ha_1
X_2043_ product\[0\] product\[16\] VSS VSS VDD VDD _0103_
+ _0158_ sky130_fd_sc_hd__ha_1
X_2044_ _1117_ _1010_ VSS VSS VDD VDD _0159_ _0160_ sky130_fd_sc_hd__ha_1
X_2045_ product\[10\] product\[26\] VSS VSS VDD VDD _0161_
+ _0162_ sky130_fd_sc_hd__ha_1
X_2046_ product\[11\] product\[27\] VSS VSS VDD VDD _0163_
+ _0164_ sky130_fd_sc_hd__ha_1
X_2047_ _0165_ _0166_ VSS VSS VDD VDD _1126_ _1127_ sky130_fd_sc_hd__ha_1
X_2048_ product\[6\] product\[22\] VSS VSS VDD VDD _0167_
+ _0168_ sky130_fd_sc_hd__ha_1
X_2049_ _1128_ _1126_ VSS VSS VDD VDD _0972_ _1124_ sky130_fd_sc_hd__ha_1
X_2050_ _1127_ _1129_ VSS VSS VDD VDD _0995_ _1130_ sky130_fd_sc_hd__ha_1
X_2051_ _0169_ _0170_ VSS VSS VDD VDD _1129_ _0171_ sky130_fd_sc_hd__ha_1
X_2052_ _0971_ _0965_ VSS VSS VDD VDD _0172_ _0173_ sky130_fd_sc_hd__ha_1
X_2053_ _0886_ _0890_ VSS VSS VDD VDD _0174_ _0175_ sky130_fd_sc_hd__ha_1
X_2054_ _0896_ _0900_ VSS VSS VDD VDD _0176_ _0177_ sky130_fd_sc_hd__ha_1
X_2055_ product\[5\] product\[21\] VSS VSS VDD VDD _0178_
+ _0179_ sky130_fd_sc_hd__ha_1
X_2056_ product\[4\] product\[20\] VSS VSS VDD VDD _0180_
+ _0181_ sky130_fd_sc_hd__ha_1
X_2057_ product\[7\] product\[23\] VSS VSS VDD VDD _0182_
+ _0183_ sky130_fd_sc_hd__ha_1
X_2058_ _0975_ _0998_ VSS VSS VDD VDD _0014_ _0184_ sky130_fd_sc_hd__ha_1
X_2059_ product\[12\] product\[28\] VSS VSS VDD VDD _0185_
+ _0186_ sky130_fd_sc_hd__ha_1
X_2060_ _0045_ _0187_ VSS VSS VDD VDD _1099_ _1098_ sky130_fd_sc_hd__ha_1
X_2061_ _0916_ _0920_ VSS VSS VDD VDD _0188_ _0189_ sky130_fd_sc_hd__ha_1
X_2062_ product\[13\] product\[29\] VSS VSS VDD VDD _0190_
+ _0191_ sky130_fd_sc_hd__ha_1
X_2063_ _0924_ _0928_ VSS VSS VDD VDD _0003_ _0192_ sky130_fd_sc_hd__ha_1
X_2064_ _1073_ _1131_ VSS VSS VDD VDD _1049_ _1051_ sky130_fd_sc_hd__ha_1
X_2065_ _1075_ _0193_ VSS VSS VDD VDD _1052_ _1125_ sky130_fd_sc_hd__ha_1
X_2066_ _0194_ _0195_ VSS VSS VDD VDD _1090_ _1131_ sky130_fd_sc_hd__ha_1
X_2067_ _0911_ _0915_ VSS VSS VDD VDD _0196_ _0197_ sky130_fd_sc_hd__ha_1
X_2068_ _1040_ _1132_ VSS VSS VDD VDD _0914_ _0918_ sky130_fd_sc_hd__ha_1
X_2069_ _1063_ _1044_ VSS VSS VDD VDD _0919_ _0922_ sky130_fd_sc_hd__ha_1
X_2070_ _1133_ _1134_ VSS VSS VDD VDD _0923_ _0926_ sky130_fd_sc_hd__ha_1
X_2071_ _0198_ _1135_ VSS VSS VDD VDD _0927_ _0199_ sky130_fd_sc_hd__ha_1
X_2072_ _0881_ _0885_ VSS VSS VDD VDD _0200_ _0201_ sky130_fd_sc_hd__ha_1
X_2073_ _1061_ _1136_ VSS VSS VDD VDD _0951_ _0953_ sky130_fd_sc_hd__ha_1
X_2074_ _1062_ _0202_ VSS VSS VDD VDD _0954_ _1132_ sky130_fd_sc_hd__ha_1
X_2075_ product\[2\] product\[18\] VSS VSS VDD VDD _0203_
+ _0204_ sky130_fd_sc_hd__ha_1
X_2076_ _0205_ _1130_ VSS VSS VDD VDD _0997_ _0206_ sky130_fd_sc_hd__ha_1
X_2077_ product\[14\] product\[30\] VSS VSS VDD VDD _0207_
+ _0208_ sky130_fd_sc_hd__ha_1
X_2078_ _1007_ _1002_ VSS VSS VDD VDD _0209_ _0210_ sky130_fd_sc_hd__ha_1
X_2079_ _0211_ _0212_ VSS VSS VDD VDD _0994_ _1136_ sky130_fd_sc_hd__ha_1
X_2080_ _0891_ _0895_ VSS VSS VDD VDD _0213_ _0214_ sky130_fd_sc_hd__ha_1
X_2081_ _0877_ _0880_ VSS VSS VDD VDD _0215_ _0216_ sky130_fd_sc_hd__ha_1
X_2082_ _1119_ _1120_ VSS VSS VDD VDD _0921_ _1134_ sky130_fd_sc_hd__ha_1
X_2083_ _1121_ _1122_ VSS VSS VDD VDD _0925_ _1135_ sky130_fd_sc_hd__ha_1
X_2084_ product\[9\] product\[25\] VSS VSS VDD VDD _0217_
+ _0218_ sky130_fd_sc_hd__ha_1
X_2085_ _0219_ _0220_ VSS VSS VDD VDD _1102_ _1103_ sky130_fd_sc_hd__ha_1
X_2086_ _0221_ _0222_ VSS VSS VDD VDD _1104_ _1105_ sky130_fd_sc_hd__ha_1
X_2087_ _0223_ _0224_ VSS VSS VDD VDD _1106_ _1109_ sky130_fd_sc_hd__ha_1
X_2088_ _0225_ _0226_ VSS VSS VDD VDD _1110_ _1128_ sky130_fd_sc_hd__ha_1
X_2089_ _0227_ _0228_ VSS VSS VDD VDD _1043_ _1133_ sky130_fd_sc_hd__ha_1
X_2090_ _0097_ _0229_ VSS VSS VDD VDD _1022_ _1021_ sky130_fd_sc_hd__ha_1
Xinput15 req_a[7] VSS VSS VDD VDD net15 sky130_fd_sc_hd__clkdlybuf4s50_1
Xinput14 req_a[6] VSS VSS VDD VDD net14 sky130_fd_sc_hd__clkdlybuf4s50_1
Xinput13 req_a[5] VSS VSS VDD VDD net13 sky130_fd_sc_hd__clkdlybuf4s50_1
Xinput12 req_a[4] VSS VSS VDD VDD net12 sky130_fd_sc_hd__clkdlybuf4s50_1
Xinput11 req_a[3] VSS VSS VDD VDD net11 sky130_fd_sc_hd__clkdlybuf4s50_1
Xinput10 req_a[2] VSS VSS VDD VDD net10 sky130_fd_sc_hd__clkdlybuf4s50_1
Xinput9 req_a[1] VSS VSS VDD VDD net9 sky130_fd_sc_hd__clkdlybuf4s50_1
Xinput8 req_a[15] VSS VSS VDD VDD net8 sky130_fd_sc_hd__clkdlybuf4s50_1
Xinput7 req_a[14] VSS VSS VDD VDD net7 sky130_fd_sc_hd__clkdlybuf4s50_1
Xinput6 req_a[13] VSS VSS VDD VDD net6 sky130_fd_sc_hd__clkdlybuf4s50_1
Xinput5 req_a[12] VSS VSS VDD VDD net5 sky130_fd_sc_hd__clkdlybuf4s50_1
Xinput4 req_a[11] VSS VSS VDD VDD net4 sky130_fd_sc_hd__clkdlybuf4s50_1
Xinput3 req_a[10] VSS VSS VDD VDD net3 sky130_fd_sc_hd__clkdlybuf4s50_1
Xinput2 req_a[0] VSS VSS VDD VDD net2 sky130_fd_sc_hd__clkdlybuf4s50_1
Xinput1 kill VSS VSS VDD VDD net1 sky130_fd_sc_hd__clkdlybuf4s50_1
Xphase\[0\]$_DFF_PN1_ clknet_2_3__leaf_clk _0232_ net61 VSS
+ VSS VDD VDD phase\[0\] sky130_fd_sc_hd__dfstp_1
Xphase\[1\]$_DFF_PN0_ clknet_2_3__leaf_clk _0230_ net61 VSS
+ VSS VDD VDD phase\[1\] sky130_fd_sc_hd__dfrtp_1
Xphase\[2\]$_DFF_PN0_ clknet_2_3__leaf_clk net59 net61 VSS
+ VSS VDD VDD phase\[2\] sky130_fd_sc_hd__dfrtp_1
Xphase\[3\]$_DFF_PN0_ clknet_2_3__leaf_clk _0233_ net61 VSS
+ VSS VDD VDD phase\[3\] sky130_fd_sc_hd__dfrtp_1
Xproduct\[0\]$_DFFE_PN0P_ clknet_2_2__leaf_clk _0263_ net60
+ VSS VSS VDD VDD product\[0\] sky130_fd_sc_hd__dfrtp_1
Xproduct\[10\]$_DFFE_PN0P_ clknet_2_0__leaf_clk _0253_ net60
+ VSS VSS VDD VDD product\[10\] sky130_fd_sc_hd__dfrtp_1
Xproduct\[11\]$_DFFE_PN0P_ clknet_2_0__leaf_clk _0252_ net60
+ VSS VSS VDD VDD product\[11\] sky130_fd_sc_hd__dfrtp_1
Xproduct\[12\]$_DFFE_PN0P_ clknet_2_0__leaf_clk _0251_ net60
+ VSS VSS VDD VDD product\[12\] sky130_fd_sc_hd__dfrtp_1
Xproduct\[13\]$_DFFE_PN0P_ clknet_2_0__leaf_clk _0250_ net60
+ VSS VSS VDD VDD product\[13\] sky130_fd_sc_hd__dfrtp_1
Xproduct\[14\]$_DFFE_PN0P_ clknet_2_0__leaf_clk _0249_ net60
+ VSS VSS VDD VDD product\[14\] sky130_fd_sc_hd__dfrtp_1
Xproduct\[15\]$_DFFE_PN0P_ clknet_2_0__leaf_clk _0282_ net60
+ VSS VSS VDD VDD product\[15\] sky130_fd_sc_hd__dfrtp_1
Xproduct\[16\]$_DFFE_PN0P_ clknet_2_3__leaf_clk _0248_ net61
+ VSS VSS VDD VDD product\[16\] sky130_fd_sc_hd__dfrtp_1
Xproduct\[17\]$_DFFE_PN0P_ clknet_2_3__leaf_clk _0247_ net61
+ VSS VSS VDD VDD product\[17\] sky130_fd_sc_hd__dfrtp_1
Xproduct\[18\]$_DFFE_PN0P_ clknet_2_3__leaf_clk _0246_ net61
+ VSS VSS VDD VDD product\[18\] sky130_fd_sc_hd__dfrtp_1
Xproduct\[19\]$_DFFE_PN0P_ clknet_2_3__leaf_clk _0245_ net61
+ VSS VSS VDD VDD product\[19\] sky130_fd_sc_hd__dfrtp_1
Xproduct\[1\]$_DFFE_PN0P_ clknet_2_2__leaf_clk _0262_ net60
+ VSS VSS VDD VDD product\[1\] sky130_fd_sc_hd__dfrtp_1
Xproduct\[20\]$_DFFE_PN0P_ clknet_2_3__leaf_clk _0244_ net61
+ VSS VSS VDD VDD product\[20\] sky130_fd_sc_hd__dfrtp_1
Xproduct\[21\]$_DFFE_PN0P_ clknet_2_1__leaf_clk _0243_ net61
+ VSS VSS VDD VDD product\[21\] sky130_fd_sc_hd__dfrtp_1
Xproduct\[22\]$_DFFE_PN0P_ clknet_2_1__leaf_clk _0242_ net61
+ VSS VSS VDD VDD product\[22\] sky130_fd_sc_hd__dfrtp_1
Xproduct\[23\]$_DFFE_PN0P_ clknet_2_1__leaf_clk _0241_ net61
+ VSS VSS VDD VDD product\[23\] sky130_fd_sc_hd__dfrtp_1
Xproduct\[24\]$_DFFE_PN0P_ clknet_2_1__leaf_clk _0240_ net60
+ VSS VSS VDD VDD product\[24\] sky130_fd_sc_hd__dfrtp_1
Xproduct\[25\]$_DFFE_PN0P_ clknet_2_1__leaf_clk _0239_ net60
+ VSS VSS VDD VDD product\[25\] sky130_fd_sc_hd__dfrtp_1
Xproduct\[26\]$_DFFE_PN0P_ clknet_2_0__leaf_clk _0238_ net60
+ VSS VSS VDD VDD product\[26\] sky130_fd_sc_hd__dfrtp_1
Xproduct\[27\]$_DFFE_PN0P_ clknet_2_0__leaf_clk _0237_ net60
+ VSS VSS VDD VDD product\[27\] sky130_fd_sc_hd__dfrtp_1
Xproduct\[28\]$_DFFE_PN0P_ clknet_2_0__leaf_clk _0236_ net60
+ VSS VSS VDD VDD product\[28\] sky130_fd_sc_hd__dfrtp_1
Xproduct\[29\]$_DFFE_PN0P_ clknet_2_0__leaf_clk _0235_ net60
+ VSS VSS VDD VDD product\[29\] sky130_fd_sc_hd__dfrtp_1
Xproduct\[2\]$_DFFE_PN0P_ clknet_2_2__leaf_clk _0261_ net60
+ VSS VSS VDD VDD product\[2\] sky130_fd_sc_hd__dfrtp_1
Xproduct\[30\]$_DFFE_PN0P_ clknet_2_0__leaf_clk _0234_ net60
+ VSS VSS VDD VDD product\[30\] sky130_fd_sc_hd__dfrtp_1
Xproduct\[31\]$_DFFE_PN0P_ clknet_2_0__leaf_clk _0281_ net60
+ VSS VSS VDD VDD product\[31\] sky130_fd_sc_hd__dfrtp_1
Xproduct\[3\]$_DFFE_PN0P_ clknet_2_2__leaf_clk _0260_ net60
+ VSS VSS VDD VDD product\[3\] sky130_fd_sc_hd__dfrtp_1
Xproduct\[4\]$_DFFE_PN0P_ clknet_2_2__leaf_clk _0259_ net60
+ VSS VSS VDD VDD product\[4\] sky130_fd_sc_hd__dfrtp_1
Xproduct\[5\]$_DFFE_PN0P_ clknet_2_1__leaf_clk _0258_ net60
+ VSS VSS VDD VDD product\[5\] sky130_fd_sc_hd__dfrtp_1
Xproduct\[6\]$_DFFE_PN0P_ clknet_2_1__leaf_clk _0257_ net61
+ VSS VSS VDD VDD product\[6\] sky130_fd_sc_hd__dfrtp_1
Xproduct\[7\]$_DFFE_PN0P_ clknet_2_1__leaf_clk _0256_ net60
+ VSS VSS VDD VDD product\[7\] sky130_fd_sc_hd__dfrtp_1
Xproduct\[8\]$_DFFE_PN0P_ clknet_2_1__leaf_clk _0255_ net60
+ VSS VSS VDD VDD product\[8\] sky130_fd_sc_hd__dfrtp_1
Xproduct\[9\]$_DFFE_PN0P_ clknet_2_1__leaf_clk _0254_ net60
+ VSS VSS VDD VDD product\[9\] sky130_fd_sc_hd__dfrtp_1
Xrsp_data\[0\]$_DFFE_PN0P_ clknet_2_3__leaf_clk _0280_ net61
+ VSS VSS VDD VDD net38 sky130_fd_sc_hd__dfrtp_1
Xrsp_data\[10\]$_DFFE_PN0P_ clknet_2_2__leaf_clk _0270_ net61
+ VSS VSS VDD VDD net39 sky130_fd_sc_hd__dfrtp_1
Xrsp_data\[11\]$_DFFE_PN0P_ clknet_2_2__leaf_clk _0269_ net61
+ VSS VSS VDD VDD net40 sky130_fd_sc_hd__dfrtp_1
Xrsp_data\[12\]$_DFFE_PN0P_ clknet_2_2__leaf_clk _0268_ net60
+ VSS VSS VDD VDD net41 sky130_fd_sc_hd__dfrtp_1
Xrsp_data\[13\]$_DFFE_PN0P_ clknet_2_2__leaf_clk _0267_ net60
+ VSS VSS VDD VDD net42 sky130_fd_sc_hd__dfrtp_1
Xrsp_data\[14\]$_DFFE_PN0P_ clknet_2_2__leaf_clk _0266_ net60
+ VSS VSS VDD VDD net43 sky130_fd_sc_hd__dfrtp_1
Xrsp_data\[15\]$_DFFE_PN0P_ clknet_2_2__leaf_clk _0265_ net60
+ VSS VSS VDD VDD net44 sky130_fd_sc_hd__dfrtp_1
Xrsp_data\[1\]$_DFFE_PN0P_ clknet_2_3__leaf_clk _0279_ net61
+ VSS VSS VDD VDD net46 sky130_fd_sc_hd__dfrtp_1
Xrsp_data\[2\]$_DFFE_PN0P_ clknet_2_3__leaf_clk _0278_ net61
+ VSS VSS VDD VDD net47 sky130_fd_sc_hd__dfrtp_1
Xrsp_data\[30\]$_DFFE_PN0P_ clknet_2_2__leaf_clk _0264_ net60
+ VSS VSS VDD VDD net45 sky130_fd_sc_hd__dfrtp_1
Xrsp_data\[3\]$_DFFE_PN0P_ clknet_2_3__leaf_clk _0277_ net61
+ VSS VSS VDD VDD net48 sky130_fd_sc_hd__dfrtp_1
Xrsp_data\[4\]$_DFFE_PN0P_ clknet_2_3__leaf_clk _0276_ net61
+ VSS VSS VDD VDD net49 sky130_fd_sc_hd__dfrtp_1
Xrsp_data\[5\]$_DFFE_PN0P_ clknet_2_3__leaf_clk _0275_ net61
+ VSS VSS VDD VDD net50 sky130_fd_sc_hd__dfrtp_1
Xrsp_data\[6\]$_DFFE_PN0P_ clknet_2_3__leaf_clk _0274_ net61
+ VSS VSS VDD VDD net51 sky130_fd_sc_hd__dfrtp_1
Xrsp_data\[7\]$_DFFE_PN0P_ clknet_2_3__leaf_clk _0273_ net61
+ VSS VSS VDD VDD net52 sky130_fd_sc_hd__dfrtp_1
Xrsp_data\[8\]$_DFFE_PN0P_ clknet_2_2__leaf_clk _0272_ net61
+ VSS VSS VDD VDD net53 sky130_fd_sc_hd__dfrtp_1
Xrsp_data\[9\]$_DFFE_PN0P_ clknet_2_2__leaf_clk _0271_ net61
+ VSS VSS VDD VDD net54 sky130_fd_sc_hd__dfrtp_1
XTAP_TAPCELL_ROW_0_0 VSS VDD sky130_fd_sc_hd__tapvpwrvgnd_1
XTAP_TAPCELL_ROW_0_1 VSS VDD sky130_fd_sc_hd__tapvpwrvgnd_1
XTAP_TAPCELL_ROW_0_2 VSS VDD sky130_fd_sc_hd__tapvpwrvgnd_1
XTAP_TAPCELL_ROW_0_3 VSS VDD sky130_fd_sc_hd__tapvpwrvgnd_1
XTAP_TAPCELL_ROW_0_4 VSS VDD sky130_fd_sc_hd__tapvpwrvgnd_1
XTAP_TAPCELL_ROW_0_5 VSS VDD sky130_fd_sc_hd__tapvpwrvgnd_1
XTAP_TAPCELL_ROW_0_6 VSS VDD sky130_fd_sc_hd__tapvpwrvgnd_1
XTAP_TAPCELL_ROW_0_7 VSS VDD sky130_fd_sc_hd__tapvpwrvgnd_1
XTAP_TAPCELL_ROW_0_8 VSS VDD sky130_fd_sc_hd__tapvpwrvgnd_1
XTAP_TAPCELL_ROW_0_9 VSS VDD sky130_fd_sc_hd__tapvpwrvgnd_1
XTAP_TAPCELL_ROW_1_10 VSS VDD sky130_fd_sc_hd__tapvpwrvgnd_1
XTAP_TAPCELL_ROW_1_11 VSS VDD sky130_fd_sc_hd__tapvpwrvgnd_1
XTAP_TAPCELL_ROW_1_12 VSS VDD sky130_fd_sc_hd__tapvpwrvgnd_1
XTAP_TAPCELL_ROW_1_13 VSS VDD sky130_fd_sc_hd__tapvpwrvgnd_1
XTAP_TAPCELL_ROW_1_14 VSS VDD sky130_fd_sc_hd__tapvpwrvgnd_1
XTAP_TAPCELL_ROW_2_15 VSS VDD sky130_fd_sc_hd__tapvpwrvgnd_1
XTAP_TAPCELL_ROW_2_16 VSS VDD sky130_fd_sc_hd__tapvpwrvgnd_1
XTAP_TAPCELL_ROW_2_17 VSS VDD sky130_fd_sc_hd__tapvpwrvgnd_1
XTAP_TAPCELL_ROW_2_18 VSS VDD sky130_fd_sc_hd__tapvpwrvgnd_1
XTAP_TAPCELL_ROW_2_19 VSS VDD sky130_fd_sc_hd__tapvpwrvgnd_1
XTAP_TAPCELL_ROW_3_20 VSS VDD sky130_fd_sc_hd__tapvpwrvgnd_1
XTAP_TAPCELL_ROW_3_21 VSS VDD sky130_fd_sc_hd__tapvpwrvgnd_1
XTAP_TAPCELL_ROW_3_22 VSS VDD sky130_fd_sc_hd__tapvpwrvgnd_1
XTAP_TAPCELL_ROW_3_23 VSS VDD sky130_fd_sc_hd__tapvpwrvgnd_1
XTAP_TAPCELL_ROW_3_24 VSS VDD sky130_fd_sc_hd__tapvpwrvgnd_1
XTAP_TAPCELL_ROW_4_25 VSS VDD sky130_fd_sc_hd__tapvpwrvgnd_1
XTAP_TAPCELL_ROW_4_26 VSS VDD sky130_fd_sc_hd__tapvpwrvgnd_1
XTAP_TAPCELL_ROW_4_27 VSS VDD sky130_fd_sc_hd__tapvpwrvgnd_1
XTAP_TAPCELL_ROW_4_28 VSS VDD sky130_fd_sc_hd__tapvpwrvgnd_1
XTAP_TAPCELL_ROW_4_29 VSS VDD sky130_fd_sc_hd__tapvpwrvgnd_1
XTAP_TAPCELL_ROW_5_30 VSS VDD sky130_fd_sc_hd__tapvpwrvgnd_1
XTAP_TAPCELL_ROW_5_31 VSS VDD sky130_fd_sc_hd__tapvpwrvgnd_1
XTAP_TAPCELL_ROW_5_32 VSS VDD sky130_fd_sc_hd__tapvpwrvgnd_1
XTAP_TAPCELL_ROW_5_33 VSS VDD sky130_fd_sc_hd__tapvpwrvgnd_1
XTAP_TAPCELL_ROW_5_34 VSS VDD sky130_fd_sc_hd__tapvpwrvgnd_1
XTAP_TAPCELL_ROW_6_35 VSS VDD sky130_fd_sc_hd__tapvpwrvgnd_1
XTAP_TAPCELL_ROW_6_36 VSS VDD sky130_fd_sc_hd__tapvpwrvgnd_1
XTAP_TAPCELL_ROW_6_37 VSS VDD sky130_fd_sc_hd__tapvpwrvgnd_1
XTAP_TAPCELL_ROW_6_38 VSS VDD sky130_fd_sc_hd__tapvpwrvgnd_1
XTAP_TAPCELL_ROW_6_39 VSS VDD sky130_fd_sc_hd__tapvpwrvgnd_1
XTAP_TAPCELL_ROW_7_40 VSS VDD sky130_fd_sc_hd__tapvpwrvgnd_1
XTAP_TAPCELL_ROW_7_41 VSS VDD sky130_fd_sc_hd__tapvpwrvgnd_1
XTAP_TAPCELL_ROW_7_42 VSS VDD sky130_fd_sc_hd__tapvpwrvgnd_1
XTAP_TAPCELL_ROW_7_43 VSS VDD sky130_fd_sc_hd__tapvpwrvgnd_1
XTAP_TAPCELL_ROW_7_44 VSS VDD sky130_fd_sc_hd__tapvpwrvgnd_1
XTAP_TAPCELL_ROW_8_45 VSS VDD sky130_fd_sc_hd__tapvpwrvgnd_1
XTAP_TAPCELL_ROW_8_46 VSS VDD sky130_fd_sc_hd__tapvpwrvgnd_1
XTAP_TAPCELL_ROW_8_47 VSS VDD sky130_fd_sc_hd__tapvpwrvgnd_1
XTAP_TAPCELL_ROW_8_48 VSS VDD sky130_fd_sc_hd__tapvpwrvgnd_1
XTAP_TAPCELL_ROW_8_49 VSS VDD sky130_fd_sc_hd__tapvpwrvgnd_1
XTAP_TAPCELL_ROW_9_50 VSS VDD sky130_fd_sc_hd__tapvpwrvgnd_1
XTAP_TAPCELL_ROW_9_51 VSS VDD sky130_fd_sc_hd__tapvpwrvgnd_1
XTAP_TAPCELL_ROW_9_52 VSS VDD sky130_fd_sc_hd__tapvpwrvgnd_1
XTAP_TAPCELL_ROW_9_53 VSS VDD sky130_fd_sc_hd__tapvpwrvgnd_1
XTAP_TAPCELL_ROW_9_54 VSS VDD sky130_fd_sc_hd__tapvpwrvgnd_1
XTAP_TAPCELL_ROW_10_55 VSS VDD sky130_fd_sc_hd__tapvpwrvgnd_1
XTAP_TAPCELL_ROW_10_56 VSS VDD sky130_fd_sc_hd__tapvpwrvgnd_1
XTAP_TAPCELL_ROW_10_57 VSS VDD sky130_fd_sc_hd__tapvpwrvgnd_1
XTAP_TAPCELL_ROW_10_58 VSS VDD sky130_fd_sc_hd__tapvpwrvgnd_1
XTAP_TAPCELL_ROW_10_59 VSS VDD sky130_fd_sc_hd__tapvpwrvgnd_1
XTAP_TAPCELL_ROW_11_60 VSS VDD sky130_fd_sc_hd__tapvpwrvgnd_1
XTAP_TAPCELL_ROW_11_61 VSS VDD sky130_fd_sc_hd__tapvpwrvgnd_1
XTAP_TAPCELL_ROW_11_62 VSS VDD sky130_fd_sc_hd__tapvpwrvgnd_1
XTAP_TAPCELL_ROW_11_63 VSS VDD sky130_fd_sc_hd__tapvpwrvgnd_1
XTAP_TAPCELL_ROW_11_64 VSS VDD sky130_fd_sc_hd__tapvpwrvgnd_1
XTAP_TAPCELL_ROW_12_65 VSS VDD sky130_fd_sc_hd__tapvpwrvgnd_1
XTAP_TAPCELL_ROW_12_66 VSS VDD sky130_fd_sc_hd__tapvpwrvgnd_1
XTAP_TAPCELL_ROW_12_67 VSS VDD sky130_fd_sc_hd__tapvpwrvgnd_1
XTAP_TAPCELL_ROW_12_68 VSS VDD sky130_fd_sc_hd__tapvpwrvgnd_1
XTAP_TAPCELL_ROW_12_69 VSS VDD sky130_fd_sc_hd__tapvpwrvgnd_1
XTAP_TAPCELL_ROW_13_70 VSS VDD sky130_fd_sc_hd__tapvpwrvgnd_1
XTAP_TAPCELL_ROW_13_71 VSS VDD sky130_fd_sc_hd__tapvpwrvgnd_1
XTAP_TAPCELL_ROW_13_72 VSS VDD sky130_fd_sc_hd__tapvpwrvgnd_1
XTAP_TAPCELL_ROW_13_73 VSS VDD sky130_fd_sc_hd__tapvpwrvgnd_1
XTAP_TAPCELL_ROW_13_74 VSS VDD sky130_fd_sc_hd__tapvpwrvgnd_1
XTAP_TAPCELL_ROW_14_75 VSS VDD sky130_fd_sc_hd__tapvpwrvgnd_1
XTAP_TAPCELL_ROW_14_76 VSS VDD sky130_fd_sc_hd__tapvpwrvgnd_1
XTAP_TAPCELL_ROW_14_77 VSS VDD sky130_fd_sc_hd__tapvpwrvgnd_1
XTAP_TAPCELL_ROW_14_78 VSS VDD sky130_fd_sc_hd__tapvpwrvgnd_1
XTAP_TAPCELL_ROW_14_79 VSS VDD sky130_fd_sc_hd__tapvpwrvgnd_1
XTAP_TAPCELL_ROW_15_80 VSS VDD sky130_fd_sc_hd__tapvpwrvgnd_1
XTAP_TAPCELL_ROW_15_81 VSS VDD sky130_fd_sc_hd__tapvpwrvgnd_1
XTAP_TAPCELL_ROW_15_82 VSS VDD sky130_fd_sc_hd__tapvpwrvgnd_1
XTAP_TAPCELL_ROW_15_83 VSS VDD sky130_fd_sc_hd__tapvpwrvgnd_1
XTAP_TAPCELL_ROW_15_84 VSS VDD sky130_fd_sc_hd__tapvpwrvgnd_1
XTAP_TAPCELL_ROW_16_85 VSS VDD sky130_fd_sc_hd__tapvpwrvgnd_1
XTAP_TAPCELL_ROW_16_86 VSS VDD sky130_fd_sc_hd__tapvpwrvgnd_1
XTAP_TAPCELL_ROW_16_87 VSS VDD sky130_fd_sc_hd__tapvpwrvgnd_1
XTAP_TAPCELL_ROW_16_88 VSS VDD sky130_fd_sc_hd__tapvpwrvgnd_1
XTAP_TAPCELL_ROW_16_89 VSS VDD sky130_fd_sc_hd__tapvpwrvgnd_1
XTAP_TAPCELL_ROW_17_90 VSS VDD sky130_fd_sc_hd__tapvpwrvgnd_1
XTAP_TAPCELL_ROW_17_91 VSS VDD sky130_fd_sc_hd__tapvpwrvgnd_1
XTAP_TAPCELL_ROW_17_92 VSS VDD sky130_fd_sc_hd__tapvpwrvgnd_1
XTAP_TAPCELL_ROW_17_93 VSS VDD sky130_fd_sc_hd__tapvpwrvgnd_1
XTAP_TAPCELL_ROW_17_94 VSS VDD sky130_fd_sc_hd__tapvpwrvgnd_1
XTAP_TAPCELL_ROW_18_95 VSS VDD sky130_fd_sc_hd__tapvpwrvgnd_1
XTAP_TAPCELL_ROW_18_96 VSS VDD sky130_fd_sc_hd__tapvpwrvgnd_1
XTAP_TAPCELL_ROW_18_97 VSS VDD sky130_fd_sc_hd__tapvpwrvgnd_1
XTAP_TAPCELL_ROW_18_98 VSS VDD sky130_fd_sc_hd__tapvpwrvgnd_1
XTAP_TAPCELL_ROW_18_99 VSS VDD sky130_fd_sc_hd__tapvpwrvgnd_1
XTAP_TAPCELL_ROW_19_100 VSS VDD sky130_fd_sc_hd__tapvpwrvgnd_1
XTAP_TAPCELL_ROW_19_101 VSS VDD sky130_fd_sc_hd__tapvpwrvgnd_1
XTAP_TAPCELL_ROW_19_102 VSS VDD sky130_fd_sc_hd__tapvpwrvgnd_1
XTAP_TAPCELL_ROW_19_103 VSS VDD sky130_fd_sc_hd__tapvpwrvgnd_1
XTAP_TAPCELL_ROW_19_104 VSS VDD sky130_fd_sc_hd__tapvpwrvgnd_1
XTAP_TAPCELL_ROW_20_105 VSS VDD sky130_fd_sc_hd__tapvpwrvgnd_1
XTAP_TAPCELL_ROW_20_106 VSS VDD sky130_fd_sc_hd__tapvpwrvgnd_1
XTAP_TAPCELL_ROW_20_107 VSS VDD sky130_fd_sc_hd__tapvpwrvgnd_1
XTAP_TAPCELL_ROW_20_108 VSS VDD sky130_fd_sc_hd__tapvpwrvgnd_1
XTAP_TAPCELL_ROW_20_109 VSS VDD sky130_fd_sc_hd__tapvpwrvgnd_1
XTAP_TAPCELL_ROW_21_110 VSS VDD sky130_fd_sc_hd__tapvpwrvgnd_1
XTAP_TAPCELL_ROW_21_111 VSS VDD sky130_fd_sc_hd__tapvpwrvgnd_1
XTAP_TAPCELL_ROW_21_112 VSS VDD sky130_fd_sc_hd__tapvpwrvgnd_1
XTAP_TAPCELL_ROW_21_113 VSS VDD sky130_fd_sc_hd__tapvpwrvgnd_1
XTAP_TAPCELL_ROW_21_114 VSS VDD sky130_fd_sc_hd__tapvpwrvgnd_1
XTAP_TAPCELL_ROW_22_115 VSS VDD sky130_fd_sc_hd__tapvpwrvgnd_1
XTAP_TAPCELL_ROW_22_116 VSS VDD sky130_fd_sc_hd__tapvpwrvgnd_1
XTAP_TAPCELL_ROW_22_117 VSS VDD sky130_fd_sc_hd__tapvpwrvgnd_1
XTAP_TAPCELL_ROW_22_118 VSS VDD sky130_fd_sc_hd__tapvpwrvgnd_1
XTAP_TAPCELL_ROW_22_119 VSS VDD sky130_fd_sc_hd__tapvpwrvgnd_1
XTAP_TAPCELL_ROW_23_120 VSS VDD sky130_fd_sc_hd__tapvpwrvgnd_1
XTAP_TAPCELL_ROW_23_121 VSS VDD sky130_fd_sc_hd__tapvpwrvgnd_1
XTAP_TAPCELL_ROW_23_122 VSS VDD sky130_fd_sc_hd__tapvpwrvgnd_1
XTAP_TAPCELL_ROW_23_123 VSS VDD sky130_fd_sc_hd__tapvpwrvgnd_1
XTAP_TAPCELL_ROW_23_124 VSS VDD sky130_fd_sc_hd__tapvpwrvgnd_1
XTAP_TAPCELL_ROW_24_125 VSS VDD sky130_fd_sc_hd__tapvpwrvgnd_1
XTAP_TAPCELL_ROW_24_126 VSS VDD sky130_fd_sc_hd__tapvpwrvgnd_1
XTAP_TAPCELL_ROW_24_127 VSS VDD sky130_fd_sc_hd__tapvpwrvgnd_1
XTAP_TAPCELL_ROW_24_128 VSS VDD sky130_fd_sc_hd__tapvpwrvgnd_1
XTAP_TAPCELL_ROW_24_129 VSS VDD sky130_fd_sc_hd__tapvpwrvgnd_1
XTAP_TAPCELL_ROW_25_130 VSS VDD sky130_fd_sc_hd__tapvpwrvgnd_1
XTAP_TAPCELL_ROW_25_131 VSS VDD sky130_fd_sc_hd__tapvpwrvgnd_1
XTAP_TAPCELL_ROW_25_132 VSS VDD sky130_fd_sc_hd__tapvpwrvgnd_1
XTAP_TAPCELL_ROW_25_133 VSS VDD sky130_fd_sc_hd__tapvpwrvgnd_1
XTAP_TAPCELL_ROW_25_134 VSS VDD sky130_fd_sc_hd__tapvpwrvgnd_1
XTAP_TAPCELL_ROW_26_135 VSS VDD sky130_fd_sc_hd__tapvpwrvgnd_1
XTAP_TAPCELL_ROW_26_136 VSS VDD sky130_fd_sc_hd__tapvpwrvgnd_1
XTAP_TAPCELL_ROW_26_137 VSS VDD sky130_fd_sc_hd__tapvpwrvgnd_1
XTAP_TAPCELL_ROW_26_138 VSS VDD sky130_fd_sc_hd__tapvpwrvgnd_1
XTAP_TAPCELL_ROW_26_139 VSS VDD sky130_fd_sc_hd__tapvpwrvgnd_1
XTAP_TAPCELL_ROW_27_140 VSS VDD sky130_fd_sc_hd__tapvpwrvgnd_1
XTAP_TAPCELL_ROW_27_141 VSS VDD sky130_fd_sc_hd__tapvpwrvgnd_1
XTAP_TAPCELL_ROW_27_142 VSS VDD sky130_fd_sc_hd__tapvpwrvgnd_1
XTAP_TAPCELL_ROW_27_143 VSS VDD sky130_fd_sc_hd__tapvpwrvgnd_1
XTAP_TAPCELL_ROW_27_144 VSS VDD sky130_fd_sc_hd__tapvpwrvgnd_1
XTAP_TAPCELL_ROW_28_145 VSS VDD sky130_fd_sc_hd__tapvpwrvgnd_1
XTAP_TAPCELL_ROW_28_146 VSS VDD sky130_fd_sc_hd__tapvpwrvgnd_1
XTAP_TAPCELL_ROW_28_147 VSS VDD sky130_fd_sc_hd__tapvpwrvgnd_1
XTAP_TAPCELL_ROW_28_148 VSS VDD sky130_fd_sc_hd__tapvpwrvgnd_1
XTAP_TAPCELL_ROW_28_149 VSS VDD sky130_fd_sc_hd__tapvpwrvgnd_1
XTAP_TAPCELL_ROW_29_150 VSS VDD sky130_fd_sc_hd__tapvpwrvgnd_1
XTAP_TAPCELL_ROW_29_151 VSS VDD sky130_fd_sc_hd__tapvpwrvgnd_1
XTAP_TAPCELL_ROW_29_152 VSS VDD sky130_fd_sc_hd__tapvpwrvgnd_1
XTAP_TAPCELL_ROW_29_153 VSS VDD sky130_fd_sc_hd__tapvpwrvgnd_1
XTAP_TAPCELL_ROW_29_154 VSS VDD sky130_fd_sc_hd__tapvpwrvgnd_1
XTAP_TAPCELL_ROW_30_155 VSS VDD sky130_fd_sc_hd__tapvpwrvgnd_1
XTAP_TAPCELL_ROW_30_156 VSS VDD sky130_fd_sc_hd__tapvpwrvgnd_1
XTAP_TAPCELL_ROW_30_157 VSS VDD sky130_fd_sc_hd__tapvpwrvgnd_1
XTAP_TAPCELL_ROW_30_158 VSS VDD sky130_fd_sc_hd__tapvpwrvgnd_1
XTAP_TAPCELL_ROW_30_159 VSS VDD sky130_fd_sc_hd__tapvpwrvgnd_1
XTAP_TAPCELL_ROW_31_160 VSS VDD sky130_fd_sc_hd__tapvpwrvgnd_1
XTAP_TAPCELL_ROW_31_161 VSS VDD sky130_fd_sc_hd__tapvpwrvgnd_1
XTAP_TAPCELL_ROW_31_162 VSS VDD sky130_fd_sc_hd__tapvpwrvgnd_1
XTAP_TAPCELL_ROW_31_163 VSS VDD sky130_fd_sc_hd__tapvpwrvgnd_1
XTAP_TAPCELL_ROW_31_164 VSS VDD sky130_fd_sc_hd__tapvpwrvgnd_1
XTAP_TAPCELL_ROW_32_165 VSS VDD sky130_fd_sc_hd__tapvpwrvgnd_1
XTAP_TAPCELL_ROW_32_166 VSS VDD sky130_fd_sc_hd__tapvpwrvgnd_1
XTAP_TAPCELL_ROW_32_167 VSS VDD sky130_fd_sc_hd__tapvpwrvgnd_1
XTAP_TAPCELL_ROW_32_168 VSS VDD sky130_fd_sc_hd__tapvpwrvgnd_1
XTAP_TAPCELL_ROW_32_169 VSS VDD sky130_fd_sc_hd__tapvpwrvgnd_1
XTAP_TAPCELL_ROW_33_170 VSS VDD sky130_fd_sc_hd__tapvpwrvgnd_1
XTAP_TAPCELL_ROW_33_171 VSS VDD sky130_fd_sc_hd__tapvpwrvgnd_1
XTAP_TAPCELL_ROW_33_172 VSS VDD sky130_fd_sc_hd__tapvpwrvgnd_1
XTAP_TAPCELL_ROW_33_173 VSS VDD sky130_fd_sc_hd__tapvpwrvgnd_1
XTAP_TAPCELL_ROW_33_174 VSS VDD sky130_fd_sc_hd__tapvpwrvgnd_1
XTAP_TAPCELL_ROW_34_175 VSS VDD sky130_fd_sc_hd__tapvpwrvgnd_1
XTAP_TAPCELL_ROW_34_176 VSS VDD sky130_fd_sc_hd__tapvpwrvgnd_1
XTAP_TAPCELL_ROW_34_177 VSS VDD sky130_fd_sc_hd__tapvpwrvgnd_1
XTAP_TAPCELL_ROW_34_178 VSS VDD sky130_fd_sc_hd__tapvpwrvgnd_1
XTAP_TAPCELL_ROW_34_179 VSS VDD sky130_fd_sc_hd__tapvpwrvgnd_1
XTAP_TAPCELL_ROW_35_180 VSS VDD sky130_fd_sc_hd__tapvpwrvgnd_1
XTAP_TAPCELL_ROW_35_181 VSS VDD sky130_fd_sc_hd__tapvpwrvgnd_1
XTAP_TAPCELL_ROW_35_182 VSS VDD sky130_fd_sc_hd__tapvpwrvgnd_1
XTAP_TAPCELL_ROW_35_183 VSS VDD sky130_fd_sc_hd__tapvpwrvgnd_1
XTAP_TAPCELL_ROW_35_184 VSS VDD sky130_fd_sc_hd__tapvpwrvgnd_1
XTAP_TAPCELL_ROW_36_185 VSS VDD sky130_fd_sc_hd__tapvpwrvgnd_1
XTAP_TAPCELL_ROW_36_186 VSS VDD sky130_fd_sc_hd__tapvpwrvgnd_1
XTAP_TAPCELL_ROW_36_187 VSS VDD sky130_fd_sc_hd__tapvpwrvgnd_1
XTAP_TAPCELL_ROW_36_188 VSS VDD sky130_fd_sc_hd__tapvpwrvgnd_1
XTAP_TAPCELL_ROW_36_189 VSS VDD sky130_fd_sc_hd__tapvpwrvgnd_1
XTAP_TAPCELL_ROW_37_190 VSS VDD sky130_fd_sc_hd__tapvpwrvgnd_1
XTAP_TAPCELL_ROW_37_191 VSS VDD sky130_fd_sc_hd__tapvpwrvgnd_1
XTAP_TAPCELL_ROW_37_192 VSS VDD sky130_fd_sc_hd__tapvpwrvgnd_1
XTAP_TAPCELL_ROW_37_193 VSS VDD sky130_fd_sc_hd__tapvpwrvgnd_1
XTAP_TAPCELL_ROW_37_194 VSS VDD sky130_fd_sc_hd__tapvpwrvgnd_1
XTAP_TAPCELL_ROW_38_195 VSS VDD sky130_fd_sc_hd__tapvpwrvgnd_1
XTAP_TAPCELL_ROW_38_196 VSS VDD sky130_fd_sc_hd__tapvpwrvgnd_1
XTAP_TAPCELL_ROW_38_197 VSS VDD sky130_fd_sc_hd__tapvpwrvgnd_1
XTAP_TAPCELL_ROW_38_198 VSS VDD sky130_fd_sc_hd__tapvpwrvgnd_1
XTAP_TAPCELL_ROW_38_199 VSS VDD sky130_fd_sc_hd__tapvpwrvgnd_1
XTAP_TAPCELL_ROW_39_200 VSS VDD sky130_fd_sc_hd__tapvpwrvgnd_1
XTAP_TAPCELL_ROW_39_201 VSS VDD sky130_fd_sc_hd__tapvpwrvgnd_1
XTAP_TAPCELL_ROW_39_202 VSS VDD sky130_fd_sc_hd__tapvpwrvgnd_1
XTAP_TAPCELL_ROW_39_203 VSS VDD sky130_fd_sc_hd__tapvpwrvgnd_1
XTAP_TAPCELL_ROW_39_204 VSS VDD sky130_fd_sc_hd__tapvpwrvgnd_1
XTAP_TAPCELL_ROW_40_205 VSS VDD sky130_fd_sc_hd__tapvpwrvgnd_1
XTAP_TAPCELL_ROW_40_206 VSS VDD sky130_fd_sc_hd__tapvpwrvgnd_1
XTAP_TAPCELL_ROW_40_207 VSS VDD sky130_fd_sc_hd__tapvpwrvgnd_1
XTAP_TAPCELL_ROW_40_208 VSS VDD sky130_fd_sc_hd__tapvpwrvgnd_1
XTAP_TAPCELL_ROW_40_209 VSS VDD sky130_fd_sc_hd__tapvpwrvgnd_1
XTAP_TAPCELL_ROW_41_210 VSS VDD sky130_fd_sc_hd__tapvpwrvgnd_1
XTAP_TAPCELL_ROW_41_211 VSS VDD sky130_fd_sc_hd__tapvpwrvgnd_1
XTAP_TAPCELL_ROW_41_212 VSS VDD sky130_fd_sc_hd__tapvpwrvgnd_1
XTAP_TAPCELL_ROW_41_213 VSS VDD sky130_fd_sc_hd__tapvpwrvgnd_1
XTAP_TAPCELL_ROW_41_214 VSS VDD sky130_fd_sc_hd__tapvpwrvgnd_1
XTAP_TAPCELL_ROW_42_215 VSS VDD sky130_fd_sc_hd__tapvpwrvgnd_1
XTAP_TAPCELL_ROW_42_216 VSS VDD sky130_fd_sc_hd__tapvpwrvgnd_1
XTAP_TAPCELL_ROW_42_217 VSS VDD sky130_fd_sc_hd__tapvpwrvgnd_1
XTAP_TAPCELL_ROW_42_218 VSS VDD sky130_fd_sc_hd__tapvpwrvgnd_1
XTAP_TAPCELL_ROW_42_219 VSS VDD sky130_fd_sc_hd__tapvpwrvgnd_1
XTAP_TAPCELL_ROW_43_220 VSS VDD sky130_fd_sc_hd__tapvpwrvgnd_1
XTAP_TAPCELL_ROW_43_221 VSS VDD sky130_fd_sc_hd__tapvpwrvgnd_1
XTAP_TAPCELL_ROW_43_222 VSS VDD sky130_fd_sc_hd__tapvpwrvgnd_1
XTAP_TAPCELL_ROW_43_223 VSS VDD sky130_fd_sc_hd__tapvpwrvgnd_1
XTAP_TAPCELL_ROW_43_224 VSS VDD sky130_fd_sc_hd__tapvpwrvgnd_1
XTAP_TAPCELL_ROW_44_225 VSS VDD sky130_fd_sc_hd__tapvpwrvgnd_1
XTAP_TAPCELL_ROW_44_226 VSS VDD sky130_fd_sc_hd__tapvpwrvgnd_1
XTAP_TAPCELL_ROW_44_227 VSS VDD sky130_fd_sc_hd__tapvpwrvgnd_1
XTAP_TAPCELL_ROW_44_228 VSS VDD sky130_fd_sc_hd__tapvpwrvgnd_1
XTAP_TAPCELL_ROW_44_229 VSS VDD sky130_fd_sc_hd__tapvpwrvgnd_1
XTAP_TAPCELL_ROW_45_230 VSS VDD sky130_fd_sc_hd__tapvpwrvgnd_1
XTAP_TAPCELL_ROW_45_231 VSS VDD sky130_fd_sc_hd__tapvpwrvgnd_1
XTAP_TAPCELL_ROW_45_232 VSS VDD sky130_fd_sc_hd__tapvpwrvgnd_1
XTAP_TAPCELL_ROW_45_233 VSS VDD sky130_fd_sc_hd__tapvpwrvgnd_1
XTAP_TAPCELL_ROW_45_234 VSS VDD sky130_fd_sc_hd__tapvpwrvgnd_1
XTAP_TAPCELL_ROW_46_235 VSS VDD sky130_fd_sc_hd__tapvpwrvgnd_1
XTAP_TAPCELL_ROW_46_236 VSS VDD sky130_fd_sc_hd__tapvpwrvgnd_1
XTAP_TAPCELL_ROW_46_237 VSS VDD sky130_fd_sc_hd__tapvpwrvgnd_1
XTAP_TAPCELL_ROW_46_238 VSS VDD sky130_fd_sc_hd__tapvpwrvgnd_1
XTAP_TAPCELL_ROW_46_239 VSS VDD sky130_fd_sc_hd__tapvpwrvgnd_1
XTAP_TAPCELL_ROW_47_240 VSS VDD sky130_fd_sc_hd__tapvpwrvgnd_1
XTAP_TAPCELL_ROW_47_241 VSS VDD sky130_fd_sc_hd__tapvpwrvgnd_1
XTAP_TAPCELL_ROW_47_242 VSS VDD sky130_fd_sc_hd__tapvpwrvgnd_1
XTAP_TAPCELL_ROW_47_243 VSS VDD sky130_fd_sc_hd__tapvpwrvgnd_1
XTAP_TAPCELL_ROW_47_244 VSS VDD sky130_fd_sc_hd__tapvpwrvgnd_1
XTAP_TAPCELL_ROW_48_245 VSS VDD sky130_fd_sc_hd__tapvpwrvgnd_1
XTAP_TAPCELL_ROW_48_246 VSS VDD sky130_fd_sc_hd__tapvpwrvgnd_1
XTAP_TAPCELL_ROW_48_247 VSS VDD sky130_fd_sc_hd__tapvpwrvgnd_1
XTAP_TAPCELL_ROW_48_248 VSS VDD sky130_fd_sc_hd__tapvpwrvgnd_1
XTAP_TAPCELL_ROW_48_249 VSS VDD sky130_fd_sc_hd__tapvpwrvgnd_1
XTAP_TAPCELL_ROW_49_250 VSS VDD sky130_fd_sc_hd__tapvpwrvgnd_1
XTAP_TAPCELL_ROW_49_251 VSS VDD sky130_fd_sc_hd__tapvpwrvgnd_1
XTAP_TAPCELL_ROW_49_252 VSS VDD sky130_fd_sc_hd__tapvpwrvgnd_1
XTAP_TAPCELL_ROW_49_253 VSS VDD sky130_fd_sc_hd__tapvpwrvgnd_1
XTAP_TAPCELL_ROW_49_254 VSS VDD sky130_fd_sc_hd__tapvpwrvgnd_1
XTAP_TAPCELL_ROW_50_255 VSS VDD sky130_fd_sc_hd__tapvpwrvgnd_1
XTAP_TAPCELL_ROW_50_256 VSS VDD sky130_fd_sc_hd__tapvpwrvgnd_1
XTAP_TAPCELL_ROW_50_257 VSS VDD sky130_fd_sc_hd__tapvpwrvgnd_1
XTAP_TAPCELL_ROW_50_258 VSS VDD sky130_fd_sc_hd__tapvpwrvgnd_1
XTAP_TAPCELL_ROW_50_259 VSS VDD sky130_fd_sc_hd__tapvpwrvgnd_1
XTAP_TAPCELL_ROW_50_260 VSS VDD sky130_fd_sc_hd__tapvpwrvgnd_1
XTAP_TAPCELL_ROW_50_261 VSS VDD sky130_fd_sc_hd__tapvpwrvgnd_1
XTAP_TAPCELL_ROW_50_262 VSS VDD sky130_fd_sc_hd__tapvpwrvgnd_1
XTAP_TAPCELL_ROW_50_263 VSS VDD sky130_fd_sc_hd__tapvpwrvgnd_1
XTAP_TAPCELL_ROW_50_264 VSS VDD sky130_fd_sc_hd__tapvpwrvgnd_1
Xoutput54 net45 VSS VSS VDD VDD rsp_data[24] sky130_fd_sc_hd__clkdlybuf4s50_1
Xoutput55 net45 VSS VSS VDD VDD rsp_data[25] sky130_fd_sc_hd__clkdlybuf4s50_1
Xoutput56 net45 VSS VSS VDD VDD rsp_data[26] sky130_fd_sc_hd__clkdlybuf4s50_1
Xoutput57 net45 VSS VSS VDD VDD rsp_data[27] sky130_fd_sc_hd__clkdlybuf4s50_1
Xoutput58 net45 VSS VSS VDD VDD rsp_data[28] sky130_fd_sc_hd__clkdlybuf4s50_1
Xoutput59 net45 VSS VSS VDD VDD rsp_data[29] sky130_fd_sc_hd__clkdlybuf4s50_1
Xoutput60 net47 VSS VSS VDD VDD rsp_data[2] sky130_fd_sc_hd__clkdlybuf4s50_1
Xoutput61 net45 VSS VSS VDD VDD rsp_data[30] sky130_fd_sc_hd__clkdlybuf4s50_1
Xoutput62 net45 VSS VSS VDD VDD rsp_data[31] sky130_fd_sc_hd__clkdlybuf4s50_1
Xoutput63 net48 VSS VSS VDD VDD rsp_data[3] sky130_fd_sc_hd__clkdlybuf4s50_1
Xoutput64 net49 VSS VSS VDD VDD rsp_data[4] sky130_fd_sc_hd__clkdlybuf4s50_1
Xoutput65 net50 VSS VSS VDD VDD rsp_data[5] sky130_fd_sc_hd__clkdlybuf4s50_1
Xoutput66 net51 VSS VSS VDD VDD rsp_data[6] sky130_fd_sc_hd__clkdlybuf4s50_1
Xoutput67 net52 VSS VSS VDD VDD rsp_data[7] sky130_fd_sc_hd__clkdlybuf4s50_1
Xoutput68 net53 VSS VSS VDD VDD rsp_data[8] sky130_fd_sc_hd__clkdlybuf4s50_1
Xoutput69 net54 VSS VSS VDD VDD rsp_data[9] sky130_fd_sc_hd__clkdlybuf4s50_1
Xoutput70 net55 VSS VSS VDD VDD rsp_valid sky130_fd_sc_hd__clkdlybuf4s50_1
Xplace74 _0367_ VSS VSS VDD VDD net59 sky130_fd_sc_hd__buf_4
Xplace75 net61 VSS VSS VDD VDD net60 sky130_fd_sc_hd__buf_4
Xclkbuf_0_clk clk VSS VSS VDD VDD clknet_0_clk sky130_fd_sc_hd__clkbuf_16
Xplace76 net36 VSS VSS VDD VDD net61 sky130_fd_sc_hd__buf_4
Xclkbuf_2_0__f_clk clknet_0_clk VSS VSS VDD VDD clknet_2_0__leaf_clk
+ sky130_fd_sc_hd__clkbuf_16
Xclkbuf_2_1__f_clk clknet_0_clk VSS VSS VDD VDD clknet_2_1__leaf_clk
+ sky130_fd_sc_hd__clkbuf_16
Xclkbuf_2_2__f_clk clknet_0_clk VSS VSS VDD VDD clknet_2_2__leaf_clk
+ sky130_fd_sc_hd__clkbuf_16
Xclkbuf_2_3__f_clk clknet_0_clk VSS VSS VDD VDD clknet_2_3__leaf_clk
+ sky130_fd_sc_hd__clkbuf_16
Xclkload0 clknet_2_0__leaf_clk VSS VSS VDD VDD _unconnected_0
+ sky130_fd_sc_hd__clkinvlp_4
Xclkload1 clknet_2_1__leaf_clk VSS VSS VDD VDD _unconnected_1
+ sky130_fd_sc_hd__inv_6
Xclkload2 clknet_2_2__leaf_clk VSS VSS VDD VDD _unconnected_2
+ sky130_fd_sc_hd__clkinv_2
.ENDS benchmark_dot
