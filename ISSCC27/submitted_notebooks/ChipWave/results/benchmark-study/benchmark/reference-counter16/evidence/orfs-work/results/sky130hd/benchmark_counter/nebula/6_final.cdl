* CDL Netlist generated by OpenROAD

*.BUSDELIMITER [

.SUBCKT benchmark_counter clk count[0] count[10] count[11]
+ count[12] count[13] count[14] count[15] count[1] count[2]
+ count[3] count[4] count[5] count[6] count[7] count[8] count[9]
+ en load load_value[0] load_value[10] load_value[11] load_value[12]
+ load_value[13] load_value[14] load_value[15] load_value[1]
+ load_value[2] load_value[3] load_value[4] load_value[5] load_value[6]
+ load_value[7] load_value[8] load_value[9] overflow rst_n VDD
+ VSS
X_120_ net25 net24 net23 VSS VSS VDD VDD _076_ sky130_fd_sc_hd__nand3_1
Xinput3 load_value[0] VSS VSS VDD VDD net3 sky130_fd_sc_hd__clkdlybuf4s50_1
X_122_ net34 net35 VSS VSS VDD VDD _086_ sky130_fd_sc_hd__nand2_1
X_123_ _096_ _059_ VSS VSS VDD VDD _060_ sky130_fd_sc_hd__nor2_1
X_124_ _041_ net24 _060_ VSS VSS VDD VDD _061_ sky130_fd_sc_hd__nand3_1
X_125_ _094_ _097_ VSS VSS VDD VDD _062_ sky130_fd_sc_hd__nor2_1
X_126_ _030_ _062_ _060_ VSS VSS VDD VDD _063_ sky130_fd_sc_hd__nand3_1
X_127_ net24 VSS VSS VDD VDD _064_ sky130_fd_sc_hd__inv_1
X_128_ _063_ _064_ VSS VSS VDD VDD _065_ sky130_fd_sc_hd__nand2_1
X_129_ _061_ _118_ _065_ VSS VSS VDD VDD _066_ sky130_fd_sc_hd__nand3_1
X_130_ net2 net7 _109_ net24 VSS VSS VDD VDD _067_ sky130_fd_sc_hd__a22oi_1
X_131_ _066_ _067_ VSS VSS VDD VDD _003_ sky130_fd_sc_hd__nand2_1
X_132_ net24 net23 VSS VSS VDD VDD _068_ sky130_fd_sc_hd__nand2_1
X_133_ net21 net22 VSS VSS VDD VDD _087_ sky130_fd_sc_hd__nand2_1
X_134_ _084_ _068_ VSS VSS VDD VDD _069_ sky130_fd_sc_hd__nor2_1
X_135_ _033_ _088_ _069_ VSS VSS VDD VDD _070_ sky130_fd_sc_hd__nand3_1
X_136_ net25 VSS VSS VDD VDD _071_ sky130_fd_sc_hd__inv_1
X_137_ _070_ _071_ VSS VSS VDD VDD _072_ sky130_fd_sc_hd__nand2_1
X_138_ _033_ _088_ _069_ net25 VSS VSS VDD VDD _073_ sky130_fd_sc_hd__nand4_1
X_139_ _072_ _073_ _118_ VSS VSS VDD VDD _074_ sky130_fd_sc_hd__nand3_1
X_140_ net2 net8 _109_ net25 VSS VSS VDD VDD _075_ sky130_fd_sc_hd__a22oi_1
X_141_ _074_ _075_ VSS VSS VDD VDD _002_ sky130_fd_sc_hd__nand2_1
X_142_ _086_ _087_ VSS VSS VDD VDD _088_ sky130_fd_sc_hd__nor2_2
X_143_ _082_ _085_ _088_ VSS VSS VDD VDD _089_ sky130_fd_sc_hd__nand3_2
X_144_ _076_ _080_ _089_ VSS VSS VDD VDD _119_ sky130_fd_sc_hd__nor3_1
X_145_ net2 VSS VSS VDD VDD _090_ sky130_fd_sc_hd__inv_2
X_146_ _090_ net22 VSS VSS VDD VDD _091_ sky130_fd_sc_hd__nand2_1
X_147_ _091_ _076_ VSS VSS VDD VDD _092_ sky130_fd_sc_hd__nor2_1
X_148_ net30 net29 VSS VSS VDD VDD _093_ sky130_fd_sc_hd__nand2_2
X_149_ net32 net31 VSS VSS VDD VDD _094_ sky130_fd_sc_hd__nand2_1
X_150_ net26 VSS VSS VDD VDD _078_ sky130_fd_sc_hd__inv_1
X_151_ _093_ _094_ VSS VSS VDD VDD _095_ sky130_fd_sc_hd__nor2_4
X_152_ net35 net21 VSS VSS VDD VDD _096_ sky130_fd_sc_hd__nand2_1
X_153_ net33 net34 VSS VSS VDD VDD _097_ sky130_fd_sc_hd__nand2_2
X_154_ _096_ _097_ VSS VSS VDD VDD _098_ sky130_fd_sc_hd__nor2_2
X_155_ net20 VSS VSS VDD VDD _099_ sky130_fd_sc_hd__inv_4
X_156_ net27 net28 VSS VSS VDD VDD _100_ sky130_fd_sc_hd__nand2_1
X_157_ _099_ _100_ VSS VSS VDD VDD _101_ sky130_fd_sc_hd__nor2_4
X_158_ _092_ _095_ _098_ _101_ VSS VSS VDD VDD _102_ sky130_fd_sc_hd__nand4_1
X_159_ net9 net2 _079_ VSS VSS VDD VDD _103_ sky130_fd_sc_hd__a21oi_1
X_160_ _102_ _103_ VSS VSS VDD VDD _104_ sky130_fd_sc_hd__nand2_1
X_161_ net2 _078_ VSS VSS VDD VDD _079_ sky130_fd_sc_hd__nor2_1
X_162_ _098_ VSS VSS VDD VDD _105_ sky130_fd_sc_hd__inv_2
X_163_ _095_ _101_ VSS VSS VDD VDD _106_ sky130_fd_sc_hd__nand2_4
X_164_ _105_ _106_ VSS VSS VDD VDD _107_ sky130_fd_sc_hd__nor2_4
X_165_ _107_ net26 _092_ VSS VSS VDD VDD _108_ sky130_fd_sc_hd__nand3_1
X_166_ net2 net1 VSS VSS VDD VDD _109_ sky130_fd_sc_hd__nor2_4
X_167_ _109_ VSS VSS VDD VDD _110_ sky130_fd_sc_hd__inv_1
X_168_ _104_ _108_ _110_ VSS VSS VDD VDD _111_ sky130_fd_sc_hd__nand3_1
Xinput2 load VSS VSS VDD VDD net2 sky130_fd_sc_hd__clkdlybuf4s50_1
X_170_ _109_ net26 VSS VSS VDD VDD _113_ sky130_fd_sc_hd__nand2_1
X_171_ _111_ _113_ VSS VSS VDD VDD _017_ sky130_fd_sc_hd__nand2_1
X_172_ _079_ net1 VSS VSS VDD VDD _080_ sky130_fd_sc_hd__nand2_1
X_173_ _090_ net1 VSS VSS VDD VDD _114_ sky130_fd_sc_hd__nand2_2
X_174_ _109_ net20 VSS VSS VDD VDD _115_ sky130_fd_sc_hd__nand2_1
Xinput1 en VSS VSS VDD VDD net1 sky130_fd_sc_hd__clkdlybuf4s50_1
X_176_ net2 net3 VSS VSS VDD VDD _117_ sky130_fd_sc_hd__nand2_1
X_177_ net20 _114_ _115_ _117_ VSS VSS VDD VDD _016_ sky130_fd_sc_hd__o211ai_1
X_178_ _114_ VSS VSS VDD VDD _118_ sky130_fd_sc_hd__inv_1
X_179_ _118_ _001_ VSS VSS VDD VDD _018_ sky130_fd_sc_hd__nand2_1
X_180_ _109_ net27 VSS VSS VDD VDD _019_ sky130_fd_sc_hd__nand2_1
X_181_ net2 net10 VSS VSS VDD VDD _020_ sky130_fd_sc_hd__nand2_1
X_182_ _018_ _019_ _020_ VSS VSS VDD VDD _015_ sky130_fd_sc_hd__nand3_1
X_183_ net29 net28 _000_ VSS VSS VDD VDD _081_ sky130_fd_sc_hd__nand3_2
X_184_ net1 _000_ VSS VSS VDD VDD _021_ sky130_fd_sc_hd__nand2_1
X_185_ net28 _021_ VSS VSS VDD VDD _022_ sky130_fd_sc_hd__xor2_1
X_186_ net11 _090_ VSS VSS VDD VDD _023_ sky130_fd_sc_hd__nor2_1
X_187_ _022_ _090_ _023_ VSS VSS VDD VDD _014_ sky130_fd_sc_hd__a21oi_1
X_188_ _101_ net1 VSS VSS VDD VDD _024_ sky130_fd_sc_hd__nand2_1
X_189_ net29 _024_ VSS VSS VDD VDD _025_ sky130_fd_sc_hd__xor2_1
X_190_ net12 _090_ VSS VSS VDD VDD _026_ sky130_fd_sc_hd__nor2_1
X_191_ _025_ _090_ _026_ VSS VSS VDD VDD _013_ sky130_fd_sc_hd__a21oi_1
X_192_ net30 _081_ VSS VSS VDD VDD _027_ sky130_fd_sc_hd__xor2_1
X_193_ net2 net13 _109_ net30 VSS VSS VDD VDD _028_ sky130_fd_sc_hd__a22oi_1
X_194_ _081_ VSS VSS VDD VDD _082_ sky130_fd_sc_hd__inv_1
X_195_ _114_ _027_ _028_ VSS VSS VDD VDD _012_ sky130_fd_sc_hd__o21ai_1
X_196_ net20 net27 net28 VSS VSS VDD VDD _029_ sky130_fd_sc_hd__nand3_1
X_197_ _093_ _029_ VSS VSS VDD VDD _030_ sky130_fd_sc_hd__nor2_1
X_198_ net31 _030_ VSS VSS VDD VDD _031_ sky130_fd_sc_hd__xnor2_1
X_199_ net2 net14 _109_ net31 VSS VSS VDD VDD _032_ sky130_fd_sc_hd__a22oi_1
X_200_ _114_ _031_ _032_ VSS VSS VDD VDD _011_ sky130_fd_sc_hd__o21ai_1
X_201_ _083_ _081_ VSS VSS VDD VDD _033_ sky130_fd_sc_hd__nor2_2
X_202_ net32 _033_ VSS VSS VDD VDD _034_ sky130_fd_sc_hd__xnor2_1
X_203_ net2 net15 _109_ net32 VSS VSS VDD VDD _035_ sky130_fd_sc_hd__a22oi_1
X_204_ _114_ _034_ _035_ VSS VSS VDD VDD _010_ sky130_fd_sc_hd__o21ai_1
X_205_ net30 net31 VSS VSS VDD VDD _083_ sky130_fd_sc_hd__nand2_1
X_206_ net33 _106_ VSS VSS VDD VDD _036_ sky130_fd_sc_hd__xor2_1
X_207_ net2 net16 _109_ net33 VSS VSS VDD VDD _037_ sky130_fd_sc_hd__a22oi_1
X_208_ _114_ _036_ _037_ VSS VSS VDD VDD _009_ sky130_fd_sc_hd__o21ai_1
X_209_ _082_ _085_ VSS VSS VDD VDD _038_ sky130_fd_sc_hd__nand2_1
X_210_ net34 _038_ VSS VSS VDD VDD _039_ sky130_fd_sc_hd__xor2_1
X_211_ net2 net17 _109_ net34 VSS VSS VDD VDD _040_ sky130_fd_sc_hd__a22oi_1
X_212_ _114_ _039_ _040_ VSS VSS VDD VDD _008_ sky130_fd_sc_hd__o21ai_1
X_213_ _097_ _106_ VSS VSS VDD VDD _041_ sky130_fd_sc_hd__nor2_4
X_214_ net35 _041_ VSS VSS VDD VDD _042_ sky130_fd_sc_hd__nor2_1
X_215_ _041_ net35 VSS VSS VDD VDD _043_ sky130_fd_sc_hd__nand2_1
X_216_ net32 net33 VSS VSS VDD VDD _084_ sky130_fd_sc_hd__nand2_1
X_217_ _043_ _118_ VSS VSS VDD VDD _044_ sky130_fd_sc_hd__nand2_1
X_218_ net2 net18 _109_ net35 VSS VSS VDD VDD _045_ sky130_fd_sc_hd__a22oi_1
X_219_ _042_ _044_ _045_ VSS VSS VDD VDD _007_ sky130_fd_sc_hd__o21ai_2
X_220_ _033_ _098_ net32 _114_ VSS VSS VDD VDD _046_ sky130_fd_sc_hd__a31oi_1
X_221_ _086_ _038_ net21 VSS VSS VDD VDD _047_ sky130_fd_sc_hd__o21bai_1
X_222_ _046_ _047_ VSS VSS VDD VDD _048_ sky130_fd_sc_hd__nand2_1
X_223_ net2 net4 _109_ net21 VSS VSS VDD VDD _049_ sky130_fd_sc_hd__a22oi_1
X_224_ _048_ _049_ VSS VSS VDD VDD _006_ sky130_fd_sc_hd__nand2_1
X_225_ _105_ _106_ net22 VSS VSS VDD VDD _050_ sky130_fd_sc_hd__o21bai_1
X_226_ _107_ net22 VSS VSS VDD VDD _051_ sky130_fd_sc_hd__nand2_1
X_227_ _083_ _084_ VSS VSS VDD VDD _085_ sky130_fd_sc_hd__nor2_2
X_228_ _050_ _051_ _118_ VSS VSS VDD VDD _052_ sky130_fd_sc_hd__nand3_1
X_229_ net2 net5 _109_ net22 VSS VSS VDD VDD _053_ sky130_fd_sc_hd__a22oi_1
X_230_ _052_ _053_ VSS VSS VDD VDD _005_ sky130_fd_sc_hd__nand2_1
X_231_ net23 VSS VSS VDD VDD _054_ sky130_fd_sc_hd__inv_1
X_232_ _054_ _089_ VSS VSS VDD VDD _055_ sky130_fd_sc_hd__nor2_1
X_233_ _089_ _054_ VSS VSS VDD VDD _056_ sky130_fd_sc_hd__nand2_1
X_234_ _056_ _118_ VSS VSS VDD VDD _057_ sky130_fd_sc_hd__nand2_1
X_235_ net2 net6 _109_ net23 VSS VSS VDD VDD _058_ sky130_fd_sc_hd__a22oi_1
X_236_ _055_ _057_ _058_ VSS VSS VDD VDD _004_ sky130_fd_sc_hd__o21ai_1
X_237_ net22 net23 VSS VSS VDD VDD _059_ sky130_fd_sc_hd__nand2_1
X_238_ net20 net27 VSS VSS VDD VDD _000_ _001_ sky130_fd_sc_hd__ha_1
Xcount\[0\]$_DFFE_PN0P_ clknet_1_0__leaf_clk _016_ net19 VSS
+ VSS VDD VDD net20 sky130_fd_sc_hd__dfrtp_1
Xcount\[10\]$_DFFE_PN0P_ clknet_1_1__leaf_clk _006_ net19
+ VSS VSS VDD VDD net21 sky130_fd_sc_hd__dfrtp_1
Xcount\[11\]$_DFFE_PN0P_ clknet_1_1__leaf_clk _005_ net19
+ VSS VSS VDD VDD net22 sky130_fd_sc_hd__dfrtp_1
Xcount\[12\]$_DFFE_PN0P_ clknet_1_1__leaf_clk _004_ net19
+ VSS VSS VDD VDD net23 sky130_fd_sc_hd__dfrtp_1
Xcount\[13\]$_DFFE_PN0P_ clknet_1_1__leaf_clk _003_ net19
+ VSS VSS VDD VDD net24 sky130_fd_sc_hd__dfrtp_1
Xcount\[14\]$_DFFE_PN0P_ clknet_1_1__leaf_clk _002_ net19
+ VSS VSS VDD VDD net25 sky130_fd_sc_hd__dfrtp_1
Xcount\[15\]$_DFFE_PN0P_ clknet_1_1__leaf_clk _017_ net19
+ VSS VSS VDD VDD net26 sky130_fd_sc_hd__dfrtp_1
Xcount\[1\]$_DFFE_PN0P_ clknet_1_0__leaf_clk _015_ net19 VSS
+ VSS VDD VDD net27 sky130_fd_sc_hd__dfrtp_1
Xcount\[2\]$_DFFE_PN0P_ clknet_1_0__leaf_clk _014_ net19 VSS
+ VSS VDD VDD net28 sky130_fd_sc_hd__dfrtp_1
Xcount\[3\]$_DFFE_PN0P_ clknet_1_0__leaf_clk _013_ net19 VSS
+ VSS VDD VDD net29 sky130_fd_sc_hd__dfrtp_1
Xcount\[4\]$_DFFE_PN0P_ clknet_1_0__leaf_clk _012_ net19 VSS
+ VSS VDD VDD net30 sky130_fd_sc_hd__dfrtp_1
Xcount\[5\]$_DFFE_PN0P_ clknet_1_0__leaf_clk _011_ net19 VSS
+ VSS VDD VDD net31 sky130_fd_sc_hd__dfrtp_1
Xcount\[6\]$_DFFE_PN0P_ clknet_1_0__leaf_clk _010_ net19 VSS
+ VSS VDD VDD net32 sky130_fd_sc_hd__dfrtp_1
Xcount\[7\]$_DFFE_PN0P_ clknet_1_0__leaf_clk _009_ net19 VSS
+ VSS VDD VDD net33 sky130_fd_sc_hd__dfrtp_1
Xcount\[8\]$_DFFE_PN0P_ clknet_1_0__leaf_clk _008_ net19 VSS
+ VSS VDD VDD net34 sky130_fd_sc_hd__dfrtp_1
Xcount\[9\]$_DFFE_PN0P_ clknet_1_1__leaf_clk _007_ net19 VSS
+ VSS VDD VDD net35 sky130_fd_sc_hd__dfrtp_1
Xoverflow$_DFF_PN0_ clknet_1_1__leaf_clk _119_ net19 VSS VSS
+ VDD VDD net36 sky130_fd_sc_hd__dfrtp_1
XTAP_TAPCELL_ROW_0_0 VSS VDD sky130_fd_sc_hd__tapvpwrvgnd_1
XTAP_TAPCELL_ROW_0_1 VSS VDD sky130_fd_sc_hd__tapvpwrvgnd_1
XTAP_TAPCELL_ROW_0_2 VSS VDD sky130_fd_sc_hd__tapvpwrvgnd_1
XTAP_TAPCELL_ROW_1_3 VSS VDD sky130_fd_sc_hd__tapvpwrvgnd_1
XTAP_TAPCELL_ROW_2_4 VSS VDD sky130_fd_sc_hd__tapvpwrvgnd_1
XTAP_TAPCELL_ROW_2_5 VSS VDD sky130_fd_sc_hd__tapvpwrvgnd_1
XTAP_TAPCELL_ROW_3_6 VSS VDD sky130_fd_sc_hd__tapvpwrvgnd_1
XTAP_TAPCELL_ROW_4_7 VSS VDD sky130_fd_sc_hd__tapvpwrvgnd_1
XTAP_TAPCELL_ROW_4_8 VSS VDD sky130_fd_sc_hd__tapvpwrvgnd_1
XTAP_TAPCELL_ROW_5_9 VSS VDD sky130_fd_sc_hd__tapvpwrvgnd_1
XTAP_TAPCELL_ROW_6_10 VSS VDD sky130_fd_sc_hd__tapvpwrvgnd_1
XTAP_TAPCELL_ROW_6_11 VSS VDD sky130_fd_sc_hd__tapvpwrvgnd_1
XTAP_TAPCELL_ROW_7_12 VSS VDD sky130_fd_sc_hd__tapvpwrvgnd_1
XTAP_TAPCELL_ROW_8_13 VSS VDD sky130_fd_sc_hd__tapvpwrvgnd_1
XTAP_TAPCELL_ROW_8_14 VSS VDD sky130_fd_sc_hd__tapvpwrvgnd_1
XTAP_TAPCELL_ROW_9_15 VSS VDD sky130_fd_sc_hd__tapvpwrvgnd_1
XTAP_TAPCELL_ROW_10_16 VSS VDD sky130_fd_sc_hd__tapvpwrvgnd_1
XTAP_TAPCELL_ROW_10_17 VSS VDD sky130_fd_sc_hd__tapvpwrvgnd_1
XTAP_TAPCELL_ROW_11_18 VSS VDD sky130_fd_sc_hd__tapvpwrvgnd_1
XTAP_TAPCELL_ROW_12_19 VSS VDD sky130_fd_sc_hd__tapvpwrvgnd_1
XTAP_TAPCELL_ROW_12_20 VSS VDD sky130_fd_sc_hd__tapvpwrvgnd_1
XTAP_TAPCELL_ROW_13_21 VSS VDD sky130_fd_sc_hd__tapvpwrvgnd_1
XTAP_TAPCELL_ROW_14_22 VSS VDD sky130_fd_sc_hd__tapvpwrvgnd_1
XTAP_TAPCELL_ROW_14_23 VSS VDD sky130_fd_sc_hd__tapvpwrvgnd_1
XTAP_TAPCELL_ROW_15_24 VSS VDD sky130_fd_sc_hd__tapvpwrvgnd_1
XTAP_TAPCELL_ROW_16_25 VSS VDD sky130_fd_sc_hd__tapvpwrvgnd_1
XTAP_TAPCELL_ROW_16_26 VSS VDD sky130_fd_sc_hd__tapvpwrvgnd_1
XTAP_TAPCELL_ROW_17_27 VSS VDD sky130_fd_sc_hd__tapvpwrvgnd_1
XTAP_TAPCELL_ROW_17_28 VSS VDD sky130_fd_sc_hd__tapvpwrvgnd_1
XTAP_TAPCELL_ROW_17_29 VSS VDD sky130_fd_sc_hd__tapvpwrvgnd_1
Xinput4 load_value[10] VSS VSS VDD VDD net4 sky130_fd_sc_hd__clkdlybuf4s50_1
Xinput5 load_value[11] VSS VSS VDD VDD net5 sky130_fd_sc_hd__clkdlybuf4s50_1
Xinput6 load_value[12] VSS VSS VDD VDD net6 sky130_fd_sc_hd__clkdlybuf4s50_1
Xinput7 load_value[13] VSS VSS VDD VDD net7 sky130_fd_sc_hd__clkdlybuf4s50_1
Xinput8 load_value[14] VSS VSS VDD VDD net8 sky130_fd_sc_hd__clkdlybuf4s50_1
Xinput9 load_value[15] VSS VSS VDD VDD net9 sky130_fd_sc_hd__clkdlybuf4s50_1
Xinput10 load_value[1] VSS VSS VDD VDD net10 sky130_fd_sc_hd__clkdlybuf4s50_1
Xinput11 load_value[2] VSS VSS VDD VDD net11 sky130_fd_sc_hd__clkdlybuf4s50_1
Xinput12 load_value[3] VSS VSS VDD VDD net12 sky130_fd_sc_hd__clkdlybuf4s50_1
Xinput13 load_value[4] VSS VSS VDD VDD net13 sky130_fd_sc_hd__clkdlybuf4s50_1
Xinput14 load_value[5] VSS VSS VDD VDD net14 sky130_fd_sc_hd__clkdlybuf4s50_1
Xinput15 load_value[6] VSS VSS VDD VDD net15 sky130_fd_sc_hd__clkdlybuf4s50_1
Xinput16 load_value[7] VSS VSS VDD VDD net16 sky130_fd_sc_hd__clkdlybuf4s50_1
Xinput17 load_value[8] VSS VSS VDD VDD net17 sky130_fd_sc_hd__clkdlybuf4s50_1
Xinput18 load_value[9] VSS VSS VDD VDD net18 sky130_fd_sc_hd__clkdlybuf4s50_1
Xinput19 rst_n VSS VSS VDD VDD net19 sky130_fd_sc_hd__clkdlybuf4s50_1
Xoutput20 net20 VSS VSS VDD VDD count[0] sky130_fd_sc_hd__clkdlybuf4s50_1
Xoutput21 net21 VSS VSS VDD VDD count[10] sky130_fd_sc_hd__clkdlybuf4s50_1
Xoutput22 net22 VSS VSS VDD VDD count[11] sky130_fd_sc_hd__clkdlybuf4s50_1
Xoutput23 net23 VSS VSS VDD VDD count[12] sky130_fd_sc_hd__clkdlybuf4s50_1
Xoutput24 net24 VSS VSS VDD VDD count[13] sky130_fd_sc_hd__clkdlybuf4s50_1
Xoutput25 net25 VSS VSS VDD VDD count[14] sky130_fd_sc_hd__clkdlybuf4s50_1
Xoutput26 net26 VSS VSS VDD VDD count[15] sky130_fd_sc_hd__clkdlybuf4s50_1
Xoutput27 net27 VSS VSS VDD VDD count[1] sky130_fd_sc_hd__clkdlybuf4s50_1
Xoutput28 net28 VSS VSS VDD VDD count[2] sky130_fd_sc_hd__clkdlybuf4s50_1
Xoutput29 net29 VSS VSS VDD VDD count[3] sky130_fd_sc_hd__clkdlybuf4s50_1
Xoutput30 net30 VSS VSS VDD VDD count[4] sky130_fd_sc_hd__clkdlybuf4s50_1
Xoutput31 net31 VSS VSS VDD VDD count[5] sky130_fd_sc_hd__clkdlybuf4s50_1
Xoutput32 net32 VSS VSS VDD VDD count[6] sky130_fd_sc_hd__clkdlybuf4s50_1
Xoutput33 net33 VSS VSS VDD VDD count[7] sky130_fd_sc_hd__clkdlybuf4s50_1
Xoutput34 net34 VSS VSS VDD VDD count[8] sky130_fd_sc_hd__clkdlybuf4s50_1
Xoutput35 net35 VSS VSS VDD VDD count[9] sky130_fd_sc_hd__clkdlybuf4s50_1
Xoutput36 net36 VSS VSS VDD VDD overflow sky130_fd_sc_hd__clkdlybuf4s50_1
Xclkbuf_0_clk clk VSS VSS VDD VDD clknet_0_clk sky130_fd_sc_hd__clkbuf_4
Xclkbuf_1_0__f_clk clknet_0_clk VSS VSS VDD VDD clknet_1_0__leaf_clk
+ sky130_fd_sc_hd__clkbuf_4
Xclkbuf_1_1__f_clk clknet_0_clk VSS VSS VDD VDD clknet_1_1__leaf_clk
+ sky130_fd_sc_hd__clkbuf_4
Xclkload0 clknet_1_1__leaf_clk VSS VSS VDD VDD _unconnected_0
+ sky130_fd_sc_hd__clkbuf_1
.ENDS benchmark_counter
