* CDL Netlist generated by OpenROAD

*.BUSDELIMITER [

.SUBCKT benchmark_dot clk kill req_a[0] req_a[10] req_a[11]
+ req_a[12] req_a[13] req_a[14] req_a[15] req_a[16] req_a[17]
+ req_a[18] req_a[19] req_a[1] req_a[20] req_a[21] req_a[22]
+ req_a[23] req_a[24] req_a[25] req_a[26] req_a[27] req_a[28]
+ req_a[29] req_a[2] req_a[30] req_a[31] req_a[3] req_a[4] req_a[5]
+ req_a[6] req_a[7] req_a[8] req_a[9] req_b[0] req_b[10] req_b[11]
+ req_b[12] req_b[13] req_b[14] req_b[15] req_b[16] req_b[17]
+ req_b[18] req_b[19] req_b[1] req_b[20] req_b[21] req_b[22]
+ req_b[23] req_b[24] req_b[25] req_b[26] req_b[27] req_b[28]
+ req_b[29] req_b[2] req_b[30] req_b[31] req_b[3] req_b[4] req_b[5]
+ req_b[6] req_b[7] req_b[8] req_b[9] req_ready req_valid rsp_data[0]
+ rsp_data[10] rsp_data[11] rsp_data[12] rsp_data[13] rsp_data[14]
+ rsp_data[15] rsp_data[16] rsp_data[17] rsp_data[18] rsp_data[19]
+ rsp_data[1] rsp_data[20] rsp_data[21] rsp_data[22] rsp_data[23]
+ rsp_data[24] rsp_data[25] rsp_data[26] rsp_data[27] rsp_data[28]
+ rsp_data[29] rsp_data[2] rsp_data[30] rsp_data[31] rsp_data[3]
+ rsp_data[4] rsp_data[5] rsp_data[6] rsp_data[7] rsp_data[8]
+ rsp_data[9] rsp_ready rsp_valid rst_n VDD VSS
X_2116_ net101 VSS VSS VDD VDD _1215_ sky130_fd_sc_hd__inv_1
X_2117_ phase\[0\] VSS VSS VDD VDD _1216_ sky130_fd_sc_hd__inv_1
X_2118_ net66 _1216_ _1217_ _1222_ VSS VSS VDD VDD _0431_
+ sky130_fd_sc_hd__o211ai_1
X_2119_ _0035_ _1305_ _1306_ VSS VSS VDD VDD _1309_ sky130_fd_sc_hd__nand3b_1
X_2120_ _1035_ VSS VSS VDD VDD _0097_ sky130_fd_sc_hd__inv_1
X_2121_ net19 net54 VSS VSS VDD VDD _1036_ sky130_fd_sc_hd__nand2_1
X_2122_ _1036_ VSS VSS VDD VDD _0094_ sky130_fd_sc_hd__inv_1
X_2123_ net20 net54 VSS VSS VDD VDD _1037_ sky130_fd_sc_hd__nand2_1
X_2124_ _1037_ VSS VSS VDD VDD _0091_ sky130_fd_sc_hd__inv_1
X_2125_ net21 net54 VSS VSS VDD VDD _1038_ sky130_fd_sc_hd__nand2_1
X_2126_ _1038_ VSS VSS VDD VDD _0088_ sky130_fd_sc_hd__inv_1
X_2127_ net22 net54 VSS VSS VDD VDD _1039_ sky130_fd_sc_hd__nand2_1
X_2128_ _1039_ VSS VSS VDD VDD _0085_ sky130_fd_sc_hd__inv_1
X_2129_ net23 net54 VSS VSS VDD VDD _1040_ sky130_fd_sc_hd__nand2_1
X_2130_ _1308_ _1309_ VSS VSS VDD VDD _1310_ sky130_fd_sc_hd__nand2_1
X_2131_ _1040_ VSS VSS VDD VDD _0082_ sky130_fd_sc_hd__inv_1
X_2132_ net25 net54 VSS VSS VDD VDD _1041_ sky130_fd_sc_hd__nand2_1
X_2133_ _1041_ VSS VSS VDD VDD _0080_ sky130_fd_sc_hd__inv_1
X_2134_ net26 net54 VSS VSS VDD VDD _1042_ sky130_fd_sc_hd__nand2_1
X_2135_ _1042_ VSS VSS VDD VDD _0079_ sky130_fd_sc_hd__inv_1
Xoutput88 net79 VSS VSS VDD VDD rsp_data[26] sky130_fd_sc_hd__clkdlybuf4s50_1
X_2137_ net18 net53 VSS VSS VDD VDD _1044_ sky130_fd_sc_hd__nand2_1
X_2138_ _1044_ VSS VSS VDD VDD _0277_ sky130_fd_sc_hd__inv_1
X_2139_ net19 net53 VSS VSS VDD VDD _1045_ sky130_fd_sc_hd__nand2_1
X_2140_ _1045_ VSS VSS VDD VDD _0096_ sky130_fd_sc_hd__inv_1
X_2141_ _1302_ _1310_ VSS VSS VDD VDD _1311_ sky130_fd_sc_hd__nand2_1
X_2142_ net20 net53 VSS VSS VDD VDD _1046_ sky130_fd_sc_hd__nand2_1
X_2143_ _1046_ VSS VSS VDD VDD _0093_ sky130_fd_sc_hd__inv_1
X_2144_ net21 net53 VSS VSS VDD VDD _1047_ sky130_fd_sc_hd__nand2_1
X_2145_ _1047_ VSS VSS VDD VDD _0090_ sky130_fd_sc_hd__inv_1
X_2146_ net22 net53 VSS VSS VDD VDD _1048_ sky130_fd_sc_hd__nand2_1
X_2147_ _1048_ VSS VSS VDD VDD _0087_ sky130_fd_sc_hd__inv_1
X_2148_ net23 net53 VSS VSS VDD VDD _1049_ sky130_fd_sc_hd__nand2_1
X_2149_ _1049_ VSS VSS VDD VDD _0084_ sky130_fd_sc_hd__inv_1
X_2150_ net25 net53 VSS VSS VDD VDD _1050_ sky130_fd_sc_hd__nand2_1
X_2151_ _1050_ VSS VSS VDD VDD _0081_ sky130_fd_sc_hd__inv_1
X_2152_ _1310_ VSS VSS VDD VDD _1312_ sky130_fd_sc_hd__inv_1
X_2153_ net26 net53 VSS VSS VDD VDD _1051_ sky130_fd_sc_hd__nand2_1
X_2154_ _1051_ VSS VSS VDD VDD _0078_ sky130_fd_sc_hd__inv_1
Xoutput87 net79 VSS VSS VDD VDD rsp_data[25] sky130_fd_sc_hd__clkdlybuf4s50_1
X_2156_ net18 net52 VSS VSS VDD VDD _1053_ sky130_fd_sc_hd__nand2_1
X_2157_ _1053_ VSS VSS VDD VDD _0263_ sky130_fd_sc_hd__inv_1
X_2158_ net19 net52 VSS VSS VDD VDD _1054_ sky130_fd_sc_hd__nand2_1
X_2159_ _1054_ VSS VSS VDD VDD _0276_ sky130_fd_sc_hd__inv_1
X_2160_ net20 net52 VSS VSS VDD VDD _1055_ sky130_fd_sc_hd__nand2_1
X_2161_ _1055_ VSS VSS VDD VDD _0095_ sky130_fd_sc_hd__inv_1
X_2162_ net21 net52 VSS VSS VDD VDD _1056_ sky130_fd_sc_hd__nand2_1
X_2163_ _1300_ _1312_ _1301_ VSS VSS VDD VDD _1313_ sky130_fd_sc_hd__nand3_1
X_2164_ _1056_ VSS VSS VDD VDD _0092_ sky130_fd_sc_hd__inv_1
X_2165_ net22 net52 VSS VSS VDD VDD _1057_ sky130_fd_sc_hd__nand2_1
X_2166_ _1057_ VSS VSS VDD VDD _0089_ sky130_fd_sc_hd__inv_1
X_2167_ net23 net52 VSS VSS VDD VDD _1058_ sky130_fd_sc_hd__nand2_1
X_2168_ _1058_ VSS VSS VDD VDD _0086_ sky130_fd_sc_hd__inv_1
X_2169_ net25 net52 VSS VSS VDD VDD _1059_ sky130_fd_sc_hd__nand2_1
X_2170_ _1059_ VSS VSS VDD VDD _0083_ sky130_fd_sc_hd__inv_1
X_2171_ net26 net52 VSS VSS VDD VDD _1060_ sky130_fd_sc_hd__nand2_1
X_2172_ _1060_ VSS VSS VDD VDD _0077_ sky130_fd_sc_hd__inv_1
Xoutput86 net79 VSS VSS VDD VDD rsp_data[24] sky130_fd_sc_hd__clkdlybuf4s50_1
X_2174_ _1311_ _1313_ VSS VSS VDD VDD _1314_ sky130_fd_sc_hd__nand2_1
X_2175_ net18 net51 VSS VSS VDD VDD _1062_ sky130_fd_sc_hd__nand2_1
X_2176_ _1062_ VSS VSS VDD VDD _0290_ sky130_fd_sc_hd__inv_1
X_2177_ net19 net51 VSS VSS VDD VDD _1063_ sky130_fd_sc_hd__nand2_1
X_2178_ _1063_ VSS VSS VDD VDD _0288_ sky130_fd_sc_hd__inv_1
X_2179_ net20 net51 VSS VSS VDD VDD _1064_ sky130_fd_sc_hd__nand2_1
X_2180_ _1064_ VSS VSS VDD VDD _0286_ sky130_fd_sc_hd__inv_1
X_2181_ net21 net51 VSS VSS VDD VDD _1065_ sky130_fd_sc_hd__nand2_1
X_2182_ _1065_ VSS VSS VDD VDD _0284_ sky130_fd_sc_hd__inv_1
X_2183_ net22 net51 VSS VSS VDD VDD _1066_ sky130_fd_sc_hd__nand2_1
X_2184_ _1066_ VSS VSS VDD VDD _0282_ sky130_fd_sc_hd__inv_1
X_2185_ _0421_ _0262_ VSS VSS VDD VDD _1315_ sky130_fd_sc_hd__nand2_1
X_2186_ net23 net51 VSS VSS VDD VDD _1067_ sky130_fd_sc_hd__nand2_1
X_2187_ _1067_ VSS VSS VDD VDD _0280_ sky130_fd_sc_hd__inv_1
X_2188_ net25 net51 VSS VSS VDD VDD _1068_ sky130_fd_sc_hd__nand2_1
X_2189_ _1068_ VSS VSS VDD VDD _0099_ sky130_fd_sc_hd__inv_1
X_2190_ net26 net51 VSS VSS VDD VDD _1069_ sky130_fd_sc_hd__nand2_1
X_2191_ _1069_ VSS VSS VDD VDD _0278_ sky130_fd_sc_hd__inv_1
X_2192_ net19 net50 VSS VSS VDD VDD _1070_ sky130_fd_sc_hd__nand2_1
X_2193_ _1070_ VSS VSS VDD VDD _0289_ sky130_fd_sc_hd__inv_1
X_2194_ net20 net50 VSS VSS VDD VDD _1071_ sky130_fd_sc_hd__nand2_1
X_2195_ _1071_ VSS VSS VDD VDD _0287_ sky130_fd_sc_hd__inv_1
X_2196_ _1315_ VSS VSS VDD VDD _1316_ sky130_fd_sc_hd__inv_1
X_2197_ net21 net50 VSS VSS VDD VDD _1072_ sky130_fd_sc_hd__nand2_1
X_2198_ _1072_ VSS VSS VDD VDD _0285_ sky130_fd_sc_hd__inv_1
X_2199_ net22 net50 VSS VSS VDD VDD _1073_ sky130_fd_sc_hd__nand2_1
X_2200_ _1073_ VSS VSS VDD VDD _0283_ sky130_fd_sc_hd__inv_1
X_2201_ net23 net50 VSS VSS VDD VDD _1074_ sky130_fd_sc_hd__nand2_1
X_2202_ _1074_ VSS VSS VDD VDD _0281_ sky130_fd_sc_hd__inv_1
X_2203_ net25 net50 VSS VSS VDD VDD _1075_ sky130_fd_sc_hd__nand2_1
X_2204_ _1075_ VSS VSS VDD VDD _0279_ sky130_fd_sc_hd__inv_1
X_2205_ net26 net50 VSS VSS VDD VDD _1076_ sky130_fd_sc_hd__nand2_1
X_2206_ _1076_ VSS VSS VDD VDD _0098_ sky130_fd_sc_hd__inv_1
X_2207_ _1316_ _0042_ VSS VSS VDD VDD _1317_ sky130_fd_sc_hd__nand2_1
X_2208_ net40 VSS VSS VDD VDD _1077_ sky130_fd_sc_hd__inv_1
X_2209_ net32 _1077_ VSS VSS VDD VDD _0221_ sky130_fd_sc_hd__nor2_1
Xoutput85 net79 VSS VSS VDD VDD rsp_data[23] sky130_fd_sc_hd__clkdlybuf4s50_1
X_2211_ net33 _1077_ VSS VSS VDD VDD _0218_ sky130_fd_sc_hd__nor2_1
Xoutput84 net79 VSS VSS VDD VDD rsp_data[22] sky130_fd_sc_hd__clkdlybuf4s50_1
X_2213_ net3 _1077_ VSS VSS VDD VDD _0215_ sky130_fd_sc_hd__nor2_1
Xoutput83 net79 VSS VSS VDD VDD rsp_data[21] sky130_fd_sc_hd__clkdlybuf4s50_1
X_2215_ net4 _1077_ VSS VSS VDD VDD _0212_ sky130_fd_sc_hd__nor2_1
Xoutput82 net79 VSS VSS VDD VDD rsp_data[20] sky130_fd_sc_hd__clkdlybuf4s50_1
X_2217_ net5 _1077_ VSS VSS VDD VDD _0225_ sky130_fd_sc_hd__nor2_1
X_2218_ _0421_ _0363_ VSS VSS VDD VDD _1318_ sky130_fd_sc_hd__nand2_1
Xoutput81 net80 VSS VSS VDD VDD rsp_data[1] sky130_fd_sc_hd__clkdlybuf4s50_1
X_2220_ net6 _1077_ VSS VSS VDD VDD _0205_ sky130_fd_sc_hd__nor2_1
Xoutput80 net79 VSS VSS VDD VDD rsp_data[19] sky130_fd_sc_hd__clkdlybuf4s50_1
X_2222_ net7 _1077_ VSS VSS VDD VDD _0203_ sky130_fd_sc_hd__nor2_1
Xoutput79 net79 VSS VSS VDD VDD rsp_data[18] sky130_fd_sc_hd__clkdlybuf4s50_1
X_2224_ net8 _1077_ VSS VSS VDD VDD _0201_ sky130_fd_sc_hd__nor2_1
Xoutput78 net78 VSS VSS VDD VDD rsp_data[17] sky130_fd_sc_hd__clkdlybuf4s50_1
X_2226_ net32 net39 VSS VSS VDD VDD _1086_ sky130_fd_sc_hd__nand2_1
X_2227_ _1086_ VSS VSS VDD VDD _0419_ sky130_fd_sc_hd__inv_1
X_2228_ net33 net39 VSS VSS VDD VDD _1087_ sky130_fd_sc_hd__nand2_1
X_2229_ phase\[0\] net66 VSS VSS VDD VDD _1223_ sky130_fd_sc_hd__nand2_1
X_2230_ _0420_ VSS VSS VDD VDD _1319_ sky130_fd_sc_hd__inv_1
X_2231_ _1087_ VSS VSS VDD VDD _0220_ sky130_fd_sc_hd__inv_1
X_2232_ net3 net39 VSS VSS VDD VDD _1088_ sky130_fd_sc_hd__nand2_1
X_2233_ _1088_ VSS VSS VDD VDD _0217_ sky130_fd_sc_hd__inv_1
X_2234_ net4 net39 VSS VSS VDD VDD _1089_ sky130_fd_sc_hd__nand2_1
X_2235_ _1089_ VSS VSS VDD VDD _0214_ sky130_fd_sc_hd__inv_1
X_2236_ net5 net39 VSS VSS VDD VDD _1090_ sky130_fd_sc_hd__nand2_1
X_2237_ _1090_ VSS VSS VDD VDD _0211_ sky130_fd_sc_hd__inv_1
X_2238_ net6 net39 VSS VSS VDD VDD _1091_ sky130_fd_sc_hd__nand2_1
X_2239_ _1091_ VSS VSS VDD VDD _0224_ sky130_fd_sc_hd__inv_1
X_2240_ net7 net39 VSS VSS VDD VDD _1092_ sky130_fd_sc_hd__nand2_1
X_2241_ _1318_ _1319_ VSS VSS VDD VDD _1320_ sky130_fd_sc_hd__nand2_1
X_2242_ _1092_ VSS VSS VDD VDD _0204_ sky130_fd_sc_hd__inv_1
X_2243_ net8 net39 VSS VSS VDD VDD _1093_ sky130_fd_sc_hd__nand2_1
X_2244_ _1093_ VSS VSS VDD VDD _0200_ sky130_fd_sc_hd__inv_1
Xoutput77 net77 VSS VSS VDD VDD rsp_data[16] sky130_fd_sc_hd__clkdlybuf4s50_1
X_2246_ net32 net38 VSS VSS VDD VDD _1095_ sky130_fd_sc_hd__nand2_1
X_2247_ _1095_ VSS VSS VDD VDD _0257_ sky130_fd_sc_hd__inv_1
X_2248_ net33 net38 VSS VSS VDD VDD _1096_ sky130_fd_sc_hd__nand2_1
X_2249_ _1096_ VSS VSS VDD VDD _0418_ sky130_fd_sc_hd__inv_1
X_2250_ net3 net38 VSS VSS VDD VDD _1097_ sky130_fd_sc_hd__nand2_1
X_2251_ _1097_ VSS VSS VDD VDD _0219_ sky130_fd_sc_hd__inv_1
X_2252_ _1320_ VSS VSS VDD VDD _1321_ sky130_fd_sc_hd__inv_1
X_2253_ net4 net38 VSS VSS VDD VDD _1098_ sky130_fd_sc_hd__nand2_1
X_2254_ _1098_ VSS VSS VDD VDD _0216_ sky130_fd_sc_hd__inv_1
X_2255_ net5 net38 VSS VSS VDD VDD _1099_ sky130_fd_sc_hd__nand2_1
X_2256_ _1099_ VSS VSS VDD VDD _0213_ sky130_fd_sc_hd__inv_1
X_2257_ net6 net38 VSS VSS VDD VDD _1100_ sky130_fd_sc_hd__nand2_1
X_2258_ _1100_ VSS VSS VDD VDD _0210_ sky130_fd_sc_hd__inv_1
X_2259_ net7 net38 VSS VSS VDD VDD _1101_ sky130_fd_sc_hd__nand2_1
X_2260_ _1101_ VSS VSS VDD VDD _0223_ sky130_fd_sc_hd__inv_1
X_2261_ net8 net38 VSS VSS VDD VDD _1102_ sky130_fd_sc_hd__nand2_1
X_2262_ _1102_ VSS VSS VDD VDD _0199_ sky130_fd_sc_hd__inv_1
X_2263_ _1317_ _1321_ VSS VSS VDD VDD _1322_ sky130_fd_sc_hd__nand2_1
Xoutput76 net76 VSS VSS VDD VDD rsp_data[15] sky130_fd_sc_hd__clkdlybuf4s50_1
X_2265_ net32 net37 VSS VSS VDD VDD _1104_ sky130_fd_sc_hd__nand2_1
X_2266_ _1104_ VSS VSS VDD VDD _0023_ sky130_fd_sc_hd__inv_1
X_2267_ net33 net37 VSS VSS VDD VDD _1105_ sky130_fd_sc_hd__nand2_1
X_2268_ _1105_ VSS VSS VDD VDD _0020_ sky130_fd_sc_hd__inv_1
X_2269_ net3 net37 VSS VSS VDD VDD _1106_ sky130_fd_sc_hd__nand2_1
X_2270_ _1106_ VSS VSS VDD VDD _0017_ sky130_fd_sc_hd__inv_1
X_2271_ net4 net37 VSS VSS VDD VDD _1107_ sky130_fd_sc_hd__nand2_1
X_2272_ _1107_ VSS VSS VDD VDD _0014_ sky130_fd_sc_hd__inv_1
X_2273_ net5 net37 VSS VSS VDD VDD _1108_ sky130_fd_sc_hd__nand2_1
X_2274_ _0266_ _0269_ VSS VSS VDD VDD _1323_ sky130_fd_sc_hd__nand2_1
X_2275_ _1108_ VSS VSS VDD VDD _0011_ sky130_fd_sc_hd__inv_1
X_2276_ net6 net37 VSS VSS VDD VDD _1109_ sky130_fd_sc_hd__nand2_1
X_2277_ _1109_ VSS VSS VDD VDD _0008_ sky130_fd_sc_hd__inv_1
X_2278_ net7 net37 VSS VSS VDD VDD _1110_ sky130_fd_sc_hd__nand2_1
X_2279_ _1110_ VSS VSS VDD VDD _0006_ sky130_fd_sc_hd__inv_1
X_2280_ net8 net37 VSS VSS VDD VDD _1111_ sky130_fd_sc_hd__nand2_1
X_2281_ _1111_ VSS VSS VDD VDD _0004_ sky130_fd_sc_hd__inv_1
Xoutput75 net75 VSS VSS VDD VDD rsp_data[14] sky130_fd_sc_hd__clkdlybuf4s50_1
X_2283_ net32 net36 VSS VSS VDD VDD _1113_ sky130_fd_sc_hd__nand2_1
X_2284_ _1113_ VSS VSS VDD VDD _0231_ sky130_fd_sc_hd__inv_1
X_2285_ _0371_ _0366_ VSS VSS VDD VDD _1324_ sky130_fd_sc_hd__nand2_1
X_2286_ net33 net36 VSS VSS VDD VDD _1114_ sky130_fd_sc_hd__nand2_1
X_2287_ _1114_ VSS VSS VDD VDD _0022_ sky130_fd_sc_hd__inv_1
X_2288_ net3 net36 VSS VSS VDD VDD _1115_ sky130_fd_sc_hd__nand2_1
X_2289_ _1115_ VSS VSS VDD VDD _0019_ sky130_fd_sc_hd__inv_1
X_2290_ net4 net36 VSS VSS VDD VDD _1116_ sky130_fd_sc_hd__nand2_1
X_2291_ _1116_ VSS VSS VDD VDD _0016_ sky130_fd_sc_hd__inv_1
X_2292_ net5 net36 VSS VSS VDD VDD _1117_ sky130_fd_sc_hd__nand2_1
X_2293_ _1117_ VSS VSS VDD VDD _0013_ sky130_fd_sc_hd__inv_1
X_2294_ net6 net36 VSS VSS VDD VDD _1118_ sky130_fd_sc_hd__nand2_1
X_2295_ _1118_ VSS VSS VDD VDD _0010_ sky130_fd_sc_hd__inv_1
X_2296_ _1323_ _1324_ VSS VSS VDD VDD _1325_ sky130_fd_sc_hd__nor2_1
X_2297_ net7 net36 VSS VSS VDD VDD _1119_ sky130_fd_sc_hd__nand2_1
X_2298_ _1119_ VSS VSS VDD VDD _0007_ sky130_fd_sc_hd__inv_1
X_2299_ net8 net36 VSS VSS VDD VDD _1120_ sky130_fd_sc_hd__nand2_1
X_2300_ _1120_ VSS VSS VDD VDD _0003_ sky130_fd_sc_hd__inv_1
Xoutput74 net74 VSS VSS VDD VDD rsp_data[13] sky130_fd_sc_hd__clkdlybuf4s50_1
X_2302_ net32 net35 VSS VSS VDD VDD _1122_ sky130_fd_sc_hd__nand2_1
X_2303_ _1122_ VSS VSS VDD VDD _0413_ sky130_fd_sc_hd__inv_1
X_2304_ net33 net35 VSS VSS VDD VDD _1123_ sky130_fd_sc_hd__nand2_1
X_2305_ _1123_ VSS VSS VDD VDD _0230_ sky130_fd_sc_hd__inv_1
X_2306_ net3 net35 VSS VSS VDD VDD _1124_ sky130_fd_sc_hd__nand2_1
X_2307_ _0251_ _0235_ VSS VSS VDD VDD _1326_ sky130_fd_sc_hd__nand2_1
X_2308_ _1124_ VSS VSS VDD VDD _0021_ sky130_fd_sc_hd__inv_1
X_2309_ net4 net35 VSS VSS VDD VDD _1125_ sky130_fd_sc_hd__nand2_1
X_2310_ _1125_ VSS VSS VDD VDD _0018_ sky130_fd_sc_hd__inv_1
X_2311_ net5 net35 VSS VSS VDD VDD _1126_ sky130_fd_sc_hd__nand2_1
X_2312_ _1126_ VSS VSS VDD VDD _0015_ sky130_fd_sc_hd__inv_1
X_2313_ net6 net35 VSS VSS VDD VDD _1127_ sky130_fd_sc_hd__nand2_1
X_2314_ _1127_ VSS VSS VDD VDD _0012_ sky130_fd_sc_hd__inv_1
X_2315_ net7 net35 VSS VSS VDD VDD _1128_ sky130_fd_sc_hd__nand2_1
X_2316_ _1128_ VSS VSS VDD VDD _0009_ sky130_fd_sc_hd__inv_1
X_2317_ net8 net35 VSS VSS VDD VDD _1129_ sky130_fd_sc_hd__nand2_1
X_2318_ _0349_ _0339_ VSS VSS VDD VDD _1327_ sky130_fd_sc_hd__nand2_1
X_2319_ _1129_ VSS VSS VDD VDD _0002_ sky130_fd_sc_hd__inv_1
Xoutput73 net73 VSS VSS VDD VDD rsp_data[12] sky130_fd_sc_hd__clkdlybuf4s50_1
X_2321_ net32 net65 VSS VSS VDD VDD _1131_ sky130_fd_sc_hd__nand2_1
X_2322_ _1131_ VSS VSS VDD VDD _0248_ sky130_fd_sc_hd__inv_1
X_2323_ net33 net65 VSS VSS VDD VDD _1132_ sky130_fd_sc_hd__nand2_1
X_2324_ _1132_ VSS VSS VDD VDD _0246_ sky130_fd_sc_hd__inv_1
X_2325_ net3 net65 VSS VSS VDD VDD _1133_ sky130_fd_sc_hd__nand2_1
X_2326_ _1133_ VSS VSS VDD VDD _0244_ sky130_fd_sc_hd__inv_1
X_2327_ net4 net65 VSS VSS VDD VDD _1134_ sky130_fd_sc_hd__nand2_1
X_2328_ _1134_ VSS VSS VDD VDD _0242_ sky130_fd_sc_hd__inv_1
X_2329_ _1326_ _1327_ VSS VSS VDD VDD _1328_ sky130_fd_sc_hd__nor2_1
X_2330_ net5 net65 VSS VSS VDD VDD _1135_ sky130_fd_sc_hd__nand2_1
X_2331_ _1135_ VSS VSS VDD VDD _0240_ sky130_fd_sc_hd__inv_1
X_2332_ net6 net65 VSS VSS VDD VDD _1136_ sky130_fd_sc_hd__nand2_1
X_2333_ _1136_ VSS VSS VDD VDD _0238_ sky130_fd_sc_hd__inv_1
X_2334_ net7 net65 VSS VSS VDD VDD _1137_ sky130_fd_sc_hd__nand2_1
X_2335_ _1137_ VSS VSS VDD VDD _0025_ sky130_fd_sc_hd__inv_1
X_2336_ net8 net65 VSS VSS VDD VDD _1138_ sky130_fd_sc_hd__nand2_1
X_2337_ _1138_ VSS VSS VDD VDD _0236_ sky130_fd_sc_hd__inv_1
X_2338_ net33 net64 VSS VSS VDD VDD _1139_ sky130_fd_sc_hd__nand2_1
X_2339_ _1139_ VSS VSS VDD VDD _0247_ sky130_fd_sc_hd__inv_1
X_2340_ net1 _1223_ VSS VSS VDD VDD _1224_ sky130_fd_sc_hd__nor2_4
X_2341_ _1322_ _1325_ _1328_ VSS VSS VDD VDD _1329_ sky130_fd_sc_hd__nand3_1
X_2342_ net3 net64 VSS VSS VDD VDD _1140_ sky130_fd_sc_hd__nand2_1
X_2343_ _1140_ VSS VSS VDD VDD _0245_ sky130_fd_sc_hd__inv_1
X_2344_ net4 net64 VSS VSS VDD VDD _1141_ sky130_fd_sc_hd__nand2_1
X_2345_ _1141_ VSS VSS VDD VDD _0243_ sky130_fd_sc_hd__inv_1
X_2346_ net5 net64 VSS VSS VDD VDD _1142_ sky130_fd_sc_hd__nand2_1
X_2347_ _1142_ VSS VSS VDD VDD _0241_ sky130_fd_sc_hd__inv_1
X_2348_ net6 net64 VSS VSS VDD VDD _1143_ sky130_fd_sc_hd__nand2_1
X_2349_ _1143_ VSS VSS VDD VDD _0239_ sky130_fd_sc_hd__inv_1
X_2350_ net7 net64 VSS VSS VDD VDD _1144_ sky130_fd_sc_hd__nand2_1
X_2351_ _1144_ VSS VSS VDD VDD _0237_ sky130_fd_sc_hd__inv_1
X_2352_ _0349_ _0338_ _0348_ VSS VSS VDD VDD _1330_ sky130_fd_sc_hd__a21o_1
X_2353_ net8 net64 VSS VSS VDD VDD _1145_ sky130_fd_sc_hd__nand2_1
X_2354_ _1145_ VSS VSS VDD VDD _0024_ sky130_fd_sc_hd__inv_1
X_2355_ net63 VSS VSS VDD VDD _1146_ sky130_fd_sc_hd__inv_1
X_2356_ net2 _1146_ VSS VSS VDD VDD _0152_ sky130_fd_sc_hd__nor2_1
Xoutput72 net72 VSS VSS VDD VDD rsp_data[11] sky130_fd_sc_hd__clkdlybuf4s50_1
X_2358_ net13 _1146_ VSS VSS VDD VDD _0149_ sky130_fd_sc_hd__nor2_1
Xoutput71 net71 VSS VSS VDD VDD rsp_data[10] sky130_fd_sc_hd__clkdlybuf4s50_1
X_2360_ net24 _1146_ VSS VSS VDD VDD _0108_ sky130_fd_sc_hd__nor2_1
Xoutput70 net70 VSS VSS VDD VDD rsp_data[0] sky130_fd_sc_hd__clkdlybuf4s50_1
X_2362_ net27 _1146_ VSS VSS VDD VDD _0111_ sky130_fd_sc_hd__nor2_1
X_2363_ _0251_ _0234_ VSS VSS VDD VDD _1331_ sky130_fd_sc_hd__nand2_1
Xoutput69 net69 VSS VSS VDD VDD req_ready sky130_fd_sc_hd__clkdlybuf4s50_1
X_2365_ net28 _1146_ VSS VSS VDD VDD _0124_ sky130_fd_sc_hd__nor2_1
Xinput68 rst_n VSS VSS VDD VDD net68 sky130_fd_sc_hd__clkdlybuf4s50_1
X_2367_ net29 _1146_ VSS VSS VDD VDD _0118_ sky130_fd_sc_hd__nor2_1
Xinput67 rsp_ready VSS VSS VDD VDD net67 sky130_fd_sc_hd__clkdlybuf4s50_1
X_2369_ net30 _1146_ VSS VSS VDD VDD _0178_ sky130_fd_sc_hd__nor2_1
Xinput66 req_valid VSS VSS VDD VDD net66 sky130_fd_sc_hd__clkdlybuf4s50_1
X_2371_ net31 _1146_ VSS VSS VDD VDD _0206_ sky130_fd_sc_hd__nor2_1
Xinput65 req_b[9] VSS VSS VDD VDD net65 sky130_fd_sc_hd__clkdlybuf4s50_1
X_2373_ net2 net62 VSS VSS VDD VDD _1155_ sky130_fd_sc_hd__nand2_1
X_2374_ _0250_ VSS VSS VDD VDD _1332_ sky130_fd_sc_hd__inv_1
X_2375_ _1155_ VSS VSS VDD VDD _0321_ sky130_fd_sc_hd__inv_1
X_2376_ net13 net62 VSS VSS VDD VDD _1156_ sky130_fd_sc_hd__nand2_1
X_2377_ _1156_ VSS VSS VDD VDD _0151_ sky130_fd_sc_hd__inv_1
X_2378_ net24 net62 VSS VSS VDD VDD _1157_ sky130_fd_sc_hd__nand2_1
X_2379_ _1157_ VSS VSS VDD VDD _0148_ sky130_fd_sc_hd__inv_1
X_2380_ net27 net62 VSS VSS VDD VDD _1158_ sky130_fd_sc_hd__nand2_1
X_2381_ _1158_ VSS VSS VDD VDD _0107_ sky130_fd_sc_hd__inv_1
X_2382_ net28 net62 VSS VSS VDD VDD _1159_ sky130_fd_sc_hd__nand2_1
X_2383_ _1159_ VSS VSS VDD VDD _0110_ sky130_fd_sc_hd__inv_1
X_2384_ net29 net62 VSS VSS VDD VDD _1160_ sky130_fd_sc_hd__nand2_1
X_2385_ _1331_ _1332_ _1327_ VSS VSS VDD VDD _1333_ sky130_fd_sc_hd__a21oi_1
X_2386_ _1160_ VSS VSS VDD VDD _0123_ sky130_fd_sc_hd__inv_1
X_2387_ net30 net62 VSS VSS VDD VDD _1161_ sky130_fd_sc_hd__nand2_1
X_2388_ _1161_ VSS VSS VDD VDD _0117_ sky130_fd_sc_hd__inv_1
X_2389_ net31 net62 VSS VSS VDD VDD _1162_ sky130_fd_sc_hd__nand2_1
X_2390_ _1162_ VSS VSS VDD VDD _0177_ sky130_fd_sc_hd__inv_1
Xinput64 req_b[8] VSS VSS VDD VDD net64 sky130_fd_sc_hd__clkdlybuf4s50_1
X_2392_ net2 net61 VSS VSS VDD VDD _1164_ sky130_fd_sc_hd__nand2_1
X_2393_ _1164_ VSS VSS VDD VDD _0309_ sky130_fd_sc_hd__inv_1
X_2394_ net13 net61 VSS VSS VDD VDD _1165_ sky130_fd_sc_hd__nand2_1
X_2395_ _1165_ VSS VSS VDD VDD _0320_ sky130_fd_sc_hd__inv_1
X_2396_ _1330_ _1333_ VSS VSS VDD VDD _1334_ sky130_fd_sc_hd__nor2_1
X_2397_ net24 net61 VSS VSS VDD VDD _1166_ sky130_fd_sc_hd__nand2_1
X_2398_ _1166_ VSS VSS VDD VDD _0150_ sky130_fd_sc_hd__inv_1
X_2399_ net27 net61 VSS VSS VDD VDD _1167_ sky130_fd_sc_hd__nand2_1
X_2400_ _1167_ VSS VSS VDD VDD _0147_ sky130_fd_sc_hd__inv_1
X_2401_ net28 net61 VSS VSS VDD VDD _1168_ sky130_fd_sc_hd__nand2_1
X_2402_ _1168_ VSS VSS VDD VDD _0106_ sky130_fd_sc_hd__inv_1
X_2403_ net29 net61 VSS VSS VDD VDD _1169_ sky130_fd_sc_hd__nand2_1
X_2404_ _1169_ VSS VSS VDD VDD _0109_ sky130_fd_sc_hd__inv_1
X_2405_ net30 net61 VSS VSS VDD VDD _1170_ sky130_fd_sc_hd__nand2_1
X_2406_ _1170_ VSS VSS VDD VDD _0122_ sky130_fd_sc_hd__inv_1
X_2407_ _0366_ _0370_ VSS VSS VDD VDD _1335_ sky130_fd_sc_hd__nand2_1
X_2408_ net31 net61 VSS VSS VDD VDD _1171_ sky130_fd_sc_hd__nand2_1
X_2409_ _1171_ VSS VSS VDD VDD _0116_ sky130_fd_sc_hd__inv_1
Xinput63 req_b[7] VSS VSS VDD VDD net63 sky130_fd_sc_hd__clkdlybuf4s50_1
X_2411_ net2 net60 VSS VSS VDD VDD _1173_ sky130_fd_sc_hd__nand2_1
X_2412_ _1173_ VSS VSS VDD VDD _0198_ sky130_fd_sc_hd__inv_1
X_2413_ net13 net60 VSS VSS VDD VDD _1174_ sky130_fd_sc_hd__nand2_1
X_2414_ _1174_ VSS VSS VDD VDD _0195_ sky130_fd_sc_hd__inv_1
X_2415_ net24 net60 VSS VSS VDD VDD _1175_ sky130_fd_sc_hd__nand2_1
X_2416_ _1175_ VSS VSS VDD VDD _0192_ sky130_fd_sc_hd__inv_1
X_2417_ net27 net60 VSS VSS VDD VDD _1176_ sky130_fd_sc_hd__nand2_1
X_2418_ _0365_ VSS VSS VDD VDD _1336_ sky130_fd_sc_hd__inv_1
X_2419_ _1176_ VSS VSS VDD VDD _0189_ sky130_fd_sc_hd__inv_1
X_2420_ net28 net60 VSS VSS VDD VDD _1177_ sky130_fd_sc_hd__nand2_1
X_2421_ _1177_ VSS VSS VDD VDD _0186_ sky130_fd_sc_hd__inv_1
X_2422_ net29 net60 VSS VSS VDD VDD _1178_ sky130_fd_sc_hd__nand2_1
X_2423_ _1178_ VSS VSS VDD VDD _0183_ sky130_fd_sc_hd__inv_1
X_2424_ net30 net60 VSS VSS VDD VDD _1179_ sky130_fd_sc_hd__nand2_1
X_2425_ _1179_ VSS VSS VDD VDD _0181_ sky130_fd_sc_hd__inv_1
X_2426_ net31 net60 VSS VSS VDD VDD _1180_ sky130_fd_sc_hd__nand2_1
X_2427_ _1180_ VSS VSS VDD VDD _0028_ sky130_fd_sc_hd__inv_1
Xinput62 req_b[6] VSS VSS VDD VDD net62 sky130_fd_sc_hd__clkdlybuf4s50_1
X_2429_ _1335_ _1336_ VSS VSS VDD VDD _1337_ sky130_fd_sc_hd__nand2_1
X_2430_ net2 net59 VSS VSS VDD VDD _1182_ sky130_fd_sc_hd__nand2_1
X_2431_ _1182_ VSS VSS VDD VDD _0357_ sky130_fd_sc_hd__inv_1
X_2432_ net13 net59 VSS VSS VDD VDD _1183_ sky130_fd_sc_hd__nand2_1
X_2433_ _1183_ VSS VSS VDD VDD _0197_ sky130_fd_sc_hd__inv_1
X_2434_ net24 net59 VSS VSS VDD VDD _1184_ sky130_fd_sc_hd__nand2_1
X_2435_ _1184_ VSS VSS VDD VDD _0194_ sky130_fd_sc_hd__inv_1
X_2436_ net27 net59 VSS VSS VDD VDD _1185_ sky130_fd_sc_hd__nand2_1
X_2437_ _1185_ VSS VSS VDD VDD _0191_ sky130_fd_sc_hd__inv_1
X_2438_ net28 net59 VSS VSS VDD VDD _1186_ sky130_fd_sc_hd__nand2_1
X_2439_ _1186_ VSS VSS VDD VDD _0188_ sky130_fd_sc_hd__inv_1
X_2440_ _1323_ VSS VSS VDD VDD _1338_ sky130_fd_sc_hd__inv_1
X_2441_ net29 net59 VSS VSS VDD VDD _1187_ sky130_fd_sc_hd__nand2_1
X_2442_ _1187_ VSS VSS VDD VDD _0185_ sky130_fd_sc_hd__inv_1
X_2443_ net30 net59 VSS VSS VDD VDD _1188_ sky130_fd_sc_hd__nand2_1
X_2444_ _1188_ VSS VSS VDD VDD _0182_ sky130_fd_sc_hd__inv_1
X_2445_ net31 net59 VSS VSS VDD VDD _1189_ sky130_fd_sc_hd__nand2_1
X_2446_ _1189_ VSS VSS VDD VDD _0027_ sky130_fd_sc_hd__inv_1
Xinput61 req_b[5] VSS VSS VDD VDD net61 sky130_fd_sc_hd__clkdlybuf4s50_1
X_2448_ net2 net56 VSS VSS VDD VDD _1191_ sky130_fd_sc_hd__nand2_1
X_2449_ _1191_ VSS VSS VDD VDD _0296_ sky130_fd_sc_hd__inv_1
X_2450_ net13 net56 VSS VSS VDD VDD _1192_ sky130_fd_sc_hd__nand2_1
Xinput60 req_b[4] VSS VSS VDD VDD net60 sky130_fd_sc_hd__clkdlybuf4s50_1
X_2452_ _1337_ _1338_ VSS VSS VDD VDD _1339_ sky130_fd_sc_hd__nand2_1
X_2453_ _1192_ VSS VSS VDD VDD _0356_ sky130_fd_sc_hd__inv_1
X_2454_ net24 net56 VSS VSS VDD VDD _1193_ sky130_fd_sc_hd__nand2_1
X_2455_ _1193_ VSS VSS VDD VDD _0196_ sky130_fd_sc_hd__inv_1
X_2456_ net27 net56 VSS VSS VDD VDD _1194_ sky130_fd_sc_hd__nand2_1
X_2457_ _1194_ VSS VSS VDD VDD _0193_ sky130_fd_sc_hd__inv_1
X_2458_ net28 net56 VSS VSS VDD VDD _1195_ sky130_fd_sc_hd__nand2_1
X_2459_ _1195_ VSS VSS VDD VDD _0190_ sky130_fd_sc_hd__inv_1
X_2460_ net29 net56 VSS VSS VDD VDD _1196_ sky130_fd_sc_hd__nand2_1
X_2461_ _1196_ VSS VSS VDD VDD _0187_ sky130_fd_sc_hd__inv_1
X_2462_ net30 net56 VSS VSS VDD VDD _1197_ sky130_fd_sc_hd__nand2_1
X_2463_ _0266_ _0268_ _0265_ VSS VSS VDD VDD _1340_ sky130_fd_sc_hd__a21oi_1
X_2464_ _1197_ VSS VSS VDD VDD _0184_ sky130_fd_sc_hd__inv_1
X_2465_ net31 net56 VSS VSS VDD VDD _1198_ sky130_fd_sc_hd__nand2_1
X_2466_ _1198_ VSS VSS VDD VDD _0026_ sky130_fd_sc_hd__inv_1
Xinput59 req_b[3] VSS VSS VDD VDD net59 sky130_fd_sc_hd__clkdlybuf4s50_1
X_2468_ net2 net45 VSS VSS VDD VDD _1200_ sky130_fd_sc_hd__nand2_1
X_2469_ _1200_ VSS VSS VDD VDD _0389_ sky130_fd_sc_hd__inv_1
X_2470_ net13 net45 VSS VSS VDD VDD _1201_ sky130_fd_sc_hd__nand2_1
X_2471_ _1201_ VSS VSS VDD VDD _0387_ sky130_fd_sc_hd__inv_1
X_2472_ net24 net45 VSS VSS VDD VDD _1202_ sky130_fd_sc_hd__nand2_1
X_2473_ _1202_ VSS VSS VDD VDD _0385_ sky130_fd_sc_hd__inv_1
X_2474_ _1339_ _1340_ VSS VSS VDD VDD _1341_ sky130_fd_sc_hd__nand2_1
X_2475_ net27 net45 VSS VSS VDD VDD _1203_ sky130_fd_sc_hd__nand2_1
X_2476_ _1203_ VSS VSS VDD VDD _0383_ sky130_fd_sc_hd__inv_1
X_2477_ net28 net45 VSS VSS VDD VDD _1204_ sky130_fd_sc_hd__nand2_1
X_2478_ _1204_ VSS VSS VDD VDD _0381_ sky130_fd_sc_hd__inv_1
X_2479_ net29 net45 VSS VSS VDD VDD _1205_ sky130_fd_sc_hd__nand2_1
X_2480_ _1205_ VSS VSS VDD VDD _0379_ sky130_fd_sc_hd__inv_1
X_2481_ net30 net45 VSS VSS VDD VDD _1206_ sky130_fd_sc_hd__nand2_1
X_2482_ _1206_ VSS VSS VDD VDD _0209_ sky130_fd_sc_hd__inv_1
X_2483_ net31 net45 VSS VSS VDD VDD _1207_ sky130_fd_sc_hd__nand2_1
X_2484_ _1207_ VSS VSS VDD VDD _0362_ sky130_fd_sc_hd__inv_1
X_2485_ _1341_ _1328_ VSS VSS VDD VDD _1342_ sky130_fd_sc_hd__nand2_1
X_2486_ net13 net34 VSS VSS VDD VDD _1208_ sky130_fd_sc_hd__nand2_1
X_2487_ _1208_ VSS VSS VDD VDD _0388_ sky130_fd_sc_hd__inv_1
X_2488_ net24 net34 VSS VSS VDD VDD _1209_ sky130_fd_sc_hd__nand2_1
X_2489_ _1209_ VSS VSS VDD VDD _0386_ sky130_fd_sc_hd__inv_1
X_2490_ net27 net34 VSS VSS VDD VDD _1210_ sky130_fd_sc_hd__nand2_1
X_2491_ _1210_ VSS VSS VDD VDD _0384_ sky130_fd_sc_hd__inv_1
X_2492_ net28 net34 VSS VSS VDD VDD _1211_ sky130_fd_sc_hd__nand2_1
X_2493_ _1211_ VSS VSS VDD VDD _0382_ sky130_fd_sc_hd__inv_1
X_2494_ net29 net34 VSS VSS VDD VDD _1212_ sky130_fd_sc_hd__nand2_1
X_2495_ _1212_ VSS VSS VDD VDD _0380_ sky130_fd_sc_hd__inv_1
X_2496_ _1329_ _1334_ _1342_ VSS VSS VDD VDD _1343_ sky130_fd_sc_hd__nand3_1
X_2497_ net30 net34 VSS VSS VDD VDD _1213_ sky130_fd_sc_hd__nand2_1
X_2498_ _1213_ VSS VSS VDD VDD _0378_ sky130_fd_sc_hd__inv_1
X_2499_ net31 net34 VSS VSS VDD VDD _1214_ sky130_fd_sc_hd__nand2_1
X_2500_ _1214_ VSS VSS VDD VDD _0208_ sky130_fd_sc_hd__inv_1
X_2501_ _1343_ VSS VSS VDD VDD _1344_ sky130_fd_sc_hd__inv_1
X_2502_ _1314_ _1344_ VSS VSS VDD VDD _1345_ sky130_fd_sc_hd__nand2_1
X_2503_ _1311_ _1313_ _1343_ VSS VSS VDD VDD _1346_ sky130_fd_sc_hd__nand3_1
X_2504_ _1345_ net98 _1346_ VSS VSS VDD VDD _1347_ sky130_fd_sc_hd__nand3_1
X_2505_ net97 product\[63\] VSS VSS VDD VDD _1348_ sky130_fd_sc_hd__nand2_1
X_2506_ phase\[2\] VSS VSS VDD VDD _1225_ sky130_fd_sc_hd__inv_1
X_2507_ _1347_ _1348_ VSS VSS VDD VDD _0514_ sky130_fd_sc_hd__nand2_1
X_2508_ _0226_ VSS VSS VDD VDD _1349_ sky130_fd_sc_hd__inv_1
X_2509_ _0001_ VSS VSS VDD VDD _1350_ sky130_fd_sc_hd__inv_1
X_2510_ _1349_ _1350_ VSS VSS VDD VDD _1351_ sky130_fd_sc_hd__nand2_1
X_2511_ _0226_ _0001_ VSS VSS VDD VDD _1352_ sky130_fd_sc_hd__nand2_1
X_2512_ _1351_ _1352_ VSS VSS VDD VDD _1353_ sky130_fd_sc_hd__nand2_1
X_2513_ _1353_ _0033_ VSS VSS VDD VDD _1354_ sky130_fd_sc_hd__nand2_1
X_2514_ _0033_ VSS VSS VDD VDD _1355_ sky130_fd_sc_hd__inv_1
X_2515_ _1351_ _1355_ _1352_ VSS VSS VDD VDD _1356_ sky130_fd_sc_hd__nand3_1
X_2516_ _1354_ _1356_ VSS VSS VDD VDD _1357_ sky130_fd_sc_hd__nand2_1
X_2517_ net1 _1225_ VSS VSS VDD VDD _0429_ sky130_fd_sc_hd__nor2_1
X_2518_ _0005_ _0000_ VSS VSS VDD VDD _1358_ sky130_fd_sc_hd__xor2_1
X_2519_ _1358_ VSS VSS VDD VDD _1359_ sky130_fd_sc_hd__inv_1
X_2520_ _1357_ _1359_ VSS VSS VDD VDD _1360_ sky130_fd_sc_hd__nand2_1
X_2521_ _1354_ _1358_ _1356_ VSS VSS VDD VDD _1361_ sky130_fd_sc_hd__nand3_1
X_2522_ _1360_ _1361_ VSS VSS VDD VDD _1362_ sky130_fd_sc_hd__nand2_1
X_2523_ _0202_ VSS VSS VDD VDD _1363_ sky130_fd_sc_hd__inv_1
X_2524_ _0034_ VSS VSS VDD VDD _1364_ sky130_fd_sc_hd__inv_1
X_2525_ _1363_ _1364_ VSS VSS VDD VDD _1365_ sky130_fd_sc_hd__nand2_1
X_2526_ _0202_ _0034_ VSS VSS VDD VDD _1366_ sky130_fd_sc_hd__nand2_1
X_2527_ _1365_ _1366_ VSS VSS VDD VDD _1367_ sky130_fd_sc_hd__nand2_1
X_2528_ _0051_ VSS VSS VDD VDD _1226_ sky130_fd_sc_hd__inv_1
X_2529_ _1367_ _0222_ VSS VSS VDD VDD _1368_ sky130_fd_sc_hd__nand2_1
X_2530_ _0222_ _1365_ _1366_ VSS VSS VDD VDD _1369_ sky130_fd_sc_hd__nand3b_1
X_2531_ _1368_ _1369_ VSS VSS VDD VDD _1370_ sky130_fd_sc_hd__nand2_1
X_2532_ _1362_ _1370_ VSS VSS VDD VDD _1371_ sky130_fd_sc_hd__nand2_1
X_2533_ _1370_ VSS VSS VDD VDD _1372_ sky130_fd_sc_hd__inv_1
X_2534_ _1360_ _1361_ _1372_ VSS VSS VDD VDD _1373_ sky130_fd_sc_hd__nand3_1
X_2535_ _1371_ _1373_ VSS VSS VDD VDD _1374_ sky130_fd_sc_hd__nand2_1
X_2536_ _0375_ _0315_ _0156_ VSS VSS VDD VDD _1375_ sky130_fd_sc_hd__nand3_1
X_2537_ _0374_ VSS VSS VDD VDD _1376_ sky130_fd_sc_hd__inv_1
X_2538_ _0375_ _0364_ VSS VSS VDD VDD _1377_ sky130_fd_sc_hd__nand2_1
X_2539_ _0056_ VSS VSS VDD VDD _1227_ sky130_fd_sc_hd__inv_1
X_2540_ _1375_ _1376_ _1377_ VSS VSS VDD VDD _1378_ sky130_fd_sc_hd__nand3_1
X_2541_ _0253_ _0407_ VSS VSS VDD VDD _1379_ sky130_fd_sc_hd__nand2_1
X_2542_ _0293_ _0405_ VSS VSS VDD VDD _1380_ sky130_fd_sc_hd__nand2_1
X_2543_ _1379_ _1380_ VSS VSS VDD VDD _1381_ sky130_fd_sc_hd__nor2_1
X_2544_ _0308_ _0425_ VSS VSS VDD VDD _1382_ sky130_fd_sc_hd__nand2_1
X_2545_ _0319_ _0368_ VSS VSS VDD VDD _1383_ sky130_fd_sc_hd__nand2_1
X_2546_ _1382_ _1383_ VSS VSS VDD VDD _1384_ sky130_fd_sc_hd__nor2_1
X_2547_ _1378_ _1381_ _1384_ VSS VSS VDD VDD _1385_ sky130_fd_sc_hd__nand3_1
X_2548_ _0292_ _0405_ VSS VSS VDD VDD _1386_ sky130_fd_sc_hd__nand2_1
X_2549_ _0404_ VSS VSS VDD VDD _1387_ sky130_fd_sc_hd__inv_1
X_2550_ _1226_ _1227_ VSS VSS VDD VDD _1228_ sky130_fd_sc_hd__nand2_1
X_2551_ _1386_ _1387_ VSS VSS VDD VDD _1388_ sky130_fd_sc_hd__nand2_1
X_2552_ _1379_ VSS VSS VDD VDD _1389_ sky130_fd_sc_hd__inv_1
X_2553_ _1388_ _1389_ VSS VSS VDD VDD _1390_ sky130_fd_sc_hd__nand2_1
X_2554_ _0252_ _0407_ _0406_ VSS VSS VDD VDD _1391_ sky130_fd_sc_hd__a21oi_1
X_2555_ _1390_ _1391_ VSS VSS VDD VDD _1392_ sky130_fd_sc_hd__nand2_1
X_2556_ _1392_ _1384_ VSS VSS VDD VDD _1393_ sky130_fd_sc_hd__nand2_1
X_2557_ _0318_ _0368_ _0367_ VSS VSS VDD VDD _1394_ sky130_fd_sc_hd__a21o_1
X_2558_ _0307_ _0425_ VSS VSS VDD VDD _1395_ sky130_fd_sc_hd__nand2_1
X_2559_ _0424_ VSS VSS VDD VDD _1396_ sky130_fd_sc_hd__inv_1
X_2560_ _1395_ _1396_ _1383_ VSS VSS VDD VDD _1397_ sky130_fd_sc_hd__a21oi_1
X_2561_ _0051_ _0056_ VSS VSS VDD VDD _1229_ sky130_fd_sc_hd__nand2_1
X_2562_ _1394_ _1397_ VSS VSS VDD VDD _1398_ sky130_fd_sc_hd__nor2_1
X_2563_ _1385_ _1393_ _1398_ VSS VSS VDD VDD _1399_ sky130_fd_sc_hd__nand3_1
X_2564_ _1399_ VSS VSS VDD VDD _1400_ sky130_fd_sc_hd__inv_1
X_2565_ _1374_ _1400_ VSS VSS VDD VDD _1401_ sky130_fd_sc_hd__nand2_1
X_2566_ _1371_ _1399_ _1373_ VSS VSS VDD VDD _1402_ sky130_fd_sc_hd__nand3_1
X_2567_ _1401_ _1402_ net98 VSS VSS VDD VDD _1403_ sky130_fd_sc_hd__nand3_1
X_2568_ net97 product\[47\] VSS VSS VDD VDD _1404_ sky130_fd_sc_hd__nand2_1
X_2569_ _1403_ _1404_ VSS VSS VDD VDD _0513_ sky130_fd_sc_hd__nand2_1
X_2570_ _0120_ VSS VSS VDD VDD _1405_ sky130_fd_sc_hd__inv_1
X_2571_ _0128_ VSS VSS VDD VDD _1406_ sky130_fd_sc_hd__inv_1
X_2572_ net1 _1215_ _1216_ VSS VSS VDD VDD net69 sky130_fd_sc_hd__nor3_1
X_2573_ _1228_ _1229_ VSS VSS VDD VDD _1230_ sky130_fd_sc_hd__nand2_1
X_2574_ _1405_ _1406_ VSS VSS VDD VDD _1407_ sky130_fd_sc_hd__nand2_1
X_2575_ _0120_ _0128_ VSS VSS VDD VDD _1408_ sky130_fd_sc_hd__nand2_1
X_2576_ _1407_ _1408_ VSS VSS VDD VDD _1409_ sky130_fd_sc_hd__nand2_1
X_2577_ _0104_ VSS VSS VDD VDD _1410_ sky130_fd_sc_hd__inv_1
X_2578_ _1409_ _1410_ VSS VSS VDD VDD _1411_ sky130_fd_sc_hd__nand2_1
X_2579_ _1407_ _0104_ _1408_ VSS VSS VDD VDD _1412_ sky130_fd_sc_hd__nand3_1
X_2580_ _1411_ _1412_ VSS VSS VDD VDD _1413_ sky130_fd_sc_hd__nand2_1
X_2581_ _0113_ _0112_ VSS VSS VDD VDD _1414_ sky130_fd_sc_hd__xnor2_1
X_2582_ _1414_ VSS VSS VDD VDD _1415_ sky130_fd_sc_hd__inv_1
X_2583_ _1413_ _1415_ VSS VSS VDD VDD _1416_ sky130_fd_sc_hd__nand2_1
X_2584_ _0046_ VSS VSS VDD VDD _1231_ sky130_fd_sc_hd__inv_1
X_2585_ _1411_ _1412_ _1414_ VSS VSS VDD VDD _1417_ sky130_fd_sc_hd__nand3_1
X_2586_ _1416_ _1417_ VSS VSS VDD VDD _1418_ sky130_fd_sc_hd__nand2_1
X_2587_ _0121_ VSS VSS VDD VDD _1419_ sky130_fd_sc_hd__inv_1
X_2588_ _0119_ VSS VSS VDD VDD _1420_ sky130_fd_sc_hd__inv_1
X_2589_ _1419_ _1420_ VSS VSS VDD VDD _1421_ sky130_fd_sc_hd__nand2_1
X_2590_ _0121_ _0119_ VSS VSS VDD VDD _1422_ sky130_fd_sc_hd__nand2_1
X_2591_ _1421_ _1422_ VSS VSS VDD VDD _1423_ sky130_fd_sc_hd__nand2_1
X_2592_ _1423_ _0103_ VSS VSS VDD VDD _1424_ sky130_fd_sc_hd__nand2_1
X_2593_ _0103_ _1421_ _1422_ VSS VSS VDD VDD _1425_ sky130_fd_sc_hd__nand3b_1
X_2594_ _1424_ _1425_ VSS VSS VDD VDD _1426_ sky130_fd_sc_hd__nand2_1
X_2595_ _1230_ _1231_ VSS VSS VDD VDD _1232_ sky130_fd_sc_hd__nand2_1
X_2596_ _1418_ _1426_ VSS VSS VDD VDD _1427_ sky130_fd_sc_hd__nand2_1
X_2597_ _1426_ VSS VSS VDD VDD _1428_ sky130_fd_sc_hd__inv_1
X_2598_ _1416_ _1428_ _1417_ VSS VSS VDD VDD _1429_ sky130_fd_sc_hd__nand3_1
X_2599_ _1427_ _1429_ VSS VSS VDD VDD _1430_ sky130_fd_sc_hd__nand2_1
X_2600_ _0337_ _0298_ VSS VSS VDD VDD _1431_ sky130_fd_sc_hd__nand2_1
X_2601_ _1431_ VSS VSS VDD VDD _1432_ sky130_fd_sc_hd__inv_1
X_2602_ _1432_ _0100_ VSS VSS VDD VDD _1433_ sky130_fd_sc_hd__nand2_1
X_2603_ _0337_ _0299_ VSS VSS VDD VDD _1434_ sky130_fd_sc_hd__nand2_1
X_2604_ _0336_ VSS VSS VDD VDD _1435_ sky130_fd_sc_hd__inv_1
X_2605_ _1434_ _1435_ VSS VSS VDD VDD _1436_ sky130_fd_sc_hd__nand2_1
X_2606_ _1228_ _0046_ _1229_ VSS VSS VDD VDD _1233_ sky130_fd_sc_hd__nand3_1
X_2607_ _1436_ VSS VSS VDD VDD _1437_ sky130_fd_sc_hd__inv_1
X_2608_ _1433_ _1437_ VSS VSS VDD VDD _1438_ sky130_fd_sc_hd__nand2_1
X_2609_ _0313_ _0427_ VSS VSS VDD VDD _1439_ sky130_fd_sc_hd__nand2_1
X_2610_ _0345_ _0341_ VSS VSS VDD VDD _1440_ sky130_fd_sc_hd__nand2_1
X_2611_ _1439_ _1440_ VSS VSS VDD VDD _1441_ sky130_fd_sc_hd__nor2_1
X_2612_ _0416_ _0402_ VSS VSS VDD VDD _1442_ sky130_fd_sc_hd__nand2_1
X_2613_ _0412_ _0373_ VSS VSS VDD VDD _1443_ sky130_fd_sc_hd__nand2_1
X_2614_ _1442_ _1443_ VSS VSS VDD VDD _1444_ sky130_fd_sc_hd__nor2_1
X_2615_ _1438_ _1441_ _1444_ VSS VSS VDD VDD _1445_ sky130_fd_sc_hd__nand3_1
X_2616_ _0412_ _0372_ _0411_ VSS VSS VDD VDD _1446_ sky130_fd_sc_hd__a21o_1
X_2617_ _1232_ _1233_ VSS VSS VDD VDD _1234_ sky130_fd_sc_hd__nand2_1
X_2618_ _0416_ _0401_ VSS VSS VDD VDD _1447_ sky130_fd_sc_hd__nand2_1
X_2619_ _0415_ VSS VSS VDD VDD _1448_ sky130_fd_sc_hd__inv_1
X_2620_ _1447_ _1448_ _1443_ VSS VSS VDD VDD _1449_ sky130_fd_sc_hd__a21oi_1
X_2621_ _1446_ _1449_ VSS VSS VDD VDD _1450_ sky130_fd_sc_hd__nor2_1
X_2622_ _0345_ _0340_ VSS VSS VDD VDD _1451_ sky130_fd_sc_hd__nand2_1
X_2623_ _0344_ VSS VSS VDD VDD _1452_ sky130_fd_sc_hd__inv_1
X_2624_ _1451_ _1452_ VSS VSS VDD VDD _1453_ sky130_fd_sc_hd__nand2_1
X_2625_ _1439_ VSS VSS VDD VDD _1454_ sky130_fd_sc_hd__inv_1
X_2626_ _1453_ _1454_ VSS VSS VDD VDD _1455_ sky130_fd_sc_hd__nand2_1
X_2627_ _0313_ _0426_ _0312_ VSS VSS VDD VDD _1456_ sky130_fd_sc_hd__a21oi_1
X_2628_ _0049_ _0048_ VSS VSS VDD VDD _1235_ sky130_fd_sc_hd__xnor2_1
X_2629_ _1455_ _1456_ VSS VSS VDD VDD _1457_ sky130_fd_sc_hd__nand2_1
X_2630_ _1457_ _1444_ VSS VSS VDD VDD _1458_ sky130_fd_sc_hd__nand2_1
X_2631_ _1445_ _1450_ _1458_ VSS VSS VDD VDD _1459_ sky130_fd_sc_hd__nand3_1
X_2632_ _1459_ VSS VSS VDD VDD _1460_ sky130_fd_sc_hd__inv_1
X_2633_ _1430_ _1460_ VSS VSS VDD VDD _1461_ sky130_fd_sc_hd__nand2_1
X_2634_ _1427_ _1429_ _1459_ VSS VSS VDD VDD _1462_ sky130_fd_sc_hd__nand3_1
X_2635_ _1461_ net98 _1462_ VSS VSS VDD VDD _1463_ sky130_fd_sc_hd__nand3_1
X_2636_ net97 product\[31\] VSS VSS VDD VDD _1464_ sky130_fd_sc_hd__nand2_1
X_2637_ _1463_ _1464_ VSS VSS VDD VDD _0512_ sky130_fd_sc_hd__nand2_1
X_2638_ _1215_ _1218_ VSS VSS VDD VDD net89 sky130_fd_sc_hd__nor2_1
X_2639_ _1235_ VSS VSS VDD VDD _1236_ sky130_fd_sc_hd__inv_1
Xinput58 req_b[31] VSS VSS VDD VDD net58 sky130_fd_sc_hd__clkdlybuf4s50_1
Xinput57 req_b[30] VSS VSS VDD VDD net57 sky130_fd_sc_hd__clkdlybuf4s50_1
Xinput56 req_b[2] VSS VSS VDD VDD net56 sky130_fd_sc_hd__clkdlybuf4s50_1
Xinput55 req_b[29] VSS VSS VDD VDD net55 sky130_fd_sc_hd__clkdlybuf4s50_1
X_2644_ net98 net18 net50 product\[0\] net97 VSS VSS VDD VDD
+ _0511_ sky130_fd_sc_hd__a32o_1
Xinput54 req_b[28] VSS VSS VDD VDD net54 sky130_fd_sc_hd__clkdlybuf4s50_1
X_2646_ net98 _0291_ net97 product\[1\] VSS VSS VDD VDD _0510_
+ sky130_fd_sc_hd__a22o_1
Xinput53 req_b[27] VSS VSS VDD VDD net53 sky130_fd_sc_hd__clkdlybuf4s50_1
X_2648_ net98 _0264_ net97 product\[2\] VSS VSS VDD VDD _0509_
+ sky130_fd_sc_hd__a22o_1
X_2649_ net98 _0047_ net97 product\[3\] VSS VSS VDD VDD _0508_
+ sky130_fd_sc_hd__a22o_1
X_2650_ _1234_ _1236_ VSS VSS VDD VDD _1237_ sky130_fd_sc_hd__nand2_1
X_2651_ net98 _0417_ net97 product\[4\] VSS VSS VDD VDD _0507_
+ sky130_fd_sc_hd__a22o_1
X_2652_ net98 _0041_ net97 product\[5\] VSS VSS VDD VDD _0506_
+ sky130_fd_sc_hd__a22o_1
X_2653_ net98 VSS VSS VDD VDD _1471_ sky130_fd_sc_hd__inv_2
Xinput52 req_b[26] VSS VSS VDD VDD net52 sky130_fd_sc_hd__clkdlybuf4s50_1
X_2655_ _0040_ _0410_ VSS VSS VDD VDD _1473_ sky130_fd_sc_hd__xnor2_1
Xinput51 req_b[25] VSS VSS VDD VDD net51 sky130_fd_sc_hd__clkdlybuf4s50_1
X_2657_ net97 product\[6\] VSS VSS VDD VDD _1475_ sky130_fd_sc_hd__nand2_1
X_2658_ _1471_ _1473_ _1475_ VSS VSS VDD VDD _0505_ sky130_fd_sc_hd__o21ai_0
X_2659_ _1259_ _0359_ _1471_ VSS VSS VDD VDD _1476_ sky130_fd_sc_hd__a21oi_1
X_2660_ _0359_ _1259_ _1476_ VSS VSS VDD VDD _1477_ sky130_fd_sc_hd__o21ai_0
X_2661_ _1232_ _1233_ _1235_ VSS VSS VDD VDD _1238_ sky130_fd_sc_hd__nand3_1
X_2662_ net97 product\[7\] VSS VSS VDD VDD _1478_ sky130_fd_sc_hd__nand2_1
X_2663_ _1477_ _1478_ VSS VSS VDD VDD _0504_ sky130_fd_sc_hd__nand2_1
X_2664_ _0409_ _0359_ _0358_ VSS VSS VDD VDD _1479_ sky130_fd_sc_hd__a21oi_1
X_2665_ _0040_ _0410_ _0359_ VSS VSS VDD VDD _1480_ sky130_fd_sc_hd__nand3_1
X_2666_ _1479_ _1480_ VSS VSS VDD VDD _1481_ sky130_fd_sc_hd__nand2_1
X_2667_ _1481_ _0400_ _1471_ VSS VSS VDD VDD _1482_ sky130_fd_sc_hd__a21oi_1
X_2668_ _0400_ _1481_ _1482_ VSS VSS VDD VDD _1483_ sky130_fd_sc_hd__o21ai_0
X_2669_ net97 product\[8\] VSS VSS VDD VDD _1484_ sky130_fd_sc_hd__nand2_1
X_2670_ _1483_ _1484_ VSS VSS VDD VDD _0503_ sky130_fd_sc_hd__nand2_1
X_2671_ _1261_ VSS VSS VDD VDD _1485_ sky130_fd_sc_hd__inv_1
X_2672_ _1237_ _1238_ VSS VSS VDD VDD _1239_ sky130_fd_sc_hd__nand2_1
X_2673_ _1259_ _1485_ VSS VSS VDD VDD _1486_ sky130_fd_sc_hd__nand2_1
X_2674_ _1274_ VSS VSS VDD VDD _1487_ sky130_fd_sc_hd__inv_1
X_2675_ _1486_ _1487_ VSS VSS VDD VDD _1488_ sky130_fd_sc_hd__nand2_1
X_2676_ _1488_ _0305_ _1471_ VSS VSS VDD VDD _1489_ sky130_fd_sc_hd__a21oi_1
X_2677_ _0305_ _1488_ _1489_ VSS VSS VDD VDD _1490_ sky130_fd_sc_hd__o21ai_0
X_2678_ net97 product\[9\] VSS VSS VDD VDD _1491_ sky130_fd_sc_hd__nand2_1
X_2679_ _1490_ _1491_ VSS VSS VDD VDD _0502_ sky130_fd_sc_hd__nand2_1
X_2680_ _0410_ _0359_ VSS VSS VDD VDD _1492_ sky130_fd_sc_hd__nand2_1
X_2681_ _0305_ _0400_ VSS VSS VDD VDD _1493_ sky130_fd_sc_hd__nand2_1
X_2682_ _1492_ _1493_ VSS VSS VDD VDD _1494_ sky130_fd_sc_hd__nor2_1
X_2683_ net1 VSS VSS VDD VDD _1217_ sky130_fd_sc_hd__inv_2
X_2684_ _0052_ VSS VSS VDD VDD _1240_ sky130_fd_sc_hd__inv_1
X_2685_ _0305_ _0399_ _0304_ VSS VSS VDD VDD _1495_ sky130_fd_sc_hd__a21oi_1
X_2686_ _1493_ _1479_ _1495_ VSS VSS VDD VDD _1496_ sky130_fd_sc_hd__o21ai_0
X_2687_ _0040_ _1494_ _1496_ VSS VSS VDD VDD _1497_ sky130_fd_sc_hd__a21o_1
X_2688_ _0343_ _1497_ VSS VSS VDD VDD _1498_ sky130_fd_sc_hd__nor2_1
X_2689_ _1497_ _0343_ VSS VSS VDD VDD _1499_ sky130_fd_sc_hd__nand2_1
Xinput50 req_b[24] VSS VSS VDD VDD net50 sky130_fd_sc_hd__clkdlybuf4s50_1
X_2691_ _1499_ net98 VSS VSS VDD VDD _1501_ sky130_fd_sc_hd__nand2_1
X_2692_ net97 product\[10\] VSS VSS VDD VDD _1502_ sky130_fd_sc_hd__nand2_1
X_2693_ _1498_ _1501_ _1502_ VSS VSS VDD VDD _0501_ sky130_fd_sc_hd__o21ai_0
X_2694_ _1259_ _1262_ VSS VSS VDD VDD _1503_ sky130_fd_sc_hd__nand2_1
X_2695_ _0050_ VSS VSS VDD VDD _1241_ sky130_fd_sc_hd__inv_1
X_2696_ _1503_ _1277_ _1276_ VSS VSS VDD VDD _1504_ sky130_fd_sc_hd__nand3_1
X_2697_ _1504_ _0347_ _1471_ VSS VSS VDD VDD _1505_ sky130_fd_sc_hd__a21oi_1
X_2698_ _0347_ _1504_ _1505_ VSS VSS VDD VDD _1506_ sky130_fd_sc_hd__o21ai_0
X_2699_ net97 product\[11\] VSS VSS VDD VDD _1507_ sky130_fd_sc_hd__nand2_1
X_2700_ _1506_ _1507_ VSS VSS VDD VDD _0500_ sky130_fd_sc_hd__nand2_1
X_2701_ _0347_ _0342_ _0346_ VSS VSS VDD VDD _1508_ sky130_fd_sc_hd__a21o_1
X_2702_ _0343_ _0347_ VSS VSS VDD VDD _1509_ sky130_fd_sc_hd__nand2_1
X_2703_ _1509_ _1495_ VSS VSS VDD VDD _1510_ sky130_fd_sc_hd__nor2_1
X_2704_ _1508_ _1510_ VSS VSS VDD VDD _1511_ sky130_fd_sc_hd__nor2_1
X_2705_ _1493_ _1509_ VSS VSS VDD VDD _1512_ sky130_fd_sc_hd__nor2_1
X_2706_ _1240_ _1241_ VSS VSS VDD VDD _1242_ sky130_fd_sc_hd__nand2_1
X_2707_ _1481_ _1512_ VSS VSS VDD VDD _1513_ sky130_fd_sc_hd__nand2_1
X_2708_ _1511_ _1513_ _0301_ VSS VSS VDD VDD _1514_ sky130_fd_sc_hd__a21boi_0
X_2709_ _1511_ _1513_ VSS VSS VDD VDD _1515_ sky130_fd_sc_hd__nand2_1
Xinput49 req_b[23] VSS VSS VDD VDD net49 sky130_fd_sc_hd__clkdlybuf4s50_1
X_2711_ _0301_ _1515_ net98 VSS VSS VDD VDD _1517_ sky130_fd_sc_hd__o21ai_0
X_2712_ net97 product\[12\] VSS VSS VDD VDD _1518_ sky130_fd_sc_hd__nand2_1
X_2713_ _1514_ _1517_ _1518_ VSS VSS VDD VDD _0499_ sky130_fd_sc_hd__o21ai_0
X_2714_ _1261_ _1258_ _1487_ VSS VSS VDD VDD _0516_ sky130_fd_sc_hd__o21ai_0
X_2715_ _1263_ _1260_ VSS VSS VDD VDD _0517_ sky130_fd_sc_hd__nor2_1
X_2716_ _0516_ _0517_ VSS VSS VDD VDD _0518_ sky130_fd_sc_hd__nand2_1
X_2717_ _0052_ _0050_ VSS VSS VDD VDD _1243_ sky130_fd_sc_hd__nand2_1
X_2718_ _1268_ _1269_ VSS VSS VDD VDD _0519_ sky130_fd_sc_hd__nand2_1
X_2719_ _1263_ _1277_ VSS VSS VDD VDD _0520_ sky130_fd_sc_hd__nor2_1
X_2720_ _0519_ _0520_ VSS VSS VDD VDD _0521_ sky130_fd_sc_hd__nor2_1
X_2721_ _0517_ _0039_ _1253_ _1485_ VSS VSS VDD VDD _0522_
+ sky130_fd_sc_hd__nand4_1
X_2722_ _0518_ _0521_ _0522_ VSS VSS VDD VDD _0523_ sky130_fd_sc_hd__nand3_1
X_2723_ _0377_ _0523_ VSS VSS VDD VDD _0524_ sky130_fd_sc_hd__nor2_1
X_2724_ _0523_ _0377_ VSS VSS VDD VDD _0525_ sky130_fd_sc_hd__nand2_1
X_2725_ _0525_ net98 VSS VSS VDD VDD _0526_ sky130_fd_sc_hd__nand2_1
Xinput48 req_b[22] VSS VSS VDD VDD net48 sky130_fd_sc_hd__clkdlybuf4s50_1
X_2727_ net97 product\[13\] VSS VSS VDD VDD _0528_ sky130_fd_sc_hd__nand2_1
X_2728_ _1242_ _1243_ VSS VSS VDD VDD _1244_ sky130_fd_sc_hd__nand2_1
X_2729_ _0524_ _0526_ _0528_ VSS VSS VDD VDD _0498_ sky130_fd_sc_hd__o21ai_0
X_2730_ _0301_ _0377_ VSS VSS VDD VDD _0529_ sky130_fd_sc_hd__nand2_1
X_2731_ _1509_ _0529_ VSS VSS VDD VDD _0530_ sky130_fd_sc_hd__nor2_1
X_2732_ _1496_ _0530_ VSS VSS VDD VDD _0531_ sky130_fd_sc_hd__nand2_1
X_2733_ _0529_ VSS VSS VDD VDD _0532_ sky130_fd_sc_hd__inv_1
X_2734_ _0300_ _0377_ _0376_ VSS VSS VDD VDD _0533_ sky130_fd_sc_hd__a21oi_1
X_2735_ _1508_ _0532_ _0533_ VSS VSS VDD VDD _0534_ sky130_fd_sc_hd__a21boi_0
X_2736_ _1494_ _0530_ _0040_ VSS VSS VDD VDD _0535_ sky130_fd_sc_hd__nand3_1
X_2737_ _0531_ _0534_ _0535_ VSS VSS VDD VDD _0536_ sky130_fd_sc_hd__nand3_1
X_2738_ _0361_ _0536_ VSS VSS VDD VDD _0537_ sky130_fd_sc_hd__nor2_1
X_2739_ _1244_ _0045_ VSS VSS VDD VDD _1245_ sky130_fd_sc_hd__nand2_1
X_2740_ _0536_ _0361_ VSS VSS VDD VDD _0538_ sky130_fd_sc_hd__nand2_1
X_2741_ _0538_ net98 VSS VSS VDD VDD _0539_ sky130_fd_sc_hd__nand2_1
X_2742_ net97 product\[14\] VSS VSS VDD VDD _0540_ sky130_fd_sc_hd__nand2_1
X_2743_ _0537_ _0539_ _0540_ VSS VSS VDD VDD _0497_ sky130_fd_sc_hd__o21ai_0
Xinput47 req_b[21] VSS VSS VDD VDD net47 sky130_fd_sc_hd__clkdlybuf4s50_1
Xinput46 req_b[20] VSS VSS VDD VDD net46 sky130_fd_sc_hd__clkdlybuf4s50_1
X_2746_ net70 net99 _1220_ _0428_ VSS VSS VDD VDD _0496_ sky130_fd_sc_hd__a22o_1
X_2747_ net80 net99 _1220_ _0227_ VSS VSS VDD VDD _0495_ sky130_fd_sc_hd__a22o_1
X_2748_ net81 net99 _1220_ _0032_ VSS VSS VDD VDD _0494_ sky130_fd_sc_hd__a22o_1
X_2749_ _0031_ _0398_ VSS VSS VDD VDD _0543_ sky130_fd_sc_hd__nor2_1
X_2750_ _0045_ _1242_ _1243_ VSS VSS VDD VDD _1246_ sky130_fd_sc_hd__nand3b_1
X_2751_ _0031_ _0398_ VSS VSS VDD VDD _0544_ sky130_fd_sc_hd__nand2_1
X_2752_ _1220_ _0544_ VSS VSS VDD VDD _0545_ sky130_fd_sc_hd__nand2_1
Xinput45 req_b[1] VSS VSS VDD VDD net45 sky130_fd_sc_hd__clkdlybuf4s50_1
X_2754_ net99 net82 VSS VSS VDD VDD _0547_ sky130_fd_sc_hd__nand2_1
X_2755_ _0543_ _0545_ _0547_ VSS VSS VDD VDD _0493_ sky130_fd_sc_hd__o21ai_1
X_2756_ _0398_ _0254_ _0030_ VSS VSS VDD VDD _0548_ sky130_fd_sc_hd__nand3_1
X_2757_ _0397_ VSS VSS VDD VDD _0549_ sky130_fd_sc_hd__inv_1
X_2758_ _0398_ _0408_ VSS VSS VDD VDD _0550_ sky130_fd_sc_hd__nand2_1
X_2759_ _0548_ _0549_ _0550_ VSS VSS VDD VDD _0551_ sky130_fd_sc_hd__nand3_1
X_2760_ _0392_ _0551_ VSS VSS VDD VDD _0552_ sky130_fd_sc_hd__xnor2_1
X_2761_ _1245_ _1246_ VSS VSS VDD VDD _1247_ sky130_fd_sc_hd__nand2_1
X_2762_ net99 net83 VSS VSS VDD VDD _0553_ sky130_fd_sc_hd__nand2_1
X_2763_ _1221_ _0552_ _0553_ VSS VSS VDD VDD _0492_ sky130_fd_sc_hd__o21ai_1
X_2764_ _0392_ _0397_ _0391_ VSS VSS VDD VDD _0554_ sky130_fd_sc_hd__a21oi_1
X_2765_ _0031_ _0398_ _0392_ VSS VSS VDD VDD _0555_ sky130_fd_sc_hd__nand3_1
X_2766_ _0554_ _0555_ VSS VSS VDD VDD _0556_ sky130_fd_sc_hd__nand2_1
X_2767_ _0275_ _0556_ VSS VSS VDD VDD _0557_ sky130_fd_sc_hd__xnor2_1
X_2768_ net99 net84 VSS VSS VDD VDD _0558_ sky130_fd_sc_hd__nand2_1
X_2769_ _1221_ _0557_ _0558_ VSS VSS VDD VDD _0491_ sky130_fd_sc_hd__o21ai_1
X_2770_ _0398_ _0254_ VSS VSS VDD VDD _0559_ sky130_fd_sc_hd__nand2_1
X_2771_ _0392_ _0275_ VSS VSS VDD VDD _0560_ sky130_fd_sc_hd__nand2_1
X_2772_ _1239_ _1247_ VSS VSS VDD VDD _1248_ sky130_fd_sc_hd__nand2_1
X_2773_ _0559_ _0560_ VSS VSS VDD VDD _0561_ sky130_fd_sc_hd__nor2_2
X_2774_ _0561_ _0030_ VSS VSS VDD VDD _0562_ sky130_fd_sc_hd__nand2_1
X_2775_ _0275_ _0391_ _0274_ VSS VSS VDD VDD _0563_ sky130_fd_sc_hd__a21oi_2
X_2776_ _0550_ _0549_ VSS VSS VDD VDD _0564_ sky130_fd_sc_hd__nand2_1
X_2777_ _0560_ VSS VSS VDD VDD _0565_ sky130_fd_sc_hd__inv_1
X_2778_ _0564_ _0565_ VSS VSS VDD VDD _0566_ sky130_fd_sc_hd__nand2_1
X_2779_ _0562_ _0563_ _0566_ VSS VSS VDD VDD _0567_ sky130_fd_sc_hd__nand3_2
X_2780_ _0295_ _0567_ VSS VSS VDD VDD _0568_ sky130_fd_sc_hd__xnor2_1
X_2781_ net99 net85 VSS VSS VDD VDD _0569_ sky130_fd_sc_hd__nand2_1
X_2782_ _1221_ _0568_ _0569_ VSS VSS VDD VDD _0490_ sky130_fd_sc_hd__o21ai_1
X_2783_ _1247_ VSS VSS VDD VDD _1249_ sky130_fd_sc_hd__inv_1
X_2784_ _0295_ _0275_ VSS VSS VDD VDD _0570_ sky130_fd_sc_hd__nand2_1
X_2785_ _0570_ VSS VSS VDD VDD _0571_ sky130_fd_sc_hd__inv_1
X_2786_ _0556_ _0571_ VSS VSS VDD VDD _0572_ sky130_fd_sc_hd__nand2_1
X_2787_ _0274_ _0295_ _0294_ VSS VSS VDD VDD _0573_ sky130_fd_sc_hd__a21oi_1
X_2788_ _0572_ _0573_ VSS VSS VDD VDD _0574_ sky130_fd_sc_hd__nand2_1
X_2789_ _0351_ _0574_ VSS VSS VDD VDD _0575_ sky130_fd_sc_hd__xnor2_1
X_2790_ net99 net86 VSS VSS VDD VDD _0576_ sky130_fd_sc_hd__nand2_1
X_2791_ _1221_ _0575_ _0576_ VSS VSS VDD VDD _0489_ sky130_fd_sc_hd__o21ai_1
X_2792_ _0351_ _0294_ VSS VSS VDD VDD _0577_ sky130_fd_sc_hd__nand2_1
X_2793_ _0350_ VSS VSS VDD VDD _0578_ sky130_fd_sc_hd__inv_1
X_2794_ _1217_ phase\[3\] VSS VSS VDD VDD _1218_ sky130_fd_sc_hd__nand2_1
X_2795_ _1237_ _1249_ _1238_ VSS VSS VDD VDD _1250_ sky130_fd_sc_hd__nand3_1
X_2796_ _0577_ _0578_ VSS VSS VDD VDD _0579_ sky130_fd_sc_hd__nand2_1
X_2797_ _0351_ _0295_ VSS VSS VDD VDD _0580_ sky130_fd_sc_hd__nand2_1
X_2798_ _0580_ _0563_ VSS VSS VDD VDD _0581_ sky130_fd_sc_hd__nor2_1
X_2799_ _0579_ _0581_ VSS VSS VDD VDD _0582_ sky130_fd_sc_hd__nor2_1
X_2800_ _0560_ _0580_ VSS VSS VDD VDD _0583_ sky130_fd_sc_hd__nor2_1
X_2801_ _0551_ _0583_ VSS VSS VDD VDD _0584_ sky130_fd_sc_hd__nand2_1
X_2802_ _0582_ _0584_ VSS VSS VDD VDD _0585_ sky130_fd_sc_hd__nand2_2
X_2803_ _0353_ _0585_ VSS VSS VDD VDD _0586_ sky130_fd_sc_hd__nor2_1
X_2804_ _0585_ _0353_ VSS VSS VDD VDD _0587_ sky130_fd_sc_hd__nand2_1
X_2805_ _0587_ _1220_ VSS VSS VDD VDD _0588_ sky130_fd_sc_hd__nand2_1
X_2806_ _1248_ _1250_ VSS VSS VDD VDD _1251_ sky130_fd_sc_hd__nand2_1
X_2807_ net99 net87 VSS VSS VDD VDD _0589_ sky130_fd_sc_hd__nand2_1
X_2808_ _0586_ _0588_ _0589_ VSS VSS VDD VDD _0488_ sky130_fd_sc_hd__o21ai_0
X_2809_ _0351_ _0353_ VSS VSS VDD VDD _0590_ sky130_fd_sc_hd__nand2_1
X_2810_ _0570_ _0590_ VSS VSS VDD VDD _0591_ sky130_fd_sc_hd__nor2_1
X_2811_ _0556_ _0591_ VSS VSS VDD VDD _0592_ sky130_fd_sc_hd__nand2_1
X_2812_ _0353_ _0350_ _0352_ VSS VSS VDD VDD _0593_ sky130_fd_sc_hd__a21oi_1
X_2813_ _0573_ VSS VSS VDD VDD _0594_ sky130_fd_sc_hd__inv_1
X_2814_ _0590_ VSS VSS VDD VDD _0595_ sky130_fd_sc_hd__inv_1
X_2815_ _0594_ _0595_ VSS VSS VDD VDD _0596_ sky130_fd_sc_hd__nand2_1
X_2816_ _0592_ _0593_ _0596_ VSS VSS VDD VDD _0597_ sky130_fd_sc_hd__nand3_1
X_2817_ _0410_ _0260_ VSS VSS VDD VDD _1252_ sky130_fd_sc_hd__nand2_1
X_2818_ _0396_ _0597_ VSS VSS VDD VDD _0598_ sky130_fd_sc_hd__xnor2_1
X_2819_ net99 net88 VSS VSS VDD VDD _0599_ sky130_fd_sc_hd__nand2_1
X_2820_ _1221_ _0598_ _0599_ VSS VSS VDD VDD _0487_ sky130_fd_sc_hd__o21ai_1
X_2821_ _0353_ _0396_ VSS VSS VDD VDD _0600_ sky130_fd_sc_hd__nand2_1
X_2822_ _0600_ VSS VSS VDD VDD _0601_ sky130_fd_sc_hd__inv_1
X_2823_ _0585_ _0601_ VSS VSS VDD VDD _0602_ sky130_fd_sc_hd__nand2_1
X_2824_ _0352_ _0396_ VSS VSS VDD VDD _0603_ sky130_fd_sc_hd__nand2_1
X_2825_ _0395_ VSS VSS VDD VDD _0604_ sky130_fd_sc_hd__inv_1
X_2826_ _0603_ _0604_ VSS VSS VDD VDD _0605_ sky130_fd_sc_hd__nand2_1
X_2827_ _0605_ VSS VSS VDD VDD _0606_ sky130_fd_sc_hd__inv_1
X_2828_ _1252_ VSS VSS VDD VDD _1253_ sky130_fd_sc_hd__inv_1
X_2829_ _0602_ _0606_ VSS VSS VDD VDD _0607_ sky130_fd_sc_hd__nand2_1
X_2830_ _0607_ _0233_ VSS VSS VDD VDD _0608_ sky130_fd_sc_hd__nand2_1
X_2831_ _0233_ _0602_ _0606_ VSS VSS VDD VDD _0609_ sky130_fd_sc_hd__nand3b_1
X_2832_ _0608_ _0609_ _1220_ VSS VSS VDD VDD _0610_ sky130_fd_sc_hd__nand3_1
X_2833_ net99 net71 VSS VSS VDD VDD _0611_ sky130_fd_sc_hd__nand2_1
X_2834_ _0610_ _0611_ VSS VSS VDD VDD _0486_ sky130_fd_sc_hd__nand2_1
X_2835_ _0233_ _0396_ VSS VSS VDD VDD _0612_ sky130_fd_sc_hd__nand2_1
X_2836_ _0612_ VSS VSS VDD VDD _0613_ sky130_fd_sc_hd__inv_1
X_2837_ _0597_ _0613_ VSS VSS VDD VDD _0614_ sky130_fd_sc_hd__nand2_1
X_2838_ _0233_ _0395_ _0232_ VSS VSS VDD VDD _0615_ sky130_fd_sc_hd__a21oi_1
X_2839_ _1253_ _0039_ VSS VSS VDD VDD _1254_ sky130_fd_sc_hd__nand2_1
X_2840_ _0614_ _0615_ VSS VSS VDD VDD _0616_ sky130_fd_sc_hd__nand2_1
X_2841_ _0616_ _0229_ VSS VSS VDD VDD _0617_ sky130_fd_sc_hd__nand2_1
X_2842_ _0229_ _0614_ _0615_ VSS VSS VDD VDD _0618_ sky130_fd_sc_hd__nand3b_1
X_2843_ _0617_ _0618_ _1220_ VSS VSS VDD VDD _0619_ sky130_fd_sc_hd__nand3_1
X_2844_ net99 net72 VSS VSS VDD VDD _0620_ sky130_fd_sc_hd__nand2_1
X_2845_ _0619_ _0620_ VSS VSS VDD VDD _0485_ sky130_fd_sc_hd__nand2_1
X_2846_ _0233_ _0229_ VSS VSS VDD VDD _0621_ sky130_fd_sc_hd__nand2_1
X_2847_ _0600_ _0621_ VSS VSS VDD VDD _0622_ sky130_fd_sc_hd__nor2_1
X_2848_ _0579_ _0581_ _0622_ VSS VSS VDD VDD _0623_ sky130_fd_sc_hd__o21ai_0
X_2849_ _0551_ _0583_ _0622_ VSS VSS VDD VDD _0624_ sky130_fd_sc_hd__nand3_1
X_2850_ _0410_ _0403_ VSS VSS VDD VDD _1255_ sky130_fd_sc_hd__nand2_1
X_2851_ _0621_ VSS VSS VDD VDD _0625_ sky130_fd_sc_hd__inv_1
X_2852_ _0229_ _0232_ VSS VSS VDD VDD _0626_ sky130_fd_sc_hd__nand2_1
X_2853_ _0228_ VSS VSS VDD VDD _0627_ sky130_fd_sc_hd__inv_1
X_2854_ _0626_ _0627_ VSS VSS VDD VDD _0628_ sky130_fd_sc_hd__nand2_1
X_2855_ _0605_ _0625_ _0628_ VSS VSS VDD VDD _0629_ sky130_fd_sc_hd__a21oi_1
X_2856_ _0623_ _0624_ _0629_ VSS VSS VDD VDD _0630_ sky130_fd_sc_hd__nand3_1
X_2857_ _0355_ _0630_ VSS VSS VDD VDD _0631_ sky130_fd_sc_hd__nor2_1
X_2858_ _0630_ _0355_ VSS VSS VDD VDD _0632_ sky130_fd_sc_hd__nand2_1
X_2859_ _0632_ _1220_ VSS VSS VDD VDD _0633_ sky130_fd_sc_hd__nand2_1
X_2860_ net99 net73 VSS VSS VDD VDD _0634_ sky130_fd_sc_hd__nand2_1
X_2861_ _0409_ VSS VSS VDD VDD _1256_ sky130_fd_sc_hd__inv_1
X_2862_ _0631_ _0633_ _0634_ VSS VSS VDD VDD _0484_ sky130_fd_sc_hd__o21ai_1
X_2863_ _0596_ _0593_ VSS VSS VDD VDD _0635_ sky130_fd_sc_hd__nand2_1
X_2864_ _0229_ _0355_ VSS VSS VDD VDD _0636_ sky130_fd_sc_hd__nand2_1
X_2865_ _0612_ _0636_ VSS VSS VDD VDD _0637_ sky130_fd_sc_hd__nor2_1
X_2866_ _0635_ _0637_ VSS VSS VDD VDD _0638_ sky130_fd_sc_hd__nand2_1
X_2867_ _0556_ _0591_ _0637_ VSS VSS VDD VDD _0639_ sky130_fd_sc_hd__nand3_1
X_2868_ _0355_ _0228_ _0354_ VSS VSS VDD VDD _0640_ sky130_fd_sc_hd__a21oi_1
X_2869_ _0636_ _0615_ _0640_ VSS VSS VDD VDD _0641_ sky130_fd_sc_hd__o21ai_0
X_2870_ _0641_ VSS VSS VDD VDD _0642_ sky130_fd_sc_hd__inv_1
X_2871_ _0638_ _0639_ _0642_ VSS VSS VDD VDD _0643_ sky130_fd_sc_hd__nand3_1
X_2872_ _1255_ _1256_ VSS VSS VDD VDD _1257_ sky130_fd_sc_hd__nand2_1
X_2873_ _0394_ _0643_ VSS VSS VDD VDD _0644_ sky130_fd_sc_hd__nor2_1
X_2874_ _0643_ _0394_ VSS VSS VDD VDD _0645_ sky130_fd_sc_hd__nand2_1
X_2875_ _0645_ _1220_ VSS VSS VDD VDD _0646_ sky130_fd_sc_hd__nand2_1
X_2876_ net99 net74 VSS VSS VDD VDD _0647_ sky130_fd_sc_hd__nand2_1
X_2877_ _0644_ _0646_ _0647_ VSS VSS VDD VDD _0483_ sky130_fd_sc_hd__o21ai_1
X_2878_ _0394_ _0355_ VSS VSS VDD VDD _0648_ sky130_fd_sc_hd__nand2_1
X_2879_ _0648_ VSS VSS VDD VDD _0649_ sky130_fd_sc_hd__inv_1
X_2880_ _0628_ _0649_ VSS VSS VDD VDD _0650_ sky130_fd_sc_hd__nand2_1
X_2881_ _0394_ _0354_ _0393_ VSS VSS VDD VDD _0651_ sky130_fd_sc_hd__a21oi_1
X_2882_ _0650_ _0651_ VSS VSS VDD VDD _0652_ sky130_fd_sc_hd__nand2_1
X_2883_ _1257_ VSS VSS VDD VDD _1258_ sky130_fd_sc_hd__inv_1
X_2884_ _0621_ _0648_ VSS VSS VDD VDD _0653_ sky130_fd_sc_hd__nor2_2
X_2885_ _0653_ VSS VSS VDD VDD _0654_ sky130_fd_sc_hd__inv_1
X_2886_ _0579_ _0601_ _0605_ VSS VSS VDD VDD _0655_ sky130_fd_sc_hd__a21oi_1
X_2887_ _0654_ _0655_ VSS VSS VDD VDD _0656_ sky130_fd_sc_hd__nor2_1
X_2888_ _0652_ _0656_ VSS VSS VDD VDD _0657_ sky130_fd_sc_hd__nor2_1
X_2889_ _0580_ _0600_ VSS VSS VDD VDD _0658_ sky130_fd_sc_hd__nor2_2
X_2890_ _0567_ _0658_ _0653_ VSS VSS VDD VDD _0659_ sky130_fd_sc_hd__nand3_1
X_2891_ _0423_ VSS VSS VDD VDD _0660_ sky130_fd_sc_hd__inv_1
X_2892_ _0657_ _0659_ _0660_ VSS VSS VDD VDD _0661_ sky130_fd_sc_hd__a21oi_1
X_2893_ _0657_ _0659_ _0660_ VSS VSS VDD VDD _0662_ sky130_fd_sc_hd__nand3_1
X_2894_ _1254_ _1258_ VSS VSS VDD VDD _1259_ sky130_fd_sc_hd__nand2_1
X_2895_ _0662_ _1220_ VSS VSS VDD VDD _0663_ sky130_fd_sc_hd__nand2_1
X_2896_ net99 net75 VSS VSS VDD VDD _0664_ sky130_fd_sc_hd__nand2_1
X_2897_ _0661_ _0663_ _0664_ VSS VSS VDD VDD _0482_ sky130_fd_sc_hd__o21ai_1
X_2898_ _0612_ _0593_ _0615_ VSS VSS VDD VDD _0665_ sky130_fd_sc_hd__o21ai_0
X_2899_ _0394_ _0423_ VSS VSS VDD VDD _0666_ sky130_fd_sc_hd__nand2_1
X_2900_ _0636_ _0666_ VSS VSS VDD VDD _0667_ sky130_fd_sc_hd__nor2_1
X_2901_ _0423_ _0393_ _0422_ VSS VSS VDD VDD _0668_ sky130_fd_sc_hd__a21oi_1
X_2902_ _0666_ _0640_ _0668_ VSS VSS VDD VDD _0669_ sky130_fd_sc_hd__o21ai_0
X_2903_ _0665_ _0667_ _0669_ VSS VSS VDD VDD _0670_ sky130_fd_sc_hd__a21oi_1
X_2904_ _0590_ _0612_ VSS VSS VDD VDD _0671_ sky130_fd_sc_hd__nor2_1
X_2905_ net1 phase\[1\] VSS VSS VDD VDD _1219_ sky130_fd_sc_hd__nor2_1
X_2906_ _0305_ _0343_ VSS VSS VDD VDD _1260_ sky130_fd_sc_hd__nand2_1
X_2907_ _0574_ _0671_ _0667_ VSS VSS VDD VDD _0672_ sky130_fd_sc_hd__nand3_1
X_2908_ _0670_ _0672_ VSS VSS VDD VDD _0673_ sky130_fd_sc_hd__nand2_1
X_2909_ _0673_ _0256_ VSS VSS VDD VDD _0674_ sky130_fd_sc_hd__nand2_1
X_2910_ _0256_ _0670_ _0672_ VSS VSS VDD VDD _0675_ sky130_fd_sc_hd__nand3b_1
X_2911_ _0674_ _0675_ _1220_ VSS VSS VDD VDD _0676_ sky130_fd_sc_hd__nand3_1
X_2912_ net99 net76 VSS VSS VDD VDD _0677_ sky130_fd_sc_hd__nand2_1
X_2913_ _0676_ _0677_ VSS VSS VDD VDD _0481_ sky130_fd_sc_hd__nand2_1
X_2914_ _0256_ _0423_ VSS VSS VDD VDD _0678_ sky130_fd_sc_hd__nand2_1
X_2915_ _0648_ _0678_ VSS VSS VDD VDD _0679_ sky130_fd_sc_hd__nor2_1
X_2916_ _0679_ VSS VSS VDD VDD _0680_ sky130_fd_sc_hd__inv_1
X_2917_ _0400_ _0359_ VSS VSS VDD VDD _1261_ sky130_fd_sc_hd__nand2_1
X_2918_ _0600_ _0621_ _0680_ VSS VSS VDD VDD _0681_ sky130_fd_sc_hd__nor3_1
X_2919_ _0585_ _0681_ VSS VSS VDD VDD _0682_ sky130_fd_sc_hd__nand2_1
X_2920_ _0256_ _0422_ VSS VSS VDD VDD _0683_ sky130_fd_sc_hd__nand2_1
X_2921_ _0255_ VSS VSS VDD VDD _0684_ sky130_fd_sc_hd__inv_1
X_2922_ _0683_ _0684_ VSS VSS VDD VDD _0685_ sky130_fd_sc_hd__nand2_1
X_2923_ _0678_ _0651_ _0685_ VSS VSS VDD VDD _0686_ sky130_fd_sc_hd__o21bai_1
X_2924_ _0680_ _0629_ VSS VSS VDD VDD _0687_ sky130_fd_sc_hd__nor2_1
X_2925_ _0686_ _0687_ VSS VSS VDD VDD _0688_ sky130_fd_sc_hd__nor2_1
X_2926_ _0682_ _0688_ VSS VSS VDD VDD _0689_ sky130_fd_sc_hd__nand2_1
X_2927_ _0689_ _0259_ VSS VSS VDD VDD _0690_ sky130_fd_sc_hd__nand2_1
X_2928_ _1260_ _1261_ VSS VSS VDD VDD _1262_ sky130_fd_sc_hd__nor2_1
X_2929_ _0259_ _0682_ _0688_ VSS VSS VDD VDD _0691_ sky130_fd_sc_hd__nand3b_1
X_2930_ _0690_ _0691_ _1220_ VSS VSS VDD VDD _0692_ sky130_fd_sc_hd__nand3_1
X_2931_ net99 net77 VSS VSS VDD VDD _0693_ sky130_fd_sc_hd__nand2_1
X_2932_ _0692_ _0693_ VSS VSS VDD VDD _0480_ sky130_fd_sc_hd__nand2_1
X_2933_ _0259_ _0256_ VSS VSS VDD VDD _0694_ sky130_fd_sc_hd__nand2_1
X_2934_ _0666_ _0694_ VSS VSS VDD VDD _0695_ sky130_fd_sc_hd__nor2_1
X_2935_ _0259_ _0255_ _0258_ VSS VSS VDD VDD _0696_ sky130_fd_sc_hd__a21oi_1
X_2936_ _0694_ _0668_ _0696_ VSS VSS VDD VDD _0697_ sky130_fd_sc_hd__o21ai_0
X_2937_ _0641_ _0695_ _0697_ VSS VSS VDD VDD _0698_ sky130_fd_sc_hd__a21oi_1
X_2938_ _0637_ _0695_ VSS VSS VDD VDD _0699_ sky130_fd_sc_hd__and2_1
X_2939_ _0301_ _0347_ VSS VSS VDD VDD _1263_ sky130_fd_sc_hd__nand2_1
X_2940_ _0597_ _0699_ VSS VSS VDD VDD _0700_ sky130_fd_sc_hd__nand2_1
X_2941_ _0698_ _0700_ VSS VSS VDD VDD _0701_ sky130_fd_sc_hd__nand2_1
X_2942_ _0701_ _0273_ VSS VSS VDD VDD _0702_ sky130_fd_sc_hd__nand2_1
X_2943_ _0273_ VSS VSS VDD VDD _0703_ sky130_fd_sc_hd__inv_1
X_2944_ _0698_ _0700_ _0703_ VSS VSS VDD VDD _0704_ sky130_fd_sc_hd__nand3_1
X_2945_ _0702_ _0704_ _1220_ VSS VSS VDD VDD _0705_ sky130_fd_sc_hd__nand3_1
X_2946_ net99 net78 VSS VSS VDD VDD _0706_ sky130_fd_sc_hd__nand2_1
X_2947_ _0705_ _0706_ VSS VSS VDD VDD _0479_ sky130_fd_sc_hd__nand2_1
X_2948_ _0566_ _0563_ VSS VSS VDD VDD _0707_ sky130_fd_sc_hd__nand2_1
X_2949_ _0707_ _0658_ VSS VSS VDD VDD _0708_ sky130_fd_sc_hd__nand2_1
X_2950_ _0361_ _0377_ VSS VSS VDD VDD _1264_ sky130_fd_sc_hd__nand2_1
X_2951_ _0708_ _0655_ VSS VSS VDD VDD _0709_ sky130_fd_sc_hd__nand2_1
X_2952_ _0273_ _0259_ VSS VSS VDD VDD _0710_ sky130_fd_sc_hd__nand2_1
X_2953_ _0678_ _0710_ VSS VSS VDD VDD _0711_ sky130_fd_sc_hd__nor2_1
X_2954_ _0653_ _0711_ VSS VSS VDD VDD _0712_ sky130_fd_sc_hd__nand2_1
X_2955_ _0712_ VSS VSS VDD VDD _0713_ sky130_fd_sc_hd__inv_1
X_2956_ _0709_ _0713_ VSS VSS VDD VDD _0714_ sky130_fd_sc_hd__nand2_1
X_2957_ _0710_ VSS VSS VDD VDD _0715_ sky130_fd_sc_hd__inv_1
X_2958_ _0685_ _0715_ VSS VSS VDD VDD _0716_ sky130_fd_sc_hd__nand2_1
X_2959_ _0273_ _0258_ _0272_ VSS VSS VDD VDD _0717_ sky130_fd_sc_hd__a21oi_1
X_2960_ _0716_ _0717_ VSS VSS VDD VDD _0718_ sky130_fd_sc_hd__nand2_1
X_2961_ _1263_ _1264_ VSS VSS VDD VDD _1265_ sky130_fd_sc_hd__nor2_1
X_2962_ _0652_ _0711_ _0718_ VSS VSS VDD VDD _0719_ sky130_fd_sc_hd__a21oi_1
X_2963_ _0561_ _0658_ VSS VSS VDD VDD _0720_ sky130_fd_sc_hd__nand2_1
X_2964_ _0720_ _0712_ VSS VSS VDD VDD _0721_ sky130_fd_sc_hd__nor2_1
X_2965_ _0721_ _0030_ VSS VSS VDD VDD _0722_ sky130_fd_sc_hd__nand2_1
X_2966_ _0714_ _0719_ _0722_ VSS VSS VDD VDD _0723_ sky130_fd_sc_hd__nand3_1
X_2967_ _0723_ _0273_ VSS VSS VDD VDD _0724_ sky130_fd_sc_hd__nand2_1
X_2968_ _0714_ _0719_ _0703_ _0722_ VSS VSS VDD VDD _0725_
+ sky130_fd_sc_hd__nand4_1
X_2969_ _0724_ _0725_ _1220_ VSS VSS VDD VDD _0726_ sky130_fd_sc_hd__nand3_1
X_2970_ net99 net79 VSS VSS VDD VDD _0727_ sky130_fd_sc_hd__nand2_1
X_2971_ _0726_ _0727_ VSS VSS VDD VDD _0478_ sky130_fd_sc_hd__nand2_1
X_2972_ _1259_ _1262_ _1265_ VSS VSS VDD VDD _1266_ sky130_fd_sc_hd__nand3_1
Xinput44 req_b[19] VSS VSS VDD VDD net44 sky130_fd_sc_hd__clkdlybuf4s50_1
Xinput43 req_b[18] VSS VSS VDD VDD net43 sky130_fd_sc_hd__clkdlybuf4s50_1
X_2975_ net98 net2 net34 product\[48\] _1286_ VSS VSS VDD
+ VDD _0477_ sky130_fd_sc_hd__a32o_1
Xinput42 req_b[17] VSS VSS VDD VDD net42 sky130_fd_sc_hd__clkdlybuf4s50_1
X_2977_ net98 _0390_ net97 product\[49\] VSS VSS VDD VDD _0476_
+ sky130_fd_sc_hd__a22o_1
X_2978_ net98 _0297_ net97 product\[50\] VSS VSS VDD VDD _0475_
+ sky130_fd_sc_hd__a22o_1
X_2979_ net98 _0037_ net97 product\[51\] VSS VSS VDD VDD _0474_
+ sky130_fd_sc_hd__a22o_1
X_2980_ net98 _0314_ net97 product\[52\] VSS VSS VDD VDD _0473_
+ sky130_fd_sc_hd__a22o_1
X_2981_ net98 _0044_ net97 product\[53\] VSS VSS VDD VDD _0472_
+ sky130_fd_sc_hd__a22o_1
X_2982_ _0421_ _0043_ VSS VSS VDD VDD _0731_ sky130_fd_sc_hd__xnor2_1
X_2983_ _0361_ _0376_ _0360_ VSS VSS VDD VDD _1267_ sky130_fd_sc_hd__a21o_1
X_2984_ net97 product\[54\] VSS VSS VDD VDD _0732_ sky130_fd_sc_hd__nand2_1
X_2985_ _1471_ _0731_ _0732_ VSS VSS VDD VDD _0471_ sky130_fd_sc_hd__o21ai_0
X_2986_ _1322_ _0371_ _1471_ VSS VSS VDD VDD _0733_ sky130_fd_sc_hd__a21oi_1
X_2987_ _0371_ _1322_ _0733_ VSS VSS VDD VDD _0734_ sky130_fd_sc_hd__o21ai_0
X_2988_ net97 product\[55\] VSS VSS VDD VDD _0735_ sky130_fd_sc_hd__nand2_1
X_2989_ _0734_ _0735_ VSS VSS VDD VDD _0470_ sky130_fd_sc_hd__nand2_1
X_2990_ _0371_ _0420_ _0370_ VSS VSS VDD VDD _0736_ sky130_fd_sc_hd__a21oi_1
X_2991_ _0421_ _0043_ _0371_ VSS VSS VDD VDD _0737_ sky130_fd_sc_hd__nand3_1
X_2992_ _0736_ _0737_ VSS VSS VDD VDD _0738_ sky130_fd_sc_hd__nand2_1
X_2993_ _0738_ _0366_ _1471_ VSS VSS VDD VDD _0739_ sky130_fd_sc_hd__a21oi_1
X_2994_ _0301_ _0346_ VSS VSS VDD VDD _1268_ sky130_fd_sc_hd__nand2_1
X_2995_ _0366_ _0738_ _0739_ VSS VSS VDD VDD _0740_ sky130_fd_sc_hd__o21ai_0
X_2996_ net97 product\[56\] VSS VSS VDD VDD _0741_ sky130_fd_sc_hd__nand2_1
X_2997_ _0740_ _0741_ VSS VSS VDD VDD _0469_ sky130_fd_sc_hd__nand2_1
X_2998_ _1324_ VSS VSS VDD VDD _0742_ sky130_fd_sc_hd__inv_1
X_2999_ _1322_ _0742_ VSS VSS VDD VDD _0743_ sky130_fd_sc_hd__nand2_1
X_3000_ _1337_ VSS VSS VDD VDD _0744_ sky130_fd_sc_hd__inv_1
X_3001_ _0743_ _0744_ VSS VSS VDD VDD _0745_ sky130_fd_sc_hd__nand2_1
X_3002_ _0745_ _0269_ _1471_ VSS VSS VDD VDD _0746_ sky130_fd_sc_hd__a21oi_1
X_3003_ _0269_ _0745_ _0746_ VSS VSS VDD VDD _0747_ sky130_fd_sc_hd__o21ai_0
X_3004_ net97 product\[57\] VSS VSS VDD VDD _0748_ sky130_fd_sc_hd__nand2_1
X_3005_ _0300_ VSS VSS VDD VDD _1269_ sky130_fd_sc_hd__inv_1
X_3006_ _0747_ _0748_ VSS VSS VDD VDD _0468_ sky130_fd_sc_hd__nand2_1
X_3007_ _0421_ _0371_ VSS VSS VDD VDD _0749_ sky130_fd_sc_hd__nand2_1
X_3008_ _0269_ _0366_ VSS VSS VDD VDD _0750_ sky130_fd_sc_hd__nand2_1
X_3009_ _0749_ _0750_ VSS VSS VDD VDD _0751_ sky130_fd_sc_hd__nor2_1
X_3010_ _0269_ _0365_ _0268_ VSS VSS VDD VDD _0752_ sky130_fd_sc_hd__a21oi_1
X_3011_ _0750_ _0736_ _0752_ VSS VSS VDD VDD _0753_ sky130_fd_sc_hd__o21ai_0
X_3012_ _0043_ _0751_ _0753_ VSS VSS VDD VDD _0754_ sky130_fd_sc_hd__a21o_1
X_3013_ _0266_ _0754_ VSS VSS VDD VDD _0755_ sky130_fd_sc_hd__nor2_1
X_3014_ _0754_ _0266_ VSS VSS VDD VDD _0756_ sky130_fd_sc_hd__nand2_1
X_3015_ _0756_ net98 VSS VSS VDD VDD _0757_ sky130_fd_sc_hd__nand2_1
X_3016_ net1 net99 VSS VSS VDD VDD _1220_ sky130_fd_sc_hd__nor2_2
X_3017_ _1268_ _1269_ _1264_ VSS VSS VDD VDD _1270_ sky130_fd_sc_hd__a21oi_1
X_3018_ net97 product\[58\] VSS VSS VDD VDD _0758_ sky130_fd_sc_hd__nand2_1
X_3019_ _0755_ _0757_ _0758_ VSS VSS VDD VDD _0467_ sky130_fd_sc_hd__o21ai_0
X_3020_ _1322_ _1325_ VSS VSS VDD VDD _0759_ sky130_fd_sc_hd__nand2_1
X_3021_ _0759_ _1340_ _1339_ VSS VSS VDD VDD _0760_ sky130_fd_sc_hd__nand3_1
X_3022_ _0760_ _0235_ _1471_ VSS VSS VDD VDD _0761_ sky130_fd_sc_hd__a21oi_1
X_3023_ _0235_ _0760_ _0761_ VSS VSS VDD VDD _0762_ sky130_fd_sc_hd__o21ai_0
X_3024_ net97 product\[59\] VSS VSS VDD VDD _0763_ sky130_fd_sc_hd__nand2_1
X_3025_ _0762_ _0763_ VSS VSS VDD VDD _0466_ sky130_fd_sc_hd__nand2_1
X_3026_ _0235_ _0265_ _0234_ VSS VSS VDD VDD _0764_ sky130_fd_sc_hd__a21o_1
X_3027_ _0235_ _0266_ VSS VSS VDD VDD _0765_ sky130_fd_sc_hd__nand2_1
X_3028_ _1267_ _1270_ VSS VSS VDD VDD _1271_ sky130_fd_sc_hd__nor2_1
X_3029_ _0765_ _0752_ VSS VSS VDD VDD _0766_ sky130_fd_sc_hd__nor2_1
X_3030_ _0764_ _0766_ VSS VSS VDD VDD _0767_ sky130_fd_sc_hd__nor2_1
X_3031_ _0750_ _0765_ VSS VSS VDD VDD _0768_ sky130_fd_sc_hd__nor2_1
X_3032_ _0738_ _0768_ VSS VSS VDD VDD _0769_ sky130_fd_sc_hd__nand2_1
X_3033_ _0767_ _0769_ _0251_ VSS VSS VDD VDD _0770_ sky130_fd_sc_hd__a21boi_0
X_3034_ _0767_ _0769_ VSS VSS VDD VDD _0771_ sky130_fd_sc_hd__nand2_1
X_3035_ _0251_ _0771_ net98 VSS VSS VDD VDD _0772_ sky130_fd_sc_hd__o21ai_0
X_3036_ net97 product\[60\] VSS VSS VDD VDD _0773_ sky130_fd_sc_hd__nand2_1
X_3037_ _0770_ _0772_ _0773_ VSS VSS VDD VDD _0465_ sky130_fd_sc_hd__o21ai_0
X_3038_ _1324_ _1321_ _0744_ VSS VSS VDD VDD _0774_ sky130_fd_sc_hd__o21ai_0
X_3039_ _0400_ _0358_ VSS VSS VDD VDD _1272_ sky130_fd_sc_hd__nand2_1
X_3040_ _1326_ _1323_ VSS VSS VDD VDD _0775_ sky130_fd_sc_hd__nor2_1
X_3041_ _0774_ _0775_ VSS VSS VDD VDD _0776_ sky130_fd_sc_hd__nand2_1
X_3042_ _1331_ _1332_ VSS VSS VDD VDD _0777_ sky130_fd_sc_hd__nand2_1
X_3043_ _1326_ _1340_ VSS VSS VDD VDD _0778_ sky130_fd_sc_hd__nor2_1
X_3044_ _0777_ _0778_ VSS VSS VDD VDD _0779_ sky130_fd_sc_hd__nor2_1
X_3045_ _0775_ _0042_ _1316_ _0742_ VSS VSS VDD VDD _0780_
+ sky130_fd_sc_hd__nand4_1
X_3046_ _0776_ _0779_ _0780_ VSS VSS VDD VDD _0781_ sky130_fd_sc_hd__nand3_1
X_3047_ _0339_ _0781_ VSS VSS VDD VDD _0782_ sky130_fd_sc_hd__nor2_1
X_3048_ _0781_ _0339_ VSS VSS VDD VDD _0783_ sky130_fd_sc_hd__nand2_1
X_3049_ _0783_ net98 VSS VSS VDD VDD _0784_ sky130_fd_sc_hd__nand2_1
X_3050_ _0399_ VSS VSS VDD VDD _1273_ sky130_fd_sc_hd__inv_1
X_3051_ net97 product\[61\] VSS VSS VDD VDD _0785_ sky130_fd_sc_hd__nand2_1
X_3052_ _0782_ _0784_ _0785_ VSS VSS VDD VDD _0464_ sky130_fd_sc_hd__o21ai_0
X_3053_ _0251_ _0339_ VSS VSS VDD VDD _0786_ sky130_fd_sc_hd__nand2_1
X_3054_ _0765_ _0786_ VSS VSS VDD VDD _0787_ sky130_fd_sc_hd__nor2_1
X_3055_ _0753_ _0787_ VSS VSS VDD VDD _0788_ sky130_fd_sc_hd__nand2_1
X_3056_ _0786_ VSS VSS VDD VDD _0789_ sky130_fd_sc_hd__inv_1
X_3057_ _0250_ _0339_ _0338_ VSS VSS VDD VDD _0790_ sky130_fd_sc_hd__a21oi_1
X_3058_ _0764_ _0789_ _0790_ VSS VSS VDD VDD _0791_ sky130_fd_sc_hd__a21boi_0
X_3059_ _0751_ _0787_ _0043_ VSS VSS VDD VDD _0792_ sky130_fd_sc_hd__nand3_1
X_3060_ _0788_ _0791_ _0792_ VSS VSS VDD VDD _0793_ sky130_fd_sc_hd__nand3_1
X_3061_ _1272_ _1273_ VSS VSS VDD VDD _1274_ sky130_fd_sc_hd__nand2_1
X_3062_ _0349_ _0793_ VSS VSS VDD VDD _0794_ sky130_fd_sc_hd__nor2_1
X_3063_ _0793_ _0349_ VSS VSS VDD VDD _0795_ sky130_fd_sc_hd__nand2_1
X_3064_ _0795_ net98 VSS VSS VDD VDD _0796_ sky130_fd_sc_hd__nand2_1
X_3065_ net97 product\[62\] VSS VSS VDD VDD _0797_ sky130_fd_sc_hd__nand2_1
X_3066_ _0794_ _0796_ _0797_ VSS VSS VDD VDD _0463_ sky130_fd_sc_hd__o21ai_0
Xinput41 req_b[16] VSS VSS VDD VDD net41 sky130_fd_sc_hd__clkdlybuf4s50_1
Xinput40 req_b[15] VSS VSS VDD VDD net40 sky130_fd_sc_hd__clkdlybuf4s50_1
X_3069_ net98 net32 net64 product\[32\] _1286_ VSS VSS VDD
+ VDD _0462_ sky130_fd_sc_hd__a32o_1
X_3070_ net98 _0249_ _1286_ product\[33\] VSS VSS VDD VDD
+ _0461_ sky130_fd_sc_hd__a22o_1
X_3071_ net98 _0414_ _1286_ product\[34\] VSS VSS VDD VDD
+ _0460_ sky130_fd_sc_hd__a22o_1
X_3072_ _1260_ VSS VSS VDD VDD _1275_ sky130_fd_sc_hd__inv_1
X_3073_ net98 _0076_ net97 product\[35\] VSS VSS VDD VDD _0459_
+ sky130_fd_sc_hd__a22o_1
X_3074_ net98 _0369_ net97 product\[36\] VSS VSS VDD VDD _0458_
+ sky130_fd_sc_hd__a22o_1
X_3075_ net98 _0158_ net97 product\[37\] VSS VSS VDD VDD _0457_
+ sky130_fd_sc_hd__a22o_1
X_3076_ _0375_ _0157_ VSS VSS VDD VDD _0800_ sky130_fd_sc_hd__xnor2_1
X_3077_ net97 product\[38\] VSS VSS VDD VDD _0801_ sky130_fd_sc_hd__nand2_1
X_3078_ _1471_ _0800_ _0801_ VSS VSS VDD VDD _0456_ sky130_fd_sc_hd__o21ai_0
X_3079_ _0293_ VSS VSS VDD VDD _0802_ sky130_fd_sc_hd__inv_1
X_3080_ _1378_ VSS VSS VDD VDD _0803_ sky130_fd_sc_hd__inv_1
X_3081_ _0802_ _0803_ VSS VSS VDD VDD _0804_ sky130_fd_sc_hd__nor2_1
X_3082_ _0293_ _1378_ net98 VSS VSS VDD VDD _0805_ sky130_fd_sc_hd__o21ai_0
X_3083_ _1274_ _1275_ VSS VSS VDD VDD _1276_ sky130_fd_sc_hd__nand2_1
X_3084_ _1286_ product\[39\] VSS VSS VDD VDD _0806_ sky130_fd_sc_hd__nand2_1
X_3085_ _0804_ _0805_ _0806_ VSS VSS VDD VDD _0455_ sky130_fd_sc_hd__o21ai_0
X_3086_ _0374_ _0293_ _0292_ VSS VSS VDD VDD _0807_ sky130_fd_sc_hd__a21oi_1
X_3087_ _0375_ _0293_ _0157_ VSS VSS VDD VDD _0808_ sky130_fd_sc_hd__nand3_1
X_3088_ _0807_ _0808_ VSS VSS VDD VDD _0809_ sky130_fd_sc_hd__nand2_1
X_3089_ _0809_ _0405_ _1471_ VSS VSS VDD VDD _0810_ sky130_fd_sc_hd__a21oi_1
X_3090_ _0405_ _0809_ _0810_ VSS VSS VDD VDD _0811_ sky130_fd_sc_hd__o21ai_0
X_3091_ net97 product\[40\] VSS VSS VDD VDD _0812_ sky130_fd_sc_hd__nand2_1
X_3092_ _0811_ _0812_ VSS VSS VDD VDD _0454_ sky130_fd_sc_hd__nand2_1
X_3093_ _1380_ _0803_ _1388_ VSS VSS VDD VDD _0813_ sky130_fd_sc_hd__o21bai_1
X_3094_ _0343_ _0304_ _0342_ VSS VSS VDD VDD _1277_ sky130_fd_sc_hd__a21oi_1
X_3095_ _0253_ _0813_ VSS VSS VDD VDD _0814_ sky130_fd_sc_hd__nor2_1
X_3096_ _0813_ _0253_ VSS VSS VDD VDD _0815_ sky130_fd_sc_hd__nand2_1
X_3097_ _0815_ net98 VSS VSS VDD VDD _0816_ sky130_fd_sc_hd__nand2_1
X_3098_ _1286_ product\[41\] VSS VSS VDD VDD _0817_ sky130_fd_sc_hd__nand2_1
X_3099_ _0814_ _0816_ _0817_ VSS VSS VDD VDD _0453_ sky130_fd_sc_hd__o21ai_0
X_3100_ _0375_ _0293_ VSS VSS VDD VDD _0818_ sky130_fd_sc_hd__nand2_1
X_3101_ _0405_ _0253_ VSS VSS VDD VDD _0819_ sky130_fd_sc_hd__nand2_1
X_3102_ _0818_ _0819_ VSS VSS VDD VDD _0820_ sky130_fd_sc_hd__nor2_1
X_3103_ _0404_ _0253_ _0252_ VSS VSS VDD VDD _0821_ sky130_fd_sc_hd__a21oi_1
X_3104_ _0819_ _0807_ _0821_ VSS VSS VDD VDD _0822_ sky130_fd_sc_hd__o21ai_0
X_3105_ _1276_ _1277_ VSS VSS VDD VDD _1278_ sky130_fd_sc_hd__nand2_1
X_3106_ _0157_ _0820_ _0822_ VSS VSS VDD VDD _0823_ sky130_fd_sc_hd__a21o_1
X_3107_ _0407_ _0823_ VSS VSS VDD VDD _0824_ sky130_fd_sc_hd__nor2_1
X_3108_ _0823_ _0407_ VSS VSS VDD VDD _0825_ sky130_fd_sc_hd__nand2_1
X_3109_ _0825_ net98 VSS VSS VDD VDD _0826_ sky130_fd_sc_hd__nand2_1
X_3110_ net97 product\[42\] VSS VSS VDD VDD _0827_ sky130_fd_sc_hd__nand2_1
X_3111_ _0824_ _0826_ _0827_ VSS VSS VDD VDD _0452_ sky130_fd_sc_hd__o21ai_0
X_3112_ _1378_ _1381_ VSS VSS VDD VDD _0828_ sky130_fd_sc_hd__nand2_1
X_3113_ _0828_ _1391_ _1390_ VSS VSS VDD VDD _0829_ sky130_fd_sc_hd__nand3_1
X_3114_ _0829_ _0308_ _1471_ VSS VSS VDD VDD _0830_ sky130_fd_sc_hd__a21oi_1
X_3115_ _0308_ _0829_ _0830_ VSS VSS VDD VDD _0831_ sky130_fd_sc_hd__o21ai_0
X_3116_ _1278_ _1265_ VSS VSS VDD VDD _1279_ sky130_fd_sc_hd__nand2_1
X_3117_ net97 product\[43\] VSS VSS VDD VDD _0832_ sky130_fd_sc_hd__nand2_1
X_3118_ _0831_ _0832_ VSS VSS VDD VDD _0451_ sky130_fd_sc_hd__nand2_1
X_3119_ _0406_ _0308_ _0307_ VSS VSS VDD VDD _0833_ sky130_fd_sc_hd__a21o_1
X_3120_ _0407_ _0308_ VSS VSS VDD VDD _0834_ sky130_fd_sc_hd__nand2_1
X_3121_ _0834_ _0821_ VSS VSS VDD VDD _0835_ sky130_fd_sc_hd__nor2_1
X_3122_ _0833_ _0835_ VSS VSS VDD VDD _0836_ sky130_fd_sc_hd__nor2_1
X_3123_ _0819_ _0834_ VSS VSS VDD VDD _0837_ sky130_fd_sc_hd__nor2_1
X_3124_ _0809_ _0837_ VSS VSS VDD VDD _0838_ sky130_fd_sc_hd__nand2_1
X_3125_ _0836_ _0838_ _0425_ VSS VSS VDD VDD _0839_ sky130_fd_sc_hd__a21boi_0
X_3126_ _0836_ _0838_ VSS VSS VDD VDD _0840_ sky130_fd_sc_hd__nand2_1
X_3127_ _1220_ VSS VSS VDD VDD _1221_ sky130_fd_sc_hd__inv_1
X_3128_ _1266_ _1271_ _1279_ VSS VSS VDD VDD _1280_ sky130_fd_sc_hd__nand3_1
X_3129_ _0425_ _0840_ net98 VSS VSS VDD VDD _0841_ sky130_fd_sc_hd__o21ai_0
X_3130_ net97 product\[44\] VSS VSS VDD VDD _0842_ sky130_fd_sc_hd__nand2_1
X_3131_ _0839_ _0841_ _0842_ VSS VSS VDD VDD _0450_ sky130_fd_sc_hd__o21ai_0
X_3132_ _1377_ _1376_ _1380_ VSS VSS VDD VDD _0843_ sky130_fd_sc_hd__a21oi_1
X_3133_ _1382_ _1379_ VSS VSS VDD VDD _0844_ sky130_fd_sc_hd__nor2_1
X_3134_ _1388_ _0843_ _0844_ VSS VSS VDD VDD _0845_ sky130_fd_sc_hd__o21ai_0
X_3135_ _1395_ _1396_ VSS VSS VDD VDD _0846_ sky130_fd_sc_hd__nand2_1
X_3136_ _1382_ _1391_ VSS VSS VDD VDD _0847_ sky130_fd_sc_hd__nor2_1
X_3137_ _0846_ _0847_ VSS VSS VDD VDD _0848_ sky130_fd_sc_hd__nor2_1
X_3138_ _0375_ _0315_ VSS VSS VDD VDD _0849_ sky130_fd_sc_hd__nand2_1
X_3139_ _1280_ VSS VSS VDD VDD _1281_ sky130_fd_sc_hd__inv_1
X_3140_ _0849_ _1380_ VSS VSS VDD VDD _0850_ sky130_fd_sc_hd__nor2_1
X_3141_ _0850_ _0844_ _0156_ VSS VSS VDD VDD _0851_ sky130_fd_sc_hd__nand3_1
X_3142_ _0845_ _0848_ _0851_ VSS VSS VDD VDD _0852_ sky130_fd_sc_hd__nand3_1
X_3143_ _0319_ _0852_ VSS VSS VDD VDD _0853_ sky130_fd_sc_hd__nor2_1
X_3144_ _0852_ _0319_ VSS VSS VDD VDD _0854_ sky130_fd_sc_hd__nand2_1
X_3145_ _0854_ net98 VSS VSS VDD VDD _0855_ sky130_fd_sc_hd__nand2_1
X_3146_ net97 product\[45\] VSS VSS VDD VDD _0856_ sky130_fd_sc_hd__nand2_1
X_3147_ _0853_ _0855_ _0856_ VSS VSS VDD VDD _0449_ sky130_fd_sc_hd__o21ai_0
X_3148_ _0425_ _0319_ VSS VSS VDD VDD _0857_ sky130_fd_sc_hd__nand2_1
X_3149_ _0834_ _0857_ VSS VSS VDD VDD _0858_ sky130_fd_sc_hd__nor2_1
X_3150_ _1251_ _1281_ VSS VSS VDD VDD _1282_ sky130_fd_sc_hd__nand2_1
X_3151_ _0822_ _0858_ VSS VSS VDD VDD _0859_ sky130_fd_sc_hd__nand2_1
X_3152_ _0857_ VSS VSS VDD VDD _0860_ sky130_fd_sc_hd__inv_1
X_3153_ _0424_ _0319_ _0318_ VSS VSS VDD VDD _0861_ sky130_fd_sc_hd__a21oi_1
X_3154_ _0833_ _0860_ _0861_ VSS VSS VDD VDD _0862_ sky130_fd_sc_hd__a21boi_0
X_3155_ _0820_ _0858_ _0157_ VSS VSS VDD VDD _0863_ sky130_fd_sc_hd__nand3_1
X_3156_ _0859_ _0862_ _0863_ VSS VSS VDD VDD _0864_ sky130_fd_sc_hd__nand3_1
X_3157_ _0368_ _0864_ VSS VSS VDD VDD _0865_ sky130_fd_sc_hd__nor2_1
X_3158_ _0864_ _0368_ VSS VSS VDD VDD _0866_ sky130_fd_sc_hd__nand2_1
X_3159_ _0866_ net98 VSS VSS VDD VDD _0867_ sky130_fd_sc_hd__nand2_1
X_3160_ net97 product\[46\] VSS VSS VDD VDD _0868_ sky130_fd_sc_hd__nand2_1
X_3161_ _1248_ _1250_ _1280_ VSS VSS VDD VDD _1283_ sky130_fd_sc_hd__nand3_1
X_3162_ _0865_ _0867_ _0868_ VSS VSS VDD VDD _0448_ sky130_fd_sc_hd__o21ai_0
Xinput39 req_b[14] VSS VSS VDD VDD net39 sky130_fd_sc_hd__clkdlybuf4s50_1
Xinput38 req_b[13] VSS VSS VDD VDD net38 sky130_fd_sc_hd__clkdlybuf4s50_1
X_3165_ net98 net9 net41 product\[16\] _1286_ VSS VSS VDD
+ VDD _0447_ sky130_fd_sc_hd__a32o_1
X_3166_ net98 _0335_ _1286_ product\[17\] VSS VSS VDD VDD
+ _0446_ sky130_fd_sc_hd__a22o_1
X_3167_ net98 _0303_ _1286_ product\[18\] VSS VSS VDD VDD
+ _0445_ sky130_fd_sc_hd__a22o_1
X_3168_ net98 _0105_ _1286_ product\[19\] VSS VSS VDD VDD
+ _0444_ sky130_fd_sc_hd__a22o_1
X_3169_ net98 _0261_ _1286_ product\[20\] VSS VSS VDD VDD
+ _0443_ sky130_fd_sc_hd__a22o_1
X_3170_ net98 _0102_ _1286_ product\[21\] VSS VSS VDD VDD
+ _0442_ sky130_fd_sc_hd__a22o_1
X_3171_ _0337_ _0101_ VSS VSS VDD VDD _0871_ sky130_fd_sc_hd__or2_2
X_3172_ _1282_ net98 _1283_ VSS VSS VDD VDD _1284_ sky130_fd_sc_hd__nand3_1
X_3173_ _0337_ _0101_ VSS VSS VDD VDD _0872_ sky130_fd_sc_hd__nand2_1
X_3174_ net98 _0871_ _0872_ product\[22\] _1286_ VSS VSS VDD
+ VDD _0441_ sky130_fd_sc_hd__a32o_1
X_3175_ _1438_ _0341_ _1471_ VSS VSS VDD VDD _0873_ sky130_fd_sc_hd__a21oi_1
X_3176_ _0341_ _1438_ _0873_ VSS VSS VDD VDD _0874_ sky130_fd_sc_hd__o21ai_0
X_3177_ _1286_ product\[23\] VSS VSS VDD VDD _0875_ sky130_fd_sc_hd__nand2_1
X_3178_ _0874_ _0875_ VSS VSS VDD VDD _0440_ sky130_fd_sc_hd__nand2_1
X_3179_ _0341_ VSS VSS VDD VDD _0876_ sky130_fd_sc_hd__inv_1
X_3180_ _0341_ _0336_ _0340_ VSS VSS VDD VDD _0877_ sky130_fd_sc_hd__a21oi_1
X_3181_ _0876_ _0872_ _0877_ VSS VSS VDD VDD _0878_ sky130_fd_sc_hd__o21ai_0
X_3182_ _0345_ _0878_ VSS VSS VDD VDD _0879_ sky130_fd_sc_hd__nor2_1
X_3183_ _1223_ _1217_ VSS VSS VDD VDD _1285_ sky130_fd_sc_hd__nand2_1
X_3184_ _0878_ _0345_ VSS VSS VDD VDD _0880_ sky130_fd_sc_hd__nand2_1
X_3185_ _0880_ net98 VSS VSS VDD VDD _0881_ sky130_fd_sc_hd__nand2_1
X_3186_ _1286_ product\[24\] VSS VSS VDD VDD _0882_ sky130_fd_sc_hd__nand2_1
X_3187_ _0879_ _0881_ _0882_ VSS VSS VDD VDD _0439_ sky130_fd_sc_hd__o21ai_0
X_3188_ _1440_ VSS VSS VDD VDD _0883_ sky130_fd_sc_hd__inv_1
X_3189_ _1438_ _0883_ VSS VSS VDD VDD _0884_ sky130_fd_sc_hd__nand2_1
X_3190_ _1453_ VSS VSS VDD VDD _0885_ sky130_fd_sc_hd__inv_1
X_3191_ _0884_ _0885_ VSS VSS VDD VDD _0886_ sky130_fd_sc_hd__nand2_1
X_3192_ _0886_ _0427_ _1471_ VSS VSS VDD VDD _0887_ sky130_fd_sc_hd__a21oi_1
X_3193_ _0427_ _0886_ _0887_ VSS VSS VDD VDD _0888_ sky130_fd_sc_hd__o21ai_0
X_3194_ _1285_ VSS VSS VDD VDD _1286_ sky130_fd_sc_hd__inv_2
X_3195_ net97 product\[25\] VSS VSS VDD VDD _0889_ sky130_fd_sc_hd__nand2_1
X_3196_ _0888_ _0889_ VSS VSS VDD VDD _0438_ sky130_fd_sc_hd__nand2_1
X_3197_ _0341_ _0337_ VSS VSS VDD VDD _0890_ sky130_fd_sc_hd__nand2_1
X_3198_ _0345_ _0427_ VSS VSS VDD VDD _0891_ sky130_fd_sc_hd__nand2_1
X_3199_ _0890_ _0891_ VSS VSS VDD VDD _0892_ sky130_fd_sc_hd__nor2_1
X_3200_ _0427_ _0344_ _0426_ VSS VSS VDD VDD _0893_ sky130_fd_sc_hd__a21oi_1
X_3201_ _0891_ _0877_ _0893_ VSS VSS VDD VDD _0894_ sky130_fd_sc_hd__o21ai_0
X_3202_ _0101_ _0892_ _0894_ VSS VSS VDD VDD _0895_ sky130_fd_sc_hd__a21o_1
X_3203_ _0313_ _0895_ VSS VSS VDD VDD _0896_ sky130_fd_sc_hd__nor2_1
X_3204_ _0895_ _0313_ VSS VSS VDD VDD _0897_ sky130_fd_sc_hd__nand2_1
Xinput37 req_b[12] VSS VSS VDD VDD net37 sky130_fd_sc_hd__clkdlybuf4s50_1
X_3206_ _0897_ net98 VSS VSS VDD VDD _0898_ sky130_fd_sc_hd__nand2_1
X_3207_ _1286_ product\[26\] VSS VSS VDD VDD _0899_ sky130_fd_sc_hd__nand2_1
X_3208_ _0896_ _0898_ _0899_ VSS VSS VDD VDD _0437_ sky130_fd_sc_hd__o21ai_0
X_3209_ _1438_ _1441_ VSS VSS VDD VDD _0900_ sky130_fd_sc_hd__nand2_1
X_3210_ _0900_ _1456_ _1455_ VSS VSS VDD VDD _0901_ sky130_fd_sc_hd__nand3_1
X_3211_ _0901_ _0402_ _1471_ VSS VSS VDD VDD _0902_ sky130_fd_sc_hd__a21oi_1
X_3212_ _0402_ _0901_ _0902_ VSS VSS VDD VDD _0903_ sky130_fd_sc_hd__o21ai_0
X_3213_ net97 product\[27\] VSS VSS VDD VDD _0904_ sky130_fd_sc_hd__nand2_1
X_3214_ _0903_ _0904_ VSS VSS VDD VDD _0436_ sky130_fd_sc_hd__nand2_1
X_3215_ _0402_ _0313_ VSS VSS VDD VDD _0905_ sky130_fd_sc_hd__nand2_1
X_3216_ net97 product\[15\] VSS VSS VDD VDD _1288_ sky130_fd_sc_hd__nand2_1
X_3217_ _0891_ _0905_ VSS VSS VDD VDD _0906_ sky130_fd_sc_hd__nor2_1
X_3218_ _0878_ _0906_ VSS VSS VDD VDD _0907_ sky130_fd_sc_hd__nand2_1
X_3219_ _0402_ _0312_ _0401_ VSS VSS VDD VDD _0908_ sky130_fd_sc_hd__a21o_1
X_3220_ _0905_ _0893_ VSS VSS VDD VDD _0909_ sky130_fd_sc_hd__nor2_1
X_3221_ _0908_ _0909_ VSS VSS VDD VDD _0910_ sky130_fd_sc_hd__nor2_1
X_3222_ _0907_ _0910_ _0416_ VSS VSS VDD VDD _0911_ sky130_fd_sc_hd__a21boi_0
X_3223_ _0907_ _0910_ VSS VSS VDD VDD _0912_ sky130_fd_sc_hd__nand2_1
X_3224_ _0416_ _0912_ net98 VSS VSS VDD VDD _0913_ sky130_fd_sc_hd__o21ai_0
X_3225_ _1286_ product\[28\] VSS VSS VDD VDD _0914_ sky130_fd_sc_hd__nand2_1
X_3226_ _0911_ _0913_ _0914_ VSS VSS VDD VDD _0435_ sky130_fd_sc_hd__o21ai_0
X_3227_ _1284_ _1288_ VSS VSS VDD VDD _0515_ sky130_fd_sc_hd__nand2_1
X_3228_ _1440_ _1437_ _0885_ VSS VSS VDD VDD _0915_ sky130_fd_sc_hd__o21ai_0
X_3229_ _1442_ _1439_ VSS VSS VDD VDD _0916_ sky130_fd_sc_hd__nor2_1
X_3230_ _0915_ _0916_ VSS VSS VDD VDD _0917_ sky130_fd_sc_hd__nand2_1
X_3231_ _1447_ _1448_ VSS VSS VDD VDD _0918_ sky130_fd_sc_hd__nand2_1
X_3232_ _1442_ _1456_ VSS VSS VDD VDD _0919_ sky130_fd_sc_hd__nor2_1
X_3233_ _0918_ _0919_ VSS VSS VDD VDD _0920_ sky130_fd_sc_hd__nor2_1
X_3234_ _0916_ _0100_ _1432_ _0883_ VSS VSS VDD VDD _0921_
+ sky130_fd_sc_hd__nand4_1
X_3235_ _0917_ _0920_ _0921_ VSS VSS VDD VDD _0922_ sky130_fd_sc_hd__nand3_1
X_3236_ _0373_ _0922_ VSS VSS VDD VDD _0923_ sky130_fd_sc_hd__nor2_1
X_3237_ _0922_ _0373_ VSS VSS VDD VDD _0924_ sky130_fd_sc_hd__nand2_1
X_3238_ net67 _1218_ _1221_ VSS VSS VDD VDD _0432_ sky130_fd_sc_hd__o21ai_0
X_3239_ _0114_ VSS VSS VDD VDD _1289_ sky130_fd_sc_hd__inv_1
X_3240_ _0924_ net98 VSS VSS VDD VDD _0925_ sky130_fd_sc_hd__nand2_1
X_3241_ _1286_ product\[29\] VSS VSS VDD VDD _0926_ sky130_fd_sc_hd__nand2_1
X_3242_ _0923_ _0925_ _0926_ VSS VSS VDD VDD _0434_ sky130_fd_sc_hd__o21ai_0
X_3243_ _0373_ _0416_ VSS VSS VDD VDD _0927_ sky130_fd_sc_hd__nand2_1
X_3244_ _0905_ _0927_ VSS VSS VDD VDD _0928_ sky130_fd_sc_hd__nor2_1
X_3245_ _0894_ _0928_ VSS VSS VDD VDD _0929_ sky130_fd_sc_hd__nand2_1
X_3246_ _0927_ VSS VSS VDD VDD _0930_ sky130_fd_sc_hd__inv_1
X_3247_ _0373_ _0415_ _0372_ VSS VSS VDD VDD _0931_ sky130_fd_sc_hd__a21oi_1
X_3248_ _0908_ _0930_ _0931_ VSS VSS VDD VDD _0932_ sky130_fd_sc_hd__a21boi_0
X_3249_ _0892_ _0928_ _0101_ VSS VSS VDD VDD _0933_ sky130_fd_sc_hd__nand3_1
X_3250_ _0207_ VSS VSS VDD VDD _1290_ sky130_fd_sc_hd__inv_1
X_3251_ _0929_ _0932_ _0933_ VSS VSS VDD VDD _0934_ sky130_fd_sc_hd__nand3_1
X_3252_ _0412_ _0934_ VSS VSS VDD VDD _0935_ sky130_fd_sc_hd__nor2_1
X_3253_ _0934_ _0412_ VSS VSS VDD VDD _0936_ sky130_fd_sc_hd__nand2_1
X_3254_ _0936_ net98 VSS VSS VDD VDD _0937_ sky130_fd_sc_hd__nand2_1
X_3255_ _1286_ product\[30\] VSS VSS VDD VDD _0938_ sky130_fd_sc_hd__nand2_1
X_3256_ _0935_ _0937_ _0938_ VSS VSS VDD VDD _0433_ sky130_fd_sc_hd__o21ai_0
X_3257_ net49 VSS VSS VDD VDD _0939_ sky130_fd_sc_hd__inv_1
X_3258_ net9 _0939_ VSS VSS VDD VDD _0146_ sky130_fd_sc_hd__nor2_1
Xinput36 req_b[11] VSS VSS VDD VDD net36 sky130_fd_sc_hd__clkdlybuf4s50_1
X_3260_ net10 _0939_ VSS VSS VDD VDD _0143_ sky130_fd_sc_hd__nor2_1
X_3261_ _1289_ _1290_ VSS VSS VDD VDD _1291_ sky130_fd_sc_hd__nand2_1
Xinput35 req_b[10] VSS VSS VDD VDD net35 sky130_fd_sc_hd__clkdlybuf4s50_1
X_3263_ net11 _0939_ VSS VSS VDD VDD _0140_ sky130_fd_sc_hd__nor2_1
Xinput34 req_b[0] VSS VSS VDD VDD net34 sky130_fd_sc_hd__clkdlybuf4s50_1
X_3265_ net12 _0939_ VSS VSS VDD VDD _0137_ sky130_fd_sc_hd__nor2_1
Xinput33 req_a[9] VSS VSS VDD VDD net33 sky130_fd_sc_hd__clkdlybuf4s50_1
X_3267_ net14 _0939_ VSS VSS VDD VDD _0134_ sky130_fd_sc_hd__nor2_1
Xinput32 req_a[8] VSS VSS VDD VDD net32 sky130_fd_sc_hd__clkdlybuf4s50_1
X_3269_ net15 _0939_ VSS VSS VDD VDD _0131_ sky130_fd_sc_hd__nor2_1
Xinput31 req_a[7] VSS VSS VDD VDD net31 sky130_fd_sc_hd__clkdlybuf4s50_1
X_3271_ net16 _0939_ VSS VSS VDD VDD _0129_ sky130_fd_sc_hd__nor2_1
X_3272_ _0114_ _0207_ VSS VSS VDD VDD _1292_ sky130_fd_sc_hd__nand2_1
Xinput30 req_a[6] VSS VSS VDD VDD net30 sky130_fd_sc_hd__clkdlybuf4s50_1
X_3274_ net17 _0939_ VSS VSS VDD VDD _0127_ sky130_fd_sc_hd__nor2_1
Xinput29 req_a[5] VSS VSS VDD VDD net29 sky130_fd_sc_hd__clkdlybuf4s50_1
X_3276_ net9 net48 VSS VSS VDD VDD _0948_ sky130_fd_sc_hd__nand2_1
X_3277_ _0948_ VSS VSS VDD VDD _0311_ sky130_fd_sc_hd__inv_1
X_3278_ net10 net48 VSS VSS VDD VDD _0949_ sky130_fd_sc_hd__nand2_1
X_3279_ _0949_ VSS VSS VDD VDD _0145_ sky130_fd_sc_hd__inv_1
X_3280_ net11 net48 VSS VSS VDD VDD _0950_ sky130_fd_sc_hd__nand2_1
X_3281_ _0950_ VSS VSS VDD VDD _0142_ sky130_fd_sc_hd__inv_1
X_3282_ net12 net48 VSS VSS VDD VDD _0951_ sky130_fd_sc_hd__nand2_1
X_3283_ _1291_ _1292_ VSS VSS VDD VDD _1293_ sky130_fd_sc_hd__nand2_1
X_3284_ _0951_ VSS VSS VDD VDD _0139_ sky130_fd_sc_hd__inv_1
X_3285_ net14 net48 VSS VSS VDD VDD _0952_ sky130_fd_sc_hd__nand2_1
X_3286_ _0952_ VSS VSS VDD VDD _0136_ sky130_fd_sc_hd__inv_1
X_3287_ net15 net48 VSS VSS VDD VDD _0953_ sky130_fd_sc_hd__nand2_1
X_3288_ _0953_ VSS VSS VDD VDD _0133_ sky130_fd_sc_hd__inv_1
X_3289_ net16 net48 VSS VSS VDD VDD _0954_ sky130_fd_sc_hd__nand2_1
X_3290_ _0954_ VSS VSS VDD VDD _0130_ sky130_fd_sc_hd__inv_1
X_3291_ net17 net48 VSS VSS VDD VDD _0955_ sky130_fd_sc_hd__nand2_1
X_3292_ _0955_ VSS VSS VDD VDD _0126_ sky130_fd_sc_hd__inv_1
Xinput28 req_a[4] VSS VSS VDD VDD net28 sky130_fd_sc_hd__clkdlybuf4s50_1
X_3294_ _0036_ VSS VSS VDD VDD _1294_ sky130_fd_sc_hd__inv_1
X_3295_ net9 net47 VSS VSS VDD VDD _0957_ sky130_fd_sc_hd__nand2_1
X_3296_ _0957_ VSS VSS VDD VDD _0306_ sky130_fd_sc_hd__inv_1
X_3297_ net10 net47 VSS VSS VDD VDD _0958_ sky130_fd_sc_hd__nand2_1
X_3298_ _0958_ VSS VSS VDD VDD _0310_ sky130_fd_sc_hd__inv_1
X_3299_ net11 net47 VSS VSS VDD VDD _0959_ sky130_fd_sc_hd__nand2_1
X_3300_ _0959_ VSS VSS VDD VDD _0144_ sky130_fd_sc_hd__inv_1
X_3301_ net12 net47 VSS VSS VDD VDD _0960_ sky130_fd_sc_hd__nand2_1
X_3302_ _0960_ VSS VSS VDD VDD _0141_ sky130_fd_sc_hd__inv_1
X_3303_ net14 net47 VSS VSS VDD VDD _0961_ sky130_fd_sc_hd__nand2_1
X_3304_ _0961_ VSS VSS VDD VDD _0138_ sky130_fd_sc_hd__inv_1
X_3305_ _1293_ _1294_ VSS VSS VDD VDD _1295_ sky130_fd_sc_hd__nand2_1
X_3306_ net15 net47 VSS VSS VDD VDD _0962_ sky130_fd_sc_hd__nand2_1
X_3307_ _0962_ VSS VSS VDD VDD _0135_ sky130_fd_sc_hd__inv_1
X_3308_ net16 net47 VSS VSS VDD VDD _0963_ sky130_fd_sc_hd__nand2_1
X_3309_ _0963_ VSS VSS VDD VDD _0132_ sky130_fd_sc_hd__inv_1
X_3310_ net17 net47 VSS VSS VDD VDD _0964_ sky130_fd_sc_hd__nand2_1
X_3311_ _0964_ VSS VSS VDD VDD _0125_ sky130_fd_sc_hd__inv_1
Xinput27 req_a[3] VSS VSS VDD VDD net27 sky130_fd_sc_hd__clkdlybuf4s50_1
X_3313_ net9 net46 VSS VSS VDD VDD _0966_ sky130_fd_sc_hd__nand2_1
X_3314_ _0966_ VSS VSS VDD VDD _0176_ sky130_fd_sc_hd__inv_1
X_3315_ net10 net46 VSS VSS VDD VDD _0967_ sky130_fd_sc_hd__nand2_1
X_3316_ _1291_ _0036_ _1292_ VSS VSS VDD VDD _1296_ sky130_fd_sc_hd__nand3_1
X_3317_ _0967_ VSS VSS VDD VDD _0173_ sky130_fd_sc_hd__inv_1
X_3318_ net11 net46 VSS VSS VDD VDD _0968_ sky130_fd_sc_hd__nand2_1
X_3319_ _0968_ VSS VSS VDD VDD _0170_ sky130_fd_sc_hd__inv_1
X_3320_ net12 net46 VSS VSS VDD VDD _0969_ sky130_fd_sc_hd__nand2_1
X_3321_ _0969_ VSS VSS VDD VDD _0167_ sky130_fd_sc_hd__inv_1
X_3322_ net14 net46 VSS VSS VDD VDD _0970_ sky130_fd_sc_hd__nand2_1
X_3323_ _0970_ VSS VSS VDD VDD _0164_ sky130_fd_sc_hd__inv_1
X_3324_ net15 net46 VSS VSS VDD VDD _0971_ sky130_fd_sc_hd__nand2_1
X_3325_ _0971_ VSS VSS VDD VDD _0161_ sky130_fd_sc_hd__inv_1
X_3326_ net16 net46 VSS VSS VDD VDD _0972_ sky130_fd_sc_hd__nand2_1
X_3327_ _1295_ _1296_ VSS VSS VDD VDD _1297_ sky130_fd_sc_hd__nand2_1
X_3328_ _0972_ VSS VSS VDD VDD _0159_ sky130_fd_sc_hd__inv_1
X_3329_ net17 net46 VSS VSS VDD VDD _0973_ sky130_fd_sc_hd__nand2_1
X_3330_ _0973_ VSS VSS VDD VDD _0155_ sky130_fd_sc_hd__inv_1
Xinput26 req_a[31] VSS VSS VDD VDD net26 sky130_fd_sc_hd__clkdlybuf4s50_1
X_3332_ net9 net44 VSS VSS VDD VDD _0975_ sky130_fd_sc_hd__nand2_1
X_3333_ _0975_ VSS VSS VDD VDD _0317_ sky130_fd_sc_hd__inv_1
X_3334_ net10 net44 VSS VSS VDD VDD _0976_ sky130_fd_sc_hd__nand2_1
X_3335_ _0976_ VSS VSS VDD VDD _0175_ sky130_fd_sc_hd__inv_1
X_3336_ net11 net44 VSS VSS VDD VDD _0977_ sky130_fd_sc_hd__nand2_1
X_3337_ _0977_ VSS VSS VDD VDD _0172_ sky130_fd_sc_hd__inv_1
X_3338_ _0075_ _0038_ VSS VSS VDD VDD _1298_ sky130_fd_sc_hd__xnor2_1
X_3339_ net12 net44 VSS VSS VDD VDD _0978_ sky130_fd_sc_hd__nand2_1
X_3340_ _0978_ VSS VSS VDD VDD _0169_ sky130_fd_sc_hd__inv_1
X_3341_ net14 net44 VSS VSS VDD VDD _0979_ sky130_fd_sc_hd__nand2_1
X_3342_ _0979_ VSS VSS VDD VDD _0166_ sky130_fd_sc_hd__inv_1
X_3343_ net15 net44 VSS VSS VDD VDD _0980_ sky130_fd_sc_hd__nand2_1
X_3344_ _0980_ VSS VSS VDD VDD _0163_ sky130_fd_sc_hd__inv_1
X_3345_ net16 net44 VSS VSS VDD VDD _0981_ sky130_fd_sc_hd__nand2_1
X_3346_ _0981_ VSS VSS VDD VDD _0160_ sky130_fd_sc_hd__inv_1
X_3347_ net17 net44 VSS VSS VDD VDD _0982_ sky130_fd_sc_hd__nand2_1
X_3348_ _0982_ VSS VSS VDD VDD _0154_ sky130_fd_sc_hd__inv_1
X_3349_ _1217_ phase\[3\] net67 VSS VSS VDD VDD _1222_ sky130_fd_sc_hd__nand3_1
X_3350_ _1298_ VSS VSS VDD VDD _1299_ sky130_fd_sc_hd__inv_1
Xinput25 req_a[30] VSS VSS VDD VDD net25 sky130_fd_sc_hd__clkdlybuf4s50_1
X_3352_ net9 net43 VSS VSS VDD VDD _0984_ sky130_fd_sc_hd__nand2_1
X_3353_ _0984_ VSS VSS VDD VDD _0302_ sky130_fd_sc_hd__inv_1
X_3354_ net10 net43 VSS VSS VDD VDD _0985_ sky130_fd_sc_hd__nand2_1
X_3355_ _0985_ VSS VSS VDD VDD _0316_ sky130_fd_sc_hd__inv_1
X_3356_ net11 net43 VSS VSS VDD VDD _0986_ sky130_fd_sc_hd__nand2_1
X_3357_ _0986_ VSS VSS VDD VDD _0174_ sky130_fd_sc_hd__inv_1
X_3358_ net12 net43 VSS VSS VDD VDD _0987_ sky130_fd_sc_hd__nand2_1
X_3359_ _0987_ VSS VSS VDD VDD _0171_ sky130_fd_sc_hd__inv_1
X_3360_ net14 net43 VSS VSS VDD VDD _0988_ sky130_fd_sc_hd__nand2_1
X_3361_ _1297_ _1299_ VSS VSS VDD VDD _1300_ sky130_fd_sc_hd__nand2_1
X_3362_ _0988_ VSS VSS VDD VDD _0168_ sky130_fd_sc_hd__inv_1
X_3363_ net15 net43 VSS VSS VDD VDD _0989_ sky130_fd_sc_hd__nand2_1
X_3364_ _0989_ VSS VSS VDD VDD _0165_ sky130_fd_sc_hd__inv_1
X_3365_ net16 net43 VSS VSS VDD VDD _0990_ sky130_fd_sc_hd__nand2_1
X_3366_ _0990_ VSS VSS VDD VDD _0162_ sky130_fd_sc_hd__inv_1
X_3367_ net17 net43 VSS VSS VDD VDD _0991_ sky130_fd_sc_hd__nand2_1
X_3368_ _0991_ VSS VSS VDD VDD _0153_ sky130_fd_sc_hd__inv_1
Xinput24 req_a[2] VSS VSS VDD VDD net24 sky130_fd_sc_hd__clkdlybuf4s50_1
X_3370_ net9 net42 VSS VSS VDD VDD _0993_ sky130_fd_sc_hd__nand2_1
X_3371_ _0993_ VSS VSS VDD VDD _0334_ sky130_fd_sc_hd__inv_1
X_3372_ _1295_ _1296_ _1298_ VSS VSS VDD VDD _1301_ sky130_fd_sc_hd__nand3_1
X_3373_ net10 net42 VSS VSS VDD VDD _0994_ sky130_fd_sc_hd__nand2_1
X_3374_ _0994_ VSS VSS VDD VDD _0332_ sky130_fd_sc_hd__inv_1
X_3375_ net11 net42 VSS VSS VDD VDD _0995_ sky130_fd_sc_hd__nand2_1
X_3376_ _0995_ VSS VSS VDD VDD _0330_ sky130_fd_sc_hd__inv_1
X_3377_ net12 net42 VSS VSS VDD VDD _0996_ sky130_fd_sc_hd__nand2_1
X_3378_ _0996_ VSS VSS VDD VDD _0328_ sky130_fd_sc_hd__inv_1
X_3379_ net14 net42 VSS VSS VDD VDD _0997_ sky130_fd_sc_hd__nand2_1
X_3380_ _0997_ VSS VSS VDD VDD _0326_ sky130_fd_sc_hd__inv_1
X_3381_ net15 net42 VSS VSS VDD VDD _0998_ sky130_fd_sc_hd__nand2_1
X_3382_ _0998_ VSS VSS VDD VDD _0324_ sky130_fd_sc_hd__inv_1
X_3383_ _1300_ _1301_ VSS VSS VDD VDD _1302_ sky130_fd_sc_hd__nand2_1
X_3384_ net16 net42 VSS VSS VDD VDD _0999_ sky130_fd_sc_hd__nand2_1
X_3385_ _0999_ VSS VSS VDD VDD _0180_ sky130_fd_sc_hd__inv_1
X_3386_ net17 net42 VSS VSS VDD VDD _1000_ sky130_fd_sc_hd__nand2_1
X_3387_ _1000_ VSS VSS VDD VDD _0322_ sky130_fd_sc_hd__inv_1
X_3388_ net10 net41 VSS VSS VDD VDD _1001_ sky130_fd_sc_hd__nand2_1
X_3389_ _1001_ VSS VSS VDD VDD _0333_ sky130_fd_sc_hd__inv_1
X_3390_ net11 net41 VSS VSS VDD VDD _1002_ sky130_fd_sc_hd__nand2_1
X_3391_ _1002_ VSS VSS VDD VDD _0331_ sky130_fd_sc_hd__inv_1
X_3392_ net12 net41 VSS VSS VDD VDD _1003_ sky130_fd_sc_hd__nand2_1
X_3393_ _1003_ VSS VSS VDD VDD _0329_ sky130_fd_sc_hd__inv_1
X_3394_ _0115_ VSS VSS VDD VDD _1303_ sky130_fd_sc_hd__inv_1
X_3395_ net14 net41 VSS VSS VDD VDD _1004_ sky130_fd_sc_hd__nand2_1
X_3396_ _1004_ VSS VSS VDD VDD _0327_ sky130_fd_sc_hd__inv_1
X_3397_ net15 net41 VSS VSS VDD VDD _1005_ sky130_fd_sc_hd__nand2_1
X_3398_ _1005_ VSS VSS VDD VDD _0325_ sky130_fd_sc_hd__inv_1
X_3399_ net16 net41 VSS VSS VDD VDD _1006_ sky130_fd_sc_hd__nand2_1
X_3400_ _1006_ VSS VSS VDD VDD _0323_ sky130_fd_sc_hd__inv_1
X_3401_ net17 net41 VSS VSS VDD VDD _1007_ sky130_fd_sc_hd__nand2_1
X_3402_ _1007_ VSS VSS VDD VDD _0179_ sky130_fd_sc_hd__inv_1
X_3403_ net58 VSS VSS VDD VDD _1008_ sky130_fd_sc_hd__inv_1
X_3404_ net18 _1008_ VSS VSS VDD VDD _0074_ sky130_fd_sc_hd__nor2_1
X_3405_ _0029_ VSS VSS VDD VDD _1304_ sky130_fd_sc_hd__inv_1
Xinput23 req_a[29] VSS VSS VDD VDD net23 sky130_fd_sc_hd__clkdlybuf4s50_1
X_3407_ net19 _1008_ VSS VSS VDD VDD _0071_ sky130_fd_sc_hd__nor2_1
Xinput22 req_a[28] VSS VSS VDD VDD net22 sky130_fd_sc_hd__clkdlybuf4s50_1
X_3409_ net20 _1008_ VSS VSS VDD VDD _0068_ sky130_fd_sc_hd__nor2_1
Xinput21 req_a[27] VSS VSS VDD VDD net21 sky130_fd_sc_hd__clkdlybuf4s50_1
X_3411_ net21 _1008_ VSS VSS VDD VDD _0065_ sky130_fd_sc_hd__nor2_1
Xinput20 req_a[26] VSS VSS VDD VDD net20 sky130_fd_sc_hd__clkdlybuf4s50_1
X_3413_ net22 _1008_ VSS VSS VDD VDD _0062_ sky130_fd_sc_hd__nor2_1
Xinput19 req_a[25] VSS VSS VDD VDD net19 sky130_fd_sc_hd__clkdlybuf4s50_1
X_3415_ net23 _1008_ VSS VSS VDD VDD _0059_ sky130_fd_sc_hd__nor2_1
X_3416_ _1303_ _1304_ VSS VSS VDD VDD _1305_ sky130_fd_sc_hd__nand2_1
Xinput18 req_a[24] VSS VSS VDD VDD net18 sky130_fd_sc_hd__clkdlybuf4s50_1
X_3418_ net25 _1008_ VSS VSS VDD VDD _0057_ sky130_fd_sc_hd__nor2_1
Xinput17 req_a[23] VSS VSS VDD VDD net17 sky130_fd_sc_hd__clkdlybuf4s50_1
X_3420_ net26 _1008_ VSS VSS VDD VDD _0055_ sky130_fd_sc_hd__nor2_1
Xinput16 req_a[22] VSS VSS VDD VDD net16 sky130_fd_sc_hd__clkdlybuf4s50_1
X_3422_ net18 net57 VSS VSS VDD VDD _1017_ sky130_fd_sc_hd__nand2_1
X_3423_ _1017_ VSS VSS VDD VDD _0271_ sky130_fd_sc_hd__inv_1
X_3424_ net19 net57 VSS VSS VDD VDD _1018_ sky130_fd_sc_hd__nand2_1
X_3425_ _1018_ VSS VSS VDD VDD _0073_ sky130_fd_sc_hd__inv_1
X_3426_ net20 net57 VSS VSS VDD VDD _1019_ sky130_fd_sc_hd__nand2_1
X_3427_ _0115_ _0029_ VSS VSS VDD VDD _1306_ sky130_fd_sc_hd__nand2_1
X_3428_ _1019_ VSS VSS VDD VDD _0070_ sky130_fd_sc_hd__inv_1
X_3429_ net21 net57 VSS VSS VDD VDD _1020_ sky130_fd_sc_hd__nand2_1
X_3430_ _1020_ VSS VSS VDD VDD _0067_ sky130_fd_sc_hd__inv_1
X_3431_ net22 net57 VSS VSS VDD VDD _1021_ sky130_fd_sc_hd__nand2_1
X_3432_ _1021_ VSS VSS VDD VDD _0064_ sky130_fd_sc_hd__inv_1
X_3433_ net23 net57 VSS VSS VDD VDD _1022_ sky130_fd_sc_hd__nand2_1
X_3434_ _1022_ VSS VSS VDD VDD _0061_ sky130_fd_sc_hd__inv_1
X_3435_ net25 net57 VSS VSS VDD VDD _1023_ sky130_fd_sc_hd__nand2_1
X_3436_ _1023_ VSS VSS VDD VDD _0058_ sky130_fd_sc_hd__inv_1
X_3437_ net26 net57 VSS VSS VDD VDD _1024_ sky130_fd_sc_hd__nand2_1
X_3438_ _1305_ _1306_ VSS VSS VDD VDD _1307_ sky130_fd_sc_hd__nand2_1
X_3439_ _1024_ VSS VSS VDD VDD _0054_ sky130_fd_sc_hd__inv_1
Xinput15 req_a[21] VSS VSS VDD VDD net15 sky130_fd_sc_hd__clkdlybuf4s50_1
X_3441_ net18 net55 VSS VSS VDD VDD _1026_ sky130_fd_sc_hd__nand2_1
X_3442_ _1026_ VSS VSS VDD VDD _0267_ sky130_fd_sc_hd__inv_1
X_3443_ net19 net55 VSS VSS VDD VDD _1027_ sky130_fd_sc_hd__nand2_1
X_3444_ _1027_ VSS VSS VDD VDD _0270_ sky130_fd_sc_hd__inv_1
X_3445_ net20 net55 VSS VSS VDD VDD _1028_ sky130_fd_sc_hd__nand2_1
X_3446_ _1028_ VSS VSS VDD VDD _0072_ sky130_fd_sc_hd__inv_1
X_3447_ net21 net55 VSS VSS VDD VDD _1029_ sky130_fd_sc_hd__nand2_1
X_3448_ _1029_ VSS VSS VDD VDD _0069_ sky130_fd_sc_hd__inv_1
X_3449_ _1307_ _0035_ VSS VSS VDD VDD _1308_ sky130_fd_sc_hd__nand2_1
X_3450_ net22 net55 VSS VSS VDD VDD _1030_ sky130_fd_sc_hd__nand2_1
X_3451_ _1030_ VSS VSS VDD VDD _0066_ sky130_fd_sc_hd__inv_1
X_3452_ net23 net55 VSS VSS VDD VDD _1031_ sky130_fd_sc_hd__nand2_1
X_3453_ _1031_ VSS VSS VDD VDD _0063_ sky130_fd_sc_hd__inv_1
X_3454_ net25 net55 VSS VSS VDD VDD _1032_ sky130_fd_sc_hd__nand2_1
X_3455_ _1032_ VSS VSS VDD VDD _0060_ sky130_fd_sc_hd__inv_1
X_3456_ net26 net55 VSS VSS VDD VDD _1033_ sky130_fd_sc_hd__nand2_1
X_3457_ _1033_ VSS VSS VDD VDD _0053_ sky130_fd_sc_hd__inv_1
Xinput14 req_a[20] VSS VSS VDD VDD net14 sky130_fd_sc_hd__clkdlybuf4s50_1
X_3459_ net18 net54 VSS VSS VDD VDD _1035_ sky130_fd_sc_hd__nand2_1
X_3460_ _1519_ _1520_ _1521_ VSS VSS VDD VDD _1522_ _1523_
+ sky130_fd_sc_hd__fa_1
X_3461_ _1524_ _1525_ _1526_ VSS VSS VDD VDD _0000_ _0001_
+ sky130_fd_sc_hd__fa_1
X_3462_ _1524_ _1525_ _1527_ VSS VSS VDD VDD _1528_ _1529_
+ sky130_fd_sc_hd__fa_1
X_3463_ _1524_ _1525_ _1530_ VSS VSS VDD VDD _1531_ _1532_
+ sky130_fd_sc_hd__fa_1
X_3464_ _1524_ _1525_ _1533_ VSS VSS VDD VDD _1534_ _1535_
+ sky130_fd_sc_hd__fa_1
X_3465_ _1524_ _1536_ _1537_ VSS VSS VDD VDD _1538_ _1539_
+ sky130_fd_sc_hd__fa_1
X_3466_ _1540_ _1541_ _1542_ VSS VSS VDD VDD _1543_ _1544_
+ sky130_fd_sc_hd__fa_1
X_3467_ _1545_ _1546_ _1547_ VSS VSS VDD VDD _1519_ _1548_
+ sky130_fd_sc_hd__fa_1
X_3468_ _1549_ _1550_ _1551_ VSS VSS VDD VDD _1552_ _1553_
+ sky130_fd_sc_hd__fa_1
X_3469_ _1554_ _1555_ _1556_ VSS VSS VDD VDD _1557_ _1558_
+ sky130_fd_sc_hd__fa_1
X_3470_ product\[63\] _1559_ _1560_ VSS VSS VDD VDD _1561_
+ _1562_ sky130_fd_sc_hd__fa_1
X_3471_ product\[53\] _1563_ _1564_ VSS VSS VDD VDD _1565_
+ _1566_ sky130_fd_sc_hd__fa_1
X_3472_ _0002_ _0003_ _0004_ VSS VSS VDD VDD _1526_ _0005_
+ sky130_fd_sc_hd__fa_1
X_3473_ _0002_ _0003_ _0006_ VSS VSS VDD VDD _1527_ _1567_
+ sky130_fd_sc_hd__fa_1
X_3474_ _0002_ _0007_ _0008_ VSS VSS VDD VDD _1530_ _1568_
+ sky130_fd_sc_hd__fa_1
X_3475_ _0009_ _0010_ _0011_ VSS VSS VDD VDD _1533_ _1569_
+ sky130_fd_sc_hd__fa_1
X_3476_ _0012_ _0013_ _0014_ VSS VSS VDD VDD _1537_ _1570_
+ sky130_fd_sc_hd__fa_1
X_3477_ _0015_ _0016_ _0017_ VSS VSS VDD VDD _1542_ _1571_
+ sky130_fd_sc_hd__fa_1
X_3478_ _0018_ _0019_ _0020_ VSS VSS VDD VDD _1547_ _1572_
+ sky130_fd_sc_hd__fa_1
X_3479_ _0021_ _0022_ _0023_ VSS VSS VDD VDD _1551_ _1573_
+ sky130_fd_sc_hd__fa_1
X_3480_ product\[52\] _1574_ _1575_ VSS VSS VDD VDD _1576_
+ _1577_ sky130_fd_sc_hd__fa_1
X_3481_ net40 _0024_ _0025_ VSS VSS VDD VDD _1536_ _1540_
+ sky130_fd_sc_hd__fa_1
X_3482_ _1531_ _1578_ _1579_ VSS VSS VDD VDD _1580_ _1581_
+ sky130_fd_sc_hd__fa_1
X_3483_ _1534_ _1582_ _1583_ VSS VSS VDD VDD _1584_ _1585_
+ sky130_fd_sc_hd__fa_1
X_3484_ product\[9\] product\[25\] product\[41\] VSS VSS VDD
+ VDD _1586_ _1587_ sky130_fd_sc_hd__fa_1
X_3485_ product\[0\] product\[16\] product\[32\] VSS VSS VDD
+ VDD _1588_ _1589_ sky130_fd_sc_hd__fa_1
X_3486_ _0026_ _0027_ _0028_ VSS VSS VDD VDD _1590_ _0029_
+ sky130_fd_sc_hd__fa_1
X_3487_ _1591_ _1592_ _0030_ VSS VSS VDD VDD _0031_ _0032_
+ sky130_fd_sc_hd__fa_1
X_3488_ _0005_ _0033_ _1593_ VSS VSS VDD VDD _0034_ _1594_
+ sky130_fd_sc_hd__fa_1
X_3489_ _0005_ _1595_ _1596_ VSS VSS VDD VDD _1597_ _1598_
+ sky130_fd_sc_hd__fa_1
X_3490_ _0005_ _1599_ _1600_ VSS VSS VDD VDD _1601_ _1602_
+ sky130_fd_sc_hd__fa_1
X_3491_ _0005_ _1603_ _1604_ VSS VSS VDD VDD _1605_ _1606_
+ sky130_fd_sc_hd__fa_1
X_3492_ _0035_ _1607_ _1608_ VSS VSS VDD VDD _0036_ _1609_
+ sky130_fd_sc_hd__fa_1
X_3493_ _0035_ _1610_ _1611_ VSS VSS VDD VDD _1612_ _1613_
+ sky130_fd_sc_hd__fa_1
X_3494_ _1567_ _1614_ _1615_ VSS VSS VDD VDD _1616_ _1617_
+ sky130_fd_sc_hd__fa_1
X_3495_ _1568_ _1618_ _1619_ VSS VSS VDD VDD _1620_ _1621_
+ sky130_fd_sc_hd__fa_1
X_3496_ _1622_ _1623_ _1624_ VSS VSS VDD VDD _1625_ _1626_
+ sky130_fd_sc_hd__fa_1
X_3497_ _1627_ _1628_ _1629_ VSS VSS VDD VDD _1630_ _1631_
+ sky130_fd_sc_hd__fa_1
X_3498_ _1632_ _1633_ _1634_ VSS VSS VDD VDD _1635_ _1636_
+ sky130_fd_sc_hd__fa_1
X_3499_ _1637_ _1638_ _1639_ VSS VSS VDD VDD _1640_ _1641_
+ sky130_fd_sc_hd__fa_1
X_3500_ _1642_ _1643_ _1644_ VSS VSS VDD VDD _1645_ _1646_
+ sky130_fd_sc_hd__fa_1
X_3501_ _1647_ _1648_ _1649_ VSS VSS VDD VDD _1650_ _1651_
+ sky130_fd_sc_hd__fa_1
X_3502_ _1569_ _1652_ _1653_ VSS VSS VDD VDD _1654_ _1655_
+ sky130_fd_sc_hd__fa_1
X_3503_ _1570_ _1656_ _1657_ VSS VSS VDD VDD _1658_ _1659_
+ sky130_fd_sc_hd__fa_1
X_3504_ _1660_ _1661_ _1662_ VSS VSS VDD VDD _1663_ _1664_
+ sky130_fd_sc_hd__fa_1
X_3505_ _1665_ _1666_ _1667_ VSS VSS VDD VDD _1668_ _1669_
+ sky130_fd_sc_hd__fa_1
X_3506_ _1670_ _1671_ _1672_ VSS VSS VDD VDD _1673_ _1674_
+ sky130_fd_sc_hd__fa_1
X_3507_ _1675_ _1676_ _1677_ VSS VSS VDD VDD _1678_ _0037_
+ sky130_fd_sc_hd__fa_1
X_3508_ _1539_ _1655_ _1658_ VSS VSS VDD VDD _1679_ _1680_
+ sky130_fd_sc_hd__fa_1
X_3509_ _0038_ _1681_ _1682_ VSS VSS VDD VDD _1608_ _1610_
+ sky130_fd_sc_hd__fa_1
X_3510_ product\[6\] product\[22\] product\[38\] VSS VSS VDD
+ VDD _1683_ _1684_ sky130_fd_sc_hd__fa_1
X_3511_ product\[13\] product\[29\] product\[45\] VSS VSS
+ VDD VDD _1685_ _1686_ sky130_fd_sc_hd__fa_1
X_3512_ product\[5\] product\[21\] product\[37\] VSS VSS VDD
+ VDD _1687_ _1563_ sky130_fd_sc_hd__fa_1
X_3513_ _1688_ _1689_ _0039_ VSS VSS VDD VDD _0040_ _0041_
+ sky130_fd_sc_hd__fa_1
X_3514_ _1669_ _1673_ _0042_ VSS VSS VDD VDD _0043_ _0044_
+ sky130_fd_sc_hd__fa_1
X_3515_ _0045_ _1690_ _1691_ VSS VSS VDD VDD _0046_ _1692_
+ sky130_fd_sc_hd__fa_1
X_3516_ _0045_ _1693_ _1694_ VSS VSS VDD VDD _1695_ _1696_
+ sky130_fd_sc_hd__fa_1
X_3517_ _1697_ _1698_ _1699_ VSS VSS VDD VDD _1700_ _1701_
+ sky130_fd_sc_hd__fa_1
X_3518_ _1702_ _1703_ _1704_ VSS VSS VDD VDD _1705_ _1706_
+ sky130_fd_sc_hd__fa_1
X_3519_ _1707_ _1708_ _1709_ VSS VSS VDD VDD _1710_ _1711_
+ sky130_fd_sc_hd__fa_1
X_3520_ _1712_ _1713_ _1714_ VSS VSS VDD VDD _1715_ _1716_
+ sky130_fd_sc_hd__fa_1
X_3521_ _1717_ _1718_ _1719_ VSS VSS VDD VDD _1720_ _1721_
+ sky130_fd_sc_hd__fa_1
X_3522_ _1722_ _1723_ _1724_ VSS VSS VDD VDD _1725_ _1726_
+ sky130_fd_sc_hd__fa_1
X_3523_ _1727_ _1728_ _1729_ VSS VSS VDD VDD _1730_ _1731_
+ sky130_fd_sc_hd__fa_1
X_3524_ _1732_ _1733_ _1734_ VSS VSS VDD VDD _1735_ _1688_
+ sky130_fd_sc_hd__fa_1
X_3525_ _1736_ _1737_ _1738_ VSS VSS VDD VDD _1689_ _1739_
+ sky130_fd_sc_hd__fa_1
X_3526_ _1740_ _1741_ _1742_ VSS VSS VDD VDD _1743_ _0047_
+ sky130_fd_sc_hd__fa_1
X_3527_ _1744_ _1745_ _1746_ VSS VSS VDD VDD _1642_ _1747_
+ sky130_fd_sc_hd__fa_1
X_3528_ _0048_ _1748_ _1749_ VSS VSS VDD VDD _0049_ _1690_
+ sky130_fd_sc_hd__fa_1
X_3529_ _0048_ _1750_ _1751_ VSS VSS VDD VDD _1691_ _1693_
+ sky130_fd_sc_hd__fa_1
X_3530_ _0048_ _1752_ _1753_ VSS VSS VDD VDD _1694_ _1698_
+ sky130_fd_sc_hd__fa_1
X_3531_ _1754_ _1755_ _1756_ VSS VSS VDD VDD _1699_ _1703_
+ sky130_fd_sc_hd__fa_1
X_3532_ _1757_ _1758_ _1759_ VSS VSS VDD VDD _1704_ _1708_
+ sky130_fd_sc_hd__fa_1
X_3533_ _1760_ _1761_ _1762_ VSS VSS VDD VDD _1709_ _1713_
+ sky130_fd_sc_hd__fa_1
X_3534_ _1763_ _1764_ _1765_ VSS VSS VDD VDD _1714_ _1718_
+ sky130_fd_sc_hd__fa_1
X_3535_ _1766_ _1767_ _1768_ VSS VSS VDD VDD _1719_ _1723_
+ sky130_fd_sc_hd__fa_1
X_3536_ _1769_ _1770_ _1771_ VSS VSS VDD VDD _1724_ _1728_
+ sky130_fd_sc_hd__fa_1
X_3537_ _0050_ _0051_ _1772_ VSS VSS VDD VDD _0052_ _1748_
+ sky130_fd_sc_hd__fa_1
X_3538_ _0050_ _1773_ _1774_ VSS VSS VDD VDD _1749_ _1750_
+ sky130_fd_sc_hd__fa_1
X_3539_ _0050_ _1775_ _1776_ VSS VSS VDD VDD _1751_ _1752_
+ sky130_fd_sc_hd__fa_1
X_3540_ _0050_ _1777_ _1778_ VSS VSS VDD VDD _1753_ _1755_
+ sky130_fd_sc_hd__fa_1
X_3541_ _1779_ _1780_ _1781_ VSS VSS VDD VDD _1756_ _1758_
+ sky130_fd_sc_hd__fa_1
X_3542_ _1782_ _1783_ _1784_ VSS VSS VDD VDD _1759_ _1761_
+ sky130_fd_sc_hd__fa_1
X_3543_ _1785_ _1786_ _1787_ VSS VSS VDD VDD _1762_ _1764_
+ sky130_fd_sc_hd__fa_1
X_3544_ _1788_ _1789_ _1790_ VSS VSS VDD VDD _1765_ _1767_
+ sky130_fd_sc_hd__fa_1
X_3545_ _1791_ _1792_ _1793_ VSS VSS VDD VDD _1647_ _1794_
+ sky130_fd_sc_hd__fa_1
X_3546_ _0053_ _0054_ _0055_ VSS VSS VDD VDD _0056_ _0051_
+ sky130_fd_sc_hd__fa_1
X_3547_ _0053_ _0054_ _0057_ VSS VSS VDD VDD _1772_ _1773_
+ sky130_fd_sc_hd__fa_1
X_3548_ _0053_ _0058_ _0059_ VSS VSS VDD VDD _1774_ _1775_
+ sky130_fd_sc_hd__fa_1
X_3549_ _0060_ _0061_ _0062_ VSS VSS VDD VDD _1776_ _1777_
+ sky130_fd_sc_hd__fa_1
X_3550_ _0063_ _0064_ _0065_ VSS VSS VDD VDD _1778_ _1780_
+ sky130_fd_sc_hd__fa_1
X_3551_ _0066_ _0067_ _0068_ VSS VSS VDD VDD _1781_ _1783_
+ sky130_fd_sc_hd__fa_1
X_3552_ _0069_ _0070_ _0071_ VSS VSS VDD VDD _1784_ _1786_
+ sky130_fd_sc_hd__fa_1
X_3553_ _0072_ _0073_ _0074_ VSS VSS VDD VDD _1787_ _1789_
+ sky130_fd_sc_hd__fa_1
X_3554_ _0038_ _1795_ _1796_ VSS VSS VDD VDD _0075_ _1607_
+ sky130_fd_sc_hd__fa_1
X_3555_ _1552_ _1797_ _1798_ VSS VSS VDD VDD _1799_ _1800_
+ sky130_fd_sc_hd__fa_1
X_3556_ _1557_ _1801_ _1802_ VSS VSS VDD VDD _1803_ _1804_
+ sky130_fd_sc_hd__fa_1
X_3557_ _1805_ _1806_ _1807_ VSS VSS VDD VDD _1808_ _1809_
+ sky130_fd_sc_hd__fa_1
X_3558_ _1810_ _1811_ _1812_ VSS VSS VDD VDD _1813_ _0076_
+ sky130_fd_sc_hd__fa_1
X_3559_ _1814_ _1815_ _1816_ VSS VSS VDD VDD _0045_ _0048_
+ sky130_fd_sc_hd__fa_1
X_3560_ _1814_ _1815_ _1817_ VSS VSS VDD VDD _1697_ _1754_
+ sky130_fd_sc_hd__fa_1
X_3561_ _1814_ _1815_ _1818_ VSS VSS VDD VDD _1702_ _1757_
+ sky130_fd_sc_hd__fa_1
X_3562_ _1814_ _1815_ _1819_ VSS VSS VDD VDD _1707_ _1760_
+ sky130_fd_sc_hd__fa_1
X_3563_ _1814_ _1820_ _1821_ VSS VSS VDD VDD _1712_ _1763_
+ sky130_fd_sc_hd__fa_1
X_3564_ _1822_ _1823_ _1824_ VSS VSS VDD VDD _1717_ _1766_
+ sky130_fd_sc_hd__fa_1
X_3565_ _1825_ _1826_ _1827_ VSS VSS VDD VDD _1722_ _1769_
+ sky130_fd_sc_hd__fa_1
X_3566_ _1828_ _1829_ _1830_ VSS VSS VDD VDD _1727_ _1831_
+ sky130_fd_sc_hd__fa_1
X_3567_ _1832_ _1833_ _1834_ VSS VSS VDD VDD _1732_ _1835_
+ sky130_fd_sc_hd__fa_1
X_3568_ _0077_ _0078_ _0079_ VSS VSS VDD VDD _1816_ _0050_
+ sky130_fd_sc_hd__fa_1
X_3569_ _0077_ _0078_ _0080_ VSS VSS VDD VDD _1817_ _1779_
+ sky130_fd_sc_hd__fa_1
X_3570_ _0077_ _0081_ _0082_ VSS VSS VDD VDD _1818_ _1782_
+ sky130_fd_sc_hd__fa_1
X_3571_ _0083_ _0084_ _0085_ VSS VSS VDD VDD _1819_ _1785_
+ sky130_fd_sc_hd__fa_1
X_3572_ _0086_ _0087_ _0088_ VSS VSS VDD VDD _1821_ _1788_
+ sky130_fd_sc_hd__fa_1
X_3573_ _0089_ _0090_ _0091_ VSS VSS VDD VDD _1824_ _1836_
+ sky130_fd_sc_hd__fa_1
X_3574_ _0092_ _0093_ _0094_ VSS VSS VDD VDD _1827_ _1837_
+ sky130_fd_sc_hd__fa_1
X_3575_ _0095_ _0096_ _0097_ VSS VSS VDD VDD _1830_ _1838_
+ sky130_fd_sc_hd__fa_1
X_3576_ _1544_ _1659_ _1839_ VSS VSS VDD VDD _1840_ _1520_
+ sky130_fd_sc_hd__fa_1
X_3577_ product\[15\] product\[31\] product\[47\] VSS VSS
+ VDD VDD _1841_ _1559_ sky130_fd_sc_hd__fa_1
X_3578_ product\[11\] product\[27\] product\[43\] VSS VSS
+ VDD VDD _1842_ _1843_ sky130_fd_sc_hd__fa_1
X_3579_ product\[2\] product\[18\] product\[34\] VSS VSS VDD
+ VDD _1844_ _1845_ sky130_fd_sc_hd__fa_1
X_3580_ product\[12\] product\[28\] product\[44\] VSS VSS
+ VDD VDD _1846_ _1847_ sky130_fd_sc_hd__fa_1
X_3581_ product\[3\] product\[19\] product\[35\] VSS VSS VDD
+ VDD _1575_ _1848_ sky130_fd_sc_hd__fa_1
X_3582_ net58 _0098_ _0099_ VSS VSS VDD VDD _1820_ _1822_
+ sky130_fd_sc_hd__fa_1
X_3583_ product\[14\] product\[30\] product\[46\] VSS VSS
+ VDD VDD _1560_ _1849_ sky130_fd_sc_hd__fa_1
X_3584_ product\[10\] product\[26\] product\[42\] VSS VSS
+ VDD VDD _1850_ _1851_ sky130_fd_sc_hd__fa_1
X_3585_ product\[1\] product\[17\] product\[33\] VSS VSS VDD
+ VDD _1852_ _1853_ sky130_fd_sc_hd__fa_1
X_3586_ _0029_ _1854_ _1855_ VSS VSS VDD VDD _1682_ _1856_
+ sky130_fd_sc_hd__fa_1
X_3587_ _1538_ _1857_ _1679_ VSS VSS VDD VDD _1858_ _1859_
+ sky130_fd_sc_hd__fa_1
X_3588_ _1543_ _1680_ _1840_ VSS VSS VDD VDD _1860_ _1861_
+ sky130_fd_sc_hd__fa_1
X_3589_ _1791_ _1792_ _1590_ VSS VSS VDD VDD _0035_ _0038_
+ sky130_fd_sc_hd__fa_1
X_3590_ _1794_ _1862_ _1863_ VSS VSS VDD VDD _1649_ _1633_
+ sky130_fd_sc_hd__fa_1
X_3591_ _0029_ _1864_ _1865_ VSS VSS VDD VDD _1796_ _1681_
+ sky130_fd_sc_hd__fa_1
X_3592_ product\[58\] _1851_ _1586_ VSS VSS VDD VDD _1866_
+ _1867_ sky130_fd_sc_hd__fa_1
X_3593_ _1791_ _1792_ _1868_ VSS VSS VDD VDD _1622_ _1869_
+ sky130_fd_sc_hd__fa_1
X_3594_ _1870_ _1871_ _1872_ VSS VSS VDD VDD _1660_ _1873_
+ sky130_fd_sc_hd__fa_1
X_3595_ _1874_ _1875_ _1876_ VSS VSS VDD VDD _1665_ _1877_
+ sky130_fd_sc_hd__fa_1
X_3596_ _1878_ _1879_ _0100_ VSS VSS VDD VDD _0101_ _0102_
+ sky130_fd_sc_hd__fa_1
X_3597_ _0103_ _1880_ _1881_ VSS VSS VDD VDD _0104_ _1882_
+ sky130_fd_sc_hd__fa_1
X_3598_ _0103_ _1883_ _1884_ VSS VSS VDD VDD _1885_ _1886_
+ sky130_fd_sc_hd__fa_1
X_3599_ _1887_ _1888_ _1889_ VSS VSS VDD VDD _1890_ _1891_
+ sky130_fd_sc_hd__fa_1
X_3600_ _1892_ _1893_ _1894_ VSS VSS VDD VDD _1895_ _1896_
+ sky130_fd_sc_hd__fa_1
X_3601_ _1897_ _1898_ _1899_ VSS VSS VDD VDD _1900_ _1901_
+ sky130_fd_sc_hd__fa_1
X_3602_ _1902_ _1903_ _1904_ VSS VSS VDD VDD _1905_ _1906_
+ sky130_fd_sc_hd__fa_1
X_3603_ _1907_ _1908_ _1909_ VSS VSS VDD VDD _1910_ _1911_
+ sky130_fd_sc_hd__fa_1
X_3604_ _1912_ _1913_ _1914_ VSS VSS VDD VDD _1915_ _1916_
+ sky130_fd_sc_hd__fa_1
X_3605_ _1917_ _1918_ _1919_ VSS VSS VDD VDD _1920_ _1921_
+ sky130_fd_sc_hd__fa_1
X_3606_ _1922_ _1923_ _1924_ VSS VSS VDD VDD _1925_ _1878_
+ sky130_fd_sc_hd__fa_1
X_3607_ _1926_ _1927_ _1928_ VSS VSS VDD VDD _1879_ _1929_
+ sky130_fd_sc_hd__fa_1
X_3608_ _1930_ _1931_ _1932_ VSS VSS VDD VDD _1933_ _0105_
+ sky130_fd_sc_hd__fa_1
X_3609_ _1791_ _1792_ _1934_ VSS VSS VDD VDD _1627_ _1935_
+ sky130_fd_sc_hd__fa_1
X_3610_ _0001_ _1602_ _1605_ VSS VSS VDD VDD _1936_ _1937_
+ sky130_fd_sc_hd__fa_1
X_3611_ _0106_ _0107_ _0108_ VSS VSS VDD VDD _1938_ _1939_
+ sky130_fd_sc_hd__fa_1
X_3612_ _0109_ _0110_ _0111_ VSS VSS VDD VDD _1940_ _1941_
+ sky130_fd_sc_hd__fa_1
X_3613_ _0112_ _1942_ _1943_ VSS VSS VDD VDD _0113_ _1880_
+ sky130_fd_sc_hd__fa_1
X_3614_ _0112_ _1944_ _1945_ VSS VSS VDD VDD _1881_ _1883_
+ sky130_fd_sc_hd__fa_1
X_3615_ _0112_ _1946_ _1947_ VSS VSS VDD VDD _1884_ _1888_
+ sky130_fd_sc_hd__fa_1
X_3616_ _1948_ _1949_ _1950_ VSS VSS VDD VDD _1889_ _1893_
+ sky130_fd_sc_hd__fa_1
X_3617_ _1951_ _1952_ _1953_ VSS VSS VDD VDD _1894_ _1898_
+ sky130_fd_sc_hd__fa_1
X_3618_ _1954_ _1955_ _1956_ VSS VSS VDD VDD _1899_ _1903_
+ sky130_fd_sc_hd__fa_1
X_3619_ _1957_ _1958_ _1959_ VSS VSS VDD VDD _1904_ _1908_
+ sky130_fd_sc_hd__fa_1
X_3620_ _1960_ _1961_ _1962_ VSS VSS VDD VDD _1909_ _1913_
+ sky130_fd_sc_hd__fa_1
X_3621_ _1963_ _1964_ _1965_ VSS VSS VDD VDD _1914_ _1918_
+ sky130_fd_sc_hd__fa_1
X_3622_ _0029_ _0114_ _1966_ VSS VSS VDD VDD _0115_ _1795_
+ sky130_fd_sc_hd__fa_1
X_3623_ _0116_ _0117_ _0118_ VSS VSS VDD VDD _1865_ _1854_
+ sky130_fd_sc_hd__fa_1
X_3624_ _0119_ _0120_ _1967_ VSS VSS VDD VDD _0121_ _1942_
+ sky130_fd_sc_hd__fa_1
X_3625_ _0119_ _1968_ _1969_ VSS VSS VDD VDD _1943_ _1944_
+ sky130_fd_sc_hd__fa_1
X_3626_ _0119_ _1970_ _1971_ VSS VSS VDD VDD _1945_ _1946_
+ sky130_fd_sc_hd__fa_1
X_3627_ _0119_ _1972_ _1973_ VSS VSS VDD VDD _1947_ _1949_
+ sky130_fd_sc_hd__fa_1
X_3628_ _1974_ _1975_ _1976_ VSS VSS VDD VDD _1950_ _1952_
+ sky130_fd_sc_hd__fa_1
X_3629_ _1977_ _1978_ _1979_ VSS VSS VDD VDD _1953_ _1955_
+ sky130_fd_sc_hd__fa_1
X_3630_ _1980_ _1981_ _1982_ VSS VSS VDD VDD _1956_ _1958_
+ sky130_fd_sc_hd__fa_1
X_3631_ _1983_ _1984_ _1985_ VSS VSS VDD VDD _1959_ _1961_
+ sky130_fd_sc_hd__fa_1
X_3632_ _1986_ _1939_ _1987_ VSS VSS VDD VDD _1988_ _1862_
+ sky130_fd_sc_hd__fa_1
X_3633_ _0122_ _0123_ _0124_ VSS VSS VDD VDD _1855_ _1989_
+ sky130_fd_sc_hd__fa_1
X_3634_ product\[56\] _1990_ _1991_ VSS VSS VDD VDD _1992_
+ _1993_ sky130_fd_sc_hd__fa_1
X_3635_ _0125_ _0126_ _0127_ VSS VSS VDD VDD _0128_ _0120_
+ sky130_fd_sc_hd__fa_1
X_3636_ _0125_ _0126_ _0129_ VSS VSS VDD VDD _1967_ _1968_
+ sky130_fd_sc_hd__fa_1
X_3637_ _0125_ _0130_ _0131_ VSS VSS VDD VDD _1969_ _1970_
+ sky130_fd_sc_hd__fa_1
X_3638_ _0132_ _0133_ _0134_ VSS VSS VDD VDD _1971_ _1972_
+ sky130_fd_sc_hd__fa_1
X_3639_ _0135_ _0136_ _0137_ VSS VSS VDD VDD _1973_ _1975_
+ sky130_fd_sc_hd__fa_1
X_3640_ _0138_ _0139_ _0140_ VSS VSS VDD VDD _1976_ _1978_
+ sky130_fd_sc_hd__fa_1
X_3641_ _0141_ _0142_ _0143_ VSS VSS VDD VDD _1979_ _1981_
+ sky130_fd_sc_hd__fa_1
X_3642_ _0144_ _0145_ _0146_ VSS VSS VDD VDD _1982_ _1984_
+ sky130_fd_sc_hd__fa_1
X_3643_ _1994_ _1995_ _1996_ VSS VSS VDD VDD _1863_ _1997_
+ sky130_fd_sc_hd__fa_1
X_3644_ product\[57\] _1587_ _1998_ VSS VSS VDD VDD _1999_
+ _2000_ sky130_fd_sc_hd__fa_1
X_3645_ product\[55\] _2001_ _1683_ VSS VSS VDD VDD _2002_
+ _2003_ sky130_fd_sc_hd__fa_1
X_3646_ _2004_ _2005_ _2006_ VSS VSS VDD VDD _1637_ _2007_
+ sky130_fd_sc_hd__fa_1
X_3647_ _2008_ _2009_ _2010_ VSS VSS VDD VDD _0103_ _0112_
+ sky130_fd_sc_hd__fa_1
X_3648_ _2008_ _2009_ _2011_ VSS VSS VDD VDD _1887_ _1948_
+ sky130_fd_sc_hd__fa_1
X_3649_ _2008_ _2009_ _2012_ VSS VSS VDD VDD _1892_ _1951_
+ sky130_fd_sc_hd__fa_1
X_3650_ _2008_ _2009_ _2013_ VSS VSS VDD VDD _1897_ _1954_
+ sky130_fd_sc_hd__fa_1
X_3651_ _2008_ _2014_ _2015_ VSS VSS VDD VDD _1902_ _1957_
+ sky130_fd_sc_hd__fa_1
X_3652_ _2016_ _2017_ _2018_ VSS VSS VDD VDD _1907_ _1960_
+ sky130_fd_sc_hd__fa_1
X_3653_ _2019_ _2020_ _2021_ VSS VSS VDD VDD _1912_ _1963_
+ sky130_fd_sc_hd__fa_1
X_3654_ _2022_ _2023_ _2024_ VSS VSS VDD VDD _1917_ _2025_
+ sky130_fd_sc_hd__fa_1
X_3655_ _2026_ _2027_ _2028_ VSS VSS VDD VDD _1922_ _2029_
+ sky130_fd_sc_hd__fa_1
X_3656_ _0147_ _0148_ _0149_ VSS VSS VDD VDD _1987_ _1995_
+ sky130_fd_sc_hd__fa_1
X_3657_ _0150_ _0151_ _0152_ VSS VSS VDD VDD _1996_ _2030_
+ sky130_fd_sc_hd__fa_1
X_3658_ product\[54\] _1684_ _1687_ VSS VSS VDD VDD _2031_
+ _2032_ sky130_fd_sc_hd__fa_1
X_3659_ _0153_ _0154_ _0155_ VSS VSS VDD VDD _2010_ _0119_
+ sky130_fd_sc_hd__fa_1
X_3660_ _1804_ _1808_ _0156_ VSS VSS VDD VDD _0157_ _0158_
+ sky130_fd_sc_hd__fa_1
X_3661_ _0153_ _0154_ _0159_ VSS VSS VDD VDD _2011_ _1974_
+ sky130_fd_sc_hd__fa_1
X_3662_ _0153_ _0160_ _0161_ VSS VSS VDD VDD _2012_ _1977_
+ sky130_fd_sc_hd__fa_1
X_3663_ _0162_ _0163_ _0164_ VSS VSS VDD VDD _2013_ _1980_
+ sky130_fd_sc_hd__fa_1
X_3664_ _0165_ _0166_ _0167_ VSS VSS VDD VDD _2015_ _1983_
+ sky130_fd_sc_hd__fa_1
X_3665_ _0168_ _0169_ _0170_ VSS VSS VDD VDD _2018_ _2033_
+ sky130_fd_sc_hd__fa_1
X_3666_ _0171_ _0172_ _0173_ VSS VSS VDD VDD _2021_ _2034_
+ sky130_fd_sc_hd__fa_1
X_3667_ _0174_ _0175_ _0176_ VSS VSS VDD VDD _2024_ _2035_
+ sky130_fd_sc_hd__fa_1
X_3668_ _0116_ _0177_ _0178_ VSS VSS VDD VDD _1966_ _1864_
+ sky130_fd_sc_hd__fa_1
X_3669_ product\[50\] _1845_ _1852_ VSS VSS VDD VDD _2036_
+ _1591_ sky130_fd_sc_hd__fa_1
X_3670_ _1869_ _2037_ _2038_ VSS VSS VDD VDD _1624_ _1628_
+ sky130_fd_sc_hd__fa_1
X_3671_ _0038_ _1856_ _2039_ VSS VSS VDD VDD _1611_ _1623_
+ sky130_fd_sc_hd__fa_1
X_3672_ net49 _0179_ _0180_ VSS VSS VDD VDD _2014_ _2016_
+ sky130_fd_sc_hd__fa_1
X_3673_ _1935_ _2040_ _1988_ VSS VSS VDD VDD _1629_ _1648_
+ sky130_fd_sc_hd__fa_1
X_3674_ _0001_ _1598_ _1601_ VSS VSS VDD VDD _2041_ _2042_
+ sky130_fd_sc_hd__fa_1
X_3675_ _0026_ _0027_ _0181_ VSS VSS VDD VDD _1868_ _2043_
+ sky130_fd_sc_hd__fa_1
X_3676_ _0026_ _0182_ _0183_ VSS VSS VDD VDD _1934_ _1986_
+ sky130_fd_sc_hd__fa_1
X_3677_ _0184_ _0185_ _0186_ VSS VSS VDD VDD _1793_ _1994_
+ sky130_fd_sc_hd__fa_1
X_3678_ _0187_ _0188_ _0189_ VSS VSS VDD VDD _2044_ _2045_
+ sky130_fd_sc_hd__fa_1
X_3679_ _0190_ _0191_ _0192_ VSS VSS VDD VDD _2006_ _2046_
+ sky130_fd_sc_hd__fa_1
X_3680_ _0193_ _0194_ _0195_ VSS VSS VDD VDD _1746_ _2047_
+ sky130_fd_sc_hd__fa_1
X_3681_ _0196_ _0197_ _0198_ VSS VSS VDD VDD _1872_ _2048_
+ sky130_fd_sc_hd__fa_1
X_3682_ product\[8\] product\[24\] product\[40\] VSS VSS VDD
+ VDD _1998_ _1990_ sky130_fd_sc_hd__fa_1
X_3683_ product\[7\] product\[23\] product\[39\] VSS VSS VDD
+ VDD _1991_ _2001_ sky130_fd_sc_hd__fa_1
X_3684_ _2043_ _1941_ _1938_ VSS VSS VDD VDD _2038_ _2040_
+ sky130_fd_sc_hd__fa_1
X_3685_ _1532_ _1617_ _1620_ VSS VSS VDD VDD _1579_ _1582_
+ sky130_fd_sc_hd__fa_1
X_3686_ _1548_ _2049_ _2050_ VSS VSS VDD VDD _1521_ _1797_
+ sky130_fd_sc_hd__fa_1
X_3687_ _0199_ _0200_ _0201_ VSS VSS VDD VDD _0202_ _0033_
+ sky130_fd_sc_hd__fa_1
X_3688_ _0199_ _0200_ _0203_ VSS VSS VDD VDD _1593_ _1595_
+ sky130_fd_sc_hd__fa_1
X_3689_ _0199_ _0204_ _0205_ VSS VSS VDD VDD _1596_ _1599_
+ sky130_fd_sc_hd__fa_1
X_3690_ _0116_ _0177_ _0206_ VSS VSS VDD VDD _0207_ _0114_
+ sky130_fd_sc_hd__fa_1
X_3691_ _2051_ _1997_ _2052_ VSS VSS VDD VDD _1634_ _1638_
+ sky130_fd_sc_hd__fa_1
X_3692_ _1529_ _1606_ _1616_ VSS VSS VDD VDD _2053_ _1578_
+ sky130_fd_sc_hd__fa_1
X_3693_ product\[51\] _1848_ _1844_ VSS VSS VDD VDD _2054_
+ _2055_ sky130_fd_sc_hd__fa_1
X_3694_ net63 _0208_ _0209_ VSS VSS VDD VDD _2056_ _2004_
+ sky130_fd_sc_hd__fa_1
X_3695_ _2007_ _2057_ _2058_ VSS VSS VDD VDD _1639_ _1643_
+ sky130_fd_sc_hd__fa_1
X_3696_ product\[4\] product\[20\] product\[36\] VSS VSS VDD
+ VDD _1564_ _1574_ sky130_fd_sc_hd__fa_1
X_3697_ _1791_ _2056_ _2044_ VSS VSS VDD VDD _1632_ _2051_
+ sky130_fd_sc_hd__fa_1
X_3698_ _0029_ _1989_ _1940_ VSS VSS VDD VDD _2039_ _2037_
+ sky130_fd_sc_hd__fa_1
X_3699_ _0210_ _0211_ _0212_ VSS VSS VDD VDD _1604_ _1614_
+ sky130_fd_sc_hd__fa_1
X_3700_ _0213_ _0214_ _0215_ VSS VSS VDD VDD _1615_ _1618_
+ sky130_fd_sc_hd__fa_1
X_3701_ product\[62\] _1849_ _1685_ VSS VSS VDD VDD _2059_
+ _2060_ sky130_fd_sc_hd__fa_1
X_3702_ _0216_ _0217_ _0218_ VSS VSS VDD VDD _1619_ _1652_
+ sky130_fd_sc_hd__fa_1
X_3703_ _0219_ _0220_ _0221_ VSS VSS VDD VDD _1653_ _1656_
+ sky130_fd_sc_hd__fa_1
X_3704_ _1747_ _2061_ _2062_ VSS VSS VDD VDD _1644_ _1661_
+ sky130_fd_sc_hd__fa_1
X_3705_ _2045_ _2030_ _2063_ VSS VSS VDD VDD _2052_ _2057_
+ sky130_fd_sc_hd__fa_1
X_3706_ product\[63\] _1559_ _1841_ VSS VSS VDD VDD _2064_
+ _2065_ sky130_fd_sc_hd__fa_1
X_3707_ product\[49\] _1853_ _1588_ VSS VSS VDD VDD _1592_
+ _2066_ sky130_fd_sc_hd__fa_1
X_3708_ _0000_ _2067_ _2041_ VSS VSS VDD VDD _0222_ _2068_
+ sky130_fd_sc_hd__fa_1
X_3709_ product\[61\] _1686_ _1846_ VSS VSS VDD VDD _2069_
+ _2070_ sky130_fd_sc_hd__fa_1
X_3710_ _0000_ _2042_ _1936_ VSS VSS VDD VDD _2071_ _2072_
+ sky130_fd_sc_hd__fa_1
X_3711_ product\[60\] _1847_ _1842_ VSS VSS VDD VDD _2073_
+ _2074_ sky130_fd_sc_hd__fa_1
X_3712_ _1535_ _1621_ _1654_ VSS VSS VDD VDD _1583_ _1857_
+ sky130_fd_sc_hd__fa_1
X_3713_ product\[59\] _1843_ _1850_ VSS VSS VDD VDD _2075_
+ _2076_ sky130_fd_sc_hd__fa_1
X_3714_ _1528_ _1937_ _2053_ VSS VSS VDD VDD _2077_ _2078_
+ sky130_fd_sc_hd__fa_1
X_3715_ _0223_ _0224_ _0225_ VSS VSS VDD VDD _1600_ _1603_
+ sky130_fd_sc_hd__fa_1
X_3716_ _0001_ _1594_ _1597_ VSS VSS VDD VDD _0226_ _2067_
+ sky130_fd_sc_hd__fa_1
X_3717_ _2079_ _2080_ VSS VSS VDD VDD _1805_ _2081_ sky130_fd_sc_hd__ha_1
X_3718_ _2082_ _2083_ VSS VSS VDD VDD _1810_ _2084_ sky130_fd_sc_hd__ha_1
X_3719_ _2066_ _2085_ VSS VSS VDD VDD _0030_ _0227_ sky130_fd_sc_hd__ha_1
X_3720_ _2076_ _1866_ VSS VSS VDD VDD _0228_ _0229_ sky130_fd_sc_hd__ha_1
X_3721_ _0230_ _0231_ VSS VSS VDD VDD _1556_ _2086_ sky130_fd_sc_hd__ha_1
X_3722_ _1867_ _1999_ VSS VSS VDD VDD _0232_ _0233_ sky130_fd_sc_hd__ha_1
X_3723_ _1631_ _1650_ VSS VSS VDD VDD _0234_ _0235_ sky130_fd_sc_hd__ha_1
X_3724_ _0024_ _0236_ VSS VSS VDD VDD _1525_ _1524_ sky130_fd_sc_hd__ha_1
X_3725_ _0237_ _0238_ VSS VSS VDD VDD _1541_ _1545_ sky130_fd_sc_hd__ha_1
X_3726_ _0239_ _0240_ VSS VSS VDD VDD _1546_ _1549_ sky130_fd_sc_hd__ha_1
X_3727_ _0241_ _0242_ VSS VSS VDD VDD _1550_ _1554_ sky130_fd_sc_hd__ha_1
X_3728_ _0243_ _0244_ VSS VSS VDD VDD _1555_ _2079_ sky130_fd_sc_hd__ha_1
X_3729_ _0245_ _0246_ VSS VSS VDD VDD _2080_ _2082_ sky130_fd_sc_hd__ha_1
X_3730_ _0247_ _0248_ VSS VSS VDD VDD _2083_ _0249_ sky130_fd_sc_hd__ha_1
X_3731_ _1626_ _1630_ VSS VSS VDD VDD _0250_ _0251_ sky130_fd_sc_hd__ha_1
X_3732_ _2086_ _2081_ VSS VSS VDD VDD _1807_ _1811_ sky130_fd_sc_hd__ha_1
X_3733_ _2087_ _2088_ VSS VSS VDD VDD _1670_ _2089_ sky130_fd_sc_hd__ha_1
X_3734_ _1859_ _1860_ VSS VSS VDD VDD _0252_ _0253_ sky130_fd_sc_hd__ha_1
X_3735_ _1562_ _2059_ VSS VSS VDD VDD _0255_ _0256_ sky130_fd_sc_hd__ha_1
X_3736_ _1571_ _2090_ VSS VSS VDD VDD _1839_ _2049_ sky130_fd_sc_hd__ha_1
X_3737_ _1572_ _0257_ VSS VSS VDD VDD _2050_ _2091_ sky130_fd_sc_hd__ha_1
X_3738_ _2065_ _1561_ VSS VSS VDD VDD _0258_ _0259_ sky130_fd_sc_hd__ha_1
X_3739_ _1929_ _1933_ VSS VSS VDD VDD _0100_ _0261_ sky130_fd_sc_hd__ha_1
X_3740_ _1831_ _2092_ VSS VSS VDD VDD _1729_ _1733_ sky130_fd_sc_hd__ha_1
X_3741_ _1838_ _1835_ VSS VSS VDD VDD _1734_ _1737_ sky130_fd_sc_hd__ha_1
X_3742_ _2093_ _2094_ VSS VSS VDD VDD _1738_ _1741_ sky130_fd_sc_hd__ha_1
X_3743_ _0263_ _2095_ VSS VSS VDD VDD _1742_ _0264_ sky130_fd_sc_hd__ha_1
X_3744_ _1651_ _1635_ VSS VSS VDD VDD _0265_ _0266_ sky130_fd_sc_hd__ha_1
X_3745_ _1836_ _2096_ VSS VSS VDD VDD _1768_ _1770_ sky130_fd_sc_hd__ha_1
X_3746_ _1837_ _0267_ VSS VSS VDD VDD _1771_ _2092_ sky130_fd_sc_hd__ha_1
X_3747_ _1636_ _1640_ VSS VSS VDD VDD _0268_ _0269_ sky130_fd_sc_hd__ha_1
X_3748_ _0270_ _0271_ VSS VSS VDD VDD _1790_ _2096_ sky130_fd_sc_hd__ha_1
X_3749_ _2065_ _2064_ VSS VSS VDD VDD _0272_ _0273_ sky130_fd_sc_hd__ha_1
X_3750_ _2097_ _2098_ VSS VSS VDD VDD _1736_ _2094_ sky130_fd_sc_hd__ha_1
X_3751_ _2099_ _2100_ VSS VSS VDD VDD _1740_ _2095_ sky130_fd_sc_hd__ha_1
X_3752_ _1566_ _1576_ VSS VSS VDD VDD _0274_ _0275_ sky130_fd_sc_hd__ha_1
X_3753_ _0276_ _0277_ VSS VSS VDD VDD _1834_ _2093_ sky130_fd_sc_hd__ha_1
X_3754_ _0098_ _0278_ VSS VSS VDD VDD _1815_ _1814_ sky130_fd_sc_hd__ha_1
X_3755_ _0279_ _0280_ VSS VSS VDD VDD _1823_ _1825_ sky130_fd_sc_hd__ha_1
X_3756_ _0281_ _0282_ VSS VSS VDD VDD _1826_ _1828_ sky130_fd_sc_hd__ha_1
X_3757_ _0283_ _0284_ VSS VSS VDD VDD _1829_ _1832_ sky130_fd_sc_hd__ha_1
X_3758_ _0285_ _0286_ VSS VSS VDD VDD _1833_ _2097_ sky130_fd_sc_hd__ha_1
X_3759_ _0287_ _0288_ VSS VSS VDD VDD _2098_ _2099_ sky130_fd_sc_hd__ha_1
X_3760_ _0289_ _0290_ VSS VSS VDD VDD _2100_ _0291_ sky130_fd_sc_hd__ha_1
X_3761_ _1523_ _1799_ VSS VSS VDD VDD _0292_ _0293_ sky130_fd_sc_hd__ha_1
X_3762_ _2032_ _1565_ VSS VSS VDD VDD _0294_ _0295_ sky130_fd_sc_hd__ha_1
X_3763_ _0296_ _2101_ VSS VSS VDD VDD _1677_ _0297_ sky130_fd_sc_hd__ha_1
X_3764_ _2102_ _2103_ VSS VSS VDD VDD _1675_ _2101_ sky130_fd_sc_hd__ha_1
X_3765_ _1878_ _1879_ VSS VSS VDD VDD _0299_ _0298_ sky130_fd_sc_hd__ha_1
X_3766_ _1701_ _1705_ VSS VSS VDD VDD _0300_ _0301_ sky130_fd_sc_hd__ha_1
X_3767_ _2025_ _2104_ VSS VSS VDD VDD _1919_ _1923_ sky130_fd_sc_hd__ha_1
X_3768_ _2035_ _2029_ VSS VSS VDD VDD _1924_ _1927_ sky130_fd_sc_hd__ha_1
X_3769_ _2105_ _2106_ VSS VSS VDD VDD _1928_ _1931_ sky130_fd_sc_hd__ha_1
X_3770_ _0302_ _2107_ VSS VSS VDD VDD _1932_ _0303_ sky130_fd_sc_hd__ha_1
X_3771_ _1716_ _1720_ VSS VSS VDD VDD _0304_ _0305_ sky130_fd_sc_hd__ha_1
X_3772_ _2033_ _2108_ VSS VSS VDD VDD _1962_ _1964_ sky130_fd_sc_hd__ha_1
X_3773_ _2034_ _0306_ VSS VSS VDD VDD _1965_ _2104_ sky130_fd_sc_hd__ha_1
X_3774_ _1581_ _1584_ VSS VSS VDD VDD _0307_ _0308_ sky130_fd_sc_hd__ha_1
X_3775_ _2047_ _0309_ VSS VSS VDD VDD _2062_ _2109_ sky130_fd_sc_hd__ha_1
X_3776_ _0310_ _0311_ VSS VSS VDD VDD _1985_ _2108_ sky130_fd_sc_hd__ha_1
X_3777_ _1901_ _1905_ VSS VSS VDD VDD _0312_ _0313_ sky130_fd_sc_hd__ha_1
X_3778_ _1674_ _1678_ VSS VSS VDD VDD _0042_ _0314_ sky130_fd_sc_hd__ha_1
X_3779_ _2110_ _2111_ VSS VSS VDD VDD _1926_ _2106_ sky130_fd_sc_hd__ha_1
X_3780_ _2112_ _2113_ VSS VSS VDD VDD _1930_ _2107_ sky130_fd_sc_hd__ha_1
X_3781_ _0316_ _0317_ VSS VSS VDD VDD _2028_ _2105_ sky130_fd_sc_hd__ha_1
X_3782_ _2072_ _2077_ VSS VSS VDD VDD _0318_ _0319_ sky130_fd_sc_hd__ha_1
X_3783_ _0320_ _0321_ VSS VSS VDD VDD _2063_ _2114_ sky130_fd_sc_hd__ha_1
X_3784_ _0179_ _0322_ VSS VSS VDD VDD _2009_ _2008_ sky130_fd_sc_hd__ha_1
X_3785_ _0323_ _0324_ VSS VSS VDD VDD _2017_ _2019_ sky130_fd_sc_hd__ha_1
X_3786_ _0325_ _0326_ VSS VSS VDD VDD _2020_ _2022_ sky130_fd_sc_hd__ha_1
X_3787_ _0327_ _0328_ VSS VSS VDD VDD _2023_ _2026_ sky130_fd_sc_hd__ha_1
X_3788_ _0329_ _0330_ VSS VSS VDD VDD _2027_ _2110_ sky130_fd_sc_hd__ha_1
X_3789_ _0331_ _0332_ VSS VSS VDD VDD _2111_ _2112_ sky130_fd_sc_hd__ha_1
X_3790_ _0333_ _0334_ VSS VSS VDD VDD _2113_ _0335_ sky130_fd_sc_hd__ha_1
X_3791_ _1921_ _1925_ VSS VSS VDD VDD _0336_ _0337_ sky130_fd_sc_hd__ha_1
X_3792_ _2048_ _1877_ VSS VSS VDD VDD _1667_ _1671_ sky130_fd_sc_hd__ha_1
X_3793_ _1613_ _1625_ VSS VSS VDD VDD _0338_ _0339_ sky130_fd_sc_hd__ha_1
X_3794_ _1873_ _2109_ VSS VSS VDD VDD _1662_ _1666_ sky130_fd_sc_hd__ha_1
X_3795_ _1916_ _1920_ VSS VSS VDD VDD _0340_ _0341_ sky130_fd_sc_hd__ha_1
X_3796_ _1711_ _1715_ VSS VSS VDD VDD _0342_ _0343_ sky130_fd_sc_hd__ha_1
X_3797_ _2115_ _2089_ VSS VSS VDD VDD _1672_ _1676_ sky130_fd_sc_hd__ha_1
X_3798_ _1911_ _1915_ VSS VSS VDD VDD _0344_ _0345_ sky130_fd_sc_hd__ha_1
X_3799_ _1706_ _1710_ VSS VSS VDD VDD _0346_ _0347_ sky130_fd_sc_hd__ha_1
X_3800_ _1609_ _1612_ VSS VSS VDD VDD _0348_ _0349_ sky130_fd_sc_hd__ha_1
X_3801_ _2003_ _2031_ VSS VSS VDD VDD _0350_ _0351_ sky130_fd_sc_hd__ha_1
X_3802_ _1993_ _2002_ VSS VSS VDD VDD _0352_ _0353_ sky130_fd_sc_hd__ha_1
X_3803_ _2074_ _2075_ VSS VSS VDD VDD _0354_ _0355_ sky130_fd_sc_hd__ha_1
X_3804_ _0356_ _0357_ VSS VSS VDD VDD _1876_ _2115_ sky130_fd_sc_hd__ha_1
X_3805_ _1726_ _1730_ VSS VSS VDD VDD _0358_ _0359_ sky130_fd_sc_hd__ha_1
X_3806_ _1692_ _1695_ VSS VSS VDD VDD _0360_ _0361_ sky130_fd_sc_hd__ha_1
X_3807_ _0208_ _0362_ VSS VSS VDD VDD _1792_ _1791_ sky130_fd_sc_hd__ha_1
X_3808_ _1669_ _1673_ VSS VSS VDD VDD _0363_ _0262_ sky130_fd_sc_hd__ha_1
X_3809_ _1804_ _1808_ VSS VSS VDD VDD _0364_ _0315_ sky130_fd_sc_hd__ha_1
X_3810_ _1641_ _1645_ VSS VSS VDD VDD _0365_ _0366_ sky130_fd_sc_hd__ha_1
X_3811_ _2068_ _2071_ VSS VSS VDD VDD _0367_ _0368_ sky130_fd_sc_hd__ha_1
X_3812_ _1809_ _1813_ VSS VSS VDD VDD _0156_ _0369_ sky130_fd_sc_hd__ha_1
X_3813_ _1646_ _1663_ VSS VSS VDD VDD _0370_ _0371_ sky130_fd_sc_hd__ha_1
X_3814_ _1886_ _1890_ VSS VSS VDD VDD _0372_ _0373_ sky130_fd_sc_hd__ha_1
X_3815_ _1800_ _1803_ VSS VSS VDD VDD _0374_ _0375_ sky130_fd_sc_hd__ha_1
X_3816_ _1696_ _1700_ VSS VSS VDD VDD _0376_ _0377_ sky130_fd_sc_hd__ha_1
X_3817_ _1573_ _1558_ VSS VSS VDD VDD _1802_ _1806_ sky130_fd_sc_hd__ha_1
X_3818_ _0378_ _0379_ VSS VSS VDD VDD _2005_ _1744_ sky130_fd_sc_hd__ha_1
X_3819_ _0380_ _0381_ VSS VSS VDD VDD _1745_ _1870_ sky130_fd_sc_hd__ha_1
X_3820_ _0382_ _0383_ VSS VSS VDD VDD _1871_ _1874_ sky130_fd_sc_hd__ha_1
X_3821_ _0384_ _0385_ VSS VSS VDD VDD _1875_ _2087_ sky130_fd_sc_hd__ha_1
X_3822_ _0386_ _0387_ VSS VSS VDD VDD _2088_ _2102_ sky130_fd_sc_hd__ha_1
X_3823_ _0388_ _0389_ VSS VSS VDD VDD _2103_ _0390_ sky130_fd_sc_hd__ha_1
X_3824_ _1577_ _2054_ VSS VSS VDD VDD _0391_ _0392_ sky130_fd_sc_hd__ha_1
X_3825_ _1553_ _2091_ VSS VSS VDD VDD _1798_ _1801_ sky130_fd_sc_hd__ha_1
X_3826_ _2070_ _2073_ VSS VSS VDD VDD _0393_ _0394_ sky130_fd_sc_hd__ha_1
X_3827_ _2000_ _1992_ VSS VSS VDD VDD _0395_ _0396_ sky130_fd_sc_hd__ha_1
X_3828_ _2055_ _2036_ VSS VSS VDD VDD _0397_ _0398_ sky130_fd_sc_hd__ha_1
X_3829_ _1721_ _1725_ VSS VSS VDD VDD _0399_ _0400_ sky130_fd_sc_hd__ha_1
X_3830_ _1896_ _1900_ VSS VSS VDD VDD _0401_ _0402_ sky130_fd_sc_hd__ha_1
X_3831_ _1688_ _1689_ VSS VSS VDD VDD _0403_ _0260_ sky130_fd_sc_hd__ha_1
X_3832_ _1861_ _1522_ VSS VSS VDD VDD _0404_ _0405_ sky130_fd_sc_hd__ha_1
X_3833_ _1585_ _1858_ VSS VSS VDD VDD _0406_ _0407_ sky130_fd_sc_hd__ha_1
X_3834_ _1591_ _1592_ VSS VSS VDD VDD _0408_ _0254_ sky130_fd_sc_hd__ha_1
X_3835_ _1731_ _1735_ VSS VSS VDD VDD _0409_ _0410_ sky130_fd_sc_hd__ha_1
X_3836_ _1882_ _1885_ VSS VSS VDD VDD _0411_ _0412_ sky130_fd_sc_hd__ha_1
X_3837_ _0413_ _2084_ VSS VSS VDD VDD _1812_ _0414_ sky130_fd_sc_hd__ha_1
X_3838_ _1891_ _1895_ VSS VSS VDD VDD _0415_ _0416_ sky130_fd_sc_hd__ha_1
X_3839_ _1739_ _1743_ VSS VSS VDD VDD _0039_ _0417_ sky130_fd_sc_hd__ha_1
X_3840_ _0418_ _0419_ VSS VSS VDD VDD _1657_ _2090_ sky130_fd_sc_hd__ha_1
X_3841_ _1664_ _1668_ VSS VSS VDD VDD _0420_ _0421_ sky130_fd_sc_hd__ha_1
X_3842_ _2060_ _2069_ VSS VSS VDD VDD _0422_ _0423_ sky130_fd_sc_hd__ha_1
X_3843_ _2078_ _1580_ VSS VSS VDD VDD _0424_ _0425_ sky130_fd_sc_hd__ha_1
X_3844_ _1906_ _1910_ VSS VSS VDD VDD _0426_ _0427_ sky130_fd_sc_hd__ha_1
X_3845_ _2046_ _2114_ VSS VSS VDD VDD _2058_ _2061_ sky130_fd_sc_hd__ha_1
X_3846_ product\[48\] _1589_ VSS VSS VDD VDD _2085_ _0428_
+ sky130_fd_sc_hd__ha_1
Xinput13 req_a[1] VSS VSS VDD VDD net13 sky130_fd_sc_hd__clkdlybuf4s50_1
Xinput12 req_a[19] VSS VSS VDD VDD net12 sky130_fd_sc_hd__clkdlybuf4s50_1
Xinput11 req_a[18] VSS VSS VDD VDD net11 sky130_fd_sc_hd__clkdlybuf4s50_1
Xinput10 req_a[17] VSS VSS VDD VDD net10 sky130_fd_sc_hd__clkdlybuf4s50_1
Xinput9 req_a[16] VSS VSS VDD VDD net9 sky130_fd_sc_hd__clkdlybuf4s50_1
Xinput8 req_a[15] VSS VSS VDD VDD net8 sky130_fd_sc_hd__clkdlybuf4s50_1
Xinput7 req_a[14] VSS VSS VDD VDD net7 sky130_fd_sc_hd__clkdlybuf4s50_1
Xinput6 req_a[13] VSS VSS VDD VDD net6 sky130_fd_sc_hd__clkdlybuf4s50_1
Xinput5 req_a[12] VSS VSS VDD VDD net5 sky130_fd_sc_hd__clkdlybuf4s50_1
Xinput4 req_a[11] VSS VSS VDD VDD net4 sky130_fd_sc_hd__clkdlybuf4s50_1
Xinput3 req_a[10] VSS VSS VDD VDD net3 sky130_fd_sc_hd__clkdlybuf4s50_1
Xinput2 req_a[0] VSS VSS VDD VDD net2 sky130_fd_sc_hd__clkdlybuf4s50_1
Xinput1 kill VSS VSS VDD VDD net1 sky130_fd_sc_hd__clkdlybuf4s50_1
Xphase\[0\]$_DFF_PN1_ clknet_3_7__leaf_clk _0431_ net101 VSS
+ VSS VDD VDD phase\[0\] sky130_fd_sc_hd__dfstp_1
Xphase\[1\]$_DFF_PN0_ clknet_3_7__leaf_clk _0429_ net101 VSS
+ VSS VDD VDD phase\[1\] sky130_fd_sc_hd__dfrtp_1
Xphase\[2\]$_DFF_PN0_ clknet_3_7__leaf_clk net98 net101 VSS
+ VSS VDD VDD phase\[2\] sky130_fd_sc_hd__dfrtp_1
Xphase\[3\]$_DFF_PN0_ clknet_3_7__leaf_clk _0432_ net101 VSS
+ VSS VDD VDD phase\[3\] sky130_fd_sc_hd__dfrtp_1
Xproduct\[0\]$_DFFE_PN0P_ clknet_3_0__leaf_clk _0511_ net100
+ VSS VSS VDD VDD product\[0\] sky130_fd_sc_hd__dfrtp_1
Xproduct\[10\]$_DFFE_PN0P_ clknet_3_0__leaf_clk _0501_ net100
+ VSS VSS VDD VDD product\[10\] sky130_fd_sc_hd__dfrtp_1
Xproduct\[11\]$_DFFE_PN0P_ clknet_3_2__leaf_clk _0500_ net100
+ VSS VSS VDD VDD product\[11\] sky130_fd_sc_hd__dfrtp_1
Xproduct\[12\]$_DFFE_PN0P_ clknet_3_0__leaf_clk _0499_ net100
+ VSS VSS VDD VDD product\[12\] sky130_fd_sc_hd__dfrtp_1
Xproduct\[13\]$_DFFE_PN0P_ clknet_3_0__leaf_clk _0498_ net100
+ VSS VSS VDD VDD product\[13\] sky130_fd_sc_hd__dfrtp_1
Xproduct\[14\]$_DFFE_PN0P_ clknet_3_0__leaf_clk _0497_ net100
+ VSS VSS VDD VDD product\[14\] sky130_fd_sc_hd__dfrtp_1
Xproduct\[15\]$_DFFE_PN0P_ clknet_3_2__leaf_clk _0515_ net100
+ VSS VSS VDD VDD product\[15\] sky130_fd_sc_hd__dfrtp_1
Xproduct\[16\]$_DFFE_PN0P_ clknet_3_7__leaf_clk _0447_ net101
+ VSS VSS VDD VDD product\[16\] sky130_fd_sc_hd__dfrtp_1
Xproduct\[17\]$_DFFE_PN0P_ clknet_3_6__leaf_clk _0446_ net101
+ VSS VSS VDD VDD product\[17\] sky130_fd_sc_hd__dfrtp_1
Xproduct\[18\]$_DFFE_PN0P_ clknet_3_7__leaf_clk _0445_ net101
+ VSS VSS VDD VDD product\[18\] sky130_fd_sc_hd__dfrtp_1
Xproduct\[19\]$_DFFE_PN0P_ clknet_3_6__leaf_clk _0444_ net101
+ VSS VSS VDD VDD product\[19\] sky130_fd_sc_hd__dfrtp_1
Xproduct\[1\]$_DFFE_PN0P_ clknet_3_0__leaf_clk _0510_ net100
+ VSS VSS VDD VDD product\[1\] sky130_fd_sc_hd__dfrtp_1
Xproduct\[20\]$_DFFE_PN0P_ clknet_3_6__leaf_clk _0443_ net101
+ VSS VSS VDD VDD product\[20\] sky130_fd_sc_hd__dfrtp_1
Xproduct\[21\]$_DFFE_PN0P_ clknet_3_6__leaf_clk _0442_ net101
+ VSS VSS VDD VDD product\[21\] sky130_fd_sc_hd__dfrtp_1
Xproduct\[22\]$_DFFE_PN0P_ clknet_3_6__leaf_clk _0441_ net101
+ VSS VSS VDD VDD product\[22\] sky130_fd_sc_hd__dfrtp_1
Xproduct\[23\]$_DFFE_PN0P_ clknet_3_6__leaf_clk _0440_ net101
+ VSS VSS VDD VDD product\[23\] sky130_fd_sc_hd__dfrtp_1
Xproduct\[24\]$_DFFE_PN0P_ clknet_3_6__leaf_clk _0439_ net101
+ VSS VSS VDD VDD product\[24\] sky130_fd_sc_hd__dfrtp_1
Xproduct\[25\]$_DFFE_PN0P_ clknet_3_3__leaf_clk _0438_ net100
+ VSS VSS VDD VDD product\[25\] sky130_fd_sc_hd__dfrtp_1
Xproduct\[26\]$_DFFE_PN0P_ clknet_3_6__leaf_clk _0437_ net101
+ VSS VSS VDD VDD product\[26\] sky130_fd_sc_hd__dfrtp_1
Xproduct\[27\]$_DFFE_PN0P_ clknet_3_3__leaf_clk _0436_ net100
+ VSS VSS VDD VDD product\[27\] sky130_fd_sc_hd__dfrtp_1
Xproduct\[28\]$_DFFE_PN0P_ clknet_3_3__leaf_clk _0435_ net101
+ VSS VSS VDD VDD product\[28\] sky130_fd_sc_hd__dfrtp_1
Xproduct\[29\]$_DFFE_PN0P_ clknet_3_3__leaf_clk _0434_ net101
+ VSS VSS VDD VDD product\[29\] sky130_fd_sc_hd__dfrtp_1
Xproduct\[2\]$_DFFE_PN0P_ clknet_3_1__leaf_clk _0509_ net100
+ VSS VSS VDD VDD product\[2\] sky130_fd_sc_hd__dfrtp_1
Xproduct\[30\]$_DFFE_PN0P_ clknet_3_3__leaf_clk _0433_ net101
+ VSS VSS VDD VDD product\[30\] sky130_fd_sc_hd__dfrtp_1
Xproduct\[31\]$_DFFE_PN0P_ clknet_3_3__leaf_clk _0512_ net100
+ VSS VSS VDD VDD product\[31\] sky130_fd_sc_hd__dfrtp_1
Xproduct\[32\]$_DFFE_PN0P_ clknet_3_3__leaf_clk _0462_ net100
+ VSS VSS VDD VDD product\[32\] sky130_fd_sc_hd__dfrtp_1
Xproduct\[33\]$_DFFE_PN0P_ clknet_3_2__leaf_clk _0461_ net100
+ VSS VSS VDD VDD product\[33\] sky130_fd_sc_hd__dfrtp_1
Xproduct\[34\]$_DFFE_PN0P_ clknet_3_2__leaf_clk _0460_ net100
+ VSS VSS VDD VDD product\[34\] sky130_fd_sc_hd__dfrtp_1
Xproduct\[35\]$_DFFE_PN0P_ clknet_3_3__leaf_clk _0459_ net100
+ VSS VSS VDD VDD product\[35\] sky130_fd_sc_hd__dfrtp_1
Xproduct\[36\]$_DFFE_PN0P_ clknet_3_2__leaf_clk _0458_ net100
+ VSS VSS VDD VDD product\[36\] sky130_fd_sc_hd__dfrtp_1
Xproduct\[37\]$_DFFE_PN0P_ clknet_3_0__leaf_clk _0457_ net100
+ VSS VSS VDD VDD product\[37\] sky130_fd_sc_hd__dfrtp_1
Xproduct\[38\]$_DFFE_PN0P_ clknet_3_2__leaf_clk _0456_ net100
+ VSS VSS VDD VDD product\[38\] sky130_fd_sc_hd__dfrtp_1
Xproduct\[39\]$_DFFE_PN0P_ clknet_3_3__leaf_clk _0455_ net100
+ VSS VSS VDD VDD product\[39\] sky130_fd_sc_hd__dfrtp_1
Xproduct\[3\]$_DFFE_PN0P_ clknet_3_1__leaf_clk _0508_ net100
+ VSS VSS VDD VDD product\[3\] sky130_fd_sc_hd__dfrtp_1
Xproduct\[40\]$_DFFE_PN0P_ clknet_3_2__leaf_clk _0454_ net100
+ VSS VSS VDD VDD product\[40\] sky130_fd_sc_hd__dfrtp_1
Xproduct\[41\]$_DFFE_PN0P_ clknet_3_2__leaf_clk _0453_ net100
+ VSS VSS VDD VDD product\[41\] sky130_fd_sc_hd__dfrtp_1
Xproduct\[42\]$_DFFE_PN0P_ clknet_3_2__leaf_clk _0452_ net100
+ VSS VSS VDD VDD product\[42\] sky130_fd_sc_hd__dfrtp_1
Xproduct\[43\]$_DFFE_PN0P_ clknet_3_3__leaf_clk _0451_ net100
+ VSS VSS VDD VDD product\[43\] sky130_fd_sc_hd__dfrtp_1
Xproduct\[44\]$_DFFE_PN0P_ clknet_3_2__leaf_clk _0450_ net100
+ VSS VSS VDD VDD product\[44\] sky130_fd_sc_hd__dfrtp_1
Xproduct\[45\]$_DFFE_PN0P_ clknet_3_2__leaf_clk _0449_ net100
+ VSS VSS VDD VDD product\[45\] sky130_fd_sc_hd__dfrtp_1
Xproduct\[46\]$_DFFE_PN0P_ clknet_3_3__leaf_clk _0448_ net100
+ VSS VSS VDD VDD product\[46\] sky130_fd_sc_hd__dfrtp_1
Xproduct\[47\]$_DFFE_PN0P_ clknet_3_3__leaf_clk _0513_ net100
+ VSS VSS VDD VDD product\[47\] sky130_fd_sc_hd__dfrtp_1
Xproduct\[48\]$_DFFE_PN0P_ clknet_3_5__leaf_clk _0477_ net101
+ VSS VSS VDD VDD product\[48\] sky130_fd_sc_hd__dfrtp_1
Xproduct\[49\]$_DFFE_PN0P_ clknet_3_4__leaf_clk _0476_ net101
+ VSS VSS VDD VDD product\[49\] sky130_fd_sc_hd__dfrtp_1
Xproduct\[4\]$_DFFE_PN0P_ clknet_3_0__leaf_clk _0507_ net100
+ VSS VSS VDD VDD product\[4\] sky130_fd_sc_hd__dfrtp_1
Xproduct\[50\]$_DFFE_PN0P_ clknet_3_4__leaf_clk _0475_ net101
+ VSS VSS VDD VDD product\[50\] sky130_fd_sc_hd__dfrtp_1
Xproduct\[51\]$_DFFE_PN0P_ clknet_3_4__leaf_clk _0474_ net101
+ VSS VSS VDD VDD product\[51\] sky130_fd_sc_hd__dfrtp_1
Xproduct\[52\]$_DFFE_PN0P_ clknet_3_4__leaf_clk _0473_ net101
+ VSS VSS VDD VDD product\[52\] sky130_fd_sc_hd__dfrtp_1
Xproduct\[53\]$_DFFE_PN0P_ clknet_3_4__leaf_clk _0472_ net101
+ VSS VSS VDD VDD product\[53\] sky130_fd_sc_hd__dfrtp_1
Xproduct\[54\]$_DFFE_PN0P_ clknet_3_4__leaf_clk _0471_ net101
+ VSS VSS VDD VDD product\[54\] sky130_fd_sc_hd__dfrtp_1
Xproduct\[55\]$_DFFE_PN0P_ clknet_3_1__leaf_clk _0470_ net100
+ VSS VSS VDD VDD product\[55\] sky130_fd_sc_hd__dfrtp_1
Xproduct\[56\]$_DFFE_PN0P_ clknet_3_1__leaf_clk _0469_ net100
+ VSS VSS VDD VDD product\[56\] sky130_fd_sc_hd__dfrtp_1
Xproduct\[57\]$_DFFE_PN0P_ clknet_3_1__leaf_clk _0468_ net100
+ VSS VSS VDD VDD product\[57\] sky130_fd_sc_hd__dfrtp_1
Xproduct\[58\]$_DFFE_PN0P_ clknet_3_1__leaf_clk _0467_ net100
+ VSS VSS VDD VDD product\[58\] sky130_fd_sc_hd__dfrtp_1
Xproduct\[59\]$_DFFE_PN0P_ clknet_3_0__leaf_clk _0466_ net100
+ VSS VSS VDD VDD product\[59\] sky130_fd_sc_hd__dfrtp_1
Xproduct\[5\]$_DFFE_PN0P_ clknet_3_1__leaf_clk _0506_ net100
+ VSS VSS VDD VDD product\[5\] sky130_fd_sc_hd__dfrtp_1
Xproduct\[60\]$_DFFE_PN0P_ clknet_3_1__leaf_clk _0465_ net100
+ VSS VSS VDD VDD product\[60\] sky130_fd_sc_hd__dfrtp_1
Xproduct\[61\]$_DFFE_PN0P_ clknet_3_1__leaf_clk _0464_ net100
+ VSS VSS VDD VDD product\[61\] sky130_fd_sc_hd__dfrtp_1
Xproduct\[62\]$_DFFE_PN0P_ clknet_3_1__leaf_clk _0463_ net100
+ VSS VSS VDD VDD product\[62\] sky130_fd_sc_hd__dfrtp_1
Xproduct\[63\]$_DFFE_PN0P_ clknet_3_0__leaf_clk _0514_ net100
+ VSS VSS VDD VDD product\[63\] sky130_fd_sc_hd__dfrtp_1
Xproduct\[6\]$_DFFE_PN0P_ clknet_3_0__leaf_clk _0505_ net100
+ VSS VSS VDD VDD product\[6\] sky130_fd_sc_hd__dfrtp_1
Xproduct\[7\]$_DFFE_PN0P_ clknet_3_1__leaf_clk _0504_ net100
+ VSS VSS VDD VDD product\[7\] sky130_fd_sc_hd__dfrtp_1
Xproduct\[8\]$_DFFE_PN0P_ clknet_3_0__leaf_clk _0503_ net100
+ VSS VSS VDD VDD product\[8\] sky130_fd_sc_hd__dfrtp_1
Xproduct\[9\]$_DFFE_PN0P_ clknet_3_3__leaf_clk _0502_ net100
+ VSS VSS VDD VDD product\[9\] sky130_fd_sc_hd__dfrtp_1
Xrsp_data\[0\]$_DFFE_PN0P_ clknet_3_5__leaf_clk _0496_ net101
+ VSS VSS VDD VDD net70 sky130_fd_sc_hd__dfrtp_1
Xrsp_data\[10\]$_DFFE_PN0P_ clknet_3_5__leaf_clk _0486_ net101
+ VSS VSS VDD VDD net71 sky130_fd_sc_hd__dfrtp_1
Xrsp_data\[11\]$_DFFE_PN0P_ clknet_3_7__leaf_clk _0485_ net101
+ VSS VSS VDD VDD net72 sky130_fd_sc_hd__dfrtp_1
Xrsp_data\[12\]$_DFFE_PN0P_ clknet_3_7__leaf_clk _0484_ net101
+ VSS VSS VDD VDD net73 sky130_fd_sc_hd__dfrtp_1
Xrsp_data\[13\]$_DFFE_PN0P_ clknet_3_7__leaf_clk _0483_ net101
+ VSS VSS VDD VDD net74 sky130_fd_sc_hd__dfrtp_1
Xrsp_data\[14\]$_DFFE_PN0P_ clknet_3_6__leaf_clk _0482_ net101
+ VSS VSS VDD VDD net75 sky130_fd_sc_hd__dfrtp_1
Xrsp_data\[15\]$_DFFE_PN0P_ clknet_3_7__leaf_clk _0481_ net101
+ VSS VSS VDD VDD net76 sky130_fd_sc_hd__dfrtp_1
Xrsp_data\[16\]$_DFFE_PN0P_ clknet_3_7__leaf_clk _0480_ net101
+ VSS VSS VDD VDD net77 sky130_fd_sc_hd__dfrtp_1
Xrsp_data\[17\]$_DFFE_PN0P_ clknet_3_7__leaf_clk _0479_ net101
+ VSS VSS VDD VDD net78 sky130_fd_sc_hd__dfrtp_1
Xrsp_data\[1\]$_DFFE_PN0P_ clknet_3_5__leaf_clk _0495_ net101
+ VSS VSS VDD VDD net80 sky130_fd_sc_hd__dfrtp_1
Xrsp_data\[2\]$_DFFE_PN0P_ clknet_3_5__leaf_clk _0494_ net101
+ VSS VSS VDD VDD net81 sky130_fd_sc_hd__dfrtp_1
Xrsp_data\[30\]$_DFFE_PN0P_ clknet_3_7__leaf_clk _0478_ net101
+ VSS VSS VDD VDD net79 sky130_fd_sc_hd__dfrtp_1
Xrsp_data\[3\]$_DFFE_PN0P_ clknet_3_4__leaf_clk _0493_ net101
+ VSS VSS VDD VDD net82 sky130_fd_sc_hd__dfrtp_1
Xrsp_data\[4\]$_DFFE_PN0P_ clknet_3_5__leaf_clk _0492_ net101
+ VSS VSS VDD VDD net83 sky130_fd_sc_hd__dfrtp_1
Xrsp_data\[5\]$_DFFE_PN0P_ clknet_3_4__leaf_clk _0491_ net101
+ VSS VSS VDD VDD net84 sky130_fd_sc_hd__dfrtp_1
Xrsp_data\[6\]$_DFFE_PN0P_ clknet_3_5__leaf_clk _0490_ net101
+ VSS VSS VDD VDD net85 sky130_fd_sc_hd__dfrtp_1
Xrsp_data\[7\]$_DFFE_PN0P_ clknet_3_5__leaf_clk _0489_ net101
+ VSS VSS VDD VDD net86 sky130_fd_sc_hd__dfrtp_1
Xrsp_data\[8\]$_DFFE_PN0P_ clknet_3_5__leaf_clk _0488_ net101
+ VSS VSS VDD VDD net87 sky130_fd_sc_hd__dfrtp_1
Xrsp_data\[9\]$_DFFE_PN0P_ clknet_3_5__leaf_clk _0487_ net101
+ VSS VSS VDD VDD net88 sky130_fd_sc_hd__dfrtp_1
XTAP_TAPCELL_ROW_0_0 VSS VDD sky130_fd_sc_hd__tapvpwrvgnd_1
XTAP_TAPCELL_ROW_0_1 VSS VDD sky130_fd_sc_hd__tapvpwrvgnd_1
XTAP_TAPCELL_ROW_0_2 VSS VDD sky130_fd_sc_hd__tapvpwrvgnd_1
XTAP_TAPCELL_ROW_0_3 VSS VDD sky130_fd_sc_hd__tapvpwrvgnd_1
XTAP_TAPCELL_ROW_0_4 VSS VDD sky130_fd_sc_hd__tapvpwrvgnd_1
XTAP_TAPCELL_ROW_0_5 VSS VDD sky130_fd_sc_hd__tapvpwrvgnd_1
XTAP_TAPCELL_ROW_0_6 VSS VDD sky130_fd_sc_hd__tapvpwrvgnd_1
XTAP_TAPCELL_ROW_0_7 VSS VDD sky130_fd_sc_hd__tapvpwrvgnd_1
XTAP_TAPCELL_ROW_0_8 VSS VDD sky130_fd_sc_hd__tapvpwrvgnd_1
XTAP_TAPCELL_ROW_0_9 VSS VDD sky130_fd_sc_hd__tapvpwrvgnd_1
XTAP_TAPCELL_ROW_0_10 VSS VDD sky130_fd_sc_hd__tapvpwrvgnd_1
XTAP_TAPCELL_ROW_0_11 VSS VDD sky130_fd_sc_hd__tapvpwrvgnd_1
XTAP_TAPCELL_ROW_0_12 VSS VDD sky130_fd_sc_hd__tapvpwrvgnd_1
XTAP_TAPCELL_ROW_1_13 VSS VDD sky130_fd_sc_hd__tapvpwrvgnd_1
XTAP_TAPCELL_ROW_1_14 VSS VDD sky130_fd_sc_hd__tapvpwrvgnd_1
XTAP_TAPCELL_ROW_1_15 VSS VDD sky130_fd_sc_hd__tapvpwrvgnd_1
XTAP_TAPCELL_ROW_1_16 VSS VDD sky130_fd_sc_hd__tapvpwrvgnd_1
XTAP_TAPCELL_ROW_1_17 VSS VDD sky130_fd_sc_hd__tapvpwrvgnd_1
XTAP_TAPCELL_ROW_1_18 VSS VDD sky130_fd_sc_hd__tapvpwrvgnd_1
XTAP_TAPCELL_ROW_2_19 VSS VDD sky130_fd_sc_hd__tapvpwrvgnd_1
XTAP_TAPCELL_ROW_2_20 VSS VDD sky130_fd_sc_hd__tapvpwrvgnd_1
XTAP_TAPCELL_ROW_2_21 VSS VDD sky130_fd_sc_hd__tapvpwrvgnd_1
XTAP_TAPCELL_ROW_2_22 VSS VDD sky130_fd_sc_hd__tapvpwrvgnd_1
XTAP_TAPCELL_ROW_2_23 VSS VDD sky130_fd_sc_hd__tapvpwrvgnd_1
XTAP_TAPCELL_ROW_2_24 VSS VDD sky130_fd_sc_hd__tapvpwrvgnd_1
XTAP_TAPCELL_ROW_2_25 VSS VDD sky130_fd_sc_hd__tapvpwrvgnd_1
XTAP_TAPCELL_ROW_3_26 VSS VDD sky130_fd_sc_hd__tapvpwrvgnd_1
XTAP_TAPCELL_ROW_3_27 VSS VDD sky130_fd_sc_hd__tapvpwrvgnd_1
XTAP_TAPCELL_ROW_3_28 VSS VDD sky130_fd_sc_hd__tapvpwrvgnd_1
XTAP_TAPCELL_ROW_3_29 VSS VDD sky130_fd_sc_hd__tapvpwrvgnd_1
XTAP_TAPCELL_ROW_3_30 VSS VDD sky130_fd_sc_hd__tapvpwrvgnd_1
XTAP_TAPCELL_ROW_3_31 VSS VDD sky130_fd_sc_hd__tapvpwrvgnd_1
XTAP_TAPCELL_ROW_4_32 VSS VDD sky130_fd_sc_hd__tapvpwrvgnd_1
XTAP_TAPCELL_ROW_4_33 VSS VDD sky130_fd_sc_hd__tapvpwrvgnd_1
XTAP_TAPCELL_ROW_4_34 VSS VDD sky130_fd_sc_hd__tapvpwrvgnd_1
XTAP_TAPCELL_ROW_4_35 VSS VDD sky130_fd_sc_hd__tapvpwrvgnd_1
XTAP_TAPCELL_ROW_4_36 VSS VDD sky130_fd_sc_hd__tapvpwrvgnd_1
XTAP_TAPCELL_ROW_4_37 VSS VDD sky130_fd_sc_hd__tapvpwrvgnd_1
XTAP_TAPCELL_ROW_4_38 VSS VDD sky130_fd_sc_hd__tapvpwrvgnd_1
XTAP_TAPCELL_ROW_5_39 VSS VDD sky130_fd_sc_hd__tapvpwrvgnd_1
XTAP_TAPCELL_ROW_5_40 VSS VDD sky130_fd_sc_hd__tapvpwrvgnd_1
XTAP_TAPCELL_ROW_5_41 VSS VDD sky130_fd_sc_hd__tapvpwrvgnd_1
XTAP_TAPCELL_ROW_5_42 VSS VDD sky130_fd_sc_hd__tapvpwrvgnd_1
XTAP_TAPCELL_ROW_5_43 VSS VDD sky130_fd_sc_hd__tapvpwrvgnd_1
XTAP_TAPCELL_ROW_5_44 VSS VDD sky130_fd_sc_hd__tapvpwrvgnd_1
XTAP_TAPCELL_ROW_6_45 VSS VDD sky130_fd_sc_hd__tapvpwrvgnd_1
XTAP_TAPCELL_ROW_6_46 VSS VDD sky130_fd_sc_hd__tapvpwrvgnd_1
XTAP_TAPCELL_ROW_6_47 VSS VDD sky130_fd_sc_hd__tapvpwrvgnd_1
XTAP_TAPCELL_ROW_6_48 VSS VDD sky130_fd_sc_hd__tapvpwrvgnd_1
XTAP_TAPCELL_ROW_6_49 VSS VDD sky130_fd_sc_hd__tapvpwrvgnd_1
XTAP_TAPCELL_ROW_6_50 VSS VDD sky130_fd_sc_hd__tapvpwrvgnd_1
XTAP_TAPCELL_ROW_6_51 VSS VDD sky130_fd_sc_hd__tapvpwrvgnd_1
XTAP_TAPCELL_ROW_7_52 VSS VDD sky130_fd_sc_hd__tapvpwrvgnd_1
XTAP_TAPCELL_ROW_7_53 VSS VDD sky130_fd_sc_hd__tapvpwrvgnd_1
XTAP_TAPCELL_ROW_7_54 VSS VDD sky130_fd_sc_hd__tapvpwrvgnd_1
XTAP_TAPCELL_ROW_7_55 VSS VDD sky130_fd_sc_hd__tapvpwrvgnd_1
XTAP_TAPCELL_ROW_7_56 VSS VDD sky130_fd_sc_hd__tapvpwrvgnd_1
XTAP_TAPCELL_ROW_7_57 VSS VDD sky130_fd_sc_hd__tapvpwrvgnd_1
XTAP_TAPCELL_ROW_8_58 VSS VDD sky130_fd_sc_hd__tapvpwrvgnd_1
XTAP_TAPCELL_ROW_8_59 VSS VDD sky130_fd_sc_hd__tapvpwrvgnd_1
XTAP_TAPCELL_ROW_8_60 VSS VDD sky130_fd_sc_hd__tapvpwrvgnd_1
XTAP_TAPCELL_ROW_8_61 VSS VDD sky130_fd_sc_hd__tapvpwrvgnd_1
XTAP_TAPCELL_ROW_8_62 VSS VDD sky130_fd_sc_hd__tapvpwrvgnd_1
XTAP_TAPCELL_ROW_8_63 VSS VDD sky130_fd_sc_hd__tapvpwrvgnd_1
XTAP_TAPCELL_ROW_8_64 VSS VDD sky130_fd_sc_hd__tapvpwrvgnd_1
XTAP_TAPCELL_ROW_9_65 VSS VDD sky130_fd_sc_hd__tapvpwrvgnd_1
XTAP_TAPCELL_ROW_9_66 VSS VDD sky130_fd_sc_hd__tapvpwrvgnd_1
XTAP_TAPCELL_ROW_9_67 VSS VDD sky130_fd_sc_hd__tapvpwrvgnd_1
XTAP_TAPCELL_ROW_9_68 VSS VDD sky130_fd_sc_hd__tapvpwrvgnd_1
XTAP_TAPCELL_ROW_9_69 VSS VDD sky130_fd_sc_hd__tapvpwrvgnd_1
XTAP_TAPCELL_ROW_9_70 VSS VDD sky130_fd_sc_hd__tapvpwrvgnd_1
XTAP_TAPCELL_ROW_10_71 VSS VDD sky130_fd_sc_hd__tapvpwrvgnd_1
XTAP_TAPCELL_ROW_10_72 VSS VDD sky130_fd_sc_hd__tapvpwrvgnd_1
XTAP_TAPCELL_ROW_10_73 VSS VDD sky130_fd_sc_hd__tapvpwrvgnd_1
XTAP_TAPCELL_ROW_10_74 VSS VDD sky130_fd_sc_hd__tapvpwrvgnd_1
XTAP_TAPCELL_ROW_10_75 VSS VDD sky130_fd_sc_hd__tapvpwrvgnd_1
XTAP_TAPCELL_ROW_10_76 VSS VDD sky130_fd_sc_hd__tapvpwrvgnd_1
XTAP_TAPCELL_ROW_10_77 VSS VDD sky130_fd_sc_hd__tapvpwrvgnd_1
XTAP_TAPCELL_ROW_11_78 VSS VDD sky130_fd_sc_hd__tapvpwrvgnd_1
XTAP_TAPCELL_ROW_11_79 VSS VDD sky130_fd_sc_hd__tapvpwrvgnd_1
XTAP_TAPCELL_ROW_11_80 VSS VDD sky130_fd_sc_hd__tapvpwrvgnd_1
XTAP_TAPCELL_ROW_11_81 VSS VDD sky130_fd_sc_hd__tapvpwrvgnd_1
XTAP_TAPCELL_ROW_11_82 VSS VDD sky130_fd_sc_hd__tapvpwrvgnd_1
XTAP_TAPCELL_ROW_11_83 VSS VDD sky130_fd_sc_hd__tapvpwrvgnd_1
XTAP_TAPCELL_ROW_12_84 VSS VDD sky130_fd_sc_hd__tapvpwrvgnd_1
XTAP_TAPCELL_ROW_12_85 VSS VDD sky130_fd_sc_hd__tapvpwrvgnd_1
XTAP_TAPCELL_ROW_12_86 VSS VDD sky130_fd_sc_hd__tapvpwrvgnd_1
XTAP_TAPCELL_ROW_12_87 VSS VDD sky130_fd_sc_hd__tapvpwrvgnd_1
XTAP_TAPCELL_ROW_12_88 VSS VDD sky130_fd_sc_hd__tapvpwrvgnd_1
XTAP_TAPCELL_ROW_12_89 VSS VDD sky130_fd_sc_hd__tapvpwrvgnd_1
XTAP_TAPCELL_ROW_12_90 VSS VDD sky130_fd_sc_hd__tapvpwrvgnd_1
XTAP_TAPCELL_ROW_13_91 VSS VDD sky130_fd_sc_hd__tapvpwrvgnd_1
XTAP_TAPCELL_ROW_13_92 VSS VDD sky130_fd_sc_hd__tapvpwrvgnd_1
XTAP_TAPCELL_ROW_13_93 VSS VDD sky130_fd_sc_hd__tapvpwrvgnd_1
XTAP_TAPCELL_ROW_13_94 VSS VDD sky130_fd_sc_hd__tapvpwrvgnd_1
XTAP_TAPCELL_ROW_13_95 VSS VDD sky130_fd_sc_hd__tapvpwrvgnd_1
XTAP_TAPCELL_ROW_13_96 VSS VDD sky130_fd_sc_hd__tapvpwrvgnd_1
XTAP_TAPCELL_ROW_14_97 VSS VDD sky130_fd_sc_hd__tapvpwrvgnd_1
XTAP_TAPCELL_ROW_14_98 VSS VDD sky130_fd_sc_hd__tapvpwrvgnd_1
XTAP_TAPCELL_ROW_14_99 VSS VDD sky130_fd_sc_hd__tapvpwrvgnd_1
XTAP_TAPCELL_ROW_14_100 VSS VDD sky130_fd_sc_hd__tapvpwrvgnd_1
XTAP_TAPCELL_ROW_14_101 VSS VDD sky130_fd_sc_hd__tapvpwrvgnd_1
XTAP_TAPCELL_ROW_14_102 VSS VDD sky130_fd_sc_hd__tapvpwrvgnd_1
XTAP_TAPCELL_ROW_14_103 VSS VDD sky130_fd_sc_hd__tapvpwrvgnd_1
XTAP_TAPCELL_ROW_15_104 VSS VDD sky130_fd_sc_hd__tapvpwrvgnd_1
XTAP_TAPCELL_ROW_15_105 VSS VDD sky130_fd_sc_hd__tapvpwrvgnd_1
XTAP_TAPCELL_ROW_15_106 VSS VDD sky130_fd_sc_hd__tapvpwrvgnd_1
XTAP_TAPCELL_ROW_15_107 VSS VDD sky130_fd_sc_hd__tapvpwrvgnd_1
XTAP_TAPCELL_ROW_15_108 VSS VDD sky130_fd_sc_hd__tapvpwrvgnd_1
XTAP_TAPCELL_ROW_15_109 VSS VDD sky130_fd_sc_hd__tapvpwrvgnd_1
XTAP_TAPCELL_ROW_16_110 VSS VDD sky130_fd_sc_hd__tapvpwrvgnd_1
XTAP_TAPCELL_ROW_16_111 VSS VDD sky130_fd_sc_hd__tapvpwrvgnd_1
XTAP_TAPCELL_ROW_16_112 VSS VDD sky130_fd_sc_hd__tapvpwrvgnd_1
XTAP_TAPCELL_ROW_16_113 VSS VDD sky130_fd_sc_hd__tapvpwrvgnd_1
XTAP_TAPCELL_ROW_16_114 VSS VDD sky130_fd_sc_hd__tapvpwrvgnd_1
XTAP_TAPCELL_ROW_16_115 VSS VDD sky130_fd_sc_hd__tapvpwrvgnd_1
XTAP_TAPCELL_ROW_16_116 VSS VDD sky130_fd_sc_hd__tapvpwrvgnd_1
XTAP_TAPCELL_ROW_17_117 VSS VDD sky130_fd_sc_hd__tapvpwrvgnd_1
XTAP_TAPCELL_ROW_17_118 VSS VDD sky130_fd_sc_hd__tapvpwrvgnd_1
XTAP_TAPCELL_ROW_17_119 VSS VDD sky130_fd_sc_hd__tapvpwrvgnd_1
XTAP_TAPCELL_ROW_17_120 VSS VDD sky130_fd_sc_hd__tapvpwrvgnd_1
XTAP_TAPCELL_ROW_17_121 VSS VDD sky130_fd_sc_hd__tapvpwrvgnd_1
XTAP_TAPCELL_ROW_17_122 VSS VDD sky130_fd_sc_hd__tapvpwrvgnd_1
XTAP_TAPCELL_ROW_18_123 VSS VDD sky130_fd_sc_hd__tapvpwrvgnd_1
XTAP_TAPCELL_ROW_18_124 VSS VDD sky130_fd_sc_hd__tapvpwrvgnd_1
XTAP_TAPCELL_ROW_18_125 VSS VDD sky130_fd_sc_hd__tapvpwrvgnd_1
XTAP_TAPCELL_ROW_18_126 VSS VDD sky130_fd_sc_hd__tapvpwrvgnd_1
XTAP_TAPCELL_ROW_18_127 VSS VDD sky130_fd_sc_hd__tapvpwrvgnd_1
XTAP_TAPCELL_ROW_18_128 VSS VDD sky130_fd_sc_hd__tapvpwrvgnd_1
XTAP_TAPCELL_ROW_18_129 VSS VDD sky130_fd_sc_hd__tapvpwrvgnd_1
XTAP_TAPCELL_ROW_19_130 VSS VDD sky130_fd_sc_hd__tapvpwrvgnd_1
XTAP_TAPCELL_ROW_19_131 VSS VDD sky130_fd_sc_hd__tapvpwrvgnd_1
XTAP_TAPCELL_ROW_19_132 VSS VDD sky130_fd_sc_hd__tapvpwrvgnd_1
XTAP_TAPCELL_ROW_19_133 VSS VDD sky130_fd_sc_hd__tapvpwrvgnd_1
XTAP_TAPCELL_ROW_19_134 VSS VDD sky130_fd_sc_hd__tapvpwrvgnd_1
XTAP_TAPCELL_ROW_19_135 VSS VDD sky130_fd_sc_hd__tapvpwrvgnd_1
XTAP_TAPCELL_ROW_20_136 VSS VDD sky130_fd_sc_hd__tapvpwrvgnd_1
XTAP_TAPCELL_ROW_20_137 VSS VDD sky130_fd_sc_hd__tapvpwrvgnd_1
XTAP_TAPCELL_ROW_20_138 VSS VDD sky130_fd_sc_hd__tapvpwrvgnd_1
XTAP_TAPCELL_ROW_20_139 VSS VDD sky130_fd_sc_hd__tapvpwrvgnd_1
XTAP_TAPCELL_ROW_20_140 VSS VDD sky130_fd_sc_hd__tapvpwrvgnd_1
XTAP_TAPCELL_ROW_20_141 VSS VDD sky130_fd_sc_hd__tapvpwrvgnd_1
XTAP_TAPCELL_ROW_20_142 VSS VDD sky130_fd_sc_hd__tapvpwrvgnd_1
XTAP_TAPCELL_ROW_21_143 VSS VDD sky130_fd_sc_hd__tapvpwrvgnd_1
XTAP_TAPCELL_ROW_21_144 VSS VDD sky130_fd_sc_hd__tapvpwrvgnd_1
XTAP_TAPCELL_ROW_21_145 VSS VDD sky130_fd_sc_hd__tapvpwrvgnd_1
XTAP_TAPCELL_ROW_21_146 VSS VDD sky130_fd_sc_hd__tapvpwrvgnd_1
XTAP_TAPCELL_ROW_21_147 VSS VDD sky130_fd_sc_hd__tapvpwrvgnd_1
XTAP_TAPCELL_ROW_21_148 VSS VDD sky130_fd_sc_hd__tapvpwrvgnd_1
XTAP_TAPCELL_ROW_22_149 VSS VDD sky130_fd_sc_hd__tapvpwrvgnd_1
XTAP_TAPCELL_ROW_22_150 VSS VDD sky130_fd_sc_hd__tapvpwrvgnd_1
XTAP_TAPCELL_ROW_22_151 VSS VDD sky130_fd_sc_hd__tapvpwrvgnd_1
XTAP_TAPCELL_ROW_22_152 VSS VDD sky130_fd_sc_hd__tapvpwrvgnd_1
XTAP_TAPCELL_ROW_22_153 VSS VDD sky130_fd_sc_hd__tapvpwrvgnd_1
XTAP_TAPCELL_ROW_22_154 VSS VDD sky130_fd_sc_hd__tapvpwrvgnd_1
XTAP_TAPCELL_ROW_22_155 VSS VDD sky130_fd_sc_hd__tapvpwrvgnd_1
XTAP_TAPCELL_ROW_23_156 VSS VDD sky130_fd_sc_hd__tapvpwrvgnd_1
XTAP_TAPCELL_ROW_23_157 VSS VDD sky130_fd_sc_hd__tapvpwrvgnd_1
XTAP_TAPCELL_ROW_23_158 VSS VDD sky130_fd_sc_hd__tapvpwrvgnd_1
XTAP_TAPCELL_ROW_23_159 VSS VDD sky130_fd_sc_hd__tapvpwrvgnd_1
XTAP_TAPCELL_ROW_23_160 VSS VDD sky130_fd_sc_hd__tapvpwrvgnd_1
XTAP_TAPCELL_ROW_23_161 VSS VDD sky130_fd_sc_hd__tapvpwrvgnd_1
XTAP_TAPCELL_ROW_24_162 VSS VDD sky130_fd_sc_hd__tapvpwrvgnd_1
XTAP_TAPCELL_ROW_24_163 VSS VDD sky130_fd_sc_hd__tapvpwrvgnd_1
XTAP_TAPCELL_ROW_24_164 VSS VDD sky130_fd_sc_hd__tapvpwrvgnd_1
XTAP_TAPCELL_ROW_24_165 VSS VDD sky130_fd_sc_hd__tapvpwrvgnd_1
XTAP_TAPCELL_ROW_24_166 VSS VDD sky130_fd_sc_hd__tapvpwrvgnd_1
XTAP_TAPCELL_ROW_24_167 VSS VDD sky130_fd_sc_hd__tapvpwrvgnd_1
XTAP_TAPCELL_ROW_24_168 VSS VDD sky130_fd_sc_hd__tapvpwrvgnd_1
XTAP_TAPCELL_ROW_25_169 VSS VDD sky130_fd_sc_hd__tapvpwrvgnd_1
XTAP_TAPCELL_ROW_25_170 VSS VDD sky130_fd_sc_hd__tapvpwrvgnd_1
XTAP_TAPCELL_ROW_25_171 VSS VDD sky130_fd_sc_hd__tapvpwrvgnd_1
XTAP_TAPCELL_ROW_25_172 VSS VDD sky130_fd_sc_hd__tapvpwrvgnd_1
XTAP_TAPCELL_ROW_25_173 VSS VDD sky130_fd_sc_hd__tapvpwrvgnd_1
XTAP_TAPCELL_ROW_25_174 VSS VDD sky130_fd_sc_hd__tapvpwrvgnd_1
XTAP_TAPCELL_ROW_26_175 VSS VDD sky130_fd_sc_hd__tapvpwrvgnd_1
XTAP_TAPCELL_ROW_26_176 VSS VDD sky130_fd_sc_hd__tapvpwrvgnd_1
XTAP_TAPCELL_ROW_26_177 VSS VDD sky130_fd_sc_hd__tapvpwrvgnd_1
XTAP_TAPCELL_ROW_26_178 VSS VDD sky130_fd_sc_hd__tapvpwrvgnd_1
XTAP_TAPCELL_ROW_26_179 VSS VDD sky130_fd_sc_hd__tapvpwrvgnd_1
XTAP_TAPCELL_ROW_26_180 VSS VDD sky130_fd_sc_hd__tapvpwrvgnd_1
XTAP_TAPCELL_ROW_26_181 VSS VDD sky130_fd_sc_hd__tapvpwrvgnd_1
XTAP_TAPCELL_ROW_27_182 VSS VDD sky130_fd_sc_hd__tapvpwrvgnd_1
XTAP_TAPCELL_ROW_27_183 VSS VDD sky130_fd_sc_hd__tapvpwrvgnd_1
XTAP_TAPCELL_ROW_27_184 VSS VDD sky130_fd_sc_hd__tapvpwrvgnd_1
XTAP_TAPCELL_ROW_27_185 VSS VDD sky130_fd_sc_hd__tapvpwrvgnd_1
XTAP_TAPCELL_ROW_27_186 VSS VDD sky130_fd_sc_hd__tapvpwrvgnd_1
XTAP_TAPCELL_ROW_27_187 VSS VDD sky130_fd_sc_hd__tapvpwrvgnd_1
XTAP_TAPCELL_ROW_28_188 VSS VDD sky130_fd_sc_hd__tapvpwrvgnd_1
XTAP_TAPCELL_ROW_28_189 VSS VDD sky130_fd_sc_hd__tapvpwrvgnd_1
XTAP_TAPCELL_ROW_28_190 VSS VDD sky130_fd_sc_hd__tapvpwrvgnd_1
XTAP_TAPCELL_ROW_28_191 VSS VDD sky130_fd_sc_hd__tapvpwrvgnd_1
XTAP_TAPCELL_ROW_28_192 VSS VDD sky130_fd_sc_hd__tapvpwrvgnd_1
XTAP_TAPCELL_ROW_28_193 VSS VDD sky130_fd_sc_hd__tapvpwrvgnd_1
XTAP_TAPCELL_ROW_28_194 VSS VDD sky130_fd_sc_hd__tapvpwrvgnd_1
XTAP_TAPCELL_ROW_29_195 VSS VDD sky130_fd_sc_hd__tapvpwrvgnd_1
XTAP_TAPCELL_ROW_29_196 VSS VDD sky130_fd_sc_hd__tapvpwrvgnd_1
XTAP_TAPCELL_ROW_29_197 VSS VDD sky130_fd_sc_hd__tapvpwrvgnd_1
XTAP_TAPCELL_ROW_29_198 VSS VDD sky130_fd_sc_hd__tapvpwrvgnd_1
XTAP_TAPCELL_ROW_29_199 VSS VDD sky130_fd_sc_hd__tapvpwrvgnd_1
XTAP_TAPCELL_ROW_29_200 VSS VDD sky130_fd_sc_hd__tapvpwrvgnd_1
XTAP_TAPCELL_ROW_30_201 VSS VDD sky130_fd_sc_hd__tapvpwrvgnd_1
XTAP_TAPCELL_ROW_30_202 VSS VDD sky130_fd_sc_hd__tapvpwrvgnd_1
XTAP_TAPCELL_ROW_30_203 VSS VDD sky130_fd_sc_hd__tapvpwrvgnd_1
XTAP_TAPCELL_ROW_30_204 VSS VDD sky130_fd_sc_hd__tapvpwrvgnd_1
XTAP_TAPCELL_ROW_30_205 VSS VDD sky130_fd_sc_hd__tapvpwrvgnd_1
XTAP_TAPCELL_ROW_30_206 VSS VDD sky130_fd_sc_hd__tapvpwrvgnd_1
XTAP_TAPCELL_ROW_30_207 VSS VDD sky130_fd_sc_hd__tapvpwrvgnd_1
XTAP_TAPCELL_ROW_31_208 VSS VDD sky130_fd_sc_hd__tapvpwrvgnd_1
XTAP_TAPCELL_ROW_31_209 VSS VDD sky130_fd_sc_hd__tapvpwrvgnd_1
XTAP_TAPCELL_ROW_31_210 VSS VDD sky130_fd_sc_hd__tapvpwrvgnd_1
XTAP_TAPCELL_ROW_31_211 VSS VDD sky130_fd_sc_hd__tapvpwrvgnd_1
XTAP_TAPCELL_ROW_31_212 VSS VDD sky130_fd_sc_hd__tapvpwrvgnd_1
XTAP_TAPCELL_ROW_31_213 VSS VDD sky130_fd_sc_hd__tapvpwrvgnd_1
XTAP_TAPCELL_ROW_32_214 VSS VDD sky130_fd_sc_hd__tapvpwrvgnd_1
XTAP_TAPCELL_ROW_32_215 VSS VDD sky130_fd_sc_hd__tapvpwrvgnd_1
XTAP_TAPCELL_ROW_32_216 VSS VDD sky130_fd_sc_hd__tapvpwrvgnd_1
XTAP_TAPCELL_ROW_32_217 VSS VDD sky130_fd_sc_hd__tapvpwrvgnd_1
XTAP_TAPCELL_ROW_32_218 VSS VDD sky130_fd_sc_hd__tapvpwrvgnd_1
XTAP_TAPCELL_ROW_32_219 VSS VDD sky130_fd_sc_hd__tapvpwrvgnd_1
XTAP_TAPCELL_ROW_32_220 VSS VDD sky130_fd_sc_hd__tapvpwrvgnd_1
XTAP_TAPCELL_ROW_33_221 VSS VDD sky130_fd_sc_hd__tapvpwrvgnd_1
XTAP_TAPCELL_ROW_33_222 VSS VDD sky130_fd_sc_hd__tapvpwrvgnd_1
XTAP_TAPCELL_ROW_33_223 VSS VDD sky130_fd_sc_hd__tapvpwrvgnd_1
XTAP_TAPCELL_ROW_33_224 VSS VDD sky130_fd_sc_hd__tapvpwrvgnd_1
XTAP_TAPCELL_ROW_33_225 VSS VDD sky130_fd_sc_hd__tapvpwrvgnd_1
XTAP_TAPCELL_ROW_33_226 VSS VDD sky130_fd_sc_hd__tapvpwrvgnd_1
XTAP_TAPCELL_ROW_34_227 VSS VDD sky130_fd_sc_hd__tapvpwrvgnd_1
XTAP_TAPCELL_ROW_34_228 VSS VDD sky130_fd_sc_hd__tapvpwrvgnd_1
XTAP_TAPCELL_ROW_34_229 VSS VDD sky130_fd_sc_hd__tapvpwrvgnd_1
XTAP_TAPCELL_ROW_34_230 VSS VDD sky130_fd_sc_hd__tapvpwrvgnd_1
XTAP_TAPCELL_ROW_34_231 VSS VDD sky130_fd_sc_hd__tapvpwrvgnd_1
XTAP_TAPCELL_ROW_34_232 VSS VDD sky130_fd_sc_hd__tapvpwrvgnd_1
XTAP_TAPCELL_ROW_34_233 VSS VDD sky130_fd_sc_hd__tapvpwrvgnd_1
XTAP_TAPCELL_ROW_35_234 VSS VDD sky130_fd_sc_hd__tapvpwrvgnd_1
XTAP_TAPCELL_ROW_35_235 VSS VDD sky130_fd_sc_hd__tapvpwrvgnd_1
XTAP_TAPCELL_ROW_35_236 VSS VDD sky130_fd_sc_hd__tapvpwrvgnd_1
XTAP_TAPCELL_ROW_35_237 VSS VDD sky130_fd_sc_hd__tapvpwrvgnd_1
XTAP_TAPCELL_ROW_35_238 VSS VDD sky130_fd_sc_hd__tapvpwrvgnd_1
XTAP_TAPCELL_ROW_35_239 VSS VDD sky130_fd_sc_hd__tapvpwrvgnd_1
XTAP_TAPCELL_ROW_36_240 VSS VDD sky130_fd_sc_hd__tapvpwrvgnd_1
XTAP_TAPCELL_ROW_36_241 VSS VDD sky130_fd_sc_hd__tapvpwrvgnd_1
XTAP_TAPCELL_ROW_36_242 VSS VDD sky130_fd_sc_hd__tapvpwrvgnd_1
XTAP_TAPCELL_ROW_36_243 VSS VDD sky130_fd_sc_hd__tapvpwrvgnd_1
XTAP_TAPCELL_ROW_36_244 VSS VDD sky130_fd_sc_hd__tapvpwrvgnd_1
XTAP_TAPCELL_ROW_36_245 VSS VDD sky130_fd_sc_hd__tapvpwrvgnd_1
XTAP_TAPCELL_ROW_36_246 VSS VDD sky130_fd_sc_hd__tapvpwrvgnd_1
XTAP_TAPCELL_ROW_37_247 VSS VDD sky130_fd_sc_hd__tapvpwrvgnd_1
XTAP_TAPCELL_ROW_37_248 VSS VDD sky130_fd_sc_hd__tapvpwrvgnd_1
XTAP_TAPCELL_ROW_37_249 VSS VDD sky130_fd_sc_hd__tapvpwrvgnd_1
XTAP_TAPCELL_ROW_37_250 VSS VDD sky130_fd_sc_hd__tapvpwrvgnd_1
XTAP_TAPCELL_ROW_37_251 VSS VDD sky130_fd_sc_hd__tapvpwrvgnd_1
XTAP_TAPCELL_ROW_37_252 VSS VDD sky130_fd_sc_hd__tapvpwrvgnd_1
XTAP_TAPCELL_ROW_38_253 VSS VDD sky130_fd_sc_hd__tapvpwrvgnd_1
XTAP_TAPCELL_ROW_38_254 VSS VDD sky130_fd_sc_hd__tapvpwrvgnd_1
XTAP_TAPCELL_ROW_38_255 VSS VDD sky130_fd_sc_hd__tapvpwrvgnd_1
XTAP_TAPCELL_ROW_38_256 VSS VDD sky130_fd_sc_hd__tapvpwrvgnd_1
XTAP_TAPCELL_ROW_38_257 VSS VDD sky130_fd_sc_hd__tapvpwrvgnd_1
XTAP_TAPCELL_ROW_38_258 VSS VDD sky130_fd_sc_hd__tapvpwrvgnd_1
XTAP_TAPCELL_ROW_38_259 VSS VDD sky130_fd_sc_hd__tapvpwrvgnd_1
XTAP_TAPCELL_ROW_39_260 VSS VDD sky130_fd_sc_hd__tapvpwrvgnd_1
XTAP_TAPCELL_ROW_39_261 VSS VDD sky130_fd_sc_hd__tapvpwrvgnd_1
XTAP_TAPCELL_ROW_39_262 VSS VDD sky130_fd_sc_hd__tapvpwrvgnd_1
XTAP_TAPCELL_ROW_39_263 VSS VDD sky130_fd_sc_hd__tapvpwrvgnd_1
XTAP_TAPCELL_ROW_39_264 VSS VDD sky130_fd_sc_hd__tapvpwrvgnd_1
XTAP_TAPCELL_ROW_39_265 VSS VDD sky130_fd_sc_hd__tapvpwrvgnd_1
XTAP_TAPCELL_ROW_40_266 VSS VDD sky130_fd_sc_hd__tapvpwrvgnd_1
XTAP_TAPCELL_ROW_40_267 VSS VDD sky130_fd_sc_hd__tapvpwrvgnd_1
XTAP_TAPCELL_ROW_40_268 VSS VDD sky130_fd_sc_hd__tapvpwrvgnd_1
XTAP_TAPCELL_ROW_40_269 VSS VDD sky130_fd_sc_hd__tapvpwrvgnd_1
XTAP_TAPCELL_ROW_40_270 VSS VDD sky130_fd_sc_hd__tapvpwrvgnd_1
XTAP_TAPCELL_ROW_40_271 VSS VDD sky130_fd_sc_hd__tapvpwrvgnd_1
XTAP_TAPCELL_ROW_40_272 VSS VDD sky130_fd_sc_hd__tapvpwrvgnd_1
XTAP_TAPCELL_ROW_41_273 VSS VDD sky130_fd_sc_hd__tapvpwrvgnd_1
XTAP_TAPCELL_ROW_41_274 VSS VDD sky130_fd_sc_hd__tapvpwrvgnd_1
XTAP_TAPCELL_ROW_41_275 VSS VDD sky130_fd_sc_hd__tapvpwrvgnd_1
XTAP_TAPCELL_ROW_41_276 VSS VDD sky130_fd_sc_hd__tapvpwrvgnd_1
XTAP_TAPCELL_ROW_41_277 VSS VDD sky130_fd_sc_hd__tapvpwrvgnd_1
XTAP_TAPCELL_ROW_41_278 VSS VDD sky130_fd_sc_hd__tapvpwrvgnd_1
XTAP_TAPCELL_ROW_42_279 VSS VDD sky130_fd_sc_hd__tapvpwrvgnd_1
XTAP_TAPCELL_ROW_42_280 VSS VDD sky130_fd_sc_hd__tapvpwrvgnd_1
XTAP_TAPCELL_ROW_42_281 VSS VDD sky130_fd_sc_hd__tapvpwrvgnd_1
XTAP_TAPCELL_ROW_42_282 VSS VDD sky130_fd_sc_hd__tapvpwrvgnd_1
XTAP_TAPCELL_ROW_42_283 VSS VDD sky130_fd_sc_hd__tapvpwrvgnd_1
XTAP_TAPCELL_ROW_42_284 VSS VDD sky130_fd_sc_hd__tapvpwrvgnd_1
XTAP_TAPCELL_ROW_42_285 VSS VDD sky130_fd_sc_hd__tapvpwrvgnd_1
XTAP_TAPCELL_ROW_43_286 VSS VDD sky130_fd_sc_hd__tapvpwrvgnd_1
XTAP_TAPCELL_ROW_43_287 VSS VDD sky130_fd_sc_hd__tapvpwrvgnd_1
XTAP_TAPCELL_ROW_43_288 VSS VDD sky130_fd_sc_hd__tapvpwrvgnd_1
XTAP_TAPCELL_ROW_43_289 VSS VDD sky130_fd_sc_hd__tapvpwrvgnd_1
XTAP_TAPCELL_ROW_43_290 VSS VDD sky130_fd_sc_hd__tapvpwrvgnd_1
XTAP_TAPCELL_ROW_43_291 VSS VDD sky130_fd_sc_hd__tapvpwrvgnd_1
XTAP_TAPCELL_ROW_44_292 VSS VDD sky130_fd_sc_hd__tapvpwrvgnd_1
XTAP_TAPCELL_ROW_44_293 VSS VDD sky130_fd_sc_hd__tapvpwrvgnd_1
XTAP_TAPCELL_ROW_44_294 VSS VDD sky130_fd_sc_hd__tapvpwrvgnd_1
XTAP_TAPCELL_ROW_44_295 VSS VDD sky130_fd_sc_hd__tapvpwrvgnd_1
XTAP_TAPCELL_ROW_44_296 VSS VDD sky130_fd_sc_hd__tapvpwrvgnd_1
XTAP_TAPCELL_ROW_44_297 VSS VDD sky130_fd_sc_hd__tapvpwrvgnd_1
XTAP_TAPCELL_ROW_44_298 VSS VDD sky130_fd_sc_hd__tapvpwrvgnd_1
XTAP_TAPCELL_ROW_45_299 VSS VDD sky130_fd_sc_hd__tapvpwrvgnd_1
XTAP_TAPCELL_ROW_45_300 VSS VDD sky130_fd_sc_hd__tapvpwrvgnd_1
XTAP_TAPCELL_ROW_45_301 VSS VDD sky130_fd_sc_hd__tapvpwrvgnd_1
XTAP_TAPCELL_ROW_45_302 VSS VDD sky130_fd_sc_hd__tapvpwrvgnd_1
XTAP_TAPCELL_ROW_45_303 VSS VDD sky130_fd_sc_hd__tapvpwrvgnd_1
XTAP_TAPCELL_ROW_45_304 VSS VDD sky130_fd_sc_hd__tapvpwrvgnd_1
XTAP_TAPCELL_ROW_46_305 VSS VDD sky130_fd_sc_hd__tapvpwrvgnd_1
XTAP_TAPCELL_ROW_46_306 VSS VDD sky130_fd_sc_hd__tapvpwrvgnd_1
XTAP_TAPCELL_ROW_46_307 VSS VDD sky130_fd_sc_hd__tapvpwrvgnd_1
XTAP_TAPCELL_ROW_46_308 VSS VDD sky130_fd_sc_hd__tapvpwrvgnd_1
XTAP_TAPCELL_ROW_46_309 VSS VDD sky130_fd_sc_hd__tapvpwrvgnd_1
XTAP_TAPCELL_ROW_46_310 VSS VDD sky130_fd_sc_hd__tapvpwrvgnd_1
XTAP_TAPCELL_ROW_46_311 VSS VDD sky130_fd_sc_hd__tapvpwrvgnd_1
XTAP_TAPCELL_ROW_47_312 VSS VDD sky130_fd_sc_hd__tapvpwrvgnd_1
XTAP_TAPCELL_ROW_47_313 VSS VDD sky130_fd_sc_hd__tapvpwrvgnd_1
XTAP_TAPCELL_ROW_47_314 VSS VDD sky130_fd_sc_hd__tapvpwrvgnd_1
XTAP_TAPCELL_ROW_47_315 VSS VDD sky130_fd_sc_hd__tapvpwrvgnd_1
XTAP_TAPCELL_ROW_47_316 VSS VDD sky130_fd_sc_hd__tapvpwrvgnd_1
XTAP_TAPCELL_ROW_47_317 VSS VDD sky130_fd_sc_hd__tapvpwrvgnd_1
XTAP_TAPCELL_ROW_48_318 VSS VDD sky130_fd_sc_hd__tapvpwrvgnd_1
XTAP_TAPCELL_ROW_48_319 VSS VDD sky130_fd_sc_hd__tapvpwrvgnd_1
XTAP_TAPCELL_ROW_48_320 VSS VDD sky130_fd_sc_hd__tapvpwrvgnd_1
XTAP_TAPCELL_ROW_48_321 VSS VDD sky130_fd_sc_hd__tapvpwrvgnd_1
XTAP_TAPCELL_ROW_48_322 VSS VDD sky130_fd_sc_hd__tapvpwrvgnd_1
XTAP_TAPCELL_ROW_48_323 VSS VDD sky130_fd_sc_hd__tapvpwrvgnd_1
XTAP_TAPCELL_ROW_48_324 VSS VDD sky130_fd_sc_hd__tapvpwrvgnd_1
XTAP_TAPCELL_ROW_49_325 VSS VDD sky130_fd_sc_hd__tapvpwrvgnd_1
XTAP_TAPCELL_ROW_49_326 VSS VDD sky130_fd_sc_hd__tapvpwrvgnd_1
XTAP_TAPCELL_ROW_49_327 VSS VDD sky130_fd_sc_hd__tapvpwrvgnd_1
XTAP_TAPCELL_ROW_49_328 VSS VDD sky130_fd_sc_hd__tapvpwrvgnd_1
XTAP_TAPCELL_ROW_49_329 VSS VDD sky130_fd_sc_hd__tapvpwrvgnd_1
XTAP_TAPCELL_ROW_49_330 VSS VDD sky130_fd_sc_hd__tapvpwrvgnd_1
XTAP_TAPCELL_ROW_50_331 VSS VDD sky130_fd_sc_hd__tapvpwrvgnd_1
XTAP_TAPCELL_ROW_50_332 VSS VDD sky130_fd_sc_hd__tapvpwrvgnd_1
XTAP_TAPCELL_ROW_50_333 VSS VDD sky130_fd_sc_hd__tapvpwrvgnd_1
XTAP_TAPCELL_ROW_50_334 VSS VDD sky130_fd_sc_hd__tapvpwrvgnd_1
XTAP_TAPCELL_ROW_50_335 VSS VDD sky130_fd_sc_hd__tapvpwrvgnd_1
XTAP_TAPCELL_ROW_50_336 VSS VDD sky130_fd_sc_hd__tapvpwrvgnd_1
XTAP_TAPCELL_ROW_50_337 VSS VDD sky130_fd_sc_hd__tapvpwrvgnd_1
XTAP_TAPCELL_ROW_51_338 VSS VDD sky130_fd_sc_hd__tapvpwrvgnd_1
XTAP_TAPCELL_ROW_51_339 VSS VDD sky130_fd_sc_hd__tapvpwrvgnd_1
XTAP_TAPCELL_ROW_51_340 VSS VDD sky130_fd_sc_hd__tapvpwrvgnd_1
XTAP_TAPCELL_ROW_51_341 VSS VDD sky130_fd_sc_hd__tapvpwrvgnd_1
XTAP_TAPCELL_ROW_51_342 VSS VDD sky130_fd_sc_hd__tapvpwrvgnd_1
XTAP_TAPCELL_ROW_51_343 VSS VDD sky130_fd_sc_hd__tapvpwrvgnd_1
XTAP_TAPCELL_ROW_52_344 VSS VDD sky130_fd_sc_hd__tapvpwrvgnd_1
XTAP_TAPCELL_ROW_52_345 VSS VDD sky130_fd_sc_hd__tapvpwrvgnd_1
XTAP_TAPCELL_ROW_52_346 VSS VDD sky130_fd_sc_hd__tapvpwrvgnd_1
XTAP_TAPCELL_ROW_52_347 VSS VDD sky130_fd_sc_hd__tapvpwrvgnd_1
XTAP_TAPCELL_ROW_52_348 VSS VDD sky130_fd_sc_hd__tapvpwrvgnd_1
XTAP_TAPCELL_ROW_52_349 VSS VDD sky130_fd_sc_hd__tapvpwrvgnd_1
XTAP_TAPCELL_ROW_52_350 VSS VDD sky130_fd_sc_hd__tapvpwrvgnd_1
XTAP_TAPCELL_ROW_53_351 VSS VDD sky130_fd_sc_hd__tapvpwrvgnd_1
XTAP_TAPCELL_ROW_53_352 VSS VDD sky130_fd_sc_hd__tapvpwrvgnd_1
XTAP_TAPCELL_ROW_53_353 VSS VDD sky130_fd_sc_hd__tapvpwrvgnd_1
XTAP_TAPCELL_ROW_53_354 VSS VDD sky130_fd_sc_hd__tapvpwrvgnd_1
XTAP_TAPCELL_ROW_53_355 VSS VDD sky130_fd_sc_hd__tapvpwrvgnd_1
XTAP_TAPCELL_ROW_53_356 VSS VDD sky130_fd_sc_hd__tapvpwrvgnd_1
XTAP_TAPCELL_ROW_54_357 VSS VDD sky130_fd_sc_hd__tapvpwrvgnd_1
XTAP_TAPCELL_ROW_54_358 VSS VDD sky130_fd_sc_hd__tapvpwrvgnd_1
XTAP_TAPCELL_ROW_54_359 VSS VDD sky130_fd_sc_hd__tapvpwrvgnd_1
XTAP_TAPCELL_ROW_54_360 VSS VDD sky130_fd_sc_hd__tapvpwrvgnd_1
XTAP_TAPCELL_ROW_54_361 VSS VDD sky130_fd_sc_hd__tapvpwrvgnd_1
XTAP_TAPCELL_ROW_54_362 VSS VDD sky130_fd_sc_hd__tapvpwrvgnd_1
XTAP_TAPCELL_ROW_54_363 VSS VDD sky130_fd_sc_hd__tapvpwrvgnd_1
XTAP_TAPCELL_ROW_55_364 VSS VDD sky130_fd_sc_hd__tapvpwrvgnd_1
XTAP_TAPCELL_ROW_55_365 VSS VDD sky130_fd_sc_hd__tapvpwrvgnd_1
XTAP_TAPCELL_ROW_55_366 VSS VDD sky130_fd_sc_hd__tapvpwrvgnd_1
XTAP_TAPCELL_ROW_55_367 VSS VDD sky130_fd_sc_hd__tapvpwrvgnd_1
XTAP_TAPCELL_ROW_55_368 VSS VDD sky130_fd_sc_hd__tapvpwrvgnd_1
XTAP_TAPCELL_ROW_55_369 VSS VDD sky130_fd_sc_hd__tapvpwrvgnd_1
XTAP_TAPCELL_ROW_56_370 VSS VDD sky130_fd_sc_hd__tapvpwrvgnd_1
XTAP_TAPCELL_ROW_56_371 VSS VDD sky130_fd_sc_hd__tapvpwrvgnd_1
XTAP_TAPCELL_ROW_56_372 VSS VDD sky130_fd_sc_hd__tapvpwrvgnd_1
XTAP_TAPCELL_ROW_56_373 VSS VDD sky130_fd_sc_hd__tapvpwrvgnd_1
XTAP_TAPCELL_ROW_56_374 VSS VDD sky130_fd_sc_hd__tapvpwrvgnd_1
XTAP_TAPCELL_ROW_56_375 VSS VDD sky130_fd_sc_hd__tapvpwrvgnd_1
XTAP_TAPCELL_ROW_56_376 VSS VDD sky130_fd_sc_hd__tapvpwrvgnd_1
XTAP_TAPCELL_ROW_57_377 VSS VDD sky130_fd_sc_hd__tapvpwrvgnd_1
XTAP_TAPCELL_ROW_57_378 VSS VDD sky130_fd_sc_hd__tapvpwrvgnd_1
XTAP_TAPCELL_ROW_57_379 VSS VDD sky130_fd_sc_hd__tapvpwrvgnd_1
XTAP_TAPCELL_ROW_57_380 VSS VDD sky130_fd_sc_hd__tapvpwrvgnd_1
XTAP_TAPCELL_ROW_57_381 VSS VDD sky130_fd_sc_hd__tapvpwrvgnd_1
XTAP_TAPCELL_ROW_57_382 VSS VDD sky130_fd_sc_hd__tapvpwrvgnd_1
XTAP_TAPCELL_ROW_58_383 VSS VDD sky130_fd_sc_hd__tapvpwrvgnd_1
XTAP_TAPCELL_ROW_58_384 VSS VDD sky130_fd_sc_hd__tapvpwrvgnd_1
XTAP_TAPCELL_ROW_58_385 VSS VDD sky130_fd_sc_hd__tapvpwrvgnd_1
XTAP_TAPCELL_ROW_58_386 VSS VDD sky130_fd_sc_hd__tapvpwrvgnd_1
XTAP_TAPCELL_ROW_58_387 VSS VDD sky130_fd_sc_hd__tapvpwrvgnd_1
XTAP_TAPCELL_ROW_58_388 VSS VDD sky130_fd_sc_hd__tapvpwrvgnd_1
XTAP_TAPCELL_ROW_58_389 VSS VDD sky130_fd_sc_hd__tapvpwrvgnd_1
XTAP_TAPCELL_ROW_59_390 VSS VDD sky130_fd_sc_hd__tapvpwrvgnd_1
XTAP_TAPCELL_ROW_59_391 VSS VDD sky130_fd_sc_hd__tapvpwrvgnd_1
XTAP_TAPCELL_ROW_59_392 VSS VDD sky130_fd_sc_hd__tapvpwrvgnd_1
XTAP_TAPCELL_ROW_59_393 VSS VDD sky130_fd_sc_hd__tapvpwrvgnd_1
XTAP_TAPCELL_ROW_59_394 VSS VDD sky130_fd_sc_hd__tapvpwrvgnd_1
XTAP_TAPCELL_ROW_59_395 VSS VDD sky130_fd_sc_hd__tapvpwrvgnd_1
XTAP_TAPCELL_ROW_60_396 VSS VDD sky130_fd_sc_hd__tapvpwrvgnd_1
XTAP_TAPCELL_ROW_60_397 VSS VDD sky130_fd_sc_hd__tapvpwrvgnd_1
XTAP_TAPCELL_ROW_60_398 VSS VDD sky130_fd_sc_hd__tapvpwrvgnd_1
XTAP_TAPCELL_ROW_60_399 VSS VDD sky130_fd_sc_hd__tapvpwrvgnd_1
XTAP_TAPCELL_ROW_60_400 VSS VDD sky130_fd_sc_hd__tapvpwrvgnd_1
XTAP_TAPCELL_ROW_60_401 VSS VDD sky130_fd_sc_hd__tapvpwrvgnd_1
XTAP_TAPCELL_ROW_60_402 VSS VDD sky130_fd_sc_hd__tapvpwrvgnd_1
XTAP_TAPCELL_ROW_61_403 VSS VDD sky130_fd_sc_hd__tapvpwrvgnd_1
XTAP_TAPCELL_ROW_61_404 VSS VDD sky130_fd_sc_hd__tapvpwrvgnd_1
XTAP_TAPCELL_ROW_61_405 VSS VDD sky130_fd_sc_hd__tapvpwrvgnd_1
XTAP_TAPCELL_ROW_61_406 VSS VDD sky130_fd_sc_hd__tapvpwrvgnd_1
XTAP_TAPCELL_ROW_61_407 VSS VDD sky130_fd_sc_hd__tapvpwrvgnd_1
XTAP_TAPCELL_ROW_61_408 VSS VDD sky130_fd_sc_hd__tapvpwrvgnd_1
XTAP_TAPCELL_ROW_62_409 VSS VDD sky130_fd_sc_hd__tapvpwrvgnd_1
XTAP_TAPCELL_ROW_62_410 VSS VDD sky130_fd_sc_hd__tapvpwrvgnd_1
XTAP_TAPCELL_ROW_62_411 VSS VDD sky130_fd_sc_hd__tapvpwrvgnd_1
XTAP_TAPCELL_ROW_62_412 VSS VDD sky130_fd_sc_hd__tapvpwrvgnd_1
XTAP_TAPCELL_ROW_62_413 VSS VDD sky130_fd_sc_hd__tapvpwrvgnd_1
XTAP_TAPCELL_ROW_62_414 VSS VDD sky130_fd_sc_hd__tapvpwrvgnd_1
XTAP_TAPCELL_ROW_62_415 VSS VDD sky130_fd_sc_hd__tapvpwrvgnd_1
XTAP_TAPCELL_ROW_63_416 VSS VDD sky130_fd_sc_hd__tapvpwrvgnd_1
XTAP_TAPCELL_ROW_63_417 VSS VDD sky130_fd_sc_hd__tapvpwrvgnd_1
XTAP_TAPCELL_ROW_63_418 VSS VDD sky130_fd_sc_hd__tapvpwrvgnd_1
XTAP_TAPCELL_ROW_63_419 VSS VDD sky130_fd_sc_hd__tapvpwrvgnd_1
XTAP_TAPCELL_ROW_63_420 VSS VDD sky130_fd_sc_hd__tapvpwrvgnd_1
XTAP_TAPCELL_ROW_63_421 VSS VDD sky130_fd_sc_hd__tapvpwrvgnd_1
XTAP_TAPCELL_ROW_64_422 VSS VDD sky130_fd_sc_hd__tapvpwrvgnd_1
XTAP_TAPCELL_ROW_64_423 VSS VDD sky130_fd_sc_hd__tapvpwrvgnd_1
XTAP_TAPCELL_ROW_64_424 VSS VDD sky130_fd_sc_hd__tapvpwrvgnd_1
XTAP_TAPCELL_ROW_64_425 VSS VDD sky130_fd_sc_hd__tapvpwrvgnd_1
XTAP_TAPCELL_ROW_64_426 VSS VDD sky130_fd_sc_hd__tapvpwrvgnd_1
XTAP_TAPCELL_ROW_64_427 VSS VDD sky130_fd_sc_hd__tapvpwrvgnd_1
XTAP_TAPCELL_ROW_64_428 VSS VDD sky130_fd_sc_hd__tapvpwrvgnd_1
XTAP_TAPCELL_ROW_65_429 VSS VDD sky130_fd_sc_hd__tapvpwrvgnd_1
XTAP_TAPCELL_ROW_65_430 VSS VDD sky130_fd_sc_hd__tapvpwrvgnd_1
XTAP_TAPCELL_ROW_65_431 VSS VDD sky130_fd_sc_hd__tapvpwrvgnd_1
XTAP_TAPCELL_ROW_65_432 VSS VDD sky130_fd_sc_hd__tapvpwrvgnd_1
XTAP_TAPCELL_ROW_65_433 VSS VDD sky130_fd_sc_hd__tapvpwrvgnd_1
XTAP_TAPCELL_ROW_65_434 VSS VDD sky130_fd_sc_hd__tapvpwrvgnd_1
XTAP_TAPCELL_ROW_66_435 VSS VDD sky130_fd_sc_hd__tapvpwrvgnd_1
XTAP_TAPCELL_ROW_66_436 VSS VDD sky130_fd_sc_hd__tapvpwrvgnd_1
XTAP_TAPCELL_ROW_66_437 VSS VDD sky130_fd_sc_hd__tapvpwrvgnd_1
XTAP_TAPCELL_ROW_66_438 VSS VDD sky130_fd_sc_hd__tapvpwrvgnd_1
XTAP_TAPCELL_ROW_66_439 VSS VDD sky130_fd_sc_hd__tapvpwrvgnd_1
XTAP_TAPCELL_ROW_66_440 VSS VDD sky130_fd_sc_hd__tapvpwrvgnd_1
XTAP_TAPCELL_ROW_66_441 VSS VDD sky130_fd_sc_hd__tapvpwrvgnd_1
XTAP_TAPCELL_ROW_67_442 VSS VDD sky130_fd_sc_hd__tapvpwrvgnd_1
XTAP_TAPCELL_ROW_67_443 VSS VDD sky130_fd_sc_hd__tapvpwrvgnd_1
XTAP_TAPCELL_ROW_67_444 VSS VDD sky130_fd_sc_hd__tapvpwrvgnd_1
XTAP_TAPCELL_ROW_67_445 VSS VDD sky130_fd_sc_hd__tapvpwrvgnd_1
XTAP_TAPCELL_ROW_67_446 VSS VDD sky130_fd_sc_hd__tapvpwrvgnd_1
XTAP_TAPCELL_ROW_67_447 VSS VDD sky130_fd_sc_hd__tapvpwrvgnd_1
XTAP_TAPCELL_ROW_68_448 VSS VDD sky130_fd_sc_hd__tapvpwrvgnd_1
XTAP_TAPCELL_ROW_68_449 VSS VDD sky130_fd_sc_hd__tapvpwrvgnd_1
XTAP_TAPCELL_ROW_68_450 VSS VDD sky130_fd_sc_hd__tapvpwrvgnd_1
XTAP_TAPCELL_ROW_68_451 VSS VDD sky130_fd_sc_hd__tapvpwrvgnd_1
XTAP_TAPCELL_ROW_68_452 VSS VDD sky130_fd_sc_hd__tapvpwrvgnd_1
XTAP_TAPCELL_ROW_68_453 VSS VDD sky130_fd_sc_hd__tapvpwrvgnd_1
XTAP_TAPCELL_ROW_68_454 VSS VDD sky130_fd_sc_hd__tapvpwrvgnd_1
XTAP_TAPCELL_ROW_69_455 VSS VDD sky130_fd_sc_hd__tapvpwrvgnd_1
XTAP_TAPCELL_ROW_69_456 VSS VDD sky130_fd_sc_hd__tapvpwrvgnd_1
XTAP_TAPCELL_ROW_69_457 VSS VDD sky130_fd_sc_hd__tapvpwrvgnd_1
XTAP_TAPCELL_ROW_69_458 VSS VDD sky130_fd_sc_hd__tapvpwrvgnd_1
XTAP_TAPCELL_ROW_69_459 VSS VDD sky130_fd_sc_hd__tapvpwrvgnd_1
XTAP_TAPCELL_ROW_69_460 VSS VDD sky130_fd_sc_hd__tapvpwrvgnd_1
XTAP_TAPCELL_ROW_69_461 VSS VDD sky130_fd_sc_hd__tapvpwrvgnd_1
XTAP_TAPCELL_ROW_69_462 VSS VDD sky130_fd_sc_hd__tapvpwrvgnd_1
XTAP_TAPCELL_ROW_69_463 VSS VDD sky130_fd_sc_hd__tapvpwrvgnd_1
XTAP_TAPCELL_ROW_69_464 VSS VDD sky130_fd_sc_hd__tapvpwrvgnd_1
XTAP_TAPCELL_ROW_69_465 VSS VDD sky130_fd_sc_hd__tapvpwrvgnd_1
XTAP_TAPCELL_ROW_69_466 VSS VDD sky130_fd_sc_hd__tapvpwrvgnd_1
XTAP_TAPCELL_ROW_69_467 VSS VDD sky130_fd_sc_hd__tapvpwrvgnd_1
Xoutput89 net79 VSS VSS VDD VDD rsp_data[27] sky130_fd_sc_hd__clkdlybuf4s50_1
Xoutput90 net79 VSS VSS VDD VDD rsp_data[28] sky130_fd_sc_hd__clkdlybuf4s50_1
Xoutput91 net79 VSS VSS VDD VDD rsp_data[29] sky130_fd_sc_hd__clkdlybuf4s50_1
Xoutput92 net81 VSS VSS VDD VDD rsp_data[2] sky130_fd_sc_hd__clkdlybuf4s50_1
Xoutput93 net79 VSS VSS VDD VDD rsp_data[30] sky130_fd_sc_hd__clkdlybuf4s50_1
Xoutput94 net79 VSS VSS VDD VDD rsp_data[31] sky130_fd_sc_hd__clkdlybuf4s50_1
Xoutput95 net82 VSS VSS VDD VDD rsp_data[3] sky130_fd_sc_hd__clkdlybuf4s50_1
Xoutput96 net83 VSS VSS VDD VDD rsp_data[4] sky130_fd_sc_hd__clkdlybuf4s50_1
Xoutput97 net84 VSS VSS VDD VDD rsp_data[5] sky130_fd_sc_hd__clkdlybuf4s50_1
Xoutput98 net85 VSS VSS VDD VDD rsp_data[6] sky130_fd_sc_hd__clkdlybuf4s50_1
Xoutput99 net86 VSS VSS VDD VDD rsp_data[7] sky130_fd_sc_hd__clkdlybuf4s50_1
Xoutput100 net87 VSS VSS VDD VDD rsp_data[8] sky130_fd_sc_hd__clkdlybuf4s50_1
Xoutput101 net88 VSS VSS VDD VDD rsp_data[9] sky130_fd_sc_hd__clkdlybuf4s50_1
Xoutput102 net89 VSS VSS VDD VDD rsp_valid sky130_fd_sc_hd__clkdlybuf4s50_1
Xclkbuf_3_0__f_clk clknet_0_clk VSS VSS VDD VDD clknet_3_0__leaf_clk
+ sky130_fd_sc_hd__clkbuf_16
Xclkbuf_0_clk clk VSS VSS VDD VDD clknet_0_clk sky130_fd_sc_hd__clkbuf_16
Xplace110 _1286_ VSS VSS VDD VDD net97 sky130_fd_sc_hd__buf_4
Xplace112 _1219_ VSS VSS VDD VDD net99 sky130_fd_sc_hd__buf_4
Xplace111 _1224_ VSS VSS VDD VDD net98 sky130_fd_sc_hd__buf_4
Xplace113 net101 VSS VSS VDD VDD net100 sky130_fd_sc_hd__buf_4
Xplace114 net68 VSS VSS VDD VDD net101 sky130_fd_sc_hd__buf_4
Xclkbuf_3_1__f_clk clknet_0_clk VSS VSS VDD VDD clknet_3_1__leaf_clk
+ sky130_fd_sc_hd__clkbuf_16
Xclkbuf_3_2__f_clk clknet_0_clk VSS VSS VDD VDD clknet_3_2__leaf_clk
+ sky130_fd_sc_hd__clkbuf_16
Xclkbuf_3_3__f_clk clknet_0_clk VSS VSS VDD VDD clknet_3_3__leaf_clk
+ sky130_fd_sc_hd__clkbuf_16
Xclkbuf_3_4__f_clk clknet_0_clk VSS VSS VDD VDD clknet_3_4__leaf_clk
+ sky130_fd_sc_hd__clkbuf_16
Xclkbuf_3_5__f_clk clknet_0_clk VSS VSS VDD VDD clknet_3_5__leaf_clk
+ sky130_fd_sc_hd__clkbuf_16
Xclkbuf_3_6__f_clk clknet_0_clk VSS VSS VDD VDD clknet_3_6__leaf_clk
+ sky130_fd_sc_hd__clkbuf_16
Xclkbuf_3_7__f_clk clknet_0_clk VSS VSS VDD VDD clknet_3_7__leaf_clk
+ sky130_fd_sc_hd__clkbuf_16
Xclkload0 clknet_3_0__leaf_clk VSS VSS VDD VDD _unconnected_0
+ sky130_fd_sc_hd__clkbuf_1
Xclkload1 clknet_3_1__leaf_clk VSS VSS VDD VDD _unconnected_1
+ sky130_fd_sc_hd__clkbuf_8
Xclkload2 clknet_3_2__leaf_clk VSS VSS VDD VDD _unconnected_2
+ sky130_fd_sc_hd__clkbuf_8
Xclkload3 clknet_3_4__leaf_clk VSS VSS VDD VDD _unconnected_3
+ sky130_fd_sc_hd__clkinvlp_4
Xclkload4 clknet_3_5__leaf_clk VSS VSS VDD VDD _unconnected_4
+ sky130_fd_sc_hd__clkinv_2
Xclkload5 clknet_3_6__leaf_clk VSS VSS VDD VDD _unconnected_5
+ sky130_fd_sc_hd__bufinv_16
Xclkload6 clknet_3_7__leaf_clk VSS VSS VDD VDD _unconnected_6
+ sky130_fd_sc_hd__clkbuf_1
.ENDS benchmark_dot
