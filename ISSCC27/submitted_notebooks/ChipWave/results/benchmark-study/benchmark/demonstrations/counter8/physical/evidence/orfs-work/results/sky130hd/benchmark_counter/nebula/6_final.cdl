* CDL Netlist generated by OpenROAD

*.BUSDELIMITER [

.SUBCKT benchmark_counter clk count[0] count[1] count[2] count[3]
+ count[4] count[5] count[6] count[7] en load load_value[0]
+ load_value[1] load_value[2] load_value[3] load_value[4] load_value[5]
+ load_value[6] load_value[7] overflow rst_n VDD VSS
X_060_ net18 VSS VSS VDD VDD _011_ sky130_fd_sc_hd__inv_1
Xinput1 en VSS VSS VDD VDD net1 sky130_fd_sc_hd__clkdlybuf4s50_1
X_062_ net15 net16 VSS VSS VDD VDD _020_ sky130_fd_sc_hd__nand2_1
X_063_ net18 net17 VSS VSS VDD VDD _021_ sky130_fd_sc_hd__nand2_1
X_064_ _020_ _021_ VSS VSS VDD VDD _022_ sky130_fd_sc_hd__nor2_1
X_065_ net12 VSS VSS VDD VDD _023_ sky130_fd_sc_hd__inv_1
X_066_ net14 net13 VSS VSS VDD VDD _024_ sky130_fd_sc_hd__nand2_1
X_067_ _023_ _024_ VSS VSS VDD VDD _025_ sky130_fd_sc_hd__nor2_1
X_068_ _022_ _025_ VSS VSS VDD VDD _026_ sky130_fd_sc_hd__nand2_1
X_069_ net19 VSS VSS VDD VDD _027_ sky130_fd_sc_hd__inv_1
X_070_ _026_ _027_ VSS VSS VDD VDD _028_ sky130_fd_sc_hd__nand2_1
X_071_ _022_ _025_ net19 VSS VSS VDD VDD _029_ sky130_fd_sc_hd__nand3_1
X_072_ net1 VSS VSS VDD VDD _013_ sky130_fd_sc_hd__inv_1
X_073_ _028_ _029_ _014_ VSS VSS VDD VDD _030_ sky130_fd_sc_hd__nand3_1
X_074_ net2 net1 VSS VSS VDD VDD _031_ sky130_fd_sc_hd__nor2_4
X_075_ net10 net2 _031_ net19 VSS VSS VDD VDD _032_ sky130_fd_sc_hd__a22oi_1
X_076_ _030_ _032_ VSS VSS VDD VDD _010_ sky130_fd_sc_hd__nand2_1
X_077_ _031_ net12 VSS VSS VDD VDD _033_ sky130_fd_sc_hd__nand2_1
X_078_ net2 net3 VSS VSS VDD VDD _034_ sky130_fd_sc_hd__nand2_1
X_079_ net12 _015_ _033_ _034_ VSS VSS VDD VDD _009_ sky130_fd_sc_hd__o211ai_1
X_080_ _014_ _001_ VSS VSS VDD VDD _035_ sky130_fd_sc_hd__nand2_1
X_081_ _031_ net13 VSS VSS VDD VDD _036_ sky130_fd_sc_hd__nand2_1
X_082_ net2 net4 VSS VSS VDD VDD _037_ sky130_fd_sc_hd__nand2_1
X_083_ net2 _013_ VSS VSS VDD VDD _014_ sky130_fd_sc_hd__nor2_4
X_084_ _035_ _036_ _037_ VSS VSS VDD VDD _008_ sky130_fd_sc_hd__nand3_1
X_085_ net14 _002_ VSS VSS VDD VDD _038_ sky130_fd_sc_hd__xnor2_1
X_086_ net2 net5 _031_ net14 VSS VSS VDD VDD _039_ sky130_fd_sc_hd__a22oi_1
X_087_ _015_ _038_ _039_ VSS VSS VDD VDD _007_ sky130_fd_sc_hd__o21ai_1
X_088_ net14 net12 net13 VSS VSS VDD VDD _040_ sky130_fd_sc_hd__nand3_1
X_089_ net15 _040_ VSS VSS VDD VDD _041_ sky130_fd_sc_hd__xnor2_1
X_090_ _041_ _014_ VSS VSS VDD VDD _042_ sky130_fd_sc_hd__nand2_1
X_091_ net2 net6 _031_ net15 VSS VSS VDD VDD _043_ sky130_fd_sc_hd__a22oi_1
X_092_ _042_ _043_ VSS VSS VDD VDD _006_ sky130_fd_sc_hd__nand2_1
X_093_ _002_ VSS VSS VDD VDD _044_ sky130_fd_sc_hd__inv_1
X_094_ _014_ VSS VSS VDD VDD _015_ sky130_fd_sc_hd__inv_2
X_095_ _044_ _016_ net16 VSS VSS VDD VDD _045_ sky130_fd_sc_hd__o21bai_1
X_096_ net15 net14 net16 _002_ VSS VSS VDD VDD _046_ sky130_fd_sc_hd__nand4_1
X_097_ _045_ _014_ _046_ VSS VSS VDD VDD _047_ sky130_fd_sc_hd__nand3_1
X_098_ net2 net7 _031_ net16 VSS VSS VDD VDD _048_ sky130_fd_sc_hd__a22oi_1
X_099_ _047_ _048_ VSS VSS VDD VDD _005_ sky130_fd_sc_hd__nand2_1
X_100_ _020_ _040_ net17 VSS VSS VDD VDD _049_ sky130_fd_sc_hd__o21bai_1
X_101_ _020_ _040_ VSS VSS VDD VDD _050_ sky130_fd_sc_hd__nor2_1
X_102_ _050_ net17 VSS VSS VDD VDD _051_ sky130_fd_sc_hd__nand2_1
X_103_ _049_ _051_ _014_ VSS VSS VDD VDD _052_ sky130_fd_sc_hd__nand3_1
X_104_ net2 net8 _031_ net17 VSS VSS VDD VDD _053_ sky130_fd_sc_hd__a22oi_1
X_105_ net15 net14 VSS VSS VDD VDD _016_ sky130_fd_sc_hd__nand2_1
X_106_ _052_ _053_ VSS VSS VDD VDD _004_ sky130_fd_sc_hd__nand2_1
X_107_ _018_ _002_ VSS VSS VDD VDD _054_ sky130_fd_sc_hd__nand2_1
X_108_ _054_ net18 _014_ VSS VSS VDD VDD _055_ sky130_fd_sc_hd__nand3_1
X_109_ _018_ _011_ _002_ _014_ VSS VSS VDD VDD _056_ sky130_fd_sc_hd__nand4_1
X_110_ net2 net9 _031_ net18 VSS VSS VDD VDD _057_ sky130_fd_sc_hd__a22oi_1
X_111_ _055_ _056_ _057_ VSS VSS VDD VDD _003_ sky130_fd_sc_hd__nand3_1
X_112_ net17 net16 VSS VSS VDD VDD _017_ sky130_fd_sc_hd__nand2_1
X_113_ _016_ _017_ VSS VSS VDD VDD _018_ sky130_fd_sc_hd__nor2_2
X_114_ _018_ net19 _000_ VSS VSS VDD VDD _019_ sky130_fd_sc_hd__nand3_1
X_115_ _011_ _015_ _019_ VSS VSS VDD VDD _058_ sky130_fd_sc_hd__nor3_2
X_116_ net12 net13 VSS VSS VDD VDD _000_ _001_ sky130_fd_sc_hd__ha_1
X_117_ net12 net13 VSS VSS VDD VDD _002_ _059_ sky130_fd_sc_hd__ha_1
Xcount\[0\]$_DFFE_PN0P_ clknet_1_0__leaf_clk _009_ net11 VSS
+ VSS VDD VDD net12 sky130_fd_sc_hd__dfrtp_1
Xcount\[1\]$_DFFE_PN0P_ clknet_1_0__leaf_clk _008_ net11 VSS
+ VSS VDD VDD net13 sky130_fd_sc_hd__dfrtp_1
Xcount\[2\]$_DFFE_PN0P_ clknet_1_0__leaf_clk _007_ net11 VSS
+ VSS VDD VDD net14 sky130_fd_sc_hd__dfrtp_1
Xcount\[3\]$_DFFE_PN0P_ clknet_1_1__leaf_clk _006_ net11 VSS
+ VSS VDD VDD net15 sky130_fd_sc_hd__dfrtp_1
Xcount\[4\]$_DFFE_PN0P_ clknet_1_1__leaf_clk _005_ net11 VSS
+ VSS VDD VDD net16 sky130_fd_sc_hd__dfrtp_1
Xcount\[5\]$_DFFE_PN0P_ clknet_1_1__leaf_clk _004_ net11 VSS
+ VSS VDD VDD net17 sky130_fd_sc_hd__dfrtp_1
Xcount\[6\]$_DFFE_PN0P_ clknet_1_0__leaf_clk _003_ net11 VSS
+ VSS VDD VDD net18 sky130_fd_sc_hd__dfrtp_1
Xcount\[7\]$_DFFE_PN0P_ clknet_1_0__leaf_clk _010_ net11 VSS
+ VSS VDD VDD net19 sky130_fd_sc_hd__dfrtp_1
Xoverflow$_DFF_PN0_ clknet_1_0__leaf_clk _058_ net11 VSS VSS
+ VDD VDD net20 sky130_fd_sc_hd__dfrtp_1
XTAP_TAPCELL_ROW_0_0 VSS VDD sky130_fd_sc_hd__tapvpwrvgnd_1
XTAP_TAPCELL_ROW_0_1 VSS VDD sky130_fd_sc_hd__tapvpwrvgnd_1
XTAP_TAPCELL_ROW_1_2 VSS VDD sky130_fd_sc_hd__tapvpwrvgnd_1
XTAP_TAPCELL_ROW_2_3 VSS VDD sky130_fd_sc_hd__tapvpwrvgnd_1
XTAP_TAPCELL_ROW_3_4 VSS VDD sky130_fd_sc_hd__tapvpwrvgnd_1
XTAP_TAPCELL_ROW_4_5 VSS VDD sky130_fd_sc_hd__tapvpwrvgnd_1
XTAP_TAPCELL_ROW_5_6 VSS VDD sky130_fd_sc_hd__tapvpwrvgnd_1
XTAP_TAPCELL_ROW_6_7 VSS VDD sky130_fd_sc_hd__tapvpwrvgnd_1
XTAP_TAPCELL_ROW_7_8 VSS VDD sky130_fd_sc_hd__tapvpwrvgnd_1
XTAP_TAPCELL_ROW_8_9 VSS VDD sky130_fd_sc_hd__tapvpwrvgnd_1
XTAP_TAPCELL_ROW_9_10 VSS VDD sky130_fd_sc_hd__tapvpwrvgnd_1
XTAP_TAPCELL_ROW_10_11 VSS VDD sky130_fd_sc_hd__tapvpwrvgnd_1
XTAP_TAPCELL_ROW_11_12 VSS VDD sky130_fd_sc_hd__tapvpwrvgnd_1
XTAP_TAPCELL_ROW_12_13 VSS VDD sky130_fd_sc_hd__tapvpwrvgnd_1
XTAP_TAPCELL_ROW_12_14 VSS VDD sky130_fd_sc_hd__tapvpwrvgnd_1
Xinput2 load VSS VSS VDD VDD net2 sky130_fd_sc_hd__clkdlybuf4s50_1
Xinput3 load_value[0] VSS VSS VDD VDD net3 sky130_fd_sc_hd__clkdlybuf4s50_1
Xinput4 load_value[1] VSS VSS VDD VDD net4 sky130_fd_sc_hd__clkdlybuf4s50_1
Xinput5 load_value[2] VSS VSS VDD VDD net5 sky130_fd_sc_hd__clkdlybuf4s50_1
Xinput6 load_value[3] VSS VSS VDD VDD net6 sky130_fd_sc_hd__clkdlybuf4s50_1
Xinput7 load_value[4] VSS VSS VDD VDD net7 sky130_fd_sc_hd__clkdlybuf4s50_1
Xinput8 load_value[5] VSS VSS VDD VDD net8 sky130_fd_sc_hd__clkdlybuf4s50_1
Xinput9 load_value[6] VSS VSS VDD VDD net9 sky130_fd_sc_hd__clkdlybuf4s50_1
Xinput10 load_value[7] VSS VSS VDD VDD net10 sky130_fd_sc_hd__clkdlybuf4s50_1
Xinput11 rst_n VSS VSS VDD VDD net11 sky130_fd_sc_hd__clkdlybuf4s50_1
Xoutput12 net12 VSS VSS VDD VDD count[0] sky130_fd_sc_hd__clkdlybuf4s50_1
Xoutput13 net13 VSS VSS VDD VDD count[1] sky130_fd_sc_hd__clkdlybuf4s50_1
Xoutput14 net14 VSS VSS VDD VDD count[2] sky130_fd_sc_hd__clkdlybuf4s50_1
Xoutput15 net15 VSS VSS VDD VDD count[3] sky130_fd_sc_hd__clkdlybuf4s50_1
Xoutput16 net16 VSS VSS VDD VDD count[4] sky130_fd_sc_hd__clkdlybuf4s50_1
Xoutput17 net17 VSS VSS VDD VDD count[5] sky130_fd_sc_hd__clkdlybuf4s50_1
Xoutput18 net18 VSS VSS VDD VDD count[6] sky130_fd_sc_hd__clkdlybuf4s50_1
Xoutput19 net19 VSS VSS VDD VDD count[7] sky130_fd_sc_hd__clkdlybuf4s50_1
Xoutput20 net20 VSS VSS VDD VDD overflow sky130_fd_sc_hd__clkdlybuf4s50_1
Xclkbuf_0_clk clk VSS VSS VDD VDD clknet_0_clk sky130_fd_sc_hd__clkbuf_4
Xclkbuf_1_0__f_clk clknet_0_clk VSS VSS VDD VDD clknet_1_0__leaf_clk
+ sky130_fd_sc_hd__clkbuf_4
Xclkbuf_1_1__f_clk clknet_0_clk VSS VSS VDD VDD clknet_1_1__leaf_clk
+ sky130_fd_sc_hd__clkbuf_4
Xclkload0 clknet_1_1__leaf_clk VSS VSS VDD VDD _unconnected_0
+ sky130_fd_sc_hd__clkinv_2
.ENDS benchmark_counter
