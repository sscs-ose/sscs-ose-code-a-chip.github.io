* NGSPICE file created from atlas.ext - technology: sky130A

.subckt atlas vinp vinn clk vdd vss qp qn tp0 tp1 tp2 tp3 tn0 tn1 tn2 tn3
X0 vdd clk qp vdd sky130_fd_pr__pfet_01v8 ad=0.29 pd=2.58 as=0.29 ps=2.58 w=1 l=0.15
X1 vss clk tail vss sky130_fd_pr__nfet_01v8 ad=2.03 pd=14.58 as=2.03 ps=14.58 w=7 l=0.15
X2 xn vinn sn0 vss sky130_fd_pr__nfet_01v8_lvt ad=0.1218 pd=1.42 as=0.1218 ps=1.42 w=0.42 l=1
X3 tail tp1 sp1 vss sky130_fd_pr__nfet_01v8 ad=0.58 pd=4.58 as=0.58 ps=4.58 w=2 l=0.15
X4 qp qn vdd vdd sky130_fd_pr__pfet_01v8 ad=0.58 pd=4.58 as=0.58 ps=4.58 w=2 l=0.15
X5 xn vinn tail vss sky130_fd_pr__nfet_01v8_lvt ad=0.87 pd=6.58 as=0.87 ps=6.58 w=3 l=0.15
X6 tail tp3 sp3 vss sky130_fd_pr__nfet_01v8 ad=2.32 pd=16.58 as=2.32 ps=16.58 w=8 l=0.15
X7 sp0 vinp xp vss sky130_fd_pr__nfet_01v8_lvt ad=0.1218 pd=1.42 as=0.1218 ps=1.42 w=0.42 l=1
X8 sp1 vinp xp vss sky130_fd_pr__nfet_01v8_lvt ad=0.2436 pd=2.26 as=0.2436 ps=2.26 w=0.84 l=1
X9 tail vinp xp vss sky130_fd_pr__nfet_01v8_lvt ad=0.87 pd=6.58 as=0.87 ps=6.58 w=3 l=0.15
X10 sn2 tn2 tail vss sky130_fd_pr__nfet_01v8 ad=1.16 pd=8.58 as=1.16 ps=8.58 w=4 l=0.15
X11 sp3 vinp xp vss sky130_fd_pr__nfet_01v8_lvt ad=0.9744 pd=7.3 as=0.9744 ps=7.3 w=3.36 l=1
X12 vdd qp qn vdd sky130_fd_pr__pfet_01v8 ad=0.58 pd=4.58 as=0.58 ps=4.58 w=2 l=0.15
X13 xn clk vdd vdd sky130_fd_pr__pfet_01v8 ad=0.29 pd=2.58 as=0.29 ps=2.58 w=1 l=0.15
X14 qp qn xn vss sky130_fd_pr__nfet_01v8 ad=0.29 pd=2.58 as=0.29 ps=2.58 w=1 l=0.15
X15 sn0 tn0 tail vss sky130_fd_pr__nfet_01v8 ad=0.29 pd=2.58 as=0.29 ps=2.58 w=1 l=0.15
X16 sp2 vinp xp vss sky130_fd_pr__nfet_01v8_lvt ad=0.4872 pd=3.94 as=0.4872 ps=3.94 w=1.68 l=1
X17 sn3 tn3 tail vss sky130_fd_pr__nfet_01v8 ad=2.32 pd=16.58 as=2.32 ps=16.58 w=8 l=0.15
X18 xn vinn sn1 vss sky130_fd_pr__nfet_01v8_lvt ad=0.2436 pd=2.26 as=0.2436 ps=2.26 w=0.84 l=1
X19 sn1 tn1 tail vss sky130_fd_pr__nfet_01v8 ad=0.58 pd=4.58 as=0.58 ps=4.58 w=2 l=0.15
X20 xn vinn sn3 vss sky130_fd_pr__nfet_01v8_lvt ad=0.9744 pd=7.3 as=0.9744 ps=7.3 w=3.36 l=1
X21 vdd clk xp vdd sky130_fd_pr__pfet_01v8 ad=0.29 pd=2.58 as=0.29 ps=2.58 w=1 l=0.15
X22 qn clk vdd vdd sky130_fd_pr__pfet_01v8 ad=0.29 pd=2.58 as=0.29 ps=2.58 w=1 l=0.15
X23 xn vinn sn2 vss sky130_fd_pr__nfet_01v8_lvt ad=0.4872 pd=3.94 as=0.4872 ps=3.94 w=1.68 l=1
X24 tail tp2 sp2 vss sky130_fd_pr__nfet_01v8 ad=1.16 pd=8.58 as=1.16 ps=8.58 w=4 l=0.15
X25 xp qp qn vss sky130_fd_pr__nfet_01v8 ad=0.29 pd=2.58 as=0.29 ps=2.58 w=1 l=0.15
X26 tail tp0 sp0 vss sky130_fd_pr__nfet_01v8 ad=0.29 pd=2.58 as=0.29 ps=2.58 w=1 l=0.15
C0 xn vinn 0.93288f
C1 tp0 xp 0.0643f
C2 vinn sn1 0.45578f
C3 xp sp2 0.20608f
C4 qp xp 0.15077f
C5 xn vdd 0.41214f
C6 tp3 vinp 0.00945f
C7 vinn qn 0.06392f
C8 vinp sp1 0.45578f
C9 vinp tp2 0.07465f
C10 vinn tn1 0.07824f
C11 qp clk 0.22345f
C12 sp0 tail 0.22127f
C13 tn0 tail 0.02986f
C14 qn vdd 0.99437f
C15 xn sn0 0.12677f
C16 sn1 sn0 0.06623f
C17 tp0 sp0 0.22193f
C18 sn2 tn2 0.27933f
C19 xp tp1 0.02154f
C20 qp sp0 0.04232f
C21 vinn clk 0.01841f
C22 qn sn0 0.0431f
C23 vdd xp 0.41214f
C24 vdd clk 4.00505f
C25 xp sp3 0.20649f
C26 vinn tn0 0.07648f
C27 tail sn3 0.78857f
C28 tp0 tail 0.02986f
C29 clk sn0 0
C30 xn tn2 0.01012f
C31 tail sp2 0.50085f
C32 vdd sp0 0
C33 xn sn2 0.20608f
C34 qp tail 0.22301f
C35 sn1 sn2 0.07813f
C36 qn vinp 0.0489f
C37 sn2 tn1 0.00558f
C38 tp3 xp 0
C39 xp sp1 0.15896f
C40 xp tp2 0.01012f
C41 tn0 sn0 0.22192f
C42 tail tn3 0.11566f
C43 vinn tail 0.1966f
C44 xp vinp 0.93288f
C45 tail tp1 0.04314f
C46 clk vinp 0.01863f
C47 sn3 tn3 0.3136f
C48 vdd tail 0.58047f
C49 vinn sn3 0.38933f
C50 xn sn1 0.15896f
C51 tp1 sp2 0.00558f
C52 vinn qp 0.04992f
C53 tail sp3 0.78857f
C54 sp0 sp1 0.06623f
C55 xn qn 0.14695f
C56 tail sn0 0.22127f
C57 sp0 vinp 0.58812f
C58 xn tn1 0.02154f
C59 sn1 tn1 0.2511f
C60 vdd qp 1.01062f
C61 sp2 sp3 0.09503f
C62 vinn tn3 0.00945f
C63 qp sn0 0
C64 xn clk 0.28793f
C65 vinn vdd 0.00959f
C66 tail tp3 0.11566f
C67 tail sp1 0.31884f
C68 tail tp2 0.07042f
C69 qn xp 0.21224f
C70 tail vinp 0.19996f
C71 qn clk 0.21005f
C72 tail tn2 0.07042f
C73 vinn sn0 0.58812f
C74 tp0 sp1 0.00558f
C75 sn2 tail 0.50085f
C76 sp2 sp1 0.07813f
C77 tp2 sp2 0.27933f
C78 xn tn0 0.0643f
C79 tn0 sn1 0.00558f
C80 tp0 vinp 0.0764f
C81 sn3 tn2 0.00557f
C82 vinp sp2 0.44962f
C83 vdd sn0 0
C84 clk xp 0.28831f
C85 sn2 sn3 0.09503f
C86 qp vinp 0.0647f
C87 qn sp0 0
C88 tp1 sp1 0.2511f
C89 sp0 xp 0.12677f
C90 xn tail 3.13866f
C91 tp1 vinp 0.0783f
C92 vinn tn2 0.07464f
C93 sn1 tail 0.31884f
C94 sp0 clk 0
C95 vinn sn2 0.44962f
C96 vdd vinp 0.00959f
C97 tp3 sp3 0.3136f
C98 xn sn3 0.20649f
C99 tp2 sp3 0.00557f
C100 qn tail 0.20387f
C101 tail tn1 0.04314f
C102 vinp sp3 0.38933f
C103 xn qp 0.21612f
C104 tail xp 3.139f
C105 qn qp 0.81839f
C106 tail clk 2.69274f
C107 xn tn3 0
C108 tn3 vss 0.77028f
C109 tn2 vss 0.78537f
C110 tn1 vss 0.78701f
C111 tn0 vss 0.77218f
C112 vinn vss 6.50596f
C113 qn vss 6.82545f
C114 qp vss 6.79917f
C115 clk vss 1.91443f
C116 tp0 vss 0.77254f
C117 tp1 vss 0.78665f
C118 tp2 vss 0.78533f
C119 vinp vss 6.50229f
C120 tp3 vss 0.77028f
C121 vdd vss 11.6088f
C122 sn3 vss 2.52815f ; **FLOATING
C123 sn2 vss 1.61658f ; **FLOATING
C124 sn1 vss 1.32921f ; **FLOATING
C125 sn0 vss 1.21296f ; **FLOATING
C126 xn vss 3.80117f ; **FLOATING
C127 sp0 vss 1.21476f ; **FLOATING
C128 sp1 vss 1.32921f ; **FLOATING
C129 sp2 vss 1.61658f ; **FLOATING
C130 xp vss 3.8004f ; **FLOATING
C131 tail vss 9.03165f ; **FLOATING
C132 sp3 vss 2.52815f ; **FLOATING
.ends
