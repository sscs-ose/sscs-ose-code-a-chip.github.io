* NGSPICE file created from atlas.ext - technology: sky130A

.subckt atlas vinp vinn clk vdd vss qp qn tp0 tp1 tp2 tp3 tn0 tn1 tn2 tn3
X0 vdd clk qp vdd sky130_fd_pr__pfet_01v8 ad=0.29 pd=2.58 as=0.29 ps=2.58 w=1 l=0.15
X1 vss clk tail vss sky130_fd_pr__nfet_01v8 ad=2.03 pd=14.58 as=2.03 ps=14.58 w=7 l=0.15
X2 xn vinn sn0 vss sky130_fd_pr__nfet_01v8_lvt ad=0.1218 pd=1.42 as=0.1218 ps=1.42 w=0.42 l=1
X3 tail tp1 sp1 vss sky130_fd_pr__nfet_01v8 ad=0.58 pd=4.58 as=0.58 ps=4.58 w=2 l=0.15
X4 qp qn vdd vdd sky130_fd_pr__pfet_01v8 ad=0.58 pd=4.58 as=0.58 ps=4.58 w=2 l=0.15
X5 xn vinn tail vss sky130_fd_pr__nfet_01v8_lvt ad=0.87 pd=6.58 as=0.87 ps=6.58 w=3 l=0.15
X6 tail tp3 sp3 vss sky130_fd_pr__nfet_01v8 ad=2.32 pd=16.58 as=2.32 ps=16.58 w=8 l=0.15
X7 sp0 vinp xp vss sky130_fd_pr__nfet_01v8_lvt ad=0.1218 pd=1.42 as=0.1218 ps=1.42 w=0.42 l=1
X8 sp1 vinp xp vss sky130_fd_pr__nfet_01v8_lvt ad=0.2436 pd=2.26 as=0.2436 ps=2.26 w=0.84 l=1
X9 tail vinp xp vss sky130_fd_pr__nfet_01v8_lvt ad=0.87 pd=6.58 as=0.87 ps=6.58 w=3 l=0.15
X10 sn2 tn2 tail vss sky130_fd_pr__nfet_01v8 ad=1.16 pd=8.58 as=1.16 ps=8.58 w=4 l=0.15
X11 sp3 vinp xp vss sky130_fd_pr__nfet_01v8_lvt ad=0.9744 pd=7.3 as=0.9744 ps=7.3 w=3.36 l=1
X12 vdd qp qn vdd sky130_fd_pr__pfet_01v8 ad=0.58 pd=4.58 as=0.58 ps=4.58 w=2 l=0.15
X13 xn clk vdd vdd sky130_fd_pr__pfet_01v8 ad=0.29 pd=2.58 as=0.29 ps=2.58 w=1 l=0.15
X14 qp qn xn vss sky130_fd_pr__nfet_01v8 ad=0.29 pd=2.58 as=0.29 ps=2.58 w=1 l=0.15
X15 sn0 tn0 tail vss sky130_fd_pr__nfet_01v8 ad=0.29 pd=2.58 as=0.29 ps=2.58 w=1 l=0.15
X16 sp2 vinp xp vss sky130_fd_pr__nfet_01v8_lvt ad=0.4872 pd=3.94 as=0.4872 ps=3.94 w=1.68 l=1
X17 sn3 tn3 tail vss sky130_fd_pr__nfet_01v8 ad=2.32 pd=16.58 as=2.32 ps=16.58 w=8 l=0.15
X18 xn vinn sn1 vss sky130_fd_pr__nfet_01v8_lvt ad=0.2436 pd=2.26 as=0.2436 ps=2.26 w=0.84 l=1
X19 sn1 tn1 tail vss sky130_fd_pr__nfet_01v8 ad=0.58 pd=4.58 as=0.58 ps=4.58 w=2 l=0.15
X20 xn vinn sn3 vss sky130_fd_pr__nfet_01v8_lvt ad=0.9744 pd=7.3 as=0.9744 ps=7.3 w=3.36 l=1
X21 vdd clk xp vdd sky130_fd_pr__pfet_01v8 ad=0.29 pd=2.58 as=0.29 ps=2.58 w=1 l=0.15
X22 qn clk vdd vdd sky130_fd_pr__pfet_01v8 ad=0.29 pd=2.58 as=0.29 ps=2.58 w=1 l=0.15
X23 xn vinn sn2 vss sky130_fd_pr__nfet_01v8_lvt ad=0.4872 pd=3.94 as=0.4872 ps=3.94 w=1.68 l=1
X24 tail tp2 sp2 vss sky130_fd_pr__nfet_01v8 ad=1.16 pd=8.58 as=1.16 ps=8.58 w=4 l=0.15
X25 xp qp qn vss sky130_fd_pr__nfet_01v8 ad=0.29 pd=2.58 as=0.29 ps=2.58 w=1 l=0.15
X26 tail tp0 sp0 vss sky130_fd_pr__nfet_01v8 ad=0.29 pd=2.58 as=0.29 ps=2.58 w=1 l=0.15
C0 xp tp2 0.01012f
C1 tail tp3 0.11566f
C2 vinn clk 0.01841f
C3 sp0 sp1 0.06623f
C4 sp3 sp2 0.09503f
C5 tn2 sn3 0.00557f
C6 tail tn0 0.02986f
C7 sp2 vinp 0.44962f
C8 vinp tp1 0.0783f
C9 vinn tn2 0.07464f
C10 tn3 sn3 0.3136f
C11 xp qp 0.15077f
C12 vinn tn3 0.00945f
C13 clk vdd 4.00505f
C14 sp3 vinp 0.38933f
C15 tn0 sn1 0.00558f
C16 tn2 sn2 0.27933f
C17 sn0 vinn 0.58812f
C18 xn qn 0.14695f
C19 tail clk 2.69274f
C20 vinn sn3 0.38933f
C21 qn vinp 0.0489f
C22 tail tn2 0.07042f
C23 tail tn3 0.11566f
C24 xp sp2 0.20608f
C25 vinn tn1 0.07824f
C26 tail sp1 0.31884f
C27 xp tp1 0.02154f
C28 sp0 vdd 0
C29 sn0 vdd 0
C30 sn3 sn2 0.09503f
C31 qp clk 0.22345f
C32 vinn sn2 0.44962f
C33 tail sp0 0.22127f
C34 vinn vdd 0.00959f
C35 sp3 xp 0.20649f
C36 sn0 tail 0.22127f
C37 xp vinp 0.93288f
C38 tp0 vinp 0.0764f
C39 tn1 sn2 0.00558f
C40 tail sn3 0.78857f
C41 tail vinn 0.1966f
C42 sp3 tp3 0.3136f
C43 xn tn0 0.0643f
C44 xp qn 0.21224f
C45 tp3 vinp 0.00945f
C46 tail tn1 0.04314f
C47 sn0 sn1 0.06623f
C48 sp0 qp 0.04232f
C49 sn0 qp 0
C50 vinn sn1 0.45578f
C51 tail sn2 0.50085f
C52 tail vdd 0.58047f
C53 vinn qp 0.04992f
C54 tn1 sn1 0.2511f
C55 xn clk 0.28793f
C56 xp tp0 0.0643f
C57 sp2 sp1 0.07813f
C58 sp1 tp1 0.2511f
C59 sn1 sn2 0.07813f
C60 clk vinp 0.01863f
C61 xn tn2 0.01012f
C62 xn tn3 0
C63 qp vdd 1.01062f
C64 tail tp2 0.07042f
C65 xp tp3 0
C66 tail sn1 0.31884f
C67 qn clk 0.21005f
C68 sp1 vinp 0.45578f
C69 tail qp 0.22301f
C70 sn0 xn 0.12677f
C71 sp0 vinp 0.58812f
C72 xn sn3 0.20649f
C73 xn vinn 0.93288f
C74 xn tn1 0.02154f
C75 xp clk 0.28831f
C76 qn sp0 0
C77 sn0 qn 0.0431f
C78 xn sn2 0.20608f
C79 xn vdd 0.41214f
C80 vinn qn 0.06392f
C81 tail sp2 0.50085f
C82 xp sp1 0.15896f
C83 tail tp1 0.04314f
C84 tp0 sp1 0.00558f
C85 vinp vdd 0.00959f
C86 xn tail 3.13866f
C87 tp2 sp2 0.27933f
C88 xp sp0 0.12677f
C89 sp0 tp0 0.22193f
C90 tail sp3 0.78857f
C91 tail vinp 0.19996f
C92 qn vdd 0.99437f
C93 sp3 tp2 0.00557f
C94 xn sn1 0.15896f
C95 tp2 vinp 0.07465f
C96 tail qn 0.20387f
C97 sn0 tn0 0.22192f
C98 xn qp 0.21612f
C99 qp vinp 0.0647f
C100 vinn tn0 0.07648f
C101 xp vdd 0.41214f
C102 qn qp 0.81839f
C103 tail xp 3.139f
C104 tail tp0 0.02986f
C105 sp0 clk 0
C106 sp2 tp1 0.00558f
C107 sn0 clk 0
C108 tn3 vss 0.77028f
C109 tn2 vss 0.78537f
C110 tn1 vss 0.78701f
C111 tn0 vss 0.77218f
C112 vinn vss 6.50596f
C113 qn vss 6.82545f
C114 qp vss 6.79917f
C115 clk vss 1.91443f
C116 tp0 vss 0.77254f
C117 tp1 vss 0.78665f
C118 tp2 vss 0.78533f
C119 vinp vss 6.50229f
C120 tp3 vss 0.77028f
C121 vdd vss 11.6088f
C122 sn3 vss 2.52815f ; **FLOATING
C123 sn2 vss 1.61658f ; **FLOATING
C124 sn1 vss 1.32921f ; **FLOATING
C125 sn0 vss 1.21296f ; **FLOATING
C126 xn vss 3.80117f ; **FLOATING
C127 sp0 vss 1.21476f ; **FLOATING
C128 sp1 vss 1.32921f ; **FLOATING
C129 sp2 vss 1.61658f ; **FLOATING
C130 xp vss 3.8004f ; **FLOATING
C131 tail vss 9.03165f ; **FLOATING
C132 sp3 vss 2.52815f ; **FLOATING
.ends
