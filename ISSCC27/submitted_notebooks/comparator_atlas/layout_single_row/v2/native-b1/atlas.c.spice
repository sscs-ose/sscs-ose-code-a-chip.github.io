* NGSPICE file created from atlas.ext - technology: sky130A

.subckt atlas vinp vinn clk vdd vss qp qn tp0 tp1 tp2 tp3 tn0 tn1 tn2 tn3
X0 tail tp0 sp0 vss sky130_fd_pr__nfet_01v8 ad=0.29 pd=2.58 as=0.29 ps=2.58 w=1 l=0.15
X1 qn clk vdd vdd sky130_fd_pr__pfet_01v8 ad=0.29 pd=2.58 as=0.29 ps=2.58 w=1 l=0.15
X2 tail tp2 sp2 vss sky130_fd_pr__nfet_01v8 ad=1.16 pd=8.58 as=1.16 ps=8.58 w=4 l=0.15
X3 vss clk tail vss sky130_fd_pr__nfet_01v8 ad=2.03 pd=14.58 as=2.03 ps=14.58 w=7 l=0.15
X4 vdd clk qp vdd sky130_fd_pr__pfet_01v8 ad=0.29 pd=2.58 as=0.29 ps=2.58 w=1 l=0.15
X5 xn vinn sn0 vss sky130_fd_pr__nfet_01v8_lvt ad=0.1218 pd=1.42 as=0.1218 ps=1.42 w=0.42 l=1
X6 xn vinn sn2 vss sky130_fd_pr__nfet_01v8_lvt ad=0.4872 pd=3.94 as=0.4872 ps=3.94 w=1.68 l=1
X7 xn vinn sn3 vss sky130_fd_pr__nfet_01v8_lvt ad=0.9744 pd=7.3 as=0.9744 ps=7.3 w=3.36 l=1
X8 sp2 vinp xp vss sky130_fd_pr__nfet_01v8_lvt ad=0.4872 pd=3.94 as=0.4872 ps=3.94 w=1.68 l=1
X9 sp0 vinp xp vss sky130_fd_pr__nfet_01v8_lvt ad=0.1218 pd=1.42 as=0.1218 ps=1.42 w=0.42 l=1
X10 xn vinn sn1 vss sky130_fd_pr__nfet_01v8_lvt ad=0.2436 pd=2.26 as=0.2436 ps=2.26 w=0.84 l=1
X11 sn3 tn3 tail vss sky130_fd_pr__nfet_01v8 ad=2.32 pd=16.58 as=2.32 ps=16.58 w=8 l=0.15
X12 sn1 tn1 tail vss sky130_fd_pr__nfet_01v8 ad=0.58 pd=4.58 as=0.58 ps=4.58 w=2 l=0.15
X13 xn clk vdd vdd sky130_fd_pr__pfet_01v8 ad=0.29 pd=2.58 as=0.29 ps=2.58 w=1 l=0.15
X14 qp qn xn vss sky130_fd_pr__nfet_01v8 ad=0.29 pd=2.58 as=0.29 ps=2.58 w=1 l=0.15
X15 qp qn vdd vdd sky130_fd_pr__pfet_01v8 ad=0.58 pd=4.58 as=0.58 ps=4.58 w=2 l=0.15
X16 sp3 vinp xp vss sky130_fd_pr__nfet_01v8_lvt ad=0.9744 pd=7.3 as=0.9744 ps=7.3 w=3.36 l=1
X17 xn vinn tail vss sky130_fd_pr__nfet_01v8_lvt ad=0.87 pd=6.58 as=0.87 ps=6.58 w=3 l=0.15
X18 sn0 tn0 tail vss sky130_fd_pr__nfet_01v8 ad=0.29 pd=2.58 as=0.29 ps=2.58 w=1 l=0.15
X19 sn2 tn2 tail vss sky130_fd_pr__nfet_01v8 ad=1.16 pd=8.58 as=1.16 ps=8.58 w=4 l=0.15
X20 tail tp1 sp1 vss sky130_fd_pr__nfet_01v8 ad=0.58 pd=4.58 as=0.58 ps=4.58 w=2 l=0.15
X21 vdd clk xp vdd sky130_fd_pr__pfet_01v8 ad=0.29 pd=2.58 as=0.29 ps=2.58 w=1 l=0.15
X22 tail tp3 sp3 vss sky130_fd_pr__nfet_01v8 ad=2.32 pd=16.58 as=2.32 ps=16.58 w=8 l=0.15
X23 sp1 vinp xp vss sky130_fd_pr__nfet_01v8_lvt ad=0.2436 pd=2.26 as=0.2436 ps=2.26 w=0.84 l=1
X24 xp qp qn vss sky130_fd_pr__nfet_01v8 ad=0.29 pd=2.58 as=0.29 ps=2.58 w=1 l=0.15
X25 tail vinp xp vss sky130_fd_pr__nfet_01v8_lvt ad=0.87 pd=6.58 as=0.87 ps=6.58 w=3 l=0.15
X26 vdd qp qn vdd sky130_fd_pr__pfet_01v8 ad=0.58 pd=4.58 as=0.58 ps=4.58 w=2 l=0.15
C0 tail sn1 0.3173f
C1 vinn tn3 0.0109f
C2 vinn tn2 0.07739f
C3 tn3 sn3 0.31508f
C4 sp0 sp1 0.08373f
C5 xp qp 0.15082f
C6 tail qp 0.2194f
C7 tn2 sn3 0.00669f
C8 sp2 vinp 0.44052f
C9 vinp tp1 0.08185f
C10 tn1 tn2 0
C11 qp tp0 0
C12 xn vinn 0.89997f
C13 tp2 tp3 0
C14 xn sn3 0.20642f
C15 tn0 sn1 0.0067f
C16 xn tn1 0.02157f
C17 clk vdd 3.57341f
C18 sn0 qn 0.05472f
C19 tn0 qp 0
C20 tn3 sn2 0
C21 tn2 sn2 0.28038f
C22 vinn sn3 0.39038f
C23 qn vinp 0.04858f
C24 vinn tn1 0.08178f
C25 xn sn2 0.20498f
C26 xn vdd 0.41924f
C27 xp sp2 0.20498f
C28 tail sp2 0.49975f
C29 xp tp1 0.02157f
C30 tail tp1 0.04358f
C31 sp0 vdd 0
C32 sn0 tail 0.21942f
C33 tp0 tp1 0
C34 vinn sn2 0.44052f
C35 vinn vdd 0.0117f
C36 sn3 sn2 0.11905f
C37 qp clk 0.22879f
C38 xp vinp 0.89997f
C39 tail vinp 0.20362f
C40 sn1 tn2 0
C41 tn1 sn2 0.0067f
C42 tp2 sp1 0
C43 tp3 sp2 0
C44 xp qn 0.21074f
C45 tail qn 0.2002f
C46 tp0 vinp 0.08031f
C47 sp3 tp2 0.00669f
C48 sn0 tn0 0.2222f
C49 xn sn1 0.15819f
C50 qn tp0 0
C51 xn qp 0.21462f
C52 tp3 vinp 0.0109f
C53 vinn sn1 0.44157f
C54 sp0 qp 0.05375f
C55 qn tn0 0
C56 vinn qp 0.04935f
C57 tn1 sn1 0.25177f
C58 tail xp 2.78942f
C59 xp tp0 0.06405f
C60 tail tp0 0.02987f
C61 sn0 clk 0
C62 sp2 sp1 0.0984f
C63 sp1 tp1 0.25177f
C64 sn1 sn2 0.0984f
C65 tail tn0 0.02987f
C66 xp tp3 0
C67 clk vinp 0.02251f
C68 tail tp3 0.11566f
C69 sp3 sp2 0.11905f
C70 qp vdd 1.03964f
C71 qn clk 0.21559f
C72 sn0 xn 0.1259f
C73 sp0 tp1 0
C74 sp1 vinp 0.44157f
C75 sp3 vinp 0.39038f
C76 sn0 vinn 0.56189f
C77 xn qn 0.14699f
C78 sp0 vinp 0.56189f
C79 sn0 tn1 0
C80 vinn vinp 0.00825f
C81 tail clk 2.26044f
C82 xp clk 0.2883f
C83 qn sp0 0.00137f
C84 tail tn3 0.11566f
C85 vinn qn 0.06742f
C86 tail tn2 0.0713f
C87 tp0 clk 0
C88 tail sp1 0.3173f
C89 xp sp1 0.15819f
C90 sn0 vdd 0
C91 xn tail 2.78892f
C92 tn0 clk 0
C93 tp0 sp1 0.0067f
C94 sp3 xp 0.20642f
C95 tail sp3 0.78742f
C96 vinp vdd 0.01171f
C97 xp sp0 0.1259f
C98 tail sp0 0.21942f
C99 tail vinn 0.19903f
C100 tp2 sp2 0.28038f
C101 qn vdd 1.0234f
C102 tp2 tp1 0
C103 sp0 tp0 0.22221f
C104 tail sn3 0.78742f
C105 xn tn0 0.06405f
C106 tail tn1 0.04358f
C107 sp3 tp3 0.31508f
C108 sn0 sn1 0.08373f
C109 tp2 vinp 0.0774f
C110 vinn tn0 0.0804f
C111 sn0 qp 0
C112 tail sn2 0.49975f
C113 tail vdd 0.56243f
C114 xp vdd 0.41924f
C115 tn1 tn0 0
C116 qp vinp 0.06796f
C117 tn3 tn2 0
C118 tp0 vdd 0
C119 qn qp 0.84961f
C120 xn clk 0.28768f
C121 xn tn3 0
C122 tn0 vdd 0
C123 xn tn2 0.01023f
C124 sp0 clk 0
C125 sp2 tp1 0.0067f
C126 xp tp2 0.01023f
C127 tail tp2 0.0713f
C128 vinn clk 0.02219f
C129 tn3 vss 0.76419f
C130 tn2 vss 0.77315f
C131 tn1 vss 0.7747f
C132 tn0 vss 0.76027f
C133 vinn vss 5.84599f
C134 qn vss 5.7004f
C135 qp vss 5.67529f
C136 clk vss 1.73166f
C137 tp0 vss 0.76068f
C138 tp1 vss 0.77428f
C139 tp2 vss 0.7731f
C140 vinp vss 5.84089f
C141 tp3 vss 0.76419f
C142 vdd vss 10.8437f
C143 sn3 vss 2.4317f ; **FLOATING
C144 sn2 vss 1.51177f ; **FLOATING
C145 sn1 vss 1.23975f ; **FLOATING
C146 sn0 vss 1.15739f ; **FLOATING
C147 xn vss 3.38562f ; **FLOATING
C148 sp0 vss 1.15946f ; **FLOATING
C149 sp1 vss 1.23975f ; **FLOATING
C150 sp2 vss 1.51177f ; **FLOATING
C151 xp vss 3.38434f ; **FLOATING
C152 tail vss 8.3707f ; **FLOATING
C153 sp3 vss 2.4317f ; **FLOATING
.ends
