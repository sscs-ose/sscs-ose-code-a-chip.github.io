* NGSPICE file created from atlas.ext - technology: sky130A

.subckt atlas vinp vinn clk vdd vss qp qn tp0 tp1 tp2 tp3 tn0 tn1 tn2 tn3
X0 tail tp0 sp0 vss sky130_fd_pr__nfet_01v8 ad=0.29 pd=2.58 as=0.29 ps=2.58 w=1 l=0.15
X1 qn clk vdd vdd sky130_fd_pr__pfet_01v8 ad=0.29 pd=2.58 as=0.29 ps=2.58 w=1 l=0.15
X2 tail tp2 sp2 vss sky130_fd_pr__nfet_01v8 ad=1.16 pd=8.58 as=1.16 ps=8.58 w=4 l=0.15
X3 vss clk tail vss sky130_fd_pr__nfet_01v8 ad=2.03 pd=14.58 as=2.03 ps=14.58 w=7 l=0.15
X4 vdd clk qp vdd sky130_fd_pr__pfet_01v8 ad=0.29 pd=2.58 as=0.29 ps=2.58 w=1 l=0.15
X5 xn vinn sn0 vss sky130_fd_pr__nfet_01v8_lvt ad=0.1218 pd=1.42 as=0.1218 ps=1.42 w=0.42 l=1
X6 xn vinn sn2 vss sky130_fd_pr__nfet_01v8_lvt ad=0.4872 pd=3.94 as=0.4872 ps=3.94 w=1.68 l=1
X7 xn vinn sn3 vss sky130_fd_pr__nfet_01v8_lvt ad=0.9744 pd=7.3 as=0.9744 ps=7.3 w=3.36 l=1
X8 sp2 vinp xp vss sky130_fd_pr__nfet_01v8_lvt ad=0.4872 pd=3.94 as=0.4872 ps=3.94 w=1.68 l=1
X9 sp0 vinp xp vss sky130_fd_pr__nfet_01v8_lvt ad=0.1218 pd=1.42 as=0.1218 ps=1.42 w=0.42 l=1
X10 xn vinn sn1 vss sky130_fd_pr__nfet_01v8_lvt ad=0.2436 pd=2.26 as=0.2436 ps=2.26 w=0.84 l=1
X11 sn3 tn3 tail vss sky130_fd_pr__nfet_01v8 ad=2.32 pd=16.58 as=2.32 ps=16.58 w=8 l=0.15
X12 sn1 tn1 tail vss sky130_fd_pr__nfet_01v8 ad=0.58 pd=4.58 as=0.58 ps=4.58 w=2 l=0.15
X13 xn clk vdd vdd sky130_fd_pr__pfet_01v8 ad=0.29 pd=2.58 as=0.29 ps=2.58 w=1 l=0.15
X14 qp qn xn vss sky130_fd_pr__nfet_01v8 ad=0.29 pd=2.58 as=0.29 ps=2.58 w=1 l=0.15
X15 qp qn vdd vdd sky130_fd_pr__pfet_01v8 ad=0.58 pd=4.58 as=0.58 ps=4.58 w=2 l=0.15
X16 sp3 vinp xp vss sky130_fd_pr__nfet_01v8_lvt ad=0.9744 pd=7.3 as=0.9744 ps=7.3 w=3.36 l=1
X17 xn vinn tail vss sky130_fd_pr__nfet_01v8_lvt ad=0.87 pd=6.58 as=0.87 ps=6.58 w=3 l=0.15
X18 sn0 tn0 tail vss sky130_fd_pr__nfet_01v8 ad=0.29 pd=2.58 as=0.29 ps=2.58 w=1 l=0.15
X19 sn2 tn2 tail vss sky130_fd_pr__nfet_01v8 ad=1.16 pd=8.58 as=1.16 ps=8.58 w=4 l=0.15
X20 tail tp1 sp1 vss sky130_fd_pr__nfet_01v8 ad=0.58 pd=4.58 as=0.58 ps=4.58 w=2 l=0.15
X21 vdd clk xp vdd sky130_fd_pr__pfet_01v8 ad=0.29 pd=2.58 as=0.29 ps=2.58 w=1 l=0.15
X22 tail tp3 sp3 vss sky130_fd_pr__nfet_01v8 ad=2.32 pd=16.58 as=2.32 ps=16.58 w=8 l=0.15
X23 sp1 vinp xp vss sky130_fd_pr__nfet_01v8_lvt ad=0.2436 pd=2.26 as=0.2436 ps=2.26 w=0.84 l=1
X24 xp qp qn vss sky130_fd_pr__nfet_01v8 ad=0.29 pd=2.58 as=0.29 ps=2.58 w=1 l=0.15
X25 tail vinp xp vss sky130_fd_pr__nfet_01v8_lvt ad=0.87 pd=6.58 as=0.87 ps=6.58 w=3 l=0.15
X26 vdd qp qn vdd sky130_fd_pr__pfet_01v8 ad=0.58 pd=4.58 as=0.58 ps=4.58 w=2 l=0.15
.ends
