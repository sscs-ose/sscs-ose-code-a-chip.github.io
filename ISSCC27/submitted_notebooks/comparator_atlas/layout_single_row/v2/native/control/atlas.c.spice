* NGSPICE file created from atlas.ext - technology: sky130A

.subckt atlas vinp vinn clk vdd vss qp qn tp0 tp1 tp2 tp3 tn0 tn1 tn2 tn3
X0 qp qn vdd vdd sky130_fd_pr__pfet_01v8 ad=0.58 pd=4.58 as=0.58 ps=4.58 w=2 l=0.15
X1 xn vinn sn2 vss sky130_fd_pr__nfet_01v8_lvt ad=0.4872 pd=3.94 as=0.4872 ps=3.94 w=1.68 l=1
X2 vss clk tail vss sky130_fd_pr__nfet_01v8 ad=2.03 pd=14.58 as=2.03 ps=14.58 w=7 l=0.15
X3 sp2 vinp xp vss sky130_fd_pr__nfet_01v8_lvt ad=0.4872 pd=3.94 as=0.4872 ps=3.94 w=1.68 l=1
X4 vdd qp qn vdd sky130_fd_pr__pfet_01v8 ad=0.58 pd=4.58 as=0.58 ps=4.58 w=2 l=0.15
X5 xn vinn sn1 vss sky130_fd_pr__nfet_01v8_lvt ad=0.2436 pd=2.26 as=0.2436 ps=2.26 w=0.84 l=1
X6 xn vinn tail vss sky130_fd_pr__nfet_01v8_lvt ad=0.87 pd=6.58 as=0.87 ps=6.58 w=3 l=0.15
X7 tail vinp xp vss sky130_fd_pr__nfet_01v8_lvt ad=0.87 pd=6.58 as=0.87 ps=6.58 w=3 l=0.15
X8 sp0 vinp xp vss sky130_fd_pr__nfet_01v8_lvt ad=0.1218 pd=1.42 as=0.1218 ps=1.42 w=0.42 l=1
X9 sn0 tn0 tail vss sky130_fd_pr__nfet_01v8 ad=0.29 pd=2.58 as=0.29 ps=2.58 w=1 l=0.15
X10 sn1 tn1 tail vss sky130_fd_pr__nfet_01v8 ad=0.58 pd=4.58 as=0.58 ps=4.58 w=2 l=0.15
X11 xn clk vdd vdd sky130_fd_pr__pfet_01v8 ad=0.29 pd=2.58 as=0.29 ps=2.58 w=1 l=0.15
X12 xn vinn sn0 vss sky130_fd_pr__nfet_01v8_lvt ad=0.1218 pd=1.42 as=0.1218 ps=1.42 w=0.42 l=1
X13 tail tp1 sp1 vss sky130_fd_pr__nfet_01v8 ad=0.58 pd=4.58 as=0.58 ps=4.58 w=2 l=0.15
X14 tail tp0 sp0 vss sky130_fd_pr__nfet_01v8 ad=0.29 pd=2.58 as=0.29 ps=2.58 w=1 l=0.15
X15 vdd clk xp vdd sky130_fd_pr__pfet_01v8 ad=0.29 pd=2.58 as=0.29 ps=2.58 w=1 l=0.15
X16 qn clk vdd vdd sky130_fd_pr__pfet_01v8 ad=0.29 pd=2.58 as=0.29 ps=2.58 w=1 l=0.15
X17 sn3 tn3 tail vss sky130_fd_pr__nfet_01v8 ad=2.32 pd=16.58 as=2.32 ps=16.58 w=8 l=0.15
X18 sp3 vinp xp vss sky130_fd_pr__nfet_01v8_lvt ad=0.9744 pd=7.3 as=0.9744 ps=7.3 w=3.36 l=1
X19 qp qn xn vss sky130_fd_pr__nfet_01v8 ad=0.29 pd=2.58 as=0.29 ps=2.58 w=1 l=0.15
X20 vdd clk qp vdd sky130_fd_pr__pfet_01v8 ad=0.29 pd=2.58 as=0.29 ps=2.58 w=1 l=0.15
X21 xn vinn sn3 vss sky130_fd_pr__nfet_01v8_lvt ad=0.9744 pd=7.3 as=0.9744 ps=7.3 w=3.36 l=1
X22 xp qp qn vss sky130_fd_pr__nfet_01v8 ad=0.29 pd=2.58 as=0.29 ps=2.58 w=1 l=0.15
X23 sn2 tn2 tail vss sky130_fd_pr__nfet_01v8 ad=1.16 pd=8.58 as=1.16 ps=8.58 w=4 l=0.15
X24 tail tp2 sp2 vss sky130_fd_pr__nfet_01v8 ad=1.16 pd=8.58 as=1.16 ps=8.58 w=4 l=0.15
X25 sp1 vinp xp vss sky130_fd_pr__nfet_01v8_lvt ad=0.2436 pd=2.26 as=0.2436 ps=2.26 w=0.84 l=1
X26 tail tp3 sp3 vss sky130_fd_pr__nfet_01v8 ad=2.32 pd=16.58 as=2.32 ps=16.58 w=8 l=0.15
C0 sn0 qn 0.04821f
C1 xn sn2 0.2056f
C2 xn vdd 0.41321f
C3 vinn qn 0.06487f
C4 tail sp2 0.49983f
C5 xp sp1 0.15864f
C6 tail tp1 0.04314f
C7 tp0 sp1 0.00609f
C8 vinp vdd 0.01026f
C9 xn tail 2.99947f
C10 xp sp0 0.1264f
C11 tp2 sp2 0.27983f
C12 sp0 tp0 0.22206f
C13 tail sp3 0.78806f
C14 tail vinp 0.20136f
C15 qn vdd 1.001f
C16 sp3 tp2 0.00608f
C17 xn sn1 0.15864f
C18 tp2 vinp 0.07593f
C19 tail qn 0.20249f
C20 sn0 tn0 0.22205f
C21 xn qp 0.21575f
C22 qp vinp 0.06559f
C23 vinn tn0 0.07831f
C24 xp vdd 0.41321f
C25 tp0 vdd 0
C26 qn qp 0.82114f
C27 tail xp 2.99986f
C28 tail tp0 0.02986f
C29 sp0 clk 0
C30 sp2 tp1 0.00609f
C31 sn0 clk 0
C32 tn0 vdd 0
C33 xp tp2 0.01017f
C34 tail tp3 0.11566f
C35 vinn clk 0.01942f
C36 sp0 sp1 0.07395f
C37 sp3 sp2 0.10567f
C38 tn2 sn3 0.00608f
C39 tail tn0 0.02986f
C40 sp2 vinp 0.44512f
C41 vinp tp1 0.07995f
C42 vinn tn2 0.07592f
C43 tn3 sn3 0.3143f
C44 xp qp 0.15045f
C45 qp tp0 0
C46 vinn tn3 0.01012f
C47 clk vdd 3.8756f
C48 sp3 vinp 0.38986f
C49 tn0 sn1 0.00609f
C50 tn2 sn2 0.27983f
C51 sn0 vinn 0.57503f
C52 tn0 qp 0
C53 tn3 sn2 0
C54 xn qn 0.14662f
C55 tail clk 2.56314f
C56 vinn sn3 0.38986f
C57 sn0 tn1 0
C58 qn vinp 0.04884f
C59 tail tn2 0.07042f
C60 tail tn3 0.11566f
C61 xp sp2 0.2056f
C62 vinn tn1 0.07989f
C63 tail sp1 0.31776f
C64 xp tp1 0.02155f
C65 sp0 vdd 0
C66 sn0 vdd 0
C67 sn3 sn2 0.10567f
C68 qp clk 0.22393f
C69 vinn sn2 0.44512f
C70 sn1 tn2 0
C71 tp2 sp1 0
C72 tail sp0 0.22025f
C73 vinn vdd 0.01025f
C74 tp3 sp2 0
C75 sp3 xp 0.20647f
C76 sn0 tail 0.22025f
C77 xp vinp 0.91645f
C78 tn1 sn2 0.00609f
C79 tp0 vinp 0.07823f
C80 tail sn3 0.78806f
C81 tail vinn 0.1977f
C82 sp3 tp3 0.3143f
C83 xn tn0 0.06417f
C84 xp qn 0.21187f
C85 tail tn1 0.04314f
C86 tp3 vinp 0.01012f
C87 qn tp0 0
C88 sn0 sn1 0.07395f
C89 sp0 qp 0.04735f
C90 sn0 qp 0
C91 vinn sn1 0.44875f
C92 tail sn2 0.49983f
C93 tail vdd 0.57601f
C94 vinn qp 0.04979f
C95 tn1 sn1 0.25142f
C96 qn tn0 0
C97 xn clk 0.28785f
C98 xp tp0 0.06417f
C99 sp2 sp1 0.08709f
C100 sp1 tp1 0.25142f
C101 sn1 sn2 0.08709f
C102 clk vinp 0.01966f
C103 xn tn2 0.01017f
C104 xn tn3 0
C105 qp vdd 1.01724f
C106 tail tp2 0.07042f
C107 xp tp3 0
C108 sp0 tp1 0
C109 tail sn1 0.31776f
C110 sp1 vinp 0.44875f
C111 qn clk 0.21061f
C112 tail qp 0.22163f
C113 sn0 xn 0.1264f
C114 sp0 vinp 0.57503f
C115 xn sn3 0.20647f
C116 xn vinn 0.91645f
C117 xn tn1 0.02155f
C118 xp clk 0.28828f
C119 qn sp0 0.00105f
C120 tn3 vss 0.76737f
C121 tn2 vss 0.78047f
C122 tn1 vss 0.78163f
C123 tn0 vss 0.76657f
C124 vinn vss 6.26645f
C125 qn vss 6.5094f
C126 qp vss 6.48361f
C127 clk vss 1.86708f
C128 tp0 vss 0.76696f
C129 tp1 vss 0.78124f
C130 tp2 vss 0.78042f
C131 vinp vss 6.26242f
C132 tp3 vss 0.76737f
C133 vdd vss 11.3875f
C134 sn3 vss 2.48106f ; **FLOATING
C135 sn2 vss 1.56726f ; **FLOATING
C136 sn1 vss 1.28684f ; **FLOATING
C137 sn0 vss 1.18592f ; **FLOATING
C138 xn vss 3.65005f ; **FLOATING
C139 sp0 vss 1.18785f ; **FLOATING
C140 sp1 vss 1.28684f ; **FLOATING
C141 sp2 vss 1.56726f ; **FLOATING
C142 xp vss 3.64914f ; **FLOATING
C143 tail vss 8.75534f ; **FLOATING
C144 sp3 vss 2.48106f ; **FLOATING
.ends
