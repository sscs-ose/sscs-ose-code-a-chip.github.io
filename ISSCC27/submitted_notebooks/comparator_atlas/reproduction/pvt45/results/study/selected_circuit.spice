* Comparator Atlas declared design: lvt_balanced_4b
* Generated physical transistor netlist. Gate-area proxy is not layout area.
.subckt atlas vinp vinn clk vdd vss qp qn tp0 tp1 tp2 tp3 tn0 tn1 tn2 tn3
+ params: pair_skew=0
Xinp xp vinp tail vss sky130_fd_pr__nfet_01v8_lvt
+ w={3*(1+pair_skew)} l=0.15
+ ad={0.29*(3*(1+pair_skew))} as={0.29*(3*(1+pair_skew))}
+ pd={2*(0.29+(3*(1+pair_skew)))} ps={2*(0.29+(3*(1+pair_skew)))}
Xinn xn vinn tail vss sky130_fd_pr__nfet_01v8_lvt
+ w={3*(1-pair_skew)} l=0.15
+ ad={0.29*(3*(1-pair_skew))} as={0.29*(3*(1-pair_skew))}
+ pd={2*(0.29+(3*(1-pair_skew)))} ps={2*(0.29+(3*(1-pair_skew)))}
Xtail tail clk vss vss sky130_fd_pr__nfet_01v8
+ w={7} l=0.15
+ ad={0.29*(7)} as={0.29*(7)}
+ pd={2*(0.29+(7))} ps={2*(0.29+(7))}
Xln qn qp xp vss sky130_fd_pr__nfet_01v8
+ w={1} l=0.15
+ ad={0.29*(1)} as={0.29*(1)}
+ pd={2*(0.29+(1))} ps={2*(0.29+(1))}
Xlp qp qn xn vss sky130_fd_pr__nfet_01v8
+ w={1} l=0.15
+ ad={0.29*(1)} as={0.29*(1)}
+ pd={2*(0.29+(1))} ps={2*(0.29+(1))}
Xpn qn qp vdd vdd sky130_fd_pr__pfet_01v8
+ w={2} l=0.15
+ ad={0.29*(2)} as={0.29*(2)}
+ pd={2*(0.29+(2))} ps={2*(0.29+(2))}
Xpp qp qn vdd vdd sky130_fd_pr__pfet_01v8
+ w={2} l=0.15
+ ad={0.29*(2)} as={0.29*(2)}
+ pd={2*(0.29+(2))} ps={2*(0.29+(2))}
Xrxp xp clk vdd vdd sky130_fd_pr__pfet_01v8
+ w={1} l=0.15
+ ad={0.29*(1)} as={0.29*(1)}
+ pd={2*(0.29+(1))} ps={2*(0.29+(1))}
Xrxn xn clk vdd vdd sky130_fd_pr__pfet_01v8
+ w={1} l=0.15
+ ad={0.29*(1)} as={0.29*(1)}
+ pd={2*(0.29+(1))} ps={2*(0.29+(1))}
Xrqp qp clk vdd vdd sky130_fd_pr__pfet_01v8
+ w={1} l=0.15
+ ad={0.29*(1)} as={0.29*(1)}
+ pd={2*(0.29+(1))} ps={2*(0.29+(1))}
Xrqn qn clk vdd vdd sky130_fd_pr__pfet_01v8
+ w={1} l=0.15
+ ad={0.29*(1)} as={0.29*(1)}
+ pd={2*(0.29+(1))} ps={2*(0.29+(1))}
Xtp0 xp vinp sp0 vss sky130_fd_pr__nfet_01v8_lvt
+ w={0.42} l=1
+ ad={0.29*(0.42)} as={0.29*(0.42)}
+ pd={2*(0.29+(0.42))} ps={2*(0.29+(0.42))}
Xsp0 sp0 tp0 tail vss sky130_fd_pr__nfet_01v8
+ w={1} l=0.15
+ ad={0.29*(1)} as={0.29*(1)}
+ pd={2*(0.29+(1))} ps={2*(0.29+(1))}
Xtp1 xp vinp sp1 vss sky130_fd_pr__nfet_01v8_lvt
+ w={0.84} l=1
+ ad={0.29*(0.84)} as={0.29*(0.84)}
+ pd={2*(0.29+(0.84))} ps={2*(0.29+(0.84))}
Xsp1 sp1 tp1 tail vss sky130_fd_pr__nfet_01v8
+ w={2} l=0.15
+ ad={0.29*(2)} as={0.29*(2)}
+ pd={2*(0.29+(2))} ps={2*(0.29+(2))}
Xtp2 xp vinp sp2 vss sky130_fd_pr__nfet_01v8_lvt
+ w={1.68} l=1
+ ad={0.29*(1.68)} as={0.29*(1.68)}
+ pd={2*(0.29+(1.68))} ps={2*(0.29+(1.68))}
Xsp2 sp2 tp2 tail vss sky130_fd_pr__nfet_01v8
+ w={4} l=0.15
+ ad={0.29*(4)} as={0.29*(4)}
+ pd={2*(0.29+(4))} ps={2*(0.29+(4))}
Xtp3 xp vinp sp3 vss sky130_fd_pr__nfet_01v8_lvt
+ w={3.36} l=1
+ ad={0.29*(3.36)} as={0.29*(3.36)}
+ pd={2*(0.29+(3.36))} ps={2*(0.29+(3.36))}
Xsp3 sp3 tp3 tail vss sky130_fd_pr__nfet_01v8
+ w={8} l=0.15
+ ad={0.29*(8)} as={0.29*(8)}
+ pd={2*(0.29+(8))} ps={2*(0.29+(8))}
Xtn0 xn vinn sn0 vss sky130_fd_pr__nfet_01v8_lvt
+ w={0.42} l=1
+ ad={0.29*(0.42)} as={0.29*(0.42)}
+ pd={2*(0.29+(0.42))} ps={2*(0.29+(0.42))}
Xsn0 sn0 tn0 tail vss sky130_fd_pr__nfet_01v8
+ w={1} l=0.15
+ ad={0.29*(1)} as={0.29*(1)}
+ pd={2*(0.29+(1))} ps={2*(0.29+(1))}
Xtn1 xn vinn sn1 vss sky130_fd_pr__nfet_01v8_lvt
+ w={0.84} l=1
+ ad={0.29*(0.84)} as={0.29*(0.84)}
+ pd={2*(0.29+(0.84))} ps={2*(0.29+(0.84))}
Xsn1 sn1 tn1 tail vss sky130_fd_pr__nfet_01v8
+ w={2} l=0.15
+ ad={0.29*(2)} as={0.29*(2)}
+ pd={2*(0.29+(2))} ps={2*(0.29+(2))}
Xtn2 xn vinn sn2 vss sky130_fd_pr__nfet_01v8_lvt
+ w={1.68} l=1
+ ad={0.29*(1.68)} as={0.29*(1.68)}
+ pd={2*(0.29+(1.68))} ps={2*(0.29+(1.68))}
Xsn2 sn2 tn2 tail vss sky130_fd_pr__nfet_01v8
+ w={4} l=0.15
+ ad={0.29*(4)} as={0.29*(4)}
+ pd={2*(0.29+(4))} ps={2*(0.29+(4))}
Xtn3 xn vinn sn3 vss sky130_fd_pr__nfet_01v8_lvt
+ w={3.36} l=1
+ ad={0.29*(3.36)} as={0.29*(3.36)}
+ pd={2*(0.29+(3.36))} ps={2*(0.29+(3.36))}
Xsn3 sn3 tn3 tail vss sky130_fd_pr__nfet_01v8
+ w={8} l=0.15
+ ad={0.29*(8)} as={0.29*(8)}
+ pd={2*(0.29+(8))} ps={2*(0.29+(8))}
.ends atlas
