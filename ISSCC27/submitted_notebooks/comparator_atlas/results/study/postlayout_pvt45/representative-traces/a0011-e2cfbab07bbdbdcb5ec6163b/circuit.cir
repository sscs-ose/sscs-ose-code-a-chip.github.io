Comparator Atlas: nominal published 27-device matched layout experiment
.option scale=1u reltol=1e-5 abstol=1e-13 vntol=1e-7
.include "../../model-source/models/parameters/lod.spice"
.include "../../model-source/cells/nfet_01v8/sky130_fd_pr__nfet_01v8__mismatch.corner.spice"
.include "../../model-source/cells/nfet_01v8/sky130_fd_pr__nfet_01v8__tt.corner.spice"
.include "../../model-source/cells/pfet_01v8/sky130_fd_pr__pfet_01v8__mismatch.corner.spice"
.include "../../model-source/cells/pfet_01v8/sky130_fd_pr__pfet_01v8__tt.corner.spice"
.include "../../model-source/cells/nfet_01v8_lvt/sky130_fd_pr__nfet_01v8_lvt__mismatch.corner.spice"
.include "../../model-source/cells/nfet_01v8_lvt/sky130_fd_pr__nfet_01v8_lvt__tt.corner.spice"
* Comparator Atlas declared design: lvt_balanced_4b
* Generated physical transistor netlist. Gate-area proxy is not layout area.
.subckt atlas vinp vinn clk vdd vss qp qn tp0 tp1 tp2 tp3 tn0 tn1 tn2 tn3
+ params: pair_skew=0
Xinp xp vinp tail vss sky130_fd_pr__nfet_01v8_lvt
+ w={3*(1+pair_skew)} l=0.15
+ ad={0.29*(3*(1+pair_skew))} as={0.29*(3*(1+pair_skew))}
+ pd={2*(0.29+(3*(1+pair_skew)))} ps={2*(0.29+(3*(1+pair_skew)))}
Xinn xn vinn tail vss sky130_fd_pr__nfet_01v8_lvt
+ w={3*(1-pair_skew)} l=0.15
+ ad={0.29*(3*(1-pair_skew))} as={0.29*(3*(1-pair_skew))}
+ pd={2*(0.29+(3*(1-pair_skew)))} ps={2*(0.29+(3*(1-pair_skew)))}
Xtail tail clk vss vss sky130_fd_pr__nfet_01v8
+ w={7} l=0.15
+ ad={0.29*(7)} as={0.29*(7)}
+ pd={2*(0.29+(7))} ps={2*(0.29+(7))}
Xln qn qp xp vss sky130_fd_pr__nfet_01v8
+ w={1} l=0.15
+ ad={0.29*(1)} as={0.29*(1)}
+ pd={2*(0.29+(1))} ps={2*(0.29+(1))}
Xlp qp qn xn vss sky130_fd_pr__nfet_01v8
+ w={1} l=0.15
+ ad={0.29*(1)} as={0.29*(1)}
+ pd={2*(0.29+(1))} ps={2*(0.29+(1))}
Xpn qn qp vdd vdd sky130_fd_pr__pfet_01v8
+ w={2} l=0.15
+ ad={0.29*(2)} as={0.29*(2)}
+ pd={2*(0.29+(2))} ps={2*(0.29+(2))}
Xpp qp qn vdd vdd sky130_fd_pr__pfet_01v8
+ w={2} l=0.15
+ ad={0.29*(2)} as={0.29*(2)}
+ pd={2*(0.29+(2))} ps={2*(0.29+(2))}
Xrxp xp clk vdd vdd sky130_fd_pr__pfet_01v8
+ w={1} l=0.15
+ ad={0.29*(1)} as={0.29*(1)}
+ pd={2*(0.29+(1))} ps={2*(0.29+(1))}
Xrxn xn clk vdd vdd sky130_fd_pr__pfet_01v8
+ w={1} l=0.15
+ ad={0.29*(1)} as={0.29*(1)}
+ pd={2*(0.29+(1))} ps={2*(0.29+(1))}
Xrqp qp clk vdd vdd sky130_fd_pr__pfet_01v8
+ w={1} l=0.15
+ ad={0.29*(1)} as={0.29*(1)}
+ pd={2*(0.29+(1))} ps={2*(0.29+(1))}
Xrqn qn clk vdd vdd sky130_fd_pr__pfet_01v8
+ w={1} l=0.15
+ ad={0.29*(1)} as={0.29*(1)}
+ pd={2*(0.29+(1))} ps={2*(0.29+(1))}
Xtp0 xp vinp sp0 vss sky130_fd_pr__nfet_01v8_lvt
+ w={0.42} l=1
+ ad={0.29*(0.42)} as={0.29*(0.42)}
+ pd={2*(0.29+(0.42))} ps={2*(0.29+(0.42))}
Xsp0 sp0 tp0 tail vss sky130_fd_pr__nfet_01v8
+ w={1} l=0.15
+ ad={0.29*(1)} as={0.29*(1)}
+ pd={2*(0.29+(1))} ps={2*(0.29+(1))}
Xtp1 xp vinp sp1 vss sky130_fd_pr__nfet_01v8_lvt
+ w={0.84} l=1
+ ad={0.29*(0.84)} as={0.29*(0.84)}
+ pd={2*(0.29+(0.84))} ps={2*(0.29+(0.84))}
Xsp1 sp1 tp1 tail vss sky130_fd_pr__nfet_01v8
+ w={2} l=0.15
+ ad={0.29*(2)} as={0.29*(2)}
+ pd={2*(0.29+(2))} ps={2*(0.29+(2))}
Xtp2 xp vinp sp2 vss sky130_fd_pr__nfet_01v8_lvt
+ w={1.68} l=1
+ ad={0.29*(1.68)} as={0.29*(1.68)}
+ pd={2*(0.29+(1.68))} ps={2*(0.29+(1.68))}
Xsp2 sp2 tp2 tail vss sky130_fd_pr__nfet_01v8
+ w={4} l=0.15
+ ad={0.29*(4)} as={0.29*(4)}
+ pd={2*(0.29+(4))} ps={2*(0.29+(4))}
Xtp3 xp vinp sp3 vss sky130_fd_pr__nfet_01v8_lvt
+ w={3.36} l=1
+ ad={0.29*(3.36)} as={0.29*(3.36)}
+ pd={2*(0.29+(3.36))} ps={2*(0.29+(3.36))}
Xsp3 sp3 tp3 tail vss sky130_fd_pr__nfet_01v8
+ w={8} l=0.15
+ ad={0.29*(8)} as={0.29*(8)}
+ pd={2*(0.29+(8))} ps={2*(0.29+(8))}
Xtn0 xn vinn sn0 vss sky130_fd_pr__nfet_01v8_lvt
+ w={0.42} l=1
+ ad={0.29*(0.42)} as={0.29*(0.42)}
+ pd={2*(0.29+(0.42))} ps={2*(0.29+(0.42))}
Xsn0 sn0 tn0 tail vss sky130_fd_pr__nfet_01v8
+ w={1} l=0.15
+ ad={0.29*(1)} as={0.29*(1)}
+ pd={2*(0.29+(1))} ps={2*(0.29+(1))}
Xtn1 xn vinn sn1 vss sky130_fd_pr__nfet_01v8_lvt
+ w={0.84} l=1
+ ad={0.29*(0.84)} as={0.29*(0.84)}
+ pd={2*(0.29+(0.84))} ps={2*(0.29+(0.84))}
Xsn1 sn1 tn1 tail vss sky130_fd_pr__nfet_01v8
+ w={2} l=0.15
+ ad={0.29*(2)} as={0.29*(2)}
+ pd={2*(0.29+(2))} ps={2*(0.29+(2))}
Xtn2 xn vinn sn2 vss sky130_fd_pr__nfet_01v8_lvt
+ w={1.68} l=1
+ ad={0.29*(1.68)} as={0.29*(1.68)}
+ pd={2*(0.29+(1.68))} ps={2*(0.29+(1.68))}
Xsn2 sn2 tn2 tail vss sky130_fd_pr__nfet_01v8
+ w={4} l=0.15
+ ad={0.29*(4)} as={0.29*(4)}
+ pd={2*(0.29+(4))} ps={2*(0.29+(4))}
Xtn3 xn vinn sn3 vss sky130_fd_pr__nfet_01v8_lvt
+ w={3.36} l=1
+ ad={0.29*(3.36)} as={0.29*(3.36)}
+ pd={2*(0.29+(3.36))} ps={2*(0.29+(3.36))}
Xsn3 sn3 tn3 tail vss sky130_fd_pr__nfet_01v8
+ w={8} l=0.15
+ ad={0.29*(8)} as={0.29*(8)}
+ pd={2*(0.29+(8))} ps={2*(0.29+(8))}
.ends atlas
.temp 27
Vdd vdd 0 1.8
Vclk clk 0 PULSE(0 1.8 2n 50p 50p 4n 10n)
Vinp vinp 0 0.8985
Vinn vinn 0 0.9015
Vtp0 tp0 0 0
Vtp1 tp1 0 0
Vtp2 tp2 0 0
Vtp3 tp3 0 0
Vtn0 tn0 0 0
Vtn1 tn1 0 0
Vtn2 tn2 0 0
Vtn3 tn3 0 0
Xdut vinp vinn clk vdd 0 qp qn tp0 tp1 tp2 tp3 tn0 tn1 tn2 tn3 atlas pair_skew=0
Cqp qp 0 5f
Cqn qn 0 5f
.save v(clk) v(qp) v(qn) v(xdut.xp) v(xdut.xn) i(vdd) v(vinp) v(vinn)
.control
set wr_singlescale
set wr_vecnames
set numdgt=15
set num_threads=1
echo PVT45W47_NUM_THREADS $num_threads
echo PVT45W47_COMPAT $ngbehavior
tran 5p 30n 19n 5p
wrdata waveform.tsv v(clk) v(qp) v(qn) v(xdut.xp) v(xdut.xn) i(vdd) v(vinp) v(vinn)
show all : w l
let audit_w0 = @m.xdut.xinp.msky130_fd_pr__nfet_01v8_lvt[w]
let audit_l0 = @m.xdut.xinp.msky130_fd_pr__nfet_01v8_lvt[l]
echo NOMINAL27_GEOMETRY Xinp sky130_fd_pr__nfet_01v8_lvt $&audit_w0 $&audit_l0
let audit_w1 = @m.xdut.xinn.msky130_fd_pr__nfet_01v8_lvt[w]
let audit_l1 = @m.xdut.xinn.msky130_fd_pr__nfet_01v8_lvt[l]
echo NOMINAL27_GEOMETRY Xinn sky130_fd_pr__nfet_01v8_lvt $&audit_w1 $&audit_l1
let audit_w2 = @m.xdut.xtail.msky130_fd_pr__nfet_01v8[w]
let audit_l2 = @m.xdut.xtail.msky130_fd_pr__nfet_01v8[l]
echo NOMINAL27_GEOMETRY Xtail sky130_fd_pr__nfet_01v8 $&audit_w2 $&audit_l2
let audit_w3 = @m.xdut.xln.msky130_fd_pr__nfet_01v8[w]
let audit_l3 = @m.xdut.xln.msky130_fd_pr__nfet_01v8[l]
echo NOMINAL27_GEOMETRY Xln sky130_fd_pr__nfet_01v8 $&audit_w3 $&audit_l3
let audit_w4 = @m.xdut.xlp.msky130_fd_pr__nfet_01v8[w]
let audit_l4 = @m.xdut.xlp.msky130_fd_pr__nfet_01v8[l]
echo NOMINAL27_GEOMETRY Xlp sky130_fd_pr__nfet_01v8 $&audit_w4 $&audit_l4
let audit_w5 = @m.xdut.xpn.msky130_fd_pr__pfet_01v8[w]
let audit_l5 = @m.xdut.xpn.msky130_fd_pr__pfet_01v8[l]
echo NOMINAL27_GEOMETRY Xpn sky130_fd_pr__pfet_01v8 $&audit_w5 $&audit_l5
let audit_w6 = @m.xdut.xpp.msky130_fd_pr__pfet_01v8[w]
let audit_l6 = @m.xdut.xpp.msky130_fd_pr__pfet_01v8[l]
echo NOMINAL27_GEOMETRY Xpp sky130_fd_pr__pfet_01v8 $&audit_w6 $&audit_l6
let audit_w7 = @m.xdut.xrxp.msky130_fd_pr__pfet_01v8[w]
let audit_l7 = @m.xdut.xrxp.msky130_fd_pr__pfet_01v8[l]
echo NOMINAL27_GEOMETRY Xrxp sky130_fd_pr__pfet_01v8 $&audit_w7 $&audit_l7
let audit_w8 = @m.xdut.xrxn.msky130_fd_pr__pfet_01v8[w]
let audit_l8 = @m.xdut.xrxn.msky130_fd_pr__pfet_01v8[l]
echo NOMINAL27_GEOMETRY Xrxn sky130_fd_pr__pfet_01v8 $&audit_w8 $&audit_l8
let audit_w9 = @m.xdut.xrqp.msky130_fd_pr__pfet_01v8[w]
let audit_l9 = @m.xdut.xrqp.msky130_fd_pr__pfet_01v8[l]
echo NOMINAL27_GEOMETRY Xrqp sky130_fd_pr__pfet_01v8 $&audit_w9 $&audit_l9
let audit_w10 = @m.xdut.xrqn.msky130_fd_pr__pfet_01v8[w]
let audit_l10 = @m.xdut.xrqn.msky130_fd_pr__pfet_01v8[l]
echo NOMINAL27_GEOMETRY Xrqn sky130_fd_pr__pfet_01v8 $&audit_w10 $&audit_l10
let audit_w11 = @m.xdut.xtp0.msky130_fd_pr__nfet_01v8_lvt[w]
let audit_l11 = @m.xdut.xtp0.msky130_fd_pr__nfet_01v8_lvt[l]
echo NOMINAL27_GEOMETRY Xtp0 sky130_fd_pr__nfet_01v8_lvt $&audit_w11 $&audit_l11
let audit_w12 = @m.xdut.xsp0.msky130_fd_pr__nfet_01v8[w]
let audit_l12 = @m.xdut.xsp0.msky130_fd_pr__nfet_01v8[l]
echo NOMINAL27_GEOMETRY Xsp0 sky130_fd_pr__nfet_01v8 $&audit_w12 $&audit_l12
let audit_w13 = @m.xdut.xtp1.msky130_fd_pr__nfet_01v8_lvt[w]
let audit_l13 = @m.xdut.xtp1.msky130_fd_pr__nfet_01v8_lvt[l]
echo NOMINAL27_GEOMETRY Xtp1 sky130_fd_pr__nfet_01v8_lvt $&audit_w13 $&audit_l13
let audit_w14 = @m.xdut.xsp1.msky130_fd_pr__nfet_01v8[w]
let audit_l14 = @m.xdut.xsp1.msky130_fd_pr__nfet_01v8[l]
echo NOMINAL27_GEOMETRY Xsp1 sky130_fd_pr__nfet_01v8 $&audit_w14 $&audit_l14
let audit_w15 = @m.xdut.xtp2.msky130_fd_pr__nfet_01v8_lvt[w]
let audit_l15 = @m.xdut.xtp2.msky130_fd_pr__nfet_01v8_lvt[l]
echo NOMINAL27_GEOMETRY Xtp2 sky130_fd_pr__nfet_01v8_lvt $&audit_w15 $&audit_l15
let audit_w16 = @m.xdut.xsp2.msky130_fd_pr__nfet_01v8[w]
let audit_l16 = @m.xdut.xsp2.msky130_fd_pr__nfet_01v8[l]
echo NOMINAL27_GEOMETRY Xsp2 sky130_fd_pr__nfet_01v8 $&audit_w16 $&audit_l16
let audit_w17 = @m.xdut.xtp3.msky130_fd_pr__nfet_01v8_lvt[w]
let audit_l17 = @m.xdut.xtp3.msky130_fd_pr__nfet_01v8_lvt[l]
echo NOMINAL27_GEOMETRY Xtp3 sky130_fd_pr__nfet_01v8_lvt $&audit_w17 $&audit_l17
let audit_w18 = @m.xdut.xsp3.msky130_fd_pr__nfet_01v8[w]
let audit_l18 = @m.xdut.xsp3.msky130_fd_pr__nfet_01v8[l]
echo NOMINAL27_GEOMETRY Xsp3 sky130_fd_pr__nfet_01v8 $&audit_w18 $&audit_l18
let audit_w19 = @m.xdut.xtn0.msky130_fd_pr__nfet_01v8_lvt[w]
let audit_l19 = @m.xdut.xtn0.msky130_fd_pr__nfet_01v8_lvt[l]
echo NOMINAL27_GEOMETRY Xtn0 sky130_fd_pr__nfet_01v8_lvt $&audit_w19 $&audit_l19
let audit_w20 = @m.xdut.xsn0.msky130_fd_pr__nfet_01v8[w]
let audit_l20 = @m.xdut.xsn0.msky130_fd_pr__nfet_01v8[l]
echo NOMINAL27_GEOMETRY Xsn0 sky130_fd_pr__nfet_01v8 $&audit_w20 $&audit_l20
let audit_w21 = @m.xdut.xtn1.msky130_fd_pr__nfet_01v8_lvt[w]
let audit_l21 = @m.xdut.xtn1.msky130_fd_pr__nfet_01v8_lvt[l]
echo NOMINAL27_GEOMETRY Xtn1 sky130_fd_pr__nfet_01v8_lvt $&audit_w21 $&audit_l21
let audit_w22 = @m.xdut.xsn1.msky130_fd_pr__nfet_01v8[w]
let audit_l22 = @m.xdut.xsn1.msky130_fd_pr__nfet_01v8[l]
echo NOMINAL27_GEOMETRY Xsn1 sky130_fd_pr__nfet_01v8 $&audit_w22 $&audit_l22
let audit_w23 = @m.xdut.xtn2.msky130_fd_pr__nfet_01v8_lvt[w]
let audit_l23 = @m.xdut.xtn2.msky130_fd_pr__nfet_01v8_lvt[l]
echo NOMINAL27_GEOMETRY Xtn2 sky130_fd_pr__nfet_01v8_lvt $&audit_w23 $&audit_l23
let audit_w24 = @m.xdut.xsn2.msky130_fd_pr__nfet_01v8[w]
let audit_l24 = @m.xdut.xsn2.msky130_fd_pr__nfet_01v8[l]
echo NOMINAL27_GEOMETRY Xsn2 sky130_fd_pr__nfet_01v8 $&audit_w24 $&audit_l24
let audit_w25 = @m.xdut.xtn3.msky130_fd_pr__nfet_01v8_lvt[w]
let audit_l25 = @m.xdut.xtn3.msky130_fd_pr__nfet_01v8_lvt[l]
echo NOMINAL27_GEOMETRY Xtn3 sky130_fd_pr__nfet_01v8_lvt $&audit_w25 $&audit_l25
let audit_w26 = @m.xdut.xsn3.msky130_fd_pr__nfet_01v8[w]
let audit_l26 = @m.xdut.xsn3.msky130_fd_pr__nfet_01v8[l]
echo NOMINAL27_GEOMETRY Xsn3 sky130_fd_pr__nfet_01v8 $&audit_w26 $&audit_l26
echo NOMINAL27_TRANSIENT_COMPLETE
quit 0
.endc
.end
