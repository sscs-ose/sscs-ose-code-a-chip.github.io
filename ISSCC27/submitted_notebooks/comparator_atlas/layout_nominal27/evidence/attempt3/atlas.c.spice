* NGSPICE file created from atlas.ext - technology: sky130A

.subckt atlas vinp vinn clk vdd vss qp qn tp0 tp1 tp2 tp3 tn0 tn1 tn2 tn3
X0 vdd clk qp vdd sky130_fd_pr__pfet_01v8 ad=0.29 pd=2.58 as=0.29 ps=2.58 w=1 l=0.15
X1 vss clk tail vss sky130_fd_pr__nfet_01v8 ad=2.03 pd=14.58 as=2.03 ps=14.58 w=7 l=0.15
X2 xn vinn sn0 vss sky130_fd_pr__nfet_01v8_lvt ad=0.1218 pd=1.42 as=0.1218 ps=1.42 w=0.42 l=1
X3 tail tp1 sp1 vss sky130_fd_pr__nfet_01v8 ad=0.58 pd=4.58 as=0.58 ps=4.58 w=2 l=0.15
X4 qp qn vdd vdd sky130_fd_pr__pfet_01v8 ad=0.58 pd=4.58 as=0.58 ps=4.58 w=2 l=0.15
X5 xn vinn tail vss sky130_fd_pr__nfet_01v8_lvt ad=0.87 pd=6.58 as=0.87 ps=6.58 w=3 l=0.15
X6 tail tp3 sp3 vss sky130_fd_pr__nfet_01v8 ad=2.32 pd=16.58 as=2.32 ps=16.58 w=8 l=0.15
X7 sp0 vinp xp vss sky130_fd_pr__nfet_01v8_lvt ad=0.1218 pd=1.42 as=0.1218 ps=1.42 w=0.42 l=1
X8 sp1 vinp xp vss sky130_fd_pr__nfet_01v8_lvt ad=0.2436 pd=2.26 as=0.2436 ps=2.26 w=0.84 l=1
X9 tail vinp xp vss sky130_fd_pr__nfet_01v8_lvt ad=0.87 pd=6.58 as=0.87 ps=6.58 w=3 l=0.15
X10 sn2 tn2 tail vss sky130_fd_pr__nfet_01v8 ad=1.16 pd=8.58 as=1.16 ps=8.58 w=4 l=0.15
X11 sp3 vinp xp vss sky130_fd_pr__nfet_01v8_lvt ad=0.9744 pd=7.3 as=0.9744 ps=7.3 w=3.36 l=1
X12 vdd qp qn vdd sky130_fd_pr__pfet_01v8 ad=0.58 pd=4.58 as=0.58 ps=4.58 w=2 l=0.15
X13 xn clk vdd vdd sky130_fd_pr__pfet_01v8 ad=0.29 pd=2.58 as=0.29 ps=2.58 w=1 l=0.15
X14 qp qn xn vss sky130_fd_pr__nfet_01v8 ad=0.29 pd=2.58 as=0.29 ps=2.58 w=1 l=0.15
X15 sn0 tn0 tail vss sky130_fd_pr__nfet_01v8 ad=0.29 pd=2.58 as=0.29 ps=2.58 w=1 l=0.15
X16 sp2 vinp xp vss sky130_fd_pr__nfet_01v8_lvt ad=0.4872 pd=3.94 as=0.4872 ps=3.94 w=1.68 l=1
X17 sn3 tn3 tail vss sky130_fd_pr__nfet_01v8 ad=2.32 pd=16.58 as=2.32 ps=16.58 w=8 l=0.15
X18 xn vinn sn1 vss sky130_fd_pr__nfet_01v8_lvt ad=0.2436 pd=2.26 as=0.2436 ps=2.26 w=0.84 l=1
X19 sn1 tn1 tail vss sky130_fd_pr__nfet_01v8 ad=0.58 pd=4.58 as=0.58 ps=4.58 w=2 l=0.15
X20 xn vinn sn3 vss sky130_fd_pr__nfet_01v8_lvt ad=0.9744 pd=7.3 as=0.9744 ps=7.3 w=3.36 l=1
X21 vdd clk xp vdd sky130_fd_pr__pfet_01v8 ad=0.29 pd=2.58 as=0.29 ps=2.58 w=1 l=0.15
X22 qn clk vdd vdd sky130_fd_pr__pfet_01v8 ad=0.29 pd=2.58 as=0.29 ps=2.58 w=1 l=0.15
X23 xn vinn sn2 vss sky130_fd_pr__nfet_01v8_lvt ad=0.4872 pd=3.94 as=0.4872 ps=3.94 w=1.68 l=1
X24 tail tp2 sp2 vss sky130_fd_pr__nfet_01v8 ad=1.16 pd=8.58 as=1.16 ps=8.58 w=4 l=0.15
X25 xp qp qn vss sky130_fd_pr__nfet_01v8 ad=0.29 pd=2.58 as=0.29 ps=2.58 w=1 l=0.15
X26 tail tp0 sp0 vss sky130_fd_pr__nfet_01v8 ad=0.29 pd=2.58 as=0.29 ps=2.58 w=1 l=0.15
C0 sn2 tn1 0.00608f
C1 tn2 xn 0.07616f
C2 sp1 tail 0.33747f
C3 xp sp1 0.17891f
C4 clk sn0 0
C5 sp0 vinp 0.90479f
C6 sn3 tn3 0.58709f
C7 clk vdd 4.12738f
C8 clk vinn 0.05247f
C9 qp sp0 0.05528f
C10 sp2 sp1 0.09954f
C11 xn sn0 0.16292f
C12 sn1 sn0 0.08708f
C13 xn vdd 0.66242f
C14 clk tail 2.67989f
C15 qn clk 0.45595f
C16 xn vinn 2.10871f
C17 sn1 vinn 0.76113f
C18 xp clk 0.39615f
C19 xn tail 3.3646f
C20 sn1 tail 0.33747f
C21 qn xn 0.44523f
C22 tp1 vinp 0.1069f
C23 xn tn1 0.07608f
C24 sn1 tn1 0.5284f
C25 sn2 xn 0.21094f
C26 sn2 sn1 0.09954f
C27 tn3 vinn 0.02577f
C28 sp0 vdd 0.10861f
C29 tp0 sp0 0.49357f
C30 qp vinp 0.08674f
C31 tail tn3 0.25334f
C32 sp0 tail 0.2417f
C33 qn sp0 0
C34 xp sp0 0.16292f
C35 tn2 sn3 0.00606f
C36 xn clk 0.39615f
C37 tp2 vinp 0.10854f
C38 sn0 tn0 0.49356f
C39 tp1 tail 0.30405f
C40 sp0 sp1 0.08708f
C41 vinp sp3 0.64746f
C42 vinp vdd 0.05563f
C43 qp sn0 0
C44 vdd tn0 0
C45 tp0 vinp 0.10038f
C46 sn1 xn 0.17891f
C47 vinn tn0 0.10046f
C48 qp vdd 1.82789f
C49 xp tp1 0.07607f
C50 sn3 vinn 0.64746f
C51 vinp tp3 0.02577f
C52 qp vinn 0.06747f
C53 vinp tail 0.56463f
C54 sp2 tp1 0.00608f
C55 qn vinp 0.06756f
C56 tail tn0 0.30229f
C57 sn3 tail 0.8463f
C58 qp tail 0.2952f
C59 qn qp 1.97209f
C60 xp vinp 2.10871f
C61 tn2 vinn 0.10853f
C62 sp0 clk 0
C63 qp xp 0.44756f
C64 sp2 vinp 0.74715f
C65 tp1 sp1 0.5284f
C66 tn2 tail 0.30563f
C67 xn tn3 0.00608f
C68 sn2 sn3 0.11716f
C69 sn0 vdd 0.10861f
C70 tp2 sp3 0.00606f
C71 vinp sp1 0.76113f
C72 sn0 vinn 0.90479f
C73 vdd vinn 0.05563f
C74 sn2 tn2 0.55745f
C75 tp0 vdd 0
C76 tp3 sp3 0.58709f
C77 sn0 tail 0.2417f
C78 tp2 tail 0.30563f
C79 qn sn0 0.05542f
C80 sp3 tail 0.8463f
C81 vdd tail 0.27714f
C82 qn vdd 1.8271f
C83 tail vinn 0.56162f
C84 tp0 tail 0.30229f
C85 qn vinn 0.08683f
C86 tp2 xp 0.07616f
C87 tp3 tail 0.25334f
C88 xp sp3 0.21004f
C89 xp vdd 0.66242f
C90 tn1 vinn 0.10684f
C91 tp0 xp 0.07608f
C92 clk vinp 0.05248f
C93 xp tp3 0.00608f
C94 sp2 tp2 0.55745f
C95 qp clk 0.45677f
C96 qn tail 0.29428f
C97 sp2 sp3 0.11716f
C98 tn1 tail 0.30405f
C99 xp tail 3.36481f
C100 qn xp 0.23091f
C101 sn2 vinn 0.74715f
C102 xn tn0 0.07608f
C103 sn1 tn0 0.00608f
C104 sn3 xn 0.21004f
C105 qp xn 0.23324f
C106 sp2 tail 0.52911f
C107 sn2 tail 0.52911f
C108 tp0 sp1 0.00608f
C109 sp2 xp 0.21094f
C110 tn3 vss 1.0748f
C111 tn2 vss 1.05623f
C112 tn1 vss 1.04126f
C113 tn0 vss 1.01957f
C114 vinn vss 7.87257f
C115 qn vss 8.68758f
C116 qp vss 8.67502f
C117 clk vss 2.13585f
C118 tp0 vss 1.01993f
C119 tp1 vss 1.04089f
C120 tp2 vss 1.05619f
C121 vinp vss 7.87089f
C122 tp3 vss 1.0748f
C123 vdd vss 14.186f
C124 sn3 vss 3.33295f ; **FLOATING
C125 sn2 vss 2.41862f ; **FLOATING
C126 sn1 vss 2.14141f ; **FLOATING
C127 sn0 vss 1.94552f ; **FLOATING
C128 xn vss 6.61753f ; **FLOATING
C129 sp0 vss 1.94573f ; **FLOATING
C130 sp1 vss 2.14141f ; **FLOATING
C131 sp2 vss 2.41862f ; **FLOATING
C132 xp vss 6.61807f ; **FLOATING
C133 tail vss 13.2651f ; **FLOATING
C134 sp3 vss 3.33295f ; **FLOATING
.ends
