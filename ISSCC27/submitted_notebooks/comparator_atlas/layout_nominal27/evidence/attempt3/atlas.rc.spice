* NGSPICE file created from atlas.ext - technology: sky130A

.subckt atlas vinp vinn clk vdd vss qp qn tp0 tp1 tp2 tp3 tn0 tn1 tn2 tn3
X0 vdd.t5 clk.t4 qp.t0 vdd.t4 sky130_fd_pr__pfet_01v8 ad=0.29 pd=2.58 as=0.29 ps=2.58 w=1 l=0.15
X1 vss.t17 clk.t2 tail.t7 vss.t16 sky130_fd_pr__nfet_01v8 ad=2.03 pd=14.58 as=2.03 ps=14.58 w=7 l=0.15
X2 xn.t3 vinn.t3 sn0.t0 vss.t11 sky130_fd_pr__nfet_01v8_lvt ad=0.1218 pd=1.42 as=0.1218 ps=1.42 w=0.42 l=1
X3 tail.t9 tp1.t0 sp1.t1 vss.t19 sky130_fd_pr__nfet_01v8 ad=0.58 pd=4.58 as=0.58 ps=4.58 w=2 l=0.15
X4 qp.t1 qn.t3 vdd.t11 vdd.t10 sky130_fd_pr__pfet_01v8 ad=0.58 pd=4.58 as=0.58 ps=4.58 w=2 l=0.15
X5 xn.t0 vinn.t4 tail.t6 vss.t10 sky130_fd_pr__nfet_01v8_lvt ad=0.87 pd=6.58 as=0.87 ps=6.58 w=3 l=0.15
X6 tail.t3 tp3.t0 sp3.t0 vss.t3 sky130_fd_pr__nfet_01v8 ad=2.32 pd=16.58 as=2.32 ps=16.58 w=8 l=0.15
X7 sp0.t1 vinp.t1 xp.t2 vss.t7 sky130_fd_pr__nfet_01v8_lvt ad=0.1218 pd=1.42 as=0.1218 ps=1.42 w=0.42 l=1
X8 sp1.t0 vinp.t2 xp.t4 vss.t6 sky130_fd_pr__nfet_01v8_lvt ad=0.2436 pd=2.26 as=0.2436 ps=2.26 w=0.84 l=1
X9 tail.t4 vinp.t0 xp.t0 vss.t8 sky130_fd_pr__nfet_01v8_lvt ad=0.87 pd=6.58 as=0.87 ps=6.58 w=3 l=0.15
X10 sn2.t1 tn2.t0 tail.t8 vss.t18 sky130_fd_pr__nfet_01v8 ad=1.16 pd=8.58 as=1.16 ps=8.58 w=4 l=0.15
X11 sp3.t1 vinp.t4 xp.t1 vss.t4 sky130_fd_pr__nfet_01v8_lvt ad=0.9744 pd=7.3 as=0.9744 ps=7.3 w=3.36 l=1
X12 vdd.t1 qp.t4 qn.t0 vdd.t0 sky130_fd_pr__pfet_01v8 ad=0.58 pd=4.58 as=0.58 ps=4.58 w=2 l=0.15
X13 xn.t5 clk.t1 vdd.t3 vdd.t2 sky130_fd_pr__pfet_01v8 ad=0.29 pd=2.58 as=0.29 ps=2.58 w=1 l=0.15
X14 qp.t2 qn.t4 xn.t6 vss.t21 sky130_fd_pr__nfet_01v8 ad=0.29 pd=2.58 as=0.29 ps=2.58 w=1 l=0.15
X15 sn0.t1 tn0.t0 tail.t10 vss.t20 sky130_fd_pr__nfet_01v8 ad=0.29 pd=2.58 as=0.29 ps=2.58 w=1 l=0.15
X16 sp2.t0 vinp.t3 xp.t3 vss.t5 sky130_fd_pr__nfet_01v8_lvt ad=0.4872 pd=3.94 as=0.4872 ps=3.94 w=1.68 l=1
X17 sn3.t0 tn3.t0 tail.t1 vss.t1 sky130_fd_pr__nfet_01v8 ad=2.32 pd=16.58 as=2.32 ps=16.58 w=8 l=0.15
X18 xn.t2 vinn.t2 sn1.t1 vss.t12 sky130_fd_pr__nfet_01v8_lvt ad=0.2436 pd=2.26 as=0.2436 ps=2.26 w=0.84 l=1
X19 sn1.t0 tn1.t0 tail.t2 vss.t2 sky130_fd_pr__nfet_01v8 ad=0.58 pd=4.58 as=0.58 ps=4.58 w=2 l=0.15
X20 xn.t4 vinn.t0 sn3.t1 vss.t14 sky130_fd_pr__nfet_01v8_lvt ad=0.9744 pd=7.3 as=0.9744 ps=7.3 w=3.36 l=1
X21 vdd.t7 clk.t3 xp.t6 vdd.t6 sky130_fd_pr__pfet_01v8 ad=0.29 pd=2.58 as=0.29 ps=2.58 w=1 l=0.15
X22 qn.t2 clk.t0 vdd.t9 vdd.t8 sky130_fd_pr__pfet_01v8 ad=0.29 pd=2.58 as=0.29 ps=2.58 w=1 l=0.15
X23 xn.t1 vinn.t1 sn2.t0 vss.t13 sky130_fd_pr__nfet_01v8_lvt ad=0.4872 pd=3.94 as=0.4872 ps=3.94 w=1.68 l=1
X24 tail.t5 tp2.t0 sp2.t1 vss.t9 sky130_fd_pr__nfet_01v8 ad=1.16 pd=8.58 as=1.16 ps=8.58 w=4 l=0.15
X25 xp.t5 qp.t3 qn.t1 vss.t15 sky130_fd_pr__nfet_01v8 ad=0.29 pd=2.58 as=0.29 ps=2.58 w=1 l=0.15
X26 tail.t0 tp0.t0 sp0.t0 vss.t0 sky130_fd_pr__nfet_01v8 ad=0.29 pd=2.58 as=0.29 ps=2.58 w=1 l=0.15
C0 sp2 tp2 0.55745f
C1 tail vinn 0.56162f
C2 sn3 tn3 0.58709f
C3 clk vinp 0.05248f
C4 tail tn0 0.30229f
C5 sp3 tp3 0.58709f
C6 tn3 vinn 0.02577f
C7 sp1 sp0 0.08708f
C8 sn3 vinn 0.64746f
C9 qp vdd 1.82789f
C10 tail vinp 0.56463f
C11 vdd tp0 0
C12 sn1 sn0 0.08708f
C13 vdd xn 0.66242f
C14 vinn tn0 0.10046f
C15 qp sn0 0
C16 tp1 tail 0.30405f
C17 sp1 tp0 0.00608f
C18 xp vinp 2.10871f
C19 xn sn0 0.16292f
C20 clk sp0 0
C21 tail tp2 0.30563f
C22 tail sp0 0.2417f
C23 xp tp1 0.07607f
C24 clk qp 0.45677f
C25 tail tn1 0.30405f
C26 tail sn1 0.33747f
C27 clk xn 0.39615f
C28 tail qp 0.2952f
C29 xp tp2 0.07616f
C30 xp sp0 0.16292f
C31 sn2 tn2 0.55745f
C32 tp1 vinp 0.1069f
C33 qn vdd 1.8271f
C34 tail tp0 0.30229f
C35 tail xn 3.3646f
C36 tn1 vinn 0.10684f
C37 sn1 vinn 0.76113f
C38 xp qp 0.44756f
C39 sn1 tn0 0.00608f
C40 xn tn3 0.00608f
C41 vinp tp2 0.10854f
C42 qn sn0 0.05542f
C43 qp vinn 0.06747f
C44 sn3 xn 0.21004f
C45 vinp sp0 0.90479f
C46 sp2 sp3 0.11716f
C47 xp tp0 0.07608f
C48 tail tp3 0.25334f
C49 xn vinn 2.10871f
C50 xn tn0 0.07608f
C51 qp vinp 0.08674f
C52 vinp tp0 0.10038f
C53 clk qn 0.45595f
C54 xp tp3 0.00608f
C55 qn tail 0.29428f
C56 vinp tp3 0.02577f
C57 sn1 tn1 0.5284f
C58 vdd sn0 0.10861f
C59 sp3 tail 0.8463f
C60 qp sp0 0.05528f
C61 sp1 sp2 0.09954f
C62 xp qn 0.23091f
C63 qn vinn 0.08683f
C64 sp0 tp0 0.49357f
C65 tail tn2 0.30563f
C66 tail sn2 0.52911f
C67 xn tn1 0.07608f
C68 sn1 xn 0.17891f
C69 sp3 xp 0.21004f
C70 sn3 tn2 0.00606f
C71 qn vinp 0.06756f
C72 sn3 sn2 0.11716f
C73 clk vdd 4.12738f
C74 qp xn 0.23324f
C75 tn2 vinn 0.10853f
C76 sn2 vinn 0.74715f
C77 tail vdd 0.27714f
C78 sp3 vinp 0.64746f
C79 sp2 tail 0.52911f
C80 clk sn0 0
C81 sp1 tail 0.33747f
C82 tail sn0 0.2417f
C83 xp vdd 0.66242f
C84 vdd vinn 0.05563f
C85 qn sp0 0
C86 sp2 xp 0.21094f
C87 vdd tn0 0
C88 sp1 xp 0.17891f
C89 sp3 tp2 0.00606f
C90 vinn sn0 0.90479f
C91 vinp vdd 0.05563f
C92 qn qp 1.97209f
C93 clk tail 2.67989f
C94 sp2 vinp 0.74715f
C95 tn0 sn0 0.49356f
C96 qn xn 0.44523f
C97 sp1 vinp 0.76113f
C98 sn2 tn1 0.00608f
C99 sn2 sn1 0.09954f
C100 sp2 tp1 0.00608f
C101 xp clk 0.39615f
C102 clk vinn 0.05247f
C103 tail tn3 0.25334f
C104 tail sn3 0.8463f
C105 sp1 tp1 0.5284f
C106 xn tn2 0.07616f
C107 xp tail 3.36481f
C108 vdd sp0 0.10861f
C109 sn2 xn 0.21094f
R0 tn3.n0 tn3 3.4105
R1 tn3.t0 tn3.n0 1516.25
R2 tn2.n0 tn2 3.4105
R3 tn2.t0 tn2.n0 873.995
R4 tn1.n0 tn1 3.4105
R5 tn1.t0 tn1.n0 552.731
R6 tn0.n0 tn0 3.4105
R7 tn0.t0 tn0.n0 391.962
R8 vinn vinn.n0 0.2825
R9 vinn vinn.n1 0.8465
R10 vinn.n1 vinn.n2 1.1285
R11 vinn.n2 vinn.t0 188.087
R12 vinn.n2 vinn.t1 146.762
R13 vinn.n1 vinn.t2 126.663
R14 vinn.n0 vinn.t3 116.615
R15 vinn.n0 vinn.t4 717.788
R16 qn qn.n0 1.246
R17 qn qn.n1 1.1285
R18 qn.n1 qn.n2 0.5645
R19 qn.n2 qn.t2 242.01
R20 qn.n2 qn.t3 568.372
R21 qn.n1 qn.t4 393.426
R22 qn.n0 qn.t1 96.2574
R23 qn.n0 qn.t0 126.755
R24 qp.n1 qp.n0 0.5645
R25 qp qp.n1 1.1285
R26 qp qp.n2 1.246
R27 qp.n2 qp.t1 126.201
R28 qp.n2 qp.t2 95.7018
R29 qp.n1 qp.t3 392.872
R30 qp.n0 qp.t4 567.817
R31 qp.n0 qp.t0 241.454
R32 clk.n0 clk 3.4105
R33 clk clk.n1 2.2565
R34 clk clk.n2 2.2565
R35 clk.n2 clk.t0 406.777
R36 clk.n2 clk.t1 406.214
R37 clk.n1 clk.t3 406.214
R38 clk.n1 clk.t4 406.777
R39 clk.t2 clk.n0 1351.31
R40 tp0.n0 tp0 3.4105
R41 tp0.t0 tp0.n0 391.962
R42 tp1.n0 tp1 3.4105
R43 tp1.t0 tp1.n0 552.731
R44 tp2.n0 tp2 3.4105
R45 tp2.t0 tp2.n0 873.995
R46 vinp.n1 vinp.n0 1.1285
R47 vinp vinp.n1 0.8465
R48 vinp vinp.n2 0.2825
R49 vinp.n2 vinp.t0 717.788
R50 vinp.n2 vinp.t1 116.615
R51 vinp.n1 vinp.t2 126.663
R52 vinp.n0 vinp.t3 146.762
R53 vinp.n0 vinp.t4 188.087
R54 tp3.n0 tp3 3.4105
R55 tp3.t0 tp3.n0 1516.25
R56 vdd.n21 vdd.n10 0.212
R57 vdd.n22 vdd.n21 0.353
R58 vdd.n33 vdd.n22 0.212
R59 vdd.n34 vdd.n33 0.353
R60 vdd vdd.n34 1.575
R61 vdd vdd.n35 1.575
R62 vdd.n35 vdd.n46 0.353
R63 vdd.n46 vdd.n47 0.212
R64 vdd.n47 vdd.n58 0.353
R65 vdd.n58 vdd.n59 0.212
R66 vdd.n59 vdd.n60 21.0196
R67 vdd.n61 vdd.n62 70.7763
R68 vdd.n60 vdd.n61 92.5005
R69 vdd.n64 vdd.n63 46.2505
R70 vdd.n60 vdd.n64 135.154
R71 vdd.t8 vdd.n65 16.7394
R72 vdd.n66 vdd.n67 92.5005
R73 vdd.n64 vdd.n67 140.048
R74 vdd.n69 vdd.n68 46.2505
R75 vdd.n69 vdd.n67 140.048
R76 vdd.n60 vdd.n69 135.154
R77 vdd.n68 vdd.n61 1312.94
R78 vdd.n62 vdd.n63 237.584
R79 vdd.n65 vdd.n66 70.7763
R80 vdd.n66 vdd.n63 1312.94
R81 vdd.n68 vdd.n65 237.584
R82 vdd.n62 vdd.t8 16.7394
R83 vdd.n59 vdd.t9 238.82
R84 vdd.n58 vdd.n48 20.6671
R85 vdd.n49 vdd.n50 70.7763
R86 vdd.n48 vdd.n49 92.5005
R87 vdd.n52 vdd.n51 46.2505
R88 vdd.n48 vdd.n52 135.154
R89 vdd.t2 vdd.n53 16.7394
R90 vdd.n54 vdd.n55 92.5005
R91 vdd.n52 vdd.n55 140.048
R92 vdd.n57 vdd.n56 46.2505
R93 vdd.n57 vdd.n55 140.048
R94 vdd.n48 vdd.n57 135.154
R95 vdd.n56 vdd.n49 1312.94
R96 vdd.n50 vdd.n51 237.584
R97 vdd.n53 vdd.n54 70.7763
R98 vdd.n54 vdd.n51 1312.94
R99 vdd.n56 vdd.n53 237.584
R100 vdd.n50 vdd.t2 16.7394
R101 vdd.n47 vdd.t3 238.82
R102 vdd.n46 vdd.n36 20.8407
R103 vdd.n37 vdd.n38 77.8163
R104 vdd.n36 vdd.n37 92.5005
R105 vdd.n40 vdd.n39 26.4291
R106 vdd.n36 vdd.n40 172.8
R107 vdd.t10 vdd.n41 10.3649
R108 vdd.n42 vdd.n43 92.5005
R109 vdd.n43 vdd.n40 177.695
R110 vdd.n45 vdd.n44 26.4291
R111 vdd.n45 vdd.n43 177.695
R112 vdd.n36 vdd.n45 172.8
R113 vdd.n44 vdd.n37 1665.88
R114 vdd.n38 vdd.n39 186.649
R115 vdd.n41 vdd.n42 77.8163
R116 vdd.n42 vdd.n39 1665.88
R117 vdd.n44 vdd.n41 186.649
R118 vdd.n38 vdd.t10 10.3649
R119 vdd.n35 vdd.t11 124.248
R120 vdd.n34 vdd.t1 124.248
R121 vdd.n33 vdd.n23 20.8407
R122 vdd.n24 vdd.n25 77.8163
R123 vdd.n23 vdd.n24 92.5005
R124 vdd.n27 vdd.n26 26.4291
R125 vdd.n23 vdd.n27 172.8
R126 vdd.t0 vdd.n28 10.3649
R127 vdd.n29 vdd.n30 92.5005
R128 vdd.n27 vdd.n30 177.695
R129 vdd.n32 vdd.n31 26.4291
R130 vdd.n32 vdd.n30 177.695
R131 vdd.n23 vdd.n32 172.8
R132 vdd.n31 vdd.n24 1665.88
R133 vdd.n25 vdd.n26 186.649
R134 vdd.n28 vdd.n29 77.8163
R135 vdd.n29 vdd.n26 1665.88
R136 vdd.n31 vdd.n28 186.649
R137 vdd.n25 vdd.t0 10.3649
R138 vdd.n22 vdd.t7 238.82
R139 vdd.n21 vdd.n11 20.6671
R140 vdd.n12 vdd.n13 70.7763
R141 vdd.n11 vdd.n12 92.5005
R142 vdd.n15 vdd.n14 46.2505
R143 vdd.n11 vdd.n15 135.154
R144 vdd.t6 vdd.n16 16.7394
R145 vdd.n17 vdd.n18 92.5005
R146 vdd.n15 vdd.n18 140.048
R147 vdd.n20 vdd.n19 46.2505
R148 vdd.n20 vdd.n18 140.048
R149 vdd.n11 vdd.n20 135.154
R150 vdd.n19 vdd.n12 1312.94
R151 vdd.n13 vdd.n14 237.584
R152 vdd.n16 vdd.n17 70.7763
R153 vdd.n17 vdd.n14 1312.94
R154 vdd.n19 vdd.n16 237.584
R155 vdd.n13 vdd.t6 16.7394
R156 vdd.n10 vdd.t5 238.82
R157 vdd.n10 vdd.n0 21.0196
R158 vdd.n1 vdd.n2 70.7763
R159 vdd.n0 vdd.n1 92.5005
R160 vdd.n4 vdd.n3 46.2505
R161 vdd.n0 vdd.n4 135.154
R162 vdd.t4 vdd.n5 16.7394
R163 vdd.n6 vdd.n7 92.5005
R164 vdd.n4 vdd.n7 140.048
R165 vdd.n9 vdd.n8 46.2505
R166 vdd.n9 vdd.n7 140.048
R167 vdd.n0 vdd.n9 135.154
R168 vdd.n8 vdd.n1 1312.94
R169 vdd.n2 vdd.n3 237.584
R170 vdd.n5 vdd.n6 70.7763
R171 vdd.n6 vdd.n3 1312.94
R172 vdd.n8 vdd.n5 237.584
R173 vdd.n2 vdd.t4 16.7394
R174 vss.n1 vss.n0 0.5645
R175 vss.n2 vss.n1 0.5645
R176 vss.n3 vss.n2 0.5645
R177 vss.n4 vss.n3 0.5645
R178 vss.n5 vss.n4 0.5645
R179 vss.n6 vss.n5 0.5645
R180 vss.n231 vss.n6 0.5645
R181 vss.n7 vss.n231 1.6925
R182 vss.n8 vss.n7 0.5645
R183 vss.n9 vss.n8 0.5645
R184 vss vss.n9 0.2355
R185 vss vss.n10 0.118
R186 vss.n10 vss.n11 0.682
R187 vss.n11 vss.n12 0.5645
R188 vss.n12 vss.n230 1.6925
R189 vss.n230 vss.n13 0.5645
R190 vss.n13 vss.n14 0.5645
R191 vss.n14 vss.n15 0.5645
R192 vss.n15 vss.n16 0.5645
R193 vss.n16 vss.n17 0.5645
R194 vss.n17 vss.n18 0.5645
R195 vss.n18 vss.n19 0.5645
R196 vss.n231 vss.n230 12.2753
R197 vss.n19 vss.n20 22.1599
R198 vss.n21 vss.n22 272.562
R199 vss.n20 vss.n21 292.5
R200 vss.n24 vss.n23 23.4005
R201 vss.n20 vss.n24 396.8
R202 vss.t1 vss.n25 292.5
R203 vss.n25 vss.n26 292.5
R204 vss.n26 vss.n24 401.695
R205 vss.n228 vss.n227 23.4005
R206 vss.n229 vss.n228 23.4005
R207 vss.n229 vss.n26 401.695
R208 vss.n20 vss.n229 396.8
R209 vss.n228 vss.n21 6182.32
R210 vss.n22 vss.n23 148.852
R211 vss.n228 vss.n25 6182.32
R212 vss.n25 vss.n23 6182.32
R213 vss.t18 vss.n27 292.5
R214 vss.n27 vss.n28 292.5
R215 vss.n30 vss.n29 45.0005
R216 vss.n31 vss.n30 45.0005
R217 vss.t18 vss.n32 292.5
R218 vss.n33 vss.n32 292.5
R219 vss.n35 vss.n34 45.0005
R220 vss.n36 vss.n35 45.0005
R221 vss.t2 vss.n37 292.5
R222 vss.n38 vss.n37 292.5
R223 vss.n40 vss.n39 83.5719
R224 vss.n41 vss.n40 83.5719
R225 vss.t2 vss.n42 292.5
R226 vss.n43 vss.n42 292.5
R227 vss.n45 vss.n44 83.5719
R228 vss.n46 vss.n45 83.5719
R229 vss.t20 vss.n47 292.5
R230 vss.n48 vss.n47 292.5
R231 vss.n50 vss.n49 146.25
R232 vss.n51 vss.n50 146.25
R233 vss.t20 vss.n52 292.5
R234 vss.n53 vss.n52 292.5
R235 vss.n55 vss.n54 146.25
R236 vss.n56 vss.n55 146.25
R237 vss.t11 vss.n57 117.001
R238 vss.n57 vss.n58 117.001
R239 vss.n59 vss.n60 195
R240 vss.n61 vss.n60 195
R241 vss.n62 vss.t11 117.001
R242 vss.n63 vss.n62 117.001
R243 vss.n64 vss.n65 195
R244 vss.n66 vss.n65 195
R245 vss.t12 vss.n67 117.001
R246 vss.n67 vss.n68 117.001
R247 vss.n69 vss.n70 146.25
R248 vss.n71 vss.n70 146.25
R249 vss.n72 vss.t12 117.001
R250 vss.n73 vss.n72 117.001
R251 vss.n74 vss.n75 146.25
R252 vss.n76 vss.n75 146.25
R253 vss.t13 vss.n77 117.001
R254 vss.n77 vss.n78 117.001
R255 vss.n80 vss.n79 97.5005
R256 vss.n81 vss.n80 97.5005
R257 vss.n82 vss.t13 117.001
R258 vss.n83 vss.n82 117.001
R259 vss.n85 vss.n84 97.5005
R260 vss.n86 vss.n85 97.5005
R261 vss.t14 vss.n87 117.001
R262 vss.n87 vss.n88 117.001
R263 vss.n90 vss.n89 53.1823
R264 vss.n91 vss.n90 53.1823
R265 vss.n92 vss.t14 117.001
R266 vss.n93 vss.n92 117.001
R267 vss.n95 vss.n94 53.1823
R268 vss.n96 vss.n95 53.1823
R269 vss.t11 vss.n64 209.689
R270 vss.t11 vss.n59 209.689
R271 vss.n59 vss.n54 482.37
R272 vss.n54 vss.t20 136.34
R273 vss.t20 vss.n49 136.34
R274 vss.n49 vss.n74 482.37
R275 vss.t12 vss.n74 209.689
R276 vss.t12 vss.n69 209.689
R277 vss.n69 vss.n44 482.37
R278 vss.n44 vss.t2 136.34
R279 vss.n39 vss.t2 136.34
R280 vss.n39 vss.n84 482.37
R281 vss.n84 vss.t13 209.689
R282 vss.t13 vss.n79 209.689
R283 vss.n79 vss.n34 482.37
R284 vss.n34 vss.t18 136.34
R285 vss.n29 vss.t18 136.34
R286 vss.n29 vss.n94 482.37
R287 vss.n94 vss.t14 209.689
R288 vss.t14 vss.n89 209.689
R289 vss.n89 vss.n227 482.37
R290 vss.n227 vss.t1 136.34
R291 vss.n22 vss.t1 7.04353
R292 vss.t16 vss.n97 292.5
R293 vss.n97 vss.n98 292.5
R294 vss.n100 vss.n99 26.5914
R295 vss.n101 vss.n100 26.5914
R296 vss.t16 vss.n102 292.5
R297 vss.n103 vss.n102 292.5
R298 vss.n105 vss.n104 26.5914
R299 vss.n106 vss.n105 26.5914
R300 vss.t8 vss.n107 292.5
R301 vss.n108 vss.n107 292.5
R302 vss.n110 vss.n109 58.5005
R303 vss.n111 vss.n110 58.5005
R304 vss.t8 vss.n112 292.5
R305 vss.n113 vss.n112 292.5
R306 vss.n115 vss.n114 58.5005
R307 vss.n116 vss.n115 58.5005
R308 vss.t15 vss.n117 292.5
R309 vss.n118 vss.n117 292.5
R310 vss.n120 vss.n119 146.25
R311 vss.n121 vss.n120 146.25
R312 vss.t15 vss.n122 292.5
R313 vss.n123 vss.n122 292.5
R314 vss.n125 vss.n124 146.25
R315 vss.n126 vss.n125 146.25
R316 vss.t10 vss.n127 292.5
R317 vss.n128 vss.n127 292.5
R318 vss.n130 vss.n129 58.5005
R319 vss.n131 vss.n130 58.5005
R320 vss.t10 vss.n132 292.5
R321 vss.n133 vss.n132 292.5
R322 vss.n135 vss.n134 58.5005
R323 vss.n136 vss.n135 58.5005
R324 vss.t21 vss.n137 292.5
R325 vss.n138 vss.n137 292.5
R326 vss.n140 vss.n139 146.25
R327 vss.n141 vss.n140 146.25
R328 vss.t21 vss.n142 292.5
R329 vss.n143 vss.n142 292.5
R330 vss.n145 vss.n144 146.25
R331 vss.n146 vss.n145 146.25
R332 vss.n124 vss.t15 136.34
R333 vss.n119 vss.t15 136.34
R334 vss.n119 vss.n114 555.717
R335 vss.n114 vss.t8 136.34
R336 vss.t8 vss.n109 136.34
R337 vss.n109 vss.n104 555.717
R338 vss.n104 vss.t16 136.34
R339 vss.n99 vss.t16 136.34
R340 vss.n99 vss.n134 555.717
R341 vss.n134 vss.t10 136.34
R342 vss.n129 vss.t10 136.34
R343 vss.n129 vss.n144 555.717
R344 vss.n144 vss.t21 136.34
R345 vss.n139 vss.t21 136.34
R346 vss.t3 vss.n147 292.5
R347 vss.n147 vss.n148 292.5
R348 vss.n150 vss.n149 23.4005
R349 vss.n151 vss.n150 23.4005
R350 vss.n152 vss.t3 7.04353
R351 vss.n154 vss.n153 292.5
R352 vss.n156 vss.n155 23.4005
R353 vss.t9 vss.n157 292.5
R354 vss.n157 vss.n158 292.5
R355 vss.n160 vss.n159 45.0005
R356 vss.n161 vss.n160 45.0005
R357 vss.t9 vss.n162 292.5
R358 vss.n163 vss.n162 292.5
R359 vss.n165 vss.n164 45.0005
R360 vss.n166 vss.n165 45.0005
R361 vss.t4 vss.n167 117.001
R362 vss.n167 vss.n168 117.001
R363 vss.n170 vss.n169 53.1823
R364 vss.n171 vss.n170 53.1823
R365 vss.n172 vss.t4 117.001
R366 vss.n173 vss.n172 117.001
R367 vss.n175 vss.n174 53.1823
R368 vss.n176 vss.n175 53.1823
R369 vss.t5 vss.n177 117.001
R370 vss.n177 vss.n178 117.001
R371 vss.n180 vss.n179 97.5005
R372 vss.n181 vss.n180 97.5005
R373 vss.n182 vss.t5 117.001
R374 vss.n183 vss.n182 117.001
R375 vss.n185 vss.n184 97.5005
R376 vss.n186 vss.n185 97.5005
R377 vss.t19 vss.n187 292.5
R378 vss.n188 vss.n187 292.5
R379 vss.n190 vss.n189 83.5719
R380 vss.n191 vss.n190 83.5719
R381 vss.t19 vss.n192 292.5
R382 vss.n193 vss.n192 292.5
R383 vss.n195 vss.n194 83.5719
R384 vss.n196 vss.n195 83.5719
R385 vss.t6 vss.n197 117.001
R386 vss.n197 vss.n198 117.001
R387 vss.n199 vss.n200 146.25
R388 vss.n201 vss.n200 146.25
R389 vss.n202 vss.t6 117.001
R390 vss.n203 vss.n202 117.001
R391 vss.n204 vss.n205 146.25
R392 vss.n206 vss.n205 146.25
R393 vss.t0 vss.n207 292.5
R394 vss.n208 vss.n207 292.5
R395 vss.n210 vss.n209 146.25
R396 vss.n211 vss.n210 146.25
R397 vss.t0 vss.n212 292.5
R398 vss.n213 vss.n212 292.5
R399 vss.n215 vss.n214 146.25
R400 vss.n216 vss.n215 146.25
R401 vss.t7 vss.n217 117.001
R402 vss.n217 vss.n218 117.001
R403 vss.n219 vss.n220 195
R404 vss.n221 vss.n220 195
R405 vss.n222 vss.t7 117.001
R406 vss.n223 vss.n222 117.001
R407 vss.n224 vss.n225 195
R408 vss.n226 vss.n225 195
R409 vss.n155 vss.n152 148.852
R410 vss.t3 vss.n149 136.34
R411 vss.n149 vss.n174 482.37
R412 vss.n174 vss.t4 209.689
R413 vss.t4 vss.n169 209.689
R414 vss.n169 vss.n164 482.37
R415 vss.n164 vss.t9 136.34
R416 vss.n159 vss.t9 136.34
R417 vss.n159 vss.n184 482.37
R418 vss.n184 vss.t5 209.689
R419 vss.t5 vss.n179 209.689
R420 vss.n179 vss.n194 482.37
R421 vss.n194 vss.t19 136.34
R422 vss.t19 vss.n189 136.34
R423 vss.n189 vss.n204 482.37
R424 vss.t6 vss.n204 209.689
R425 vss.t6 vss.n199 209.689
R426 vss.n199 vss.n214 482.37
R427 vss.n214 vss.t0 136.34
R428 vss.t0 vss.n209 136.34
R429 vss.n209 vss.n224 482.37
R430 vss.t7 vss.n224 209.689
R431 vss.t7 vss.n219 209.689
R432 vss.n219 vss.n124 1521.79
R433 vss.n223 vss.n226 143.435
R434 vss.n223 vss.n221 143.435
R435 vss.n226 vss.n218 148.329
R436 vss.n221 vss.n218 148.329
R437 vss.n6 vss.n223 20.2799
R438 vss.n225 vss.n222 2282.88
R439 vss.n222 vss.n220 2282.88
R440 vss.n225 vss.n217 2282.88
R441 vss.n217 vss.n220 2282.88
R442 vss.n213 vss.n216 133.272
R443 vss.n213 vss.n211 133.272
R444 vss.n216 vss.n208 138.166
R445 vss.n211 vss.n208 138.166
R446 vss.n5 vss.n213 20.3806
R447 vss.n215 vss.n212 2126.44
R448 vss.n212 vss.n210 2126.44
R449 vss.n215 vss.n207 2126.44
R450 vss.n207 vss.n210 2126.44
R451 vss.n203 vss.n206 159.248
R452 vss.n203 vss.n201 159.248
R453 vss.n206 vss.n198 164.142
R454 vss.n201 vss.n198 164.142
R455 vss.n4 vss.n203 20.3529
R456 vss.n205 vss.n202 2526.24
R457 vss.n202 vss.n200 2526.24
R458 vss.n205 vss.n197 2526.24
R459 vss.n197 vss.n200 2526.24
R460 vss.n193 vss.n196 170.918
R461 vss.n193 vss.n191 170.918
R462 vss.n196 vss.n188 175.812
R463 vss.n191 vss.n188 175.812
R464 vss.n3 vss.n193 20.5542
R465 vss.n195 vss.n192 2705.85
R466 vss.n192 vss.n190 2705.85
R467 vss.n195 vss.n187 2705.85
R468 vss.n187 vss.n190 2705.85
R469 vss.n183 vss.n186 190.871
R470 vss.n183 vss.n181 190.871
R471 vss.n186 vss.n178 195.766
R472 vss.n178 vss.n181 195.766
R473 vss.n2 vss.n183 20.4987
R474 vss.n185 vss.n182 3012.94
R475 vss.n182 vss.n180 3012.94
R476 vss.n185 vss.n177 3012.94
R477 vss.n177 vss.n180 3012.94
R478 vss.n173 vss.n176 254.119
R479 vss.n173 vss.n171 254.119
R480 vss.n176 vss.n168 259.012
R481 vss.n168 vss.n171 259.012
R482 vss.n0 vss.n173 20.7904
R483 vss.n175 vss.n172 3986.35
R484 vss.n172 vss.n170 3986.35
R485 vss.n175 vss.n167 3986.35
R486 vss.n167 vss.n170 3986.35
R487 vss.n163 vss.n166 246.213
R488 vss.n163 vss.n161 246.213
R489 vss.n166 vss.n158 251.107
R490 vss.n161 vss.n158 251.107
R491 vss.n1 vss.n163 20.9015
R492 vss.n165 vss.n162 3864.68
R493 vss.n162 vss.n160 3864.68
R494 vss.n165 vss.n157 3864.68
R495 vss.n157 vss.n160 3864.68
R496 vss.n154 vss.n156 396.8
R497 vss.n154 vss.n151 396.8
R498 vss.n156 vss.n148 401.695
R499 vss.n148 vss.n151 401.695
R500 vss.n0 vss.n154 22.1599
R501 vss.n153 vss.n152 272.562
R502 vss.n153 vss.n150 6182.32
R503 vss.n155 vss.n147 6182.32
R504 vss.n147 vss.n150 6182.32
R505 vss.n143 vss.n146 133.272
R506 vss.n143 vss.n141 133.272
R507 vss.n146 vss.n138 138.166
R508 vss.n138 vss.n141 138.166
R509 vss.n12 vss.n143 20.3806
R510 vss.n145 vss.n142 2126.44
R511 vss.n142 vss.n140 2126.44
R512 vss.n145 vss.n137 2126.44
R513 vss.n137 vss.n140 2126.44
R514 vss.n133 vss.n136 208.565
R515 vss.n133 vss.n131 208.565
R516 vss.n136 vss.n128 213.459
R517 vss.n131 vss.n128 213.459
R518 vss.n11 vss.n133 20.7279
R519 vss.n135 vss.n132 3285.26
R520 vss.n132 vss.n130 3285.26
R521 vss.n135 vss.n127 3285.26
R522 vss.n127 vss.n130 3285.26
R523 vss.n123 vss.n126 133.272
R524 vss.n123 vss.n121 133.272
R525 vss.n126 vss.n118 138.166
R526 vss.n118 vss.n121 138.166
R527 vss.n7 vss.n123 20.3806
R528 vss.n125 vss.n122 2126.44
R529 vss.n122 vss.n120 2126.44
R530 vss.n125 vss.n117 2126.44
R531 vss.n117 vss.n120 2126.44
R532 vss.n113 vss.n116 208.565
R533 vss.n113 vss.n111 208.565
R534 vss.n116 vss.n108 213.459
R535 vss.n111 vss.n108 213.459
R536 vss.n8 vss.n113 20.7279
R537 vss.n115 vss.n112 3285.26
R538 vss.n112 vss.n110 3285.26
R539 vss.n115 vss.n107 3285.26
R540 vss.n107 vss.n110 3285.26
R541 vss.n103 vss.n106 359.154
R542 vss.n103 vss.n101 359.154
R543 vss.n106 vss.n98 364.048
R544 vss.n98 vss.n101 364.048
R545 vss.n9 vss.n103 21.4223
R546 vss.n105 vss.n102 5602.91
R547 vss.n102 vss.n100 5602.91
R548 vss.n105 vss.n97 5602.91
R549 vss.n97 vss.n100 5602.91
R550 vss.n139 vss.n64 1521.79
R551 vss.n93 vss.n96 254.119
R552 vss.n93 vss.n91 254.119
R553 vss.n96 vss.n88 259.012
R554 vss.n88 vss.n91 259.012
R555 vss.n19 vss.n93 20.7904
R556 vss.n95 vss.n92 3986.35
R557 vss.n92 vss.n90 3986.35
R558 vss.n95 vss.n87 3986.35
R559 vss.n87 vss.n90 3986.35
R560 vss.n83 vss.n86 190.871
R561 vss.n83 vss.n81 190.871
R562 vss.n86 vss.n78 195.766
R563 vss.n78 vss.n81 195.766
R564 vss.n17 vss.n83 20.4987
R565 vss.n85 vss.n82 3012.94
R566 vss.n82 vss.n80 3012.94
R567 vss.n85 vss.n77 3012.94
R568 vss.n77 vss.n80 3012.94
R569 vss.n73 vss.n76 159.248
R570 vss.n73 vss.n71 159.248
R571 vss.n76 vss.n68 164.142
R572 vss.n71 vss.n68 164.142
R573 vss.n15 vss.n73 20.3529
R574 vss.n75 vss.n72 2526.24
R575 vss.n72 vss.n70 2526.24
R576 vss.n75 vss.n67 2526.24
R577 vss.n67 vss.n70 2526.24
R578 vss.n63 vss.n66 143.435
R579 vss.n63 vss.n61 143.435
R580 vss.n66 vss.n58 148.329
R581 vss.n58 vss.n61 148.329
R582 vss.n13 vss.n63 20.2799
R583 vss.n65 vss.n62 2282.88
R584 vss.n62 vss.n60 2282.88
R585 vss.n65 vss.n57 2282.88
R586 vss.n57 vss.n60 2282.88
R587 vss.n53 vss.n56 133.272
R588 vss.n53 vss.n51 133.272
R589 vss.n56 vss.n48 138.166
R590 vss.n51 vss.n48 138.166
R591 vss.n14 vss.n53 20.3806
R592 vss.n55 vss.n52 2126.44
R593 vss.n52 vss.n50 2126.44
R594 vss.n55 vss.n47 2126.44
R595 vss.n47 vss.n50 2126.44
R596 vss.n43 vss.n46 170.918
R597 vss.n43 vss.n41 170.918
R598 vss.n46 vss.n38 175.812
R599 vss.n41 vss.n38 175.812
R600 vss.n16 vss.n43 20.5542
R601 vss.n45 vss.n42 2705.85
R602 vss.n42 vss.n40 2705.85
R603 vss.n45 vss.n37 2705.85
R604 vss.n37 vss.n40 2705.85
R605 vss.n33 vss.n36 246.213
R606 vss.n33 vss.n31 246.213
R607 vss.n36 vss.n28 251.107
R608 vss.n31 vss.n28 251.107
R609 vss.n18 vss.n33 20.9015
R610 vss.n35 vss.n32 3864.68
R611 vss.n32 vss.n30 3864.68
R612 vss.n35 vss.n27 3864.68
R613 vss.n27 vss.n30 3864.68
R614 vss.n10 vss.t17 22.5437
R615 sn3.t0 sn3 25.2481
R616 sn3 sn3.t1 39.0479
R617 sn2.t1 sn2 36.3427
R618 sn2 sn2.t0 63.7404
R619 sn1.t0 sn1 55.4447
R620 sn1 sn1.t1 131.644
R621 sn0.t1 sn0 97.4902
R622 sn0 sn0.t0 249.232
R623 xn.t0 xn.n0 41.8461
R624 xn.n1 xn.n0 1.3635
R625 xn.n2 xn.n1 1.1285
R626 xn xn.n2 0.2825
R627 xn xn.n3 0.8465
R628 xn.n3 xn.n4 1.1285
R629 xn.n4 xn.t4 36.9987
R630 xn.n4 xn.t1 60.8409
R631 xn.n3 xn.t2 129.024
R632 xn.n2 xn.t3 246.887
R633 xn.n1 xn.t5 239.654
R634 xn.n0 xn.t6 95.1463
R635 sp0 sp0.t0 97.4902
R636 sp0 sp0.t1 249.232
R637 sp1 sp1.t1 55.4447
R638 sp1 sp1.t0 131.644
R639 sp2 sp2.t1 36.3427
R640 sp2 sp2.t0 63.7404
R641 xp.n4 xp.t0 41.8461
R642 xp.n1 xp.n0 1.1285
R643 xp xp.n1 0.8465
R644 xp xp.n2 0.2825
R645 xp.n2 xp.n3 1.1285
R646 xp.n3 xp.n4 1.3635
R647 xp.n4 xp.t5 95.1463
R648 xp.n3 xp.t6 239.654
R649 xp.n2 xp.t2 246.887
R650 xp.n1 xp.t4 129.024
R651 xp.n0 xp.t3 60.8409
R652 xp.n0 xp.t1 36.9987
R653 tail.n8 tail.t1 22.921
R654 tail.n1 tail.n0 1.1285
R655 tail.n2 tail.n1 1.1285
R656 tail.n3 tail.n2 3.3845
R657 tail.n4 tail.n3 0.3295
R658 tail tail.n4 0.118
R659 tail tail.n5 0.447
R660 tail.n5 tail.n6 3.3845
R661 tail.n6 tail.n7 1.1285
R662 tail.n7 tail.n8 1.1285
R663 tail.n8 tail.t8 33.1655
R664 tail.n7 tail.t2 52.5452
R665 tail.n6 tail.t10 94.8685
R666 tail.n5 tail.t6 41.2393
R667 tail.n4 tail.t7 23.377
R668 tail.n3 tail.t4 41.2393
R669 tail.n2 tail.t0 94.8685
R670 tail.n1 tail.t9 52.5452
R671 tail.n0 tail.t5 33.1655
R672 tail.n0 tail.t3 22.921
R673 sp3 sp3.t0 25.2481
R674 sp3 sp3.t1 39.0479
C110 tn3 vss 1.11657f
C111 tn2 vss 1.10558f
C112 tn1 vss 1.08935f
C113 tn0 vss 1.06611f
C114 vinn vss 8.15734f
C115 qn vss 9.15569f
C116 qp vss 9.14384f
C117 clk vss 4.04464f
C118 tp0 vss 1.06647f
C119 tp1 vss 1.08899f
C120 tp2 vss 1.10555f
C121 vinp vss 8.15576f
C122 tp3 vss 1.11657f
C123 vdd vss 14.601f
C124 sn3 vss 4.97436f ; **FLOATING
C125 sn2 vss 4.23775f ; **FLOATING
C126 sn1 vss 3.91777f ; **FLOATING
C127 sn0 vss 3.87735f ; **FLOATING
C128 xn vss 7.00255f ; **FLOATING
C129 sp0 vss 3.87752f ; **FLOATING
C130 sp1 vss 3.91777f ; **FLOATING
C131 sp2 vss 4.23775f ; **FLOATING
C132 xp vss 7.0031f ; **FLOATING
C133 tail vss 13.59159f ; **FLOATING
C134 sp3 vss 4.97436f ; **FLOATING
C135 sp3.t0 vss 0.59673f ; **FLOATING
C136 sp3.t1 vss 0.25709f ; **FLOATING
C137 tail.t1 vss 0.74913f ; **FLOATING
C138 tail.t3 vss 0.74913f ; **FLOATING
C139 tail.t5 vss 0.32604f ; **FLOATING
C140 tail.n0 vss 2.10496f ; **FLOATING
C141 tail.t9 vss 0.15779f ; **FLOATING
C142 tail.n1 vss 1.15089f ; **FLOATING
C143 tail.t0 vss 0.07596f ; **FLOATING
C144 tail.n2 vss 1.7042f ; **FLOATING
C145 tail.t4 vss 0.23668f ; **FLOATING
C146 tail.n3 vss 1.54648f ; **FLOATING
C147 tail.t7 vss 0.6058f ; **FLOATING
C148 tail.n4 vss 0.75826f ; **FLOATING
C149 tail.t6 vss 0.23668f ; **FLOATING
C150 tail.n5 vss 1.57641f ; **FLOATING
C151 tail.t10 vss 0.07596f ; **FLOATING
C152 tail.n6 vss 1.7042f ; **FLOATING
C153 tail.t2 vss 0.15779f ; **FLOATING
C154 tail.n7 vss 1.15089f ; **FLOATING
C155 tail.t8 vss 0.32604f ; **FLOATING
C156 tail.n8 vss 2.10496f ; **FLOATING
C157 xp.t0 vss 0.24801f ; **FLOATING
C158 xp.t1 vss 0.30172f ; **FLOATING
C159 xp.t3 vss 0.13028f ; **FLOATING
C160 xp.n0 vss 2.04818f ; **FLOATING
C161 xp.t4 vss 0.05919f ; **FLOATING
C162 xp.n1 vss 1.06824f ; **FLOATING
C163 xp.t2 vss 0.02901f ; **FLOATING
C164 xp.n2 vss 0.91297f ; **FLOATING
C165 xp.t6 vss 0.05564f ; **FLOATING
C166 xp.n3 vss 1.2428f ; **FLOATING
C167 xp.t5 vss 0.07847f ; **FLOATING
C168 xp.n4 vss 1.74836f ; **FLOATING
C169 sp2.t1 vss 0.34142f ; **FLOATING
C170 sp2.t0 vss 0.1463f ; **FLOATING
C171 sp1.t1 vss 0.17497f ; **FLOATING
C172 sp1.t0 vss 0.06588f ; **FLOATING
C173 sp0.t0 vss 0.09605f ; **FLOATING
C174 sp0.t1 vss 0.03579f ; **FLOATING
C175 xn.t0 vss 0.248f ; **FLOATING
C176 xn.t6 vss 0.07847f ; **FLOATING
C177 xn.n0 vss 1.74832f ; **FLOATING
C178 xn.t5 vss 0.05564f ; **FLOATING
C179 xn.n1 vss 1.24277f ; **FLOATING
C180 xn.t3 vss 0.02901f ; **FLOATING
C181 xn.n2 vss 0.91294f ; **FLOATING
C182 xn.t2 vss 0.05919f ; **FLOATING
C183 xn.n3 vss 1.06821f ; **FLOATING
C184 xn.t1 vss 0.13027f ; **FLOATING
C185 xn.n4 vss 2.04814f ; **FLOATING
C186 xn.t4 vss 0.30171f ; **FLOATING
C187 sn0.t1 vss 0.09606f ; **FLOATING
C188 sn0.t0 vss 0.0358f ; **FLOATING
C189 sn1.t0 vss 0.17497f ; **FLOATING
C190 sn1.t1 vss 0.06588f ; **FLOATING
C191 sn2.t1 vss 0.34142f ; **FLOATING
C192 sn2.t0 vss 0.1463f ; **FLOATING
C193 sn3.t0 vss 0.59673f ; **FLOATING
C194 sn3.t1 vss 0.25709f ; **FLOATING
C195 vdd.n0 vss 0.12291f ; **FLOATING
C196 vdd.n1 vss 0.02577f ; **FLOATING
C197 vdd.n3 vss 0.14894f ; **FLOATING
C198 vdd.n4 vss 0.02504f ; **FLOATING
C199 vdd.t4 vss 0.21694f ; **FLOATING
C200 vdd.n6 vss 0.02577f ; **FLOATING
C201 vdd.n7 vss 0.02577f ; **FLOATING
C202 vdd.n8 vss 0.14894f ; **FLOATING
C203 vdd.n9 vss 0.02504f ; **FLOATING
C204 vdd.t5 vss 0.02709f ; **FLOATING
C205 vdd.n10 vss 0.59282f ; **FLOATING
C206 vdd.n11 vss 0.11842f ; **FLOATING
C207 vdd.n12 vss 0.02577f ; **FLOATING
C208 vdd.n14 vss 0.14894f ; **FLOATING
C209 vdd.n15 vss 0.02504f ; **FLOATING
C210 vdd.t6 vss 0.21694f ; **FLOATING
C211 vdd.n17 vss 0.02577f ; **FLOATING
C212 vdd.n18 vss 0.02577f ; **FLOATING
C213 vdd.n19 vss 0.14894f ; **FLOATING
C214 vdd.n20 vss 0.02504f ; **FLOATING
C215 vdd.n21 vss 0.28325f ; **FLOATING
C216 vdd.t7 vss 0.02709f ; **FLOATING
C217 vdd.n22 vss 0.32954f ; **FLOATING
C218 vdd.n23 vss 0.12926f ; **FLOATING
C219 vdd.n24 vss 0.03255f ; **FLOATING
C220 vdd.n26 vss 0.20466f ; **FLOATING
C221 vdd.n27 vss 0.03141f ; **FLOATING
C222 vdd.t0 vss 0.28162f ; **FLOATING
C223 vdd.n29 vss 0.03255f ; **FLOATING
C224 vdd.n30 vss 0.03255f ; **FLOATING
C225 vdd.n31 vss 0.20466f ; **FLOATING
C226 vdd.n32 vss 0.03141f ; **FLOATING
C227 vdd.n33 vss 0.29315f ; **FLOATING
C228 vdd.t1 vss 0.05636f ; **FLOATING
C229 vdd.n34 vss 0.53332f ; **FLOATING
C230 vdd.t11 vss 0.05636f ; **FLOATING
C231 vdd.n35 vss 0.53332f ; **FLOATING
C232 vdd.n36 vss 0.12926f ; **FLOATING
C233 vdd.n37 vss 0.03255f ; **FLOATING
C234 vdd.n39 vss 0.20466f ; **FLOATING
C235 vdd.n40 vss 0.03141f ; **FLOATING
C236 vdd.t10 vss 0.28162f ; **FLOATING
C237 vdd.n42 vss 0.03255f ; **FLOATING
C238 vdd.n43 vss 0.03255f ; **FLOATING
C239 vdd.n44 vss 0.20466f ; **FLOATING
C240 vdd.n45 vss 0.03141f ; **FLOATING
C241 vdd.n46 vss 0.29315f ; **FLOATING
C242 vdd.t3 vss 0.02709f ; **FLOATING
C243 vdd.n47 vss 0.32954f ; **FLOATING
C244 vdd.n48 vss 0.11842f ; **FLOATING
C245 vdd.n49 vss 0.02577f ; **FLOATING
C246 vdd.n51 vss 0.14894f ; **FLOATING
C247 vdd.n52 vss 0.02504f ; **FLOATING
C248 vdd.t2 vss 0.21694f ; **FLOATING
C249 vdd.n54 vss 0.02577f ; **FLOATING
C250 vdd.n55 vss 0.02577f ; **FLOATING
C251 vdd.n56 vss 0.14894f ; **FLOATING
C252 vdd.n57 vss 0.02504f ; **FLOATING
C253 vdd.n58 vss 0.28325f ; **FLOATING
C254 vdd.t9 vss 0.02709f ; **FLOATING
C255 vdd.n59 vss 0.59282f ; **FLOATING
C256 vdd.n60 vss 0.12291f ; **FLOATING
C257 vdd.n61 vss 0.02577f ; **FLOATING
C258 vdd.n63 vss 0.14894f ; **FLOATING
C259 vdd.n64 vss 0.02504f ; **FLOATING
C260 vdd.t8 vss 0.21694f ; **FLOATING
C261 vdd.n66 vss 0.02577f ; **FLOATING
C262 vdd.n67 vss 0.02577f ; **FLOATING
C263 vdd.n68 vss 0.14894f ; **FLOATING
C264 vdd.n69 vss 0.02504f ; **FLOATING
C265 tp3.n0 vss 0.72559f ; **FLOATING
C266 tp3.t0 vss 0.11094f ; **FLOATING
C267 vinp.t4 vss 0.40074f ; **FLOATING
C268 vinp.t3 vss 0.2489f ; **FLOATING
C269 vinp.n0 vss 1.85417f ; **FLOATING
C270 vinp.t2 vss 0.1742f ; **FLOATING
C271 vinp.n1 vss 0.96782f ; **FLOATING
C272 vinp.t1 vss 0.13633f ; **FLOATING
C273 vinp.n2 vss 2.28322f ; **FLOATING
C274 vinp.t0 vss 0.05665f ; **FLOATING
C275 tp2.n0 vss 0.93238f ; **FLOATING
C276 tp2.t0 vss 0.07732f ; **FLOATING
C277 tp1.n0 vss 0.92807f ; **FLOATING
C278 tp1.t0 vss 0.04932f ; **FLOATING
C279 tp0.n0 vss 0.89811f ; **FLOATING
C280 tp0.t0 vss 0.03664f ; **FLOATING
C281 clk.n0 vss 0.50534f ; **FLOATING
C282 clk.t2 vss 0.21546f ; **FLOATING
C283 clk.t4 vss 0.06349f ; **FLOATING
C284 clk.t3 vss 0.06213f ; **FLOATING
C285 clk.n1 vss 2.87174f ; **FLOATING
C286 clk.t1 vss 0.06213f ; **FLOATING
C287 clk.n2 vss 2.87174f ; **FLOATING
C288 clk.t0 vss 0.06349f ; **FLOATING
C289 qp.t0 vss 0.05037f ; **FLOATING
C290 qp.t4 vss 0.04125f ; **FLOATING
C291 qp.n0 vss 1.71636f ; **FLOATING
C292 qp.t3 vss 0.03137f ; **FLOATING
C293 qp.n1 vss 0.8489f ; **FLOATING
C294 qp.t2 vss 0.06797f ; **FLOATING
C295 qp.n2 vss 2.12441f ; **FLOATING
C296 qp.t1 vss 0.10028f ; **FLOATING
C297 qn.t0 vss 0.1027f ; **FLOATING
C298 qn.t1 vss 0.07098f ; **FLOATING
C299 qn.n0 vss 2.11609f ; **FLOATING
C300 qn.t4 vss 0.032f ; **FLOATING
C301 qn.n1 vss 0.84724f ; **FLOATING
C302 qn.t3 vss 0.04165f ; **FLOATING
C303 qn.n2 vss 1.71262f ; **FLOATING
C304 qn.t2 vss 0.05157f ; **FLOATING
C305 vinn.t4 vss 0.05663f ; **FLOATING
C306 vinn.t3 vss 0.13626f ; **FLOATING
C307 vinn.n0 vss 2.28214f ; **FLOATING
C308 vinn.t2 vss 0.17411f ; **FLOATING
C309 vinn.n1 vss 0.96736f ; **FLOATING
C310 vinn.t1 vss 0.24878f ; **FLOATING
C311 vinn.n2 vss 1.8533f ; **FLOATING
C312 vinn.t0 vss 0.40055f ; **FLOATING
C313 tn0.n0 vss 0.89818f ; **FLOATING
C314 tn0.t0 vss 0.03664f ; **FLOATING
C315 tn1.n0 vss 0.92803f ; **FLOATING
C316 tn1.t0 vss 0.04931f ; **FLOATING
C317 tn2.n0 vss 0.93238f ; **FLOATING
C318 tn2.t0 vss 0.07732f ; **FLOATING
C319 tn3.n0 vss 0.72559f ; **FLOATING
C320 tn3.t0 vss 0.11094f ; **FLOATING
.ends
