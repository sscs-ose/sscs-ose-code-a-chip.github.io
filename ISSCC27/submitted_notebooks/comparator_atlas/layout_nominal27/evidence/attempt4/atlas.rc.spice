* NGSPICE file created from atlas.ext - technology: sky130A

.subckt atlas vinp vinn clk vdd vss qp qn tp0 tp1 tp2 tp3 tn0 tn1 tn2 tn3
X0 vdd.t5 clk.t4 qp.t0 vdd.t4 sky130_fd_pr__pfet_01v8 ad=0.29 pd=2.58 as=0.29 ps=2.58 w=1 l=0.15
X1 vss.t17 clk.t2 tail.t7 vss.t16 sky130_fd_pr__nfet_01v8 ad=2.03 pd=14.58 as=2.03 ps=14.58 w=7 l=0.15
X2 xn.t3 vinn.t3 sn0.t0 vss.t11 sky130_fd_pr__nfet_01v8_lvt ad=0.1218 pd=1.42 as=0.1218 ps=1.42 w=0.42 l=1
X3 tail.t9 tp1.t0 sp1.t1 vss.t19 sky130_fd_pr__nfet_01v8 ad=0.58 pd=4.58 as=0.58 ps=4.58 w=2 l=0.15
X4 qp.t1 qn.t3 vdd.t11 vdd.t10 sky130_fd_pr__pfet_01v8 ad=0.58 pd=4.58 as=0.58 ps=4.58 w=2 l=0.15
X5 xn.t0 vinn.t4 tail.t6 vss.t10 sky130_fd_pr__nfet_01v8_lvt ad=0.87 pd=6.58 as=0.87 ps=6.58 w=3 l=0.15
X6 tail.t3 tp3.t0 sp3.t0 vss.t3 sky130_fd_pr__nfet_01v8 ad=2.32 pd=16.58 as=2.32 ps=16.58 w=8 l=0.15
X7 sp0.t1 vinp.t1 xp.t2 vss.t7 sky130_fd_pr__nfet_01v8_lvt ad=0.1218 pd=1.42 as=0.1218 ps=1.42 w=0.42 l=1
X8 sp1.t0 vinp.t2 xp.t4 vss.t6 sky130_fd_pr__nfet_01v8_lvt ad=0.2436 pd=2.26 as=0.2436 ps=2.26 w=0.84 l=1
X9 tail.t4 vinp.t0 xp.t0 vss.t8 sky130_fd_pr__nfet_01v8_lvt ad=0.87 pd=6.58 as=0.87 ps=6.58 w=3 l=0.15
X10 sn2.t1 tn2.t0 tail.t8 vss.t18 sky130_fd_pr__nfet_01v8 ad=1.16 pd=8.58 as=1.16 ps=8.58 w=4 l=0.15
X11 sp3.t1 vinp.t4 xp.t1 vss.t4 sky130_fd_pr__nfet_01v8_lvt ad=0.9744 pd=7.3 as=0.9744 ps=7.3 w=3.36 l=1
X12 vdd.t1 qp.t4 qn.t0 vdd.t0 sky130_fd_pr__pfet_01v8 ad=0.58 pd=4.58 as=0.58 ps=4.58 w=2 l=0.15
X13 xn.t5 clk.t1 vdd.t3 vdd.t2 sky130_fd_pr__pfet_01v8 ad=0.29 pd=2.58 as=0.29 ps=2.58 w=1 l=0.15
X14 qp.t2 qn.t4 xn.t6 vss.t21 sky130_fd_pr__nfet_01v8 ad=0.29 pd=2.58 as=0.29 ps=2.58 w=1 l=0.15
X15 sn0.t1 tn0.t0 tail.t10 vss.t20 sky130_fd_pr__nfet_01v8 ad=0.29 pd=2.58 as=0.29 ps=2.58 w=1 l=0.15
X16 sp2.t0 vinp.t3 xp.t3 vss.t5 sky130_fd_pr__nfet_01v8_lvt ad=0.4872 pd=3.94 as=0.4872 ps=3.94 w=1.68 l=1
X17 sn3.t0 tn3.t0 tail.t1 vss.t1 sky130_fd_pr__nfet_01v8 ad=2.32 pd=16.58 as=2.32 ps=16.58 w=8 l=0.15
X18 xn.t2 vinn.t2 sn1.t1 vss.t12 sky130_fd_pr__nfet_01v8_lvt ad=0.2436 pd=2.26 as=0.2436 ps=2.26 w=0.84 l=1
X19 sn1.t0 tn1.t0 tail.t2 vss.t2 sky130_fd_pr__nfet_01v8 ad=0.58 pd=4.58 as=0.58 ps=4.58 w=2 l=0.15
X20 xn.t4 vinn.t0 sn3.t1 vss.t14 sky130_fd_pr__nfet_01v8_lvt ad=0.9744 pd=7.3 as=0.9744 ps=7.3 w=3.36 l=1
X21 vdd.t7 clk.t3 xp.t6 vdd.t6 sky130_fd_pr__pfet_01v8 ad=0.29 pd=2.58 as=0.29 ps=2.58 w=1 l=0.15
X22 qn.t1 clk.t0 vdd.t9 vdd.t8 sky130_fd_pr__pfet_01v8 ad=0.29 pd=2.58 as=0.29 ps=2.58 w=1 l=0.15
X23 xn.t1 vinn.t1 sn2.t0 vss.t13 sky130_fd_pr__nfet_01v8_lvt ad=0.4872 pd=3.94 as=0.4872 ps=3.94 w=1.68 l=1
X24 tail.t5 tp2.t0 sp2.t1 vss.t9 sky130_fd_pr__nfet_01v8 ad=1.16 pd=8.58 as=1.16 ps=8.58 w=4 l=0.15
X25 xp.t5 qp.t3 qn.t2 vss.t15 sky130_fd_pr__nfet_01v8 ad=0.29 pd=2.58 as=0.29 ps=2.58 w=1 l=0.15
X26 tail.t0 tp0.t0 sp0.t0 vss.t0 sky130_fd_pr__nfet_01v8 ad=0.29 pd=2.58 as=0.29 ps=2.58 w=1 l=0.15
C0 qp qn 0.81839f
C1 clk sn0 0
C2 sp3 tp3 0.3136f
C3 tn3 xn 0
C4 tail qn 0.20387f
C5 sn3 xn 0.20649f
C6 qp vinn 0.04992f
C7 tail sp3 0.78857f
C8 xp tp1 0.02154f
C9 tail vinn 0.1966f
C10 xp sp0 0.12677f
C11 clk sp0 0
C12 vdd xn 0.41183f
C13 sp2 tp1 0.00558f
C14 tail tp3 0.11566f
C15 tail qp 0.22301f
C16 sn1 tn1 0.2511f
C17 vinp qn 0.0489f
C18 xp vdd 0.41183f
C19 sp3 vinp 0.38933f
C20 sn0 qn 0.0431f
C21 clk vdd 3.9943f
C22 tn0 vinn 0.07648f
C23 sn0 vinn 0.58812f
C24 tp3 vinp 0.00945f
C25 xp tp0 0.0643f
C26 qp vinp 0.0647f
C27 tail vinp 0.19996f
C28 sn3 tn2 0.00557f
C29 tail sp1 0.31884f
C30 sn3 sn2 0.09503f
C31 sp0 qn 0
C32 qp sn0 0
C33 tail tn0 0.02986f
C34 tail sn0 0.22127f
C35 tn3 vinn 0.00945f
C36 tn1 xn 0.02154f
C37 sn3 vinn 0.38933f
C38 sn1 xn 0.15896f
C39 qp sp0 0.04232f
C40 vdd qn 0.99433f
C41 tail tp1 0.04314f
C42 tail sp0 0.22127f
C43 sp1 vinp 0.45578f
C44 vdd vinn 0.00956f
C45 tail tn3 0.11566f
C46 tail sn3 0.78857f
C47 sn0 tn0 0.22192f
C48 qp vdd 1.01053f
C49 tail vdd 0.57768f
C50 tp1 vinp 0.0783f
C51 sp1 tp1 0.2511f
C52 sp0 vinp 0.58812f
C53 sp0 sp1 0.06623f
C54 xp tp2 0.01012f
C55 tail tp0 0.02986f
C56 sn2 tn1 0.00558f
C57 sn2 sn1 0.07813f
C58 sp2 tp2 0.27933f
C59 vdd vinp 0.00957f
C60 clk xn 0.28793f
C61 tn1 vinn 0.07824f
C62 vdd sn0 0
C63 sn1 vinn 0.45578f
C64 tp0 vinp 0.0764f
C65 tp0 sp1 0.00558f
C66 sn3 tn3 0.3136f
C67 xp clk 0.28831f
C68 sp2 xp 0.20608f
C69 tail tn1 0.04314f
C70 vdd sp0 0
C71 tail sn1 0.31884f
C72 tn2 xn 0.01012f
C73 tp2 sp3 0.00557f
C74 sn2 xn 0.20608f
C75 tp0 sp0 0.22193f
C76 qn xn 0.14695f
C77 vinn xn 0.93288f
C78 tail tp2 0.07042f
C79 xp qn 0.21224f
C80 sn1 tn0 0.00558f
C81 sn1 sn0 0.06623f
C82 xp sp3 0.20649f
C83 qp xn 0.21612f
C84 clk qn 0.21006f
C85 tail xn 3.13866f
C86 clk vinn 0.01841f
C87 sp2 sp3 0.09503f
C88 xp tp3 0
C89 xp qp 0.15077f
C90 tp2 vinp 0.07465f
C91 xp tail 3.139f
C92 sn2 tn2 0.27933f
C93 qp clk 0.22345f
C94 tail clk 2.69274f
C95 sp2 tail 0.50085f
C96 tn2 vinn 0.07464f
C97 tn0 xn 0.0643f
C98 sn2 vinn 0.44962f
C99 sn0 xn 0.12677f
C100 xp vinp 0.93288f
C101 xp sp1 0.15896f
C102 qn vinn 0.06392f
C103 clk vinp 0.01863f
C104 tail tn2 0.07042f
C105 sp2 vinp 0.44962f
C106 tail sn2 0.50085f
C107 sp2 sp1 0.07813f
R0 tn3.n0 tn3 3.4105
R1 tn3.t0 tn3.n0 1515.4
R2 tn2.n0 tn2 3.4105
R3 tn2.t0 tn2.n0 873.486
R4 tn1.n0 tn1 3.4105
R5 tn1.t0 tn1.n0 552.278
R6 tn0.n0 tn0 3.4105
R7 tn0.t0 tn0.n0 391.423
R8 vinn vinn.n0 0.332265
R9 vinn vinn.n1 0.995794
R10 vinn.n1 vinn.n2 1.32756
R11 vinn.n2 vinn.t0 186.309
R12 vinn.n2 vinn.t1 145.018
R13 vinn.n1 vinn.t2 125.037
R14 vinn.n0 vinn.t3 115.046
R15 vinn.n0 vinn.t4 716.36
R16 qn qn.n0 1.46579
R17 qn qn.n1 1.32756
R18 qn.n1 qn.n2 0.664029
R19 qn.n2 qn.t1 240.415
R20 qn.n2 qn.t3 566.135
R21 qn.n1 qn.t4 391.334
R22 qn.n0 qn.t2 94.435
R23 qn.n0 qn.t0 125.04
R24 qp.n1 qp.n0 0.664029
R25 qp qp.n1 1.32756
R26 qp qp.n2 1.46579
R27 qp.n2 qp.t1 124.04
R28 qp.n2 qp.t2 93.435
R29 qp.n1 qp.t3 390.334
R30 qp.n0 qp.t4 565.135
R31 qp.n0 qp.t0 239.415
R32 clk.n0 clk 3.4105
R33 clk.t2 clk.n0 1352.82
R34 clk clk.n1 2.65462
R35 clk clk.n2 2.65462
R36 clk.n2 clk.t0 405.495
R37 clk.n2 clk.t1 404.83
R38 clk.n1 clk.t3 404.83
R39 clk.n1 clk.t4 405.495
R40 tp0.n0 tp0 3.4105
R41 tp0.t0 tp0.n0 391.423
R42 tp1.n0 tp1 3.4105
R43 tp1.t0 tp1.n0 552.278
R44 tp2.n0 tp2 3.4105
R45 tp2.t0 tp2.n0 873.486
R46 vinp.n1 vinp.n0 1.32756
R47 vinp vinp.n1 0.995794
R48 vinp vinp.n2 0.332265
R49 vinp.n2 vinp.t0 716.36
R50 vinp.n2 vinp.t1 115.046
R51 vinp.n1 vinp.t2 125.037
R52 vinp.n0 vinp.t3 145.018
R53 vinp.n0 vinp.t4 186.309
R54 tp3.n0 tp3 3.4105
R55 tp3.t0 tp3.n0 1515.4
R56 vdd.n26 vdd.n0 0.249324
R57 vdd.n1 vdd.n26 0.415206
R58 vdd.n58 vdd.n1 0.249324
R59 vdd.n2 vdd.n58 0.415206
R60 vdd vdd.n2 1.85285
R61 vdd vdd.n3 1.85285
R62 vdd.n3 vdd.n69 0.415206
R63 vdd.n69 vdd.n4 0.249324
R64 vdd.n4 vdd.n37 0.415206
R65 vdd.n37 vdd.n5 0.249324
R66 vdd.n69 vdd.n59 17.9295
R67 vdd.n60 vdd.n61 77.8163
R68 vdd.n59 vdd.n60 92.5005
R69 vdd.n63 vdd.n62 26.4291
R70 vdd.n59 vdd.n63 172.8
R71 vdd.t10 vdd.n64 10.3649
R72 vdd.n65 vdd.n66 92.5005
R73 vdd.n66 vdd.n63 177.695
R74 vdd.n68 vdd.n67 26.4291
R75 vdd.n68 vdd.n66 177.695
R76 vdd.n59 vdd.n68 172.8
R77 vdd.n67 vdd.n60 1665.88
R78 vdd.n61 vdd.n62 186.649
R79 vdd.n64 vdd.n65 77.8163
R80 vdd.n65 vdd.n62 1665.88
R81 vdd.n67 vdd.n64 186.649
R82 vdd.n61 vdd.t10 10.3649
R83 vdd.n58 vdd.n48 17.9295
R84 vdd.n49 vdd.n50 77.8163
R85 vdd.n48 vdd.n49 92.5005
R86 vdd.n52 vdd.n51 26.4291
R87 vdd.n48 vdd.n52 172.8
R88 vdd.t0 vdd.n53 10.3649
R89 vdd.n54 vdd.n55 92.5005
R90 vdd.n52 vdd.n55 177.695
R91 vdd.n57 vdd.n56 26.4291
R92 vdd.n57 vdd.n55 177.695
R93 vdd.n48 vdd.n57 172.8
R94 vdd.n56 vdd.n49 1665.88
R95 vdd.n50 vdd.n51 186.649
R96 vdd.n53 vdd.n54 77.8163
R97 vdd.n54 vdd.n51 1665.88
R98 vdd.n56 vdd.n53 186.649
R99 vdd.n50 vdd.t0 10.3649
R100 vdd.n5 vdd.n38 18.5379
R101 vdd.n39 vdd.n40 70.7763
R102 vdd.n38 vdd.n39 92.5005
R103 vdd.n42 vdd.n41 46.2505
R104 vdd.n38 vdd.n42 135.154
R105 vdd.t8 vdd.n43 16.7394
R106 vdd.n44 vdd.n45 92.5005
R107 vdd.n42 vdd.n45 140.048
R108 vdd.n47 vdd.n46 46.2505
R109 vdd.n47 vdd.n45 140.048
R110 vdd.n38 vdd.n47 135.154
R111 vdd.n46 vdd.n39 1312.94
R112 vdd.n40 vdd.n41 237.584
R113 vdd.n43 vdd.n44 70.7763
R114 vdd.n44 vdd.n41 1312.94
R115 vdd.n46 vdd.n43 237.584
R116 vdd.n40 vdd.t8 16.7394
R117 vdd.n37 vdd.n27 18.1232
R118 vdd.n28 vdd.n29 70.7763
R119 vdd.n27 vdd.n28 92.5005
R120 vdd.n31 vdd.n30 46.2505
R121 vdd.n27 vdd.n31 135.154
R122 vdd.t2 vdd.n32 16.7394
R123 vdd.n33 vdd.n34 92.5005
R124 vdd.n31 vdd.n34 140.048
R125 vdd.n36 vdd.n35 46.2505
R126 vdd.n36 vdd.n34 140.048
R127 vdd.n27 vdd.n36 135.154
R128 vdd.n35 vdd.n28 1312.94
R129 vdd.n29 vdd.n30 237.584
R130 vdd.n32 vdd.n33 70.7763
R131 vdd.n33 vdd.n30 1312.94
R132 vdd.n35 vdd.n32 237.584
R133 vdd.n29 vdd.t2 16.7394
R134 vdd.n26 vdd.n16 18.1232
R135 vdd.n17 vdd.n18 70.7763
R136 vdd.n16 vdd.n17 92.5005
R137 vdd.n20 vdd.n19 46.2505
R138 vdd.n16 vdd.n20 135.154
R139 vdd.t6 vdd.n21 16.7394
R140 vdd.n22 vdd.n23 92.5005
R141 vdd.n20 vdd.n23 140.048
R142 vdd.n25 vdd.n24 46.2505
R143 vdd.n25 vdd.n23 140.048
R144 vdd.n16 vdd.n25 135.154
R145 vdd.n24 vdd.n17 1312.94
R146 vdd.n18 vdd.n19 237.584
R147 vdd.n21 vdd.n22 70.7763
R148 vdd.n22 vdd.n19 1312.94
R149 vdd.n24 vdd.n21 237.584
R150 vdd.n18 vdd.t6 16.7394
R151 vdd.n0 vdd.n6 18.5379
R152 vdd.n7 vdd.n8 70.7763
R153 vdd.n6 vdd.n7 92.5005
R154 vdd.n10 vdd.n9 46.2505
R155 vdd.n6 vdd.n10 135.154
R156 vdd.t4 vdd.n11 16.7394
R157 vdd.n12 vdd.n13 92.5005
R158 vdd.n10 vdd.n13 140.048
R159 vdd.n15 vdd.n14 46.2505
R160 vdd.n15 vdd.n13 140.048
R161 vdd.n6 vdd.n15 135.154
R162 vdd.n14 vdd.n7 1312.94
R163 vdd.n8 vdd.n9 237.584
R164 vdd.n11 vdd.n12 70.7763
R165 vdd.n12 vdd.n9 1312.94
R166 vdd.n14 vdd.n11 237.584
R167 vdd.n8 vdd.t4 16.7394
R168 vdd.n5 vdd.t9 237.224
R169 vdd.n4 vdd.t3 237.224
R170 vdd.n3 vdd.t11 122.651
R171 vdd.n2 vdd.t1 122.651
R172 vdd.n1 vdd.t7 237.224
R173 vdd.n0 vdd.t5 237.224
R174 vss.n15 vss.n0 0.664029
R175 vss.n5 vss.n15 0.664029
R176 vss.n6 vss.n5 0.664029
R177 vss.n4 vss.n6 0.664029
R178 vss.n7 vss.n4 0.664029
R179 vss.n3 vss.n7 0.664029
R180 vss.n230 vss.n3 0.664029
R181 vss.n8 vss.n230 1.99109
R182 vss.n16 vss.n8 0.664029
R183 vss.n17 vss.n16 0.664029
R184 vss vss.n17 0.276971
R185 vss vss.n2 0.138735
R186 vss.n2 vss.n18 0.802265
R187 vss.n18 vss.n10 0.664029
R188 vss.n10 vss.n231 1.99109
R189 vss.n231 vss.n9 0.664029
R190 vss.n9 vss.n12 0.664029
R191 vss.n12 vss.n11 0.664029
R192 vss.n11 vss.n14 0.664029
R193 vss.n14 vss.n13 0.664029
R194 vss.n13 vss.n19 0.664029
R195 vss.n19 vss.n1 0.664029
R196 vss.n231 vss.n230 12.6351
R197 vss.n1 vss.n20 19.9023
R198 vss.n21 vss.n22 269.834
R199 vss.n20 vss.n21 292.5
R200 vss.n24 vss.n23 23.4005
R201 vss.n20 vss.n24 396.8
R202 vss.t1 vss.n25 292.5
R203 vss.n25 vss.n26 292.5
R204 vss.n26 vss.n24 401.695
R205 vss.n228 vss.n227 23.4005
R206 vss.n229 vss.n228 23.4005
R207 vss.n229 vss.n26 401.695
R208 vss.n20 vss.n229 396.8
R209 vss.n228 vss.n21 6182.32
R210 vss.n22 vss.n23 209.274
R211 vss.n228 vss.n25 6182.32
R212 vss.n25 vss.n23 6182.32
R213 vss.t18 vss.n27 292.5
R214 vss.n28 vss.n27 292.5
R215 vss.n30 vss.n29 45.0005
R216 vss.n31 vss.n30 45.0005
R217 vss.t18 vss.n32 292.5
R218 vss.n33 vss.n32 292.5
R219 vss.n35 vss.n34 45.0005
R220 vss.n36 vss.n35 45.0005
R221 vss.t2 vss.n37 292.5
R222 vss.n38 vss.n37 292.5
R223 vss.n40 vss.n39 83.5719
R224 vss.n41 vss.n40 83.5719
R225 vss.t2 vss.n42 292.5
R226 vss.n43 vss.n42 292.5
R227 vss.n45 vss.n44 83.5719
R228 vss.n46 vss.n45 83.5719
R229 vss.t20 vss.n47 292.5
R230 vss.n48 vss.n47 292.5
R231 vss.n50 vss.n49 146.25
R232 vss.n51 vss.n50 146.25
R233 vss.n52 vss.t20 292.5
R234 vss.n53 vss.n52 292.5
R235 vss.n55 vss.n54 146.25
R236 vss.n56 vss.n55 146.25
R237 vss.t11 vss.n57 117.001
R238 vss.n57 vss.n58 117.001
R239 vss.n60 vss.n59 195
R240 vss.n61 vss.n60 195
R241 vss.n62 vss.t11 117.001
R242 vss.n63 vss.n62 117.001
R243 vss.n65 vss.n64 195
R244 vss.n66 vss.n65 195
R245 vss.t12 vss.n67 117.001
R246 vss.n67 vss.n68 117.001
R247 vss.n70 vss.n69 146.25
R248 vss.n71 vss.n70 146.25
R249 vss.n72 vss.t12 117.001
R250 vss.n73 vss.n72 117.001
R251 vss.n75 vss.n74 146.25
R252 vss.n76 vss.n75 146.25
R253 vss.t13 vss.n77 117.001
R254 vss.n77 vss.n78 117.001
R255 vss.n80 vss.n79 97.5005
R256 vss.n81 vss.n80 97.5005
R257 vss.n82 vss.t13 117.001
R258 vss.n83 vss.n82 117.001
R259 vss.n85 vss.n84 97.5005
R260 vss.n86 vss.n85 97.5005
R261 vss.t14 vss.n87 117.001
R262 vss.n87 vss.n88 117.001
R263 vss.n90 vss.n89 53.1823
R264 vss.n91 vss.n90 53.1823
R265 vss.n92 vss.t14 117.001
R266 vss.n93 vss.n92 117.001
R267 vss.n95 vss.n94 53.1823
R268 vss.n96 vss.n95 53.1823
R269 vss.n64 vss.t11 312.906
R270 vss.t11 vss.n59 312.906
R271 vss.n59 vss.n54 719.813
R272 vss.n54 vss.t20 203.453
R273 vss.t20 vss.n49 203.453
R274 vss.n49 vss.n74 719.813
R275 vss.n74 vss.t12 312.906
R276 vss.t12 vss.n69 312.906
R277 vss.n69 vss.n44 719.813
R278 vss.n44 vss.t2 203.453
R279 vss.n39 vss.t2 203.453
R280 vss.n39 vss.n84 719.813
R281 vss.n84 vss.t13 312.906
R282 vss.t13 vss.n79 312.906
R283 vss.n79 vss.n34 719.813
R284 vss.n34 vss.t18 203.453
R285 vss.n29 vss.t18 203.453
R286 vss.n29 vss.n94 719.813
R287 vss.n94 vss.t14 312.906
R288 vss.t14 vss.n89 312.906
R289 vss.n89 vss.n227 719.813
R290 vss.n227 vss.t1 203.453
R291 vss.n22 vss.t1 9.90219
R292 vss.t16 vss.n97 292.5
R293 vss.n97 vss.n98 292.5
R294 vss.n100 vss.n99 26.5914
R295 vss.n101 vss.n100 26.5914
R296 vss.n102 vss.t16 292.5
R297 vss.n103 vss.n102 292.5
R298 vss.n105 vss.n104 26.5914
R299 vss.n106 vss.n105 26.5914
R300 vss.t8 vss.n107 292.5
R301 vss.n108 vss.n107 292.5
R302 vss.n110 vss.n109 58.5005
R303 vss.n111 vss.n110 58.5005
R304 vss.t8 vss.n112 292.5
R305 vss.n113 vss.n112 292.5
R306 vss.n115 vss.n114 58.5005
R307 vss.n116 vss.n115 58.5005
R308 vss.t15 vss.n117 292.5
R309 vss.n118 vss.n117 292.5
R310 vss.n120 vss.n119 146.25
R311 vss.n121 vss.n120 146.25
R312 vss.n122 vss.t15 292.5
R313 vss.n123 vss.n122 292.5
R314 vss.n125 vss.n124 146.25
R315 vss.n126 vss.n125 146.25
R316 vss.t10 vss.n127 292.5
R317 vss.n128 vss.n127 292.5
R318 vss.n130 vss.n129 58.5005
R319 vss.n131 vss.n130 58.5005
R320 vss.t10 vss.n132 292.5
R321 vss.n133 vss.n132 292.5
R322 vss.n135 vss.n134 58.5005
R323 vss.n136 vss.n135 58.5005
R324 vss.t21 vss.n137 292.5
R325 vss.n138 vss.n137 292.5
R326 vss.n140 vss.n139 146.25
R327 vss.n141 vss.n140 146.25
R328 vss.n142 vss.t21 292.5
R329 vss.n143 vss.n142 292.5
R330 vss.n145 vss.n144 146.25
R331 vss.n146 vss.n145 146.25
R332 vss.n124 vss.t15 203.453
R333 vss.t15 vss.n119 203.453
R334 vss.n119 vss.n114 829.265
R335 vss.n114 vss.t8 203.453
R336 vss.t8 vss.n109 203.453
R337 vss.n109 vss.n104 829.265
R338 vss.n104 vss.t16 203.453
R339 vss.t16 vss.n99 203.453
R340 vss.n99 vss.n134 829.265
R341 vss.n134 vss.t10 203.453
R342 vss.t10 vss.n129 203.453
R343 vss.n129 vss.n144 829.265
R344 vss.n144 vss.t21 203.453
R345 vss.t21 vss.n139 203.453
R346 vss.n139 vss.n64 5079.65
R347 vss.n219 vss.n124 5079.65
R348 vss.t3 vss.n147 292.5
R349 vss.n147 vss.n148 292.5
R350 vss.n150 vss.n149 23.4005
R351 vss.n151 vss.n150 23.4005
R352 vss.n152 vss.t3 9.90219
R353 vss.n154 vss.n153 292.5
R354 vss.n156 vss.n155 23.4005
R355 vss.t9 vss.n157 292.5
R356 vss.n158 vss.n157 292.5
R357 vss.n160 vss.n159 45.0005
R358 vss.n161 vss.n160 45.0005
R359 vss.t9 vss.n162 292.5
R360 vss.n163 vss.n162 292.5
R361 vss.n165 vss.n164 45.0005
R362 vss.n166 vss.n165 45.0005
R363 vss.t4 vss.n167 117.001
R364 vss.n167 vss.n168 117.001
R365 vss.n170 vss.n169 53.1823
R366 vss.n171 vss.n170 53.1823
R367 vss.n172 vss.t4 117.001
R368 vss.n173 vss.n172 117.001
R369 vss.n175 vss.n174 53.1823
R370 vss.n176 vss.n175 53.1823
R371 vss.t5 vss.n177 117.001
R372 vss.n177 vss.n178 117.001
R373 vss.n180 vss.n179 97.5005
R374 vss.n181 vss.n180 97.5005
R375 vss.n182 vss.t5 117.001
R376 vss.n183 vss.n182 117.001
R377 vss.n185 vss.n184 97.5005
R378 vss.n186 vss.n185 97.5005
R379 vss.t19 vss.n187 292.5
R380 vss.n188 vss.n187 292.5
R381 vss.n190 vss.n189 83.5719
R382 vss.n191 vss.n190 83.5719
R383 vss.t19 vss.n192 292.5
R384 vss.n193 vss.n192 292.5
R385 vss.n195 vss.n194 83.5719
R386 vss.n196 vss.n195 83.5719
R387 vss.t6 vss.n197 117.001
R388 vss.n197 vss.n198 117.001
R389 vss.n200 vss.n199 146.25
R390 vss.n201 vss.n200 146.25
R391 vss.n202 vss.t6 117.001
R392 vss.n203 vss.n202 117.001
R393 vss.n205 vss.n204 146.25
R394 vss.n206 vss.n205 146.25
R395 vss.t0 vss.n207 292.5
R396 vss.n208 vss.n207 292.5
R397 vss.n210 vss.n209 146.25
R398 vss.n211 vss.n210 146.25
R399 vss.n212 vss.t0 292.5
R400 vss.n213 vss.n212 292.5
R401 vss.n215 vss.n214 146.25
R402 vss.n216 vss.n215 146.25
R403 vss.t7 vss.n217 117.001
R404 vss.n217 vss.n218 117.001
R405 vss.n220 vss.n219 195
R406 vss.n221 vss.n220 195
R407 vss.n222 vss.t7 117.001
R408 vss.n223 vss.n222 117.001
R409 vss.n225 vss.n224 195
R410 vss.n226 vss.n225 195
R411 vss.n155 vss.n152 209.274
R412 vss.t3 vss.n149 203.453
R413 vss.n149 vss.n174 719.813
R414 vss.n174 vss.t4 312.906
R415 vss.t4 vss.n169 312.906
R416 vss.n169 vss.n164 719.813
R417 vss.n164 vss.t9 203.453
R418 vss.n159 vss.t9 203.453
R419 vss.n159 vss.n184 719.813
R420 vss.n184 vss.t5 312.906
R421 vss.t5 vss.n179 312.906
R422 vss.n179 vss.n194 719.813
R423 vss.n194 vss.t19 203.453
R424 vss.n189 vss.t19 203.453
R425 vss.n189 vss.n204 719.813
R426 vss.n204 vss.t6 312.906
R427 vss.t6 vss.n199 312.906
R428 vss.n199 vss.n214 719.813
R429 vss.n214 vss.t0 203.453
R430 vss.t0 vss.n209 203.453
R431 vss.n209 vss.n224 719.813
R432 vss.n224 vss.t7 312.906
R433 vss.t7 vss.n219 312.906
R434 vss.n223 vss.n226 143.435
R435 vss.n223 vss.n221 143.435
R436 vss.n226 vss.n218 148.329
R437 vss.n221 vss.n218 148.329
R438 vss.n3 vss.n223 18.8201
R439 vss.n225 vss.n222 2282.88
R440 vss.n222 vss.n220 2282.88
R441 vss.n225 vss.n217 2282.88
R442 vss.n217 vss.n220 2282.88
R443 vss.n213 vss.n216 133.272
R444 vss.n213 vss.n211 133.272
R445 vss.n216 vss.n208 138.166
R446 vss.n211 vss.n208 138.166
R447 vss.n7 vss.n213 18.6388
R448 vss.n215 vss.n212 2126.44
R449 vss.n212 vss.n210 2126.44
R450 vss.n215 vss.n207 2126.44
R451 vss.n207 vss.n210 2126.44
R452 vss.n203 vss.n206 159.248
R453 vss.n203 vss.n201 159.248
R454 vss.n206 vss.n198 164.142
R455 vss.n201 vss.n198 164.142
R456 vss.n4 vss.n203 18.6888
R457 vss.n205 vss.n202 2526.24
R458 vss.n202 vss.n200 2526.24
R459 vss.n205 vss.n197 2526.24
R460 vss.n197 vss.n200 2526.24
R461 vss.n193 vss.n196 170.918
R462 vss.n193 vss.n191 170.918
R463 vss.n196 vss.n188 175.812
R464 vss.n191 vss.n188 175.812
R465 vss.n6 vss.n193 18.3263
R466 vss.n195 vss.n192 2705.85
R467 vss.n192 vss.n190 2705.85
R468 vss.n195 vss.n187 2705.85
R469 vss.n187 vss.n190 2705.85
R470 vss.n183 vss.n186 190.871
R471 vss.n183 vss.n181 190.871
R472 vss.n186 vss.n178 195.766
R473 vss.n178 vss.n181 195.766
R474 vss.n5 vss.n183 18.4263
R475 vss.n185 vss.n182 3012.94
R476 vss.n182 vss.n180 3012.94
R477 vss.n185 vss.n177 3012.94
R478 vss.n177 vss.n180 3012.94
R479 vss.n173 vss.n176 254.119
R480 vss.n173 vss.n171 254.119
R481 vss.n176 vss.n168 259.012
R482 vss.n168 vss.n171 259.012
R483 vss.n0 vss.n173 17.9451
R484 vss.n175 vss.n172 3986.35
R485 vss.n172 vss.n170 3986.35
R486 vss.n175 vss.n167 3986.35
R487 vss.n167 vss.n170 3986.35
R488 vss.n163 vss.n166 246.213
R489 vss.n163 vss.n161 246.213
R490 vss.n166 vss.n158 251.107
R491 vss.n161 vss.n158 251.107
R492 vss.n15 vss.n163 18.009
R493 vss.n165 vss.n162 3864.68
R494 vss.n162 vss.n160 3864.68
R495 vss.n165 vss.n157 3864.68
R496 vss.n157 vss.n160 3864.68
R497 vss.n154 vss.n156 396.8
R498 vss.n154 vss.n151 396.8
R499 vss.n156 vss.n148 401.695
R500 vss.n148 vss.n151 401.695
R501 vss.n0 vss.n154 19.9023
R502 vss.n153 vss.n152 269.834
R503 vss.n153 vss.n150 6182.32
R504 vss.n155 vss.n147 6182.32
R505 vss.n147 vss.n150 6182.32
R506 vss.n143 vss.n146 133.272
R507 vss.n143 vss.n141 133.272
R508 vss.n146 vss.n138 138.166
R509 vss.n138 vss.n141 138.166
R510 vss.n10 vss.n143 18.6388
R511 vss.n145 vss.n142 2126.44
R512 vss.n142 vss.n140 2126.44
R513 vss.n145 vss.n137 2126.44
R514 vss.n137 vss.n140 2126.44
R515 vss.n133 vss.n136 208.565
R516 vss.n133 vss.n131 208.565
R517 vss.n136 vss.n128 213.459
R518 vss.n131 vss.n128 213.459
R519 vss.n18 vss.n133 18.0282
R520 vss.n135 vss.n132 3285.26
R521 vss.n132 vss.n130 3285.26
R522 vss.n135 vss.n127 3285.26
R523 vss.n127 vss.n130 3285.26
R524 vss.n123 vss.n126 133.272
R525 vss.n123 vss.n121 133.272
R526 vss.n126 vss.n118 138.166
R527 vss.n118 vss.n121 138.166
R528 vss.n8 vss.n123 18.6388
R529 vss.n125 vss.n122 2126.44
R530 vss.n122 vss.n120 2126.44
R531 vss.n125 vss.n117 2126.44
R532 vss.n117 vss.n120 2126.44
R533 vss.n113 vss.n116 208.565
R534 vss.n113 vss.n111 208.565
R535 vss.n116 vss.n108 213.459
R536 vss.n111 vss.n108 213.459
R537 vss.n16 vss.n113 18.0282
R538 vss.n115 vss.n112 3285.26
R539 vss.n112 vss.n110 3285.26
R540 vss.n115 vss.n107 3285.26
R541 vss.n107 vss.n110 3285.26
R542 vss.n103 vss.n106 359.154
R543 vss.n103 vss.n101 359.154
R544 vss.n106 vss.n98 364.048
R545 vss.n98 vss.n101 364.048
R546 vss.n17 vss.n103 18.9263
R547 vss.n105 vss.n102 5602.91
R548 vss.n102 vss.n100 5602.91
R549 vss.n105 vss.n97 5602.91
R550 vss.n97 vss.n100 5602.91
R551 vss.n93 vss.n96 254.119
R552 vss.n93 vss.n91 254.119
R553 vss.n96 vss.n88 259.012
R554 vss.n88 vss.n91 259.012
R555 vss.n1 vss.n93 17.9451
R556 vss.n95 vss.n92 3986.35
R557 vss.n92 vss.n90 3986.35
R558 vss.n95 vss.n87 3986.35
R559 vss.n87 vss.n90 3986.35
R560 vss.n83 vss.n86 190.871
R561 vss.n83 vss.n81 190.871
R562 vss.n86 vss.n78 195.766
R563 vss.n78 vss.n81 195.766
R564 vss.n13 vss.n83 18.4263
R565 vss.n85 vss.n82 3012.94
R566 vss.n82 vss.n80 3012.94
R567 vss.n85 vss.n77 3012.94
R568 vss.n77 vss.n80 3012.94
R569 vss.n73 vss.n76 159.248
R570 vss.n73 vss.n71 159.248
R571 vss.n76 vss.n68 164.142
R572 vss.n68 vss.n71 164.142
R573 vss.n11 vss.n73 18.6888
R574 vss.n75 vss.n72 2526.24
R575 vss.n72 vss.n70 2526.24
R576 vss.n75 vss.n67 2526.24
R577 vss.n67 vss.n70 2526.24
R578 vss.n63 vss.n66 143.435
R579 vss.n63 vss.n61 143.435
R580 vss.n66 vss.n58 148.329
R581 vss.n58 vss.n61 148.329
R582 vss.n9 vss.n63 18.8201
R583 vss.n65 vss.n62 2282.88
R584 vss.n62 vss.n60 2282.88
R585 vss.n65 vss.n57 2282.88
R586 vss.n57 vss.n60 2282.88
R587 vss.n53 vss.n56 133.272
R588 vss.n53 vss.n51 133.272
R589 vss.n56 vss.n48 138.166
R590 vss.n51 vss.n48 138.166
R591 vss.n12 vss.n53 18.6388
R592 vss.n55 vss.n52 2126.44
R593 vss.n52 vss.n50 2126.44
R594 vss.n55 vss.n47 2126.44
R595 vss.n47 vss.n50 2126.44
R596 vss.n43 vss.n46 170.918
R597 vss.n43 vss.n41 170.918
R598 vss.n46 vss.n38 175.812
R599 vss.n41 vss.n38 175.812
R600 vss.n14 vss.n43 18.3263
R601 vss.n45 vss.n42 2705.85
R602 vss.n42 vss.n40 2705.85
R603 vss.n45 vss.n37 2705.85
R604 vss.n37 vss.n40 2705.85
R605 vss.n33 vss.n36 246.213
R606 vss.n33 vss.n31 246.213
R607 vss.n36 vss.n28 251.107
R608 vss.n31 vss.n28 251.107
R609 vss.n19 vss.n33 18.009
R610 vss.n35 vss.n32 3864.68
R611 vss.n32 vss.n30 3864.68
R612 vss.n35 vss.n27 3864.68
R613 vss.n27 vss.n30 3864.68
R614 vss.n2 vss.t17 21.7498
R615 sn3.t0 sn3 24.8295
R616 sn3 sn3.t1 38.6294
R617 sn2.t1 sn2 35.702
R618 sn2 sn2.t0 63.0996
R619 sn1.t0 sn1 54.5817
R620 sn1 sn1.t1 130.781
R621 sn0.t1 sn0 96.405
R622 sn0 sn0.t0 248.147
R623 xn.t0 xn.n0 39.1929
R624 xn.n1 xn.n0 1.60403
R625 xn.n2 xn.n1 1.32756
R626 xn xn.n2 0.332265
R627 xn xn.n3 0.995794
R628 xn.n3 xn.n4 1.32756
R629 xn.n4 xn.t4 34.4864
R630 xn.n4 xn.t1 58.1296
R631 xn.n3 xn.t2 126.311
R632 xn.n2 xn.t3 244.177
R633 xn.n1 xn.t5 236.948
R634 xn.n0 xn.t6 92.435
R635 sp0 sp0.t0 96.405
R636 sp0 sp0.t1 248.147
R637 sp1 sp1.t1 54.5817
R638 sp1 sp1.t0 130.781
R639 sp2 sp2.t1 35.702
R640 sp2 sp2.t0 63.0996
R641 xp.n4 xp.t0 39.1929
R642 xp.n1 xp.n0 1.32756
R643 xp xp.n1 0.995794
R644 xp xp.n2 0.332265
R645 xp.n2 xp.n3 1.32756
R646 xp.n3 xp.n4 1.60403
R647 xp.n4 xp.t5 92.435
R648 xp.n3 xp.t6 236.948
R649 xp.n2 xp.t2 244.177
R650 xp.n1 xp.t4 126.311
R651 xp.n0 xp.t3 58.1296
R652 xp.n0 xp.t1 34.4864
R653 tail.n8 tail.t1 20.2188
R654 tail.n1 tail.n0 1.32756
R655 tail.n2 tail.n1 1.32756
R656 tail.n3 tail.n2 3.98168
R657 tail.n4 tail.n3 0.387559
R658 tail tail.n4 0.138735
R659 tail tail.n5 0.525794
R660 tail.n5 tail.n6 3.98168
R661 tail.n6 tail.n7 1.32756
R662 tail.n7 tail.n8 1.32756
R663 tail.n8 tail.t8 30.2642
R664 tail.n7 tail.t2 49.6439
R665 tail.n6 tail.t10 91.9672
R666 tail.n5 tail.t6 38.338
R667 tail.n4 tail.t7 20.4757
R668 tail.n3 tail.t4 38.338
R669 tail.n2 tail.t0 91.9672
R670 tail.n1 tail.t9 49.6439
R671 tail.n0 tail.t5 30.2642
R672 tail.n0 tail.t3 20.2188
R673 sp3 sp3.t0 24.8295
R674 sp3 sp3.t1 38.6294
C108 tn3 vss 0.81138f
C109 tn2 vss 0.82963f
C110 tn1 vss 0.82967f
C111 tn0 vss 0.81655f
C112 vinn vss 6.74143f
C113 qn vss 7.19305f
C114 qp vss 7.17544f
C115 clk vss 4.12704f
C116 tp0 vss 0.81691f
C117 tp1 vss 0.82931f
C118 tp2 vss 0.82959f
C119 vinp vss 6.73792f
C120 tp3 vss 0.81138f
C121 vdd vss 11.94454f
C122 sn3 vss 3.62241f ; **FLOATING
C123 sn2 vss 2.82828f ; **FLOATING
C124 sn1 vss 2.47509f ; **FLOATING
C125 sn0 vss 2.38606f ; **FLOATING
C126 xn vss 4.26009f ; **FLOATING
C127 sp0 vss 2.38742f ; **FLOATING
C128 sp1 vss 2.47509f ; **FLOATING
C129 sp2 vss 2.82828f ; **FLOATING
C130 xp vss 4.25936f ; **FLOATING
C131 tail vss 9.40993f ; **FLOATING
C132 sp3 vss 3.62241f ; **FLOATING
C133 sp3.t0 vss 0.57654f ; **FLOATING
C134 sp3.t1 vss 0.21628f ; **FLOATING
C135 tail.t1 vss 0.75338f ; **FLOATING
C136 tail.t3 vss 0.75338f ; **FLOATING
C137 tail.t5 vss 0.30153f ; **FLOATING
C138 tail.n0 vss 1.6428f ; **FLOATING
C139 tail.t9 vss 0.13473f ; **FLOATING
C140 tail.n1 vss 0.83249f ; **FLOATING
C141 tail.t0 vss 0.06191f ; **FLOATING
C142 tail.n2 vss 1.39355f ; **FLOATING
C143 tail.t4 vss 0.21313f ; **FLOATING
C144 tail.n3 vss 1.28482f ; **FLOATING
C145 tail.t7 vss 0.59728f ; **FLOATING
C146 tail.n4 vss 0.52776f ; **FLOATING
C147 tail.t6 vss 0.21313f ; **FLOATING
C148 tail.n5 vss 1.31707f ; **FLOATING
C149 tail.t10 vss 0.06191f ; **FLOATING
C150 tail.n6 vss 1.39355f ; **FLOATING
C151 tail.t2 vss 0.13473f ; **FLOATING
C152 tail.n7 vss 0.83249f ; **FLOATING
C153 tail.t8 vss 0.30153f ; **FLOATING
C154 tail.n8 vss 1.6428f ; **FLOATING
C155 xp.t0 vss 0.23418f ; **FLOATING
C156 xp.t1 vss 0.2828f ; **FLOATING
C157 xp.t3 vss 0.11426f ; **FLOATING
C158 xp.n0 vss 1.48472f ; **FLOATING
C159 xp.t4 vss 0.052f ; **FLOATING
C160 xp.n1 vss 0.72593f ; **FLOATING
C161 xp.t2 vss 0.02493f ; **FLOATING
C162 xp.n2 vss 0.53303f ; **FLOATING
C163 xp.t6 vss 0.05932f ; **FLOATING
C164 xp.n3 vss 0.9208f ; **FLOATING
C165 xp.t5 vss 0.06704f ; **FLOATING
C166 xp.n4 vss 1.1064f ; **FLOATING
C167 sp2.t1 vss 0.32716f ; **FLOATING
C168 sp2.t0 vss 0.12279f ; **FLOATING
C169 sp1.t1 vss 0.15863f ; **FLOATING
C170 sp1.t0 vss 0.0563f ; **FLOATING
C171 sp0.t0 vss 0.0814f ; **FLOATING
C172 sp0.t1 vss 0.02959f ; **FLOATING
C173 xn.t0 vss 0.23416f ; **FLOATING
C174 xn.t6 vss 0.06703f ; **FLOATING
C175 xn.n0 vss 1.10628f ; **FLOATING
C176 xn.t5 vss 0.05932f ; **FLOATING
C177 xn.n1 vss 0.92069f ; **FLOATING
C178 xn.t3 vss 0.02493f ; **FLOATING
C179 xn.n2 vss 0.53297f ; **FLOATING
C180 xn.t2 vss 0.05199f ; **FLOATING
C181 xn.n3 vss 0.72585f ; **FLOATING
C182 xn.t1 vss 0.11425f ; **FLOATING
C183 xn.n4 vss 1.48455f ; **FLOATING
C184 xn.t4 vss 0.28277f ; **FLOATING
C185 sn0.t1 vss 0.08143f ; **FLOATING
C186 sn0.t0 vss 0.0296f ; **FLOATING
C187 sn1.t0 vss 0.15863f ; **FLOATING
C188 sn1.t1 vss 0.0563f ; **FLOATING
C189 sn2.t1 vss 0.32716f ; **FLOATING
C190 sn2.t0 vss 0.12279f ; **FLOATING
C191 sn3.t0 vss 0.57654f ; **FLOATING
C192 sn3.t1 vss 0.21628f ; **FLOATING
C193 vdd.t5 vss 0.02434f ; **FLOATING
C194 vdd.n0 vss 0.25666f ; **FLOATING
C195 vdd.t7 vss 0.02434f ; **FLOATING
C196 vdd.n1 vss 0.15599f ; **FLOATING
C197 vdd.t1 vss 0.05089f ; **FLOATING
C198 vdd.n2 vss 0.34501f ; **FLOATING
C199 vdd.t11 vss 0.05089f ; **FLOATING
C200 vdd.n3 vss 0.34501f ; **FLOATING
C201 vdd.t3 vss 0.02434f ; **FLOATING
C202 vdd.n4 vss 0.15599f ; **FLOATING
C203 vdd.t9 vss 0.02434f ; **FLOATING
C204 vdd.n5 vss 0.25666f ; **FLOATING
C205 vdd.n6 vss 0.06879f ; **FLOATING
C206 vdd.n7 vss 0.02695f ; **FLOATING
C207 vdd.n9 vss 0.15578f ; **FLOATING
C208 vdd.n10 vss 0.02619f ; **FLOATING
C209 vdd.t4 vss 0.2269f ; **FLOATING
C210 vdd.n12 vss 0.02695f ; **FLOATING
C211 vdd.n13 vss 0.02695f ; **FLOATING
C212 vdd.n14 vss 0.15578f ; **FLOATING
C213 vdd.n15 vss 0.02619f ; **FLOATING
C214 vdd.n16 vss 0.06649f ; **FLOATING
C215 vdd.n17 vss 0.02695f ; **FLOATING
C216 vdd.n19 vss 0.15578f ; **FLOATING
C217 vdd.n20 vss 0.02619f ; **FLOATING
C218 vdd.t6 vss 0.2269f ; **FLOATING
C219 vdd.n22 vss 0.02695f ; **FLOATING
C220 vdd.n23 vss 0.02695f ; **FLOATING
C221 vdd.n24 vss 0.15578f ; **FLOATING
C222 vdd.n25 vss 0.02619f ; **FLOATING
C223 vdd.n26 vss 0.11674f ; **FLOATING
C224 vdd.n27 vss 0.06649f ; **FLOATING
C225 vdd.n28 vss 0.02695f ; **FLOATING
C226 vdd.n30 vss 0.15578f ; **FLOATING
C227 vdd.n31 vss 0.02619f ; **FLOATING
C228 vdd.t2 vss 0.2269f ; **FLOATING
C229 vdd.n33 vss 0.02695f ; **FLOATING
C230 vdd.n34 vss 0.02695f ; **FLOATING
C231 vdd.n35 vss 0.15578f ; **FLOATING
C232 vdd.n36 vss 0.02619f ; **FLOATING
C233 vdd.n37 vss 0.11674f ; **FLOATING
C234 vdd.n38 vss 0.06879f ; **FLOATING
C235 vdd.n39 vss 0.02695f ; **FLOATING
C236 vdd.n41 vss 0.15578f ; **FLOATING
C237 vdd.n42 vss 0.02619f ; **FLOATING
C238 vdd.t8 vss 0.2269f ; **FLOATING
C239 vdd.n44 vss 0.02695f ; **FLOATING
C240 vdd.n45 vss 0.02695f ; **FLOATING
C241 vdd.n46 vss 0.15578f ; **FLOATING
C242 vdd.n47 vss 0.02619f ; **FLOATING
C243 vdd.n48 vss 0.07166f ; **FLOATING
C244 vdd.n49 vss 0.03405f ; **FLOATING
C245 vdd.n51 vss 0.21406f ; **FLOATING
C246 vdd.n52 vss 0.03285f ; **FLOATING
C247 vdd.t0 vss 0.29455f ; **FLOATING
C248 vdd.n54 vss 0.03405f ; **FLOATING
C249 vdd.n55 vss 0.03405f ; **FLOATING
C250 vdd.n56 vss 0.21406f ; **FLOATING
C251 vdd.n57 vss 0.03285f ; **FLOATING
C252 vdd.n58 vss 0.11084f ; **FLOATING
C253 vdd.n59 vss 0.07166f ; **FLOATING
C254 vdd.n60 vss 0.03405f ; **FLOATING
C255 vdd.n62 vss 0.21406f ; **FLOATING
C256 vdd.n63 vss 0.03285f ; **FLOATING
C257 vdd.t10 vss 0.29455f ; **FLOATING
C258 vdd.n65 vss 0.03405f ; **FLOATING
C259 vdd.n66 vss 0.03405f ; **FLOATING
C260 vdd.n67 vss 0.21406f ; **FLOATING
C261 vdd.n68 vss 0.03285f ; **FLOATING
C262 vdd.n69 vss 0.11084f ; **FLOATING
C263 tp3.n0 vss 0.28172f ; **FLOATING
C264 tp3.t0 vss 0.1236f ; **FLOATING
C265 vinp.t4 vss 0.33685f ; **FLOATING
C266 vinp.t3 vss 0.20224f ; **FLOATING
C267 vinp.n0 vss 0.84159f ; **FLOATING
C268 vinp.t2 vss 0.13414f ; **FLOATING
C269 vinp.n1 vss 0.44093f ; **FLOATING
C270 vinp.t1 vss 0.09927f ; **FLOATING
C271 vinp.n2 vss 1.13548f ; **FLOATING
C272 vinp.t0 vss 0.04528f ; **FLOATING
C273 tp2.n0 vss 0.32568f ; **FLOATING
C274 tp2.t0 vss 0.0763f ; **FLOATING
C275 tp1.n0 vss 0.31583f ; **FLOATING
C276 tp1.t0 vss 0.04608f ; **FLOATING
C277 tp0.n0 vss 0.32287f ; **FLOATING
C278 tp0.t0 vss 0.03464f ; **FLOATING
C279 clk.n0 vss 0.5373f ; **FLOATING
C280 clk.t4 vss 0.07676f ; **FLOATING
C281 clk.t3 vss 0.07582f ; **FLOATING
C282 clk.n1 vss 2.19999f ; **FLOATING
C283 clk.t1 vss 0.07582f ; **FLOATING
C284 clk.n2 vss 2.19999f ; **FLOATING
C285 clk.t0 vss 0.07676f ; **FLOATING
C286 clk.t2 vss 0.2932f ; **FLOATING
C287 qp.t0 vss 0.03543f ; **FLOATING
C288 qp.t4 vss 0.03484f ; **FLOATING
C289 qp.n0 vss 0.7595f ; **FLOATING
C290 qp.t3 vss 0.02395f ; **FLOATING
C291 qp.n1 vss 0.36981f ; **FLOATING
C292 qp.t2 vss 0.0394f ; **FLOATING
C293 qp.n2 vss 1.09939f ; **FLOATING
C294 qp.t1 vss 0.07277f ; **FLOATING
C295 qn.t0 vss 0.07254f ; **FLOATING
C296 qn.t2 vss 0.04001f ; **FLOATING
C297 qn.n0 vss 1.07397f ; **FLOATING
C298 qn.t4 vss 0.02362f ; **FLOATING
C299 qn.n1 vss 0.36266f ; **FLOATING
C300 qn.t3 vss 0.03416f ; **FLOATING
C301 qn.n2 vss 0.7444f ; **FLOATING
C302 qn.t1 vss 0.03523f ; **FLOATING
C303 vinn.t4 vss 0.04524f ; **FLOATING
C304 vinn.t3 vss 0.09917f ; **FLOATING
C305 vinn.n0 vss 1.13437f ; **FLOATING
C306 vinn.t2 vss 0.13401f ; **FLOATING
C307 vinn.n1 vss 0.44049f ; **FLOATING
C308 vinn.t1 vss 0.20204f ; **FLOATING
C309 vinn.n2 vss 0.84076f ; **FLOATING
C310 vinn.t0 vss 0.33652f ; **FLOATING
C311 tn0.n0 vss 0.32293f ; **FLOATING
C312 tn0.t0 vss 0.03465f ; **FLOATING
C313 tn1.n0 vss 0.31579f ; **FLOATING
C314 tn1.t0 vss 0.04607f ; **FLOATING
C315 tn2.n0 vss 0.32567f ; **FLOATING
C316 tn2.t0 vss 0.0763f ; **FLOATING
C317 tn3.n0 vss 0.28172f ; **FLOATING
C318 tn3.t0 vss 0.1236f ; **FLOATING
.ends
