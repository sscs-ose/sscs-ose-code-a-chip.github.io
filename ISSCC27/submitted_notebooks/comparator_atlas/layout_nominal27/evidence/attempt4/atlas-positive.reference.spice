* Independently declared nominal source table, not layout extraction.
.subckt atlas vinp vinn clk vdd vss qp qn tp0 tp1 tp2 tp3 tn0 tn1 tn2 tn3
Xinp xp vinp tail vss sky130_fd_pr__nfet_01v8_lvt w=3 l=0.15 m=1
Xinn xn vinn tail vss sky130_fd_pr__nfet_01v8_lvt w=3 l=0.15 m=1
Xtail tail clk vss vss sky130_fd_pr__nfet_01v8 w=7 l=0.15 m=1
Xln qn qp xp vss sky130_fd_pr__nfet_01v8 w=1 l=0.15 m=1
Xlp qp qn xn vss sky130_fd_pr__nfet_01v8 w=1 l=0.15 m=1
Xpn qn qp vdd vdd sky130_fd_pr__pfet_01v8 w=2 l=0.15 m=1
Xpp qp qn vdd vdd sky130_fd_pr__pfet_01v8 w=2 l=0.15 m=1
Xrxp xp clk vdd vdd sky130_fd_pr__pfet_01v8 w=1 l=0.15 m=1
Xrxn xn clk vdd vdd sky130_fd_pr__pfet_01v8 w=1 l=0.15 m=1
Xrqp qp clk vdd vdd sky130_fd_pr__pfet_01v8 w=1 l=0.15 m=1
Xrqn qn clk vdd vdd sky130_fd_pr__pfet_01v8 w=1 l=0.15 m=1
Xtp0 xp vinp sp0 vss sky130_fd_pr__nfet_01v8_lvt w=0.42 l=1 m=1
Xsp0 sp0 tp0 tail vss sky130_fd_pr__nfet_01v8 w=1 l=0.15 m=1
Xtp1 xp vinp sp1 vss sky130_fd_pr__nfet_01v8_lvt w=0.84 l=1 m=1
Xsp1 sp1 tp1 tail vss sky130_fd_pr__nfet_01v8 w=2 l=0.15 m=1
Xtp2 xp vinp sp2 vss sky130_fd_pr__nfet_01v8_lvt w=1.68 l=1 m=1
Xsp2 sp2 tp2 tail vss sky130_fd_pr__nfet_01v8 w=4 l=0.15 m=1
Xtp3 xp vinp sp3 vss sky130_fd_pr__nfet_01v8_lvt w=3.36 l=1 m=1
Xsp3 sp3 tp3 tail vss sky130_fd_pr__nfet_01v8 w=8 l=0.15 m=1
Xtn0 xn vinn sn0 vss sky130_fd_pr__nfet_01v8_lvt w=0.42 l=1 m=1
Xsn0 sn0 tn0 tail vss sky130_fd_pr__nfet_01v8 w=1 l=0.15 m=1
Xtn1 xn vinn sn1 vss sky130_fd_pr__nfet_01v8_lvt w=0.84 l=1 m=1
Xsn1 sn1 tn1 tail vss sky130_fd_pr__nfet_01v8 w=2 l=0.15 m=1
Xtn2 xn vinn sn2 vss sky130_fd_pr__nfet_01v8_lvt w=1.68 l=1 m=1
Xsn2 sn2 tn2 tail vss sky130_fd_pr__nfet_01v8 w=4 l=0.15 m=1
Xtn3 xn vinn sn3 vss sky130_fd_pr__nfet_01v8_lvt w=3.36 l=1 m=1
Xsn3 sn3 tn3 tail vss sky130_fd_pr__nfet_01v8 w=8 l=0.15 m=1
.ends atlas
