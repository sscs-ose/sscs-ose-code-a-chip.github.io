* NGSPICE file created from atlas.ext - technology: sky130A

.subckt atlas vinp vinn clk vdd vss qp qn tp0 tp1 tp2 tp3 tn0 tn1 tn2 tn3
X0 vdd clk qp vdd sky130_fd_pr__pfet_01v8 ad=0.29 pd=2.58 as=0.29 ps=2.58 w=1 l=0.15
X1 vss clk tail vss sky130_fd_pr__nfet_01v8 ad=2.03 pd=14.58 as=2.03 ps=14.58 w=7 l=0.15
X2 xn vinn sn0 vss sky130_fd_pr__nfet_01v8_lvt ad=0.1218 pd=1.42 as=0.1218 ps=1.42 w=0.42 l=1
X3 tail tp1 sp1 vss sky130_fd_pr__nfet_01v8 ad=0.58 pd=4.58 as=0.58 ps=4.58 w=2 l=0.15
X4 qp qn vdd vdd sky130_fd_pr__pfet_01v8 ad=0.58 pd=4.58 as=0.58 ps=4.58 w=2 l=0.15
X5 xn vinn tail vss sky130_fd_pr__nfet_01v8_lvt ad=0.87 pd=6.58 as=0.87 ps=6.58 w=3 l=0.15
X6 tail tp3 sp3 vss sky130_fd_pr__nfet_01v8 ad=2.32 pd=16.58 as=2.32 ps=16.58 w=8 l=0.15
X7 sp0 vinp xp vss sky130_fd_pr__nfet_01v8_lvt ad=0.1218 pd=1.42 as=0.1218 ps=1.42 w=0.42 l=1
X8 sp1 vinp xp vss sky130_fd_pr__nfet_01v8_lvt ad=0.2436 pd=2.26 as=0.2436 ps=2.26 w=0.84 l=1
X9 tail vinp xp vss sky130_fd_pr__nfet_01v8_lvt ad=0.87 pd=6.58 as=0.87 ps=6.58 w=3 l=0.15
X10 sn2 tn2 tail vss sky130_fd_pr__nfet_01v8 ad=1.16 pd=8.58 as=1.16 ps=8.58 w=4 l=0.15
X11 sp3 vinp xp vss sky130_fd_pr__nfet_01v8_lvt ad=0.9744 pd=7.3 as=0.9744 ps=7.3 w=3.36 l=1
X12 vdd qp qn vdd sky130_fd_pr__pfet_01v8 ad=0.58 pd=4.58 as=0.58 ps=4.58 w=2 l=0.15
X13 xn clk vdd vdd sky130_fd_pr__pfet_01v8 ad=0.29 pd=2.58 as=0.29 ps=2.58 w=1 l=0.15
X14 qp qn xn vss sky130_fd_pr__nfet_01v8 ad=0.29 pd=2.58 as=0.29 ps=2.58 w=1 l=0.15
X15 sn0 tn0 tail vss sky130_fd_pr__nfet_01v8 ad=0.29 pd=2.58 as=0.29 ps=2.58 w=1 l=0.15
X16 sp2 vinp xp vss sky130_fd_pr__nfet_01v8_lvt ad=0.4872 pd=3.94 as=0.4872 ps=3.94 w=1.68 l=1
X17 sn3 tn3 tail vss sky130_fd_pr__nfet_01v8 ad=2.32 pd=16.58 as=2.32 ps=16.58 w=8 l=0.15
X18 xn vinn sn1 vss sky130_fd_pr__nfet_01v8_lvt ad=0.2436 pd=2.26 as=0.2436 ps=2.26 w=0.84 l=1
X19 sn1 tn1 tail vss sky130_fd_pr__nfet_01v8 ad=0.58 pd=4.58 as=0.58 ps=4.58 w=2 l=0.15
X20 xn vinn sn3 vss sky130_fd_pr__nfet_01v8_lvt ad=0.9744 pd=7.3 as=0.9744 ps=7.3 w=3.36 l=1
X21 vdd clk xp vdd sky130_fd_pr__pfet_01v8 ad=0.29 pd=2.58 as=0.29 ps=2.58 w=1 l=0.15
X22 qn clk vdd vdd sky130_fd_pr__pfet_01v8 ad=0.29 pd=2.58 as=0.29 ps=2.58 w=1 l=0.15
X23 xn vinn sn2 vss sky130_fd_pr__nfet_01v8_lvt ad=0.4872 pd=3.94 as=0.4872 ps=3.94 w=1.68 l=1
X24 tail tp2 sp2 vss sky130_fd_pr__nfet_01v8 ad=1.16 pd=8.58 as=1.16 ps=8.58 w=4 l=0.15
X25 xp qp qn vss sky130_fd_pr__nfet_01v8 ad=0.29 pd=2.58 as=0.29 ps=2.58 w=1 l=0.15
X26 tail tp0 sp0 vss sky130_fd_pr__nfet_01v8 ad=0.29 pd=2.58 as=0.29 ps=2.58 w=1 l=0.15
C0 qp clk 0.22345f
C1 xn vinn 0.93288f
C2 tn3 vinn 0.00945f
C3 vinn tn0 0.07648f
C4 tn1 vinn 0.07824f
C5 xn sn2 0.20608f
C6 tn1 sn2 0.00558f
C7 sn1 vinn 0.45578f
C8 sn3 vinn 0.38933f
C9 xn sn0 0.12677f
C10 tp1 tail 0.04314f
C11 sn1 sn2 0.07813f
C12 sn3 sn2 0.09503f
C13 sn0 tn0 0.22192f
C14 sp0 tail 0.22127f
C15 sn1 sn0 0.06623f
C16 xn qp 0.21612f
C17 xp tp0 0.0643f
C18 tail vinp 0.19996f
C19 vdd tail 0.57768f
C20 tp1 vinp 0.0783f
C21 sp0 vinp 0.58812f
C22 sp0 vdd 0
C23 sp1 tp0 0.00558f
C24 qn tail 0.20387f
C25 xn clk 0.28793f
C26 tn2 xn 0.01012f
C27 vdd vinp 0.00957f
C28 sp0 qn 0
C29 sn3 tn2 0.00557f
C30 sp3 tail 0.78857f
C31 tail vinn 0.1966f
C32 qn vinp 0.0489f
C33 qn vdd 0.99433f
C34 sn2 tail 0.50085f
C35 tp2 tail 0.07042f
C36 tail xp 3.139f
C37 tn3 xn 0
C38 tp3 tail 0.11566f
C39 xn tn0 0.0643f
C40 tn1 xn 0.02154f
C41 tail sn0 0.22127f
C42 tp1 xp 0.02154f
C43 sp3 vinp 0.38933f
C44 sn1 xn 0.15896f
C45 sp0 xp 0.12677f
C46 sn3 xn 0.20649f
C47 tail sp2 0.50085f
C48 sn3 tn3 0.3136f
C49 sn1 tn0 0.00558f
C50 vdd vinn 0.00956f
C51 sn1 tn1 0.2511f
C52 tail qp 0.22301f
C53 tp2 vinp 0.07465f
C54 tp1 sp2 0.00558f
C55 sp1 tail 0.31884f
C56 vinp xp 0.93288f
C57 tp3 vinp 0.00945f
C58 vdd xp 0.41183f
C59 sp1 tp1 0.2511f
C60 vdd sn0 0
C61 sp0 qp 0.04232f
C62 qn vinn 0.06392f
C63 sp0 sp1 0.06623f
C64 vinp sp2 0.44962f
C65 qn xp 0.21224f
C66 vinp qp 0.0647f
C67 sp1 vinp 0.45578f
C68 tail clk 2.69274f
C69 tn2 tail 0.07042f
C70 vdd qp 1.01053f
C71 qn sn0 0.0431f
C72 tp2 sp3 0.00557f
C73 sp3 xp 0.20649f
C74 sp0 clk 0
C75 sn2 vinn 0.44962f
C76 tp3 sp3 0.3136f
C77 qn qp 0.81839f
C78 vinp clk 0.01863f
C79 tp2 xp 0.01012f
C80 sn0 vinn 0.58812f
C81 vdd clk 3.9943f
C82 sp3 sp2 0.09503f
C83 xn tail 3.13866f
C84 tn3 tail 0.11566f
C85 tp3 xp 0
C86 tail tn0 0.02986f
C87 tn1 tail 0.04314f
C88 tp2 sp2 0.27933f
C89 qp vinn 0.04992f
C90 qn clk 0.21006f
C91 xp sp2 0.20608f
C92 sn1 tail 0.31884f
C93 sn3 tail 0.78857f
C94 xp qp 0.15077f
C95 sp1 xp 0.15896f
C96 tail tp0 0.02986f
C97 sn0 qp 0
C98 vdd xn 0.41183f
C99 sp1 sp2 0.07813f
C100 sp0 tp0 0.22193f
C101 vinn clk 0.01841f
C102 tn2 vinn 0.07464f
C103 tn2 sn2 0.27933f
C104 qn xn 0.14695f
C105 xp clk 0.28831f
C106 vinp tp0 0.0764f
C107 sn0 clk 0
C108 tn3 vss 0.77028f
C109 tn2 vss 0.78537f
C110 tn1 vss 0.78701f
C111 tn0 vss 0.77218f
C112 vinn vss 6.50596f
C113 qn vss 6.82545f
C114 qp vss 6.79917f
C115 clk vss 1.91589f
C116 tp0 vss 0.77254f
C117 tp1 vss 0.78665f
C118 tp2 vss 0.78533f
C119 vinp vss 6.50229f
C120 tp3 vss 0.77028f
C121 vdd vss 11.5625f
C122 sn3 vss 2.52815f ; **FLOATING
C123 sn2 vss 1.61658f ; **FLOATING
C124 sn1 vss 1.32921f ; **FLOATING
C125 sn0 vss 1.21296f ; **FLOATING
C126 xn vss 3.80117f ; **FLOATING
C127 sp0 vss 1.21476f ; **FLOATING
C128 sp1 vss 1.32921f ; **FLOATING
C129 sp2 vss 1.61658f ; **FLOATING
C130 xp vss 3.8004f ; **FLOATING
C131 tail vss 9.03191f ; **FLOATING
C132 sp3 vss 2.52815f ; **FLOATING
.ends
