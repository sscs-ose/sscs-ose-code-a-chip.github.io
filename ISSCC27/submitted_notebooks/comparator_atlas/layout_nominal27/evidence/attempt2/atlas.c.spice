* NGSPICE file created from atlas.ext - technology: sky130A

.subckt atlas vinp vinn clk vdd vss qp qn tp0 tp1 tp2 tp3 tn0 tn1 tn2 tn3
X0 vdd clk qp vdd sky130_fd_pr__pfet_01v8 ad=0.29 pd=2.58 as=0.29 ps=2.58 w=1 l=0.15
X1 vss clk tail vss sky130_fd_pr__nfet_01v8 ad=2.03 pd=14.58 as=2.03 ps=14.58 w=7 l=0.15
X2 xn vinn sn0 vss sky130_fd_pr__nfet_01v8_lvt ad=0.1218 pd=1.42 as=0.1218 ps=1.42 w=0.42 l=1
X3 tail tp1 sp1 vss sky130_fd_pr__nfet_01v8 ad=0.58 pd=4.58 as=0.58 ps=4.58 w=2 l=0.15
X4 qp qn vdd vdd sky130_fd_pr__pfet_01v8 ad=0.58 pd=4.58 as=0.58 ps=4.58 w=2 l=0.15
X5 xn vinn tail vss sky130_fd_pr__nfet_01v8_lvt ad=0.87 pd=6.58 as=0.87 ps=6.58 w=3 l=0.15
X6 tail tp3 sp3 vss sky130_fd_pr__nfet_01v8 ad=2.32 pd=16.58 as=2.32 ps=16.58 w=8 l=0.15
X7 sp0 vinp xp vss sky130_fd_pr__nfet_01v8_lvt ad=0.1218 pd=1.42 as=0.1218 ps=1.42 w=0.42 l=1
X8 sp1 vinp xp vss sky130_fd_pr__nfet_01v8_lvt ad=0.2436 pd=2.26 as=0.2436 ps=2.26 w=0.84 l=1
X9 tail vinp xp vss sky130_fd_pr__nfet_01v8_lvt ad=0.87 pd=6.58 as=0.87 ps=6.58 w=3 l=0.15
X10 sn2 tn2 tail vss sky130_fd_pr__nfet_01v8 ad=1.16 pd=8.58 as=1.16 ps=8.58 w=4 l=0.15
X11 sp3 vinp xp vss sky130_fd_pr__nfet_01v8_lvt ad=0.9744 pd=7.3 as=0.9744 ps=7.3 w=3.36 l=1
X12 vdd qp qn vdd sky130_fd_pr__pfet_01v8 ad=0.58 pd=4.58 as=0.58 ps=4.58 w=2 l=0.15
X13 xn clk vdd vdd sky130_fd_pr__pfet_01v8 ad=0.29 pd=2.58 as=0.29 ps=2.58 w=1 l=0.15
X14 qp qn xn vss sky130_fd_pr__nfet_01v8 ad=0.29 pd=2.58 as=0.29 ps=2.58 w=1 l=0.15
X15 sn0 tn0 tail vss sky130_fd_pr__nfet_01v8 ad=0.29 pd=2.58 as=0.29 ps=2.58 w=1 l=0.15
X16 sp2 vinp xp vss sky130_fd_pr__nfet_01v8_lvt ad=0.4872 pd=3.94 as=0.4872 ps=3.94 w=1.68 l=1
X17 sn3 tn3 tail vss sky130_fd_pr__nfet_01v8 ad=2.32 pd=16.58 as=2.32 ps=16.58 w=8 l=0.15
X18 xn vinn sn1 vss sky130_fd_pr__nfet_01v8_lvt ad=0.2436 pd=2.26 as=0.2436 ps=2.26 w=0.84 l=1
X19 sn1 tn1 tail vss sky130_fd_pr__nfet_01v8 ad=0.58 pd=4.58 as=0.58 ps=4.58 w=2 l=0.15
X20 xn vinn sn3 vss sky130_fd_pr__nfet_01v8_lvt ad=0.9744 pd=7.3 as=0.9744 ps=7.3 w=3.36 l=1
X21 vdd clk xp vdd sky130_fd_pr__pfet_01v8 ad=0.29 pd=2.58 as=0.29 ps=2.58 w=1 l=0.15
X22 qn clk vdd vdd sky130_fd_pr__pfet_01v8 ad=0.29 pd=2.58 as=0.29 ps=2.58 w=1 l=0.15
X23 xn vinn sn2 vss sky130_fd_pr__nfet_01v8_lvt ad=0.4872 pd=3.94 as=0.4872 ps=3.94 w=1.68 l=1
X24 tail tp2 sp2 vss sky130_fd_pr__nfet_01v8 ad=1.16 pd=8.58 as=1.16 ps=8.58 w=4 l=0.15
X25 xp qp qn vss sky130_fd_pr__nfet_01v8 ad=0.29 pd=2.58 as=0.29 ps=2.58 w=1 l=0.15
X26 tail tp0 sp0 vss sky130_fd_pr__nfet_01v8 ad=0.29 pd=2.58 as=0.29 ps=2.58 w=1 l=0.15
C0 xn sn1 0.19312f
C1 qn vinp 0.60291f
C2 sn3 tail 0.85453f
C3 vdd tail 0.27493f
C4 xp sp2 0.20855f
C5 xp clk 0.44901f
C6 sn2 tn2 0.66317f
C7 qp sp0 0.04082f
C8 xn tn1 0.08853f
C9 sp2 sp1 0.09954f
C10 sp2 tp2 0.6419f
C11 sp2 vinp 0.70136f
C12 xp tp1 0.0749f
C13 qp tail 0.47818f
C14 sn3 xn 0.21245f
C15 clk vinp 0.05258f
C16 vdd xn 0.71347f
C17 qn tail 0.31934f
C18 sn2 tail 0.54554f
C19 sn2 sn1 0.10684f
C20 tp1 sp1 0.5896f
C21 tail tn0 0.36375f
C22 tp1 vinp 0.10122f
C23 sn1 tn0 0.01143f
C24 qp xn 0.7387f
C25 sp0 clk 0
C26 sp2 tail 0.529f
C27 vinn tn3 0.01733f
C28 sn2 tn1 0.01143f
C29 qn xn 0.78134f
C30 sn2 xn 0.2251f
C31 clk tail 2.73222f
C32 sp2 sp3 0.12446f
C33 vinn tn2 0.10134f
C34 qp vdd 1.98644f
C35 tp0 xp 0.07491f
C36 sn0 tail 0.25823f
C37 xp sp1 0.17657f
C38 xp tp2 0.07499f
C39 xn tn0 0.08853f
C40 tp3 xp 0.00608f
C41 vdd qn 1.98614f
C42 sn2 sn3 0.13176f
C43 sn0 sn1 0.08708f
C44 xp vinp 2.50397f
C45 tp1 tail 0.35724f
C46 tp0 sp1 0.01143f
C47 vinn tail 0.65001f
C48 vdd tn0 0
C49 tp0 vinp 0.09905f
C50 vinn sn1 0.70992f
C51 vinp sp1 0.68865f
C52 vinp tp2 0.10135f
C53 clk xn 0.44786f
C54 tp3 vinp 0.01733f
C55 sn0 xn 0.17715f
C56 qp qn 3.20721f
C57 sp0 xp 0.1606f
C58 vdd clk 4.33828f
C59 xp tail 3.36465f
C60 sn0 vdd 0.13734f
C61 vinn tn1 0.10117f
C62 vinn xn 2.64345f
C63 sp0 tp0 0.53435f
C64 sp0 sp1 0.07979f
C65 xp sp3 0.20417f
C66 tp0 tail 0.35548f
C67 sp0 vinp 0.75152f
C68 sp1 tail 0.33744f
C69 vinn sn3 0.66933f
C70 tp2 tail 0.35882f
C71 vdd vinn 0.0557f
C72 tp3 tail 0.30653f
C73 qp clk 0.50909f
C74 vinp tail 0.62008f
C75 tp2 sp3 0.01141f
C76 tp3 sp3 0.69388f
C77 vinp sp3 0.64805f
C78 qn clk 0.50881f
C79 tn3 tail 0.30653f
C80 sn0 qn 0.04812f
C81 tail tn2 0.36709f
C82 qp vinn 0.07699f
C83 vdd xp 0.71469f
C84 sn0 tn0 0.55562f
C85 sp0 tail 0.24171f
C86 vinn qn 0.57229f
C87 vinn sn2 0.72264f
C88 vdd tp0 0
C89 vinn tn0 0.09913f
C90 sn1 tail 0.35398f
C91 sp3 tail 0.84625f
C92 xn tn3 0.01143f
C93 vdd vinp 0.05582f
C94 sn0 clk 0
C95 xn tn2 0.08861f
C96 qp xp 0.98807f
C97 sp2 tp1 0.01143f
C98 sn3 tn3 0.71516f
C99 qn xp 0.24761f
C100 vinn clk 0.0525f
C101 sn3 tn2 0.01141f
C102 tail tn1 0.36552f
C103 sn0 vinn 0.77279f
C104 xn tail 2.17577f
C105 qp vinp 0.31135f
C106 sp0 vdd 0.13734f
C107 sn1 tn1 0.61087f
C108 tn3 vss 1.46432f
C109 tn2 vss 1.4017f
C110 tn1 vss 1.35707f
C111 tn0 vss 1.30253f
C112 vinn vss 6.66291f
C113 qn vss 3.83289f
C114 qp vss 3.3337f
C115 clk vss 2.33399f
C116 tp0 vss 1.27674f
C117 tp1 vss 1.33054f
C118 tp2 vss 1.3755f
C119 vinp vss 6.50375f
C120 tp3 vss 1.43816f
C121 vdd vss 14.5751f
C122 sn3 vss 3.77875f ; **FLOATING
C123 sn2 vss 2.79037f ; **FLOATING
C124 sn1 vss 2.44295f ; **FLOATING
C125 sn0 vss 2.10756f ; **FLOATING
C126 xn vss 6.42037f ; **FLOATING
C127 sp0 vss 2.06186f ; **FLOATING
C128 sp1 vss 2.39721f ; **FLOATING
C129 sp2 vss 2.74463f ; **FLOATING
C130 xp vss 6.05296f ; **FLOATING
C131 tail vss 13.9168f ; **FLOATING
C132 sp3 vss 3.7164f ; **FLOATING
.ends
