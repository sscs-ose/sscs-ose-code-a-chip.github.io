* NGSPICE file created from atlas.ext - technology: sky130A

.subckt atlas vinp vinn clk vdd vss qp qn tp0 tp1 tp2 tp3 tn0 tn1 tn2 tn3
X0 vdd clk qp vdd sky130_fd_pr__pfet_01v8 ad=0.29 pd=2.58 as=0.29 ps=2.58 w=1 l=0.15
X1 vss clk tail vss sky130_fd_pr__nfet_01v8 ad=2.03 pd=14.58 as=2.03 ps=14.58 w=7 l=0.15
X2 xn vinn sn0 vss sky130_fd_pr__nfet_01v8_lvt ad=0.1218 pd=1.42 as=0.1218 ps=1.42 w=0.42 l=1
X3 tail tp1 sp1 vss sky130_fd_pr__nfet_01v8 ad=0.58 pd=4.58 as=0.58 ps=4.58 w=2 l=0.15
X4 qp qn vdd vdd sky130_fd_pr__pfet_01v8 ad=0.58 pd=4.58 as=0.58 ps=4.58 w=2 l=0.15
X5 xn vinn tail vss sky130_fd_pr__nfet_01v8_lvt ad=0.87 pd=6.58 as=0.87 ps=6.58 w=3 l=0.15
X6 tail tp3 sp3 vss sky130_fd_pr__nfet_01v8 ad=2.32 pd=16.58 as=2.32 ps=16.58 w=8 l=0.15
X7 sp0 vinp xp vss sky130_fd_pr__nfet_01v8_lvt ad=0.1218 pd=1.42 as=0.1218 ps=1.42 w=0.42 l=1
X8 sp1 vinp xp vss sky130_fd_pr__nfet_01v8_lvt ad=0.2436 pd=2.26 as=0.2436 ps=2.26 w=0.84 l=1
X9 tail vinp xp vss sky130_fd_pr__nfet_01v8_lvt ad=0.87 pd=6.58 as=0.87 ps=6.58 w=3 l=0.15
X10 sn2 tn2 tail vss sky130_fd_pr__nfet_01v8 ad=1.16 pd=8.58 as=1.16 ps=8.58 w=4 l=0.15
X11 sp3 vinp xp vss sky130_fd_pr__nfet_01v8_lvt ad=0.9744 pd=7.3 as=0.9744 ps=7.3 w=3.36 l=1
X12 vdd qp qn vdd sky130_fd_pr__pfet_01v8 ad=0.58 pd=4.58 as=0.58 ps=4.58 w=2 l=0.15
X13 xn clk vdd vdd sky130_fd_pr__pfet_01v8 ad=0.29 pd=2.58 as=0.29 ps=2.58 w=1 l=0.15
X14 qp qn xn vss sky130_fd_pr__nfet_01v8 ad=0.29 pd=2.58 as=0.29 ps=2.58 w=1 l=0.15
X15 sn0 tn0 tail vss sky130_fd_pr__nfet_01v8 ad=0.29 pd=2.58 as=0.29 ps=2.58 w=1 l=0.15
X16 sp2 vinp xp vss sky130_fd_pr__nfet_01v8_lvt ad=0.4872 pd=3.94 as=0.4872 ps=3.94 w=1.68 l=1
X17 sn3 tn3 tail vss sky130_fd_pr__nfet_01v8 ad=2.32 pd=16.58 as=2.32 ps=16.58 w=8 l=0.15
X18 xn vinn sn1 vss sky130_fd_pr__nfet_01v8_lvt ad=0.2436 pd=2.26 as=0.2436 ps=2.26 w=0.84 l=1
X19 sn1 tn1 tail vss sky130_fd_pr__nfet_01v8 ad=0.58 pd=4.58 as=0.58 ps=4.58 w=2 l=0.15
X20 xn vinn sn3 vss sky130_fd_pr__nfet_01v8_lvt ad=0.9744 pd=7.3 as=0.9744 ps=7.3 w=3.36 l=1
X21 vdd clk xp vdd sky130_fd_pr__pfet_01v8 ad=0.29 pd=2.58 as=0.29 ps=2.58 w=1 l=0.15
X22 qn clk vdd vdd sky130_fd_pr__pfet_01v8 ad=0.29 pd=2.58 as=0.29 ps=2.58 w=1 l=0.15
X23 xn vinn sn2 vss sky130_fd_pr__nfet_01v8_lvt ad=0.4872 pd=3.94 as=0.4872 ps=3.94 w=1.68 l=1
X24 tail tp2 sp2 vss sky130_fd_pr__nfet_01v8 ad=1.16 pd=8.58 as=1.16 ps=8.58 w=4 l=0.15
X25 xp qp qn vss sky130_fd_pr__nfet_01v8 ad=0.29 pd=2.58 as=0.29 ps=2.58 w=1 l=0.15
X26 tail tp0 sp0 vss sky130_fd_pr__nfet_01v8 ad=0.29 pd=2.58 as=0.29 ps=2.58 w=1 l=0.15
C0 tp3 sp3 0.69388f
C1 vinp sp3 0.64805f
C2 qn clk 0.50881f
C3 tn3 tail 0.30653f
C4 sn0 qn 0.04812f
C5 tail tn2 0.36709f
C6 qp vinn 0.07699f
C7 vdd xp 0.71469f
C8 sn0 tn0 0.55562f
C9 sp0 tail 0.24171f
C10 vinn qn 0.57229f
C11 vinn sn2 0.72264f
C12 vdd tp0 0
C13 vinn tn0 0.09913f
C14 sn1 tail 0.35398f
C15 sp3 tail 0.84625f
C16 xn tn3 0.01143f
C17 vdd vinp 0.05582f
C18 sn0 clk 0
C19 xn tn2 0.08861f
C20 qp xp 0.98807f
C21 sp2 tp1 0.01143f
C22 qn xp 0.24761f
C23 sn3 tn3 0.71516f
C24 vinn clk 0.0525f
C25 sn3 tn2 0.01141f
C26 tail tn1 0.36552f
C27 sn0 vinn 0.77279f
C28 xn tail 2.17577f
C29 qp vinp 0.31135f
C30 sp0 vdd 0.13734f
C31 sn1 tn1 0.61087f
C32 xn sn1 0.19312f
C33 qn vinp 0.60291f
C34 sn3 tail 0.85453f
C35 vdd tail 0.27493f
C36 xp sp2 0.20855f
C37 xp clk 0.44901f
C38 sn2 tn2 0.66317f
C39 qp sp0 0.04082f
C40 xn tn1 0.08853f
C41 sp2 sp1 0.09954f
C42 sp2 tp2 0.6419f
C43 sp2 vinp 0.70136f
C44 xp tp1 0.0749f
C45 qp tail 0.47818f
C46 sn3 xn 0.21245f
C47 vdd xn 0.71347f
C48 clk vinp 0.05258f
C49 qn tail 0.31934f
C50 sn2 tail 0.54554f
C51 sn2 sn1 0.10684f
C52 tp1 sp1 0.5896f
C53 tail tn0 0.36375f
C54 tp1 vinp 0.10122f
C55 sn1 tn0 0.01143f
C56 qp xn 0.7387f
C57 sp0 clk 0
C58 sp2 tail 0.529f
C59 vinn tn3 0.01733f
C60 sn2 tn1 0.01143f
C61 qn xn 0.78134f
C62 sn2 xn 0.2251f
C63 clk tail 2.73222f
C64 sp2 sp3 0.12446f
C65 vinn tn2 0.10134f
C66 qp vdd 1.98644f
C67 tp0 xp 0.07491f
C68 sn0 tail 0.25823f
C69 xp sp1 0.17657f
C70 xp tp2 0.07499f
C71 xn tn0 0.08853f
C72 tp3 xp 0.00608f
C73 sn2 sn3 0.13176f
C74 vdd qn 1.98614f
C75 sn0 sn1 0.08708f
C76 xp vinp 2.50397f
C77 tp1 tail 0.35724f
C78 tp0 sp1 0.01143f
C79 vinn tail 0.65001f
C80 vdd tn0 0
C81 tp0 vinp 0.09905f
C82 vinn sn1 0.70992f
C83 vinp tp2 0.10135f
C84 vinp sp1 0.68865f
C85 clk xn 0.44786f
C86 tp3 vinp 0.01733f
C87 sn0 xn 0.17715f
C88 qp qn 3.20721f
C89 sp0 xp 0.1606f
C90 vdd clk 4.33828f
C91 xp tail 3.36465f
C92 sn0 vdd 0.13734f
C93 vinn tn1 0.10117f
C94 vinn xn 2.64345f
C95 sp0 tp0 0.53435f
C96 sp0 sp1 0.07979f
C97 xp sp3 0.20417f
C98 tp0 tail 0.35548f
C99 sp0 vinp 0.75152f
C100 sp1 tail 0.33744f
C101 vinn sn3 0.66933f
C102 tp2 tail 0.35882f
C103 vdd vinn 0.0557f
C104 tp3 tail 0.30653f
C105 qp clk 0.50909f
C106 vinp tail 0.62008f
C107 tp2 sp3 0.01141f
C108 tn3 vss 1.46432f
C109 tn2 vss 1.4017f
C110 tn1 vss 1.35707f
C111 tn0 vss 1.30253f
C112 vinn vss 6.66291f
C113 qn vss 3.83289f
C114 qp vss 3.3337f
C115 clk vss 2.33399f
C116 tp0 vss 1.27674f
C117 tp1 vss 1.33054f
C118 tp2 vss 1.3755f
C119 vinp vss 6.50375f
C120 tp3 vss 1.43816f
C121 vdd vss 14.5751f
C122 sn3 vss 3.77875f ; **FLOATING
C123 sn2 vss 2.79037f ; **FLOATING
C124 sn1 vss 2.44295f ; **FLOATING
C125 sn0 vss 2.10756f ; **FLOATING
C126 xn vss 6.42037f ; **FLOATING
C127 sp0 vss 2.06186f ; **FLOATING
C128 sp1 vss 2.39721f ; **FLOATING
C129 sp2 vss 2.74463f ; **FLOATING
C130 xp vss 6.05296f ; **FLOATING
C131 tail vss 13.9168f ; **FLOATING
C132 sp3 vss 3.7164f ; **FLOATING
.ends
