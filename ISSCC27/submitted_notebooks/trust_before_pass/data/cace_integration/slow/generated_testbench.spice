** sch_path: C:/Users/QuRYous/Documents/Codex/2026-10-13/open-source-analog-verification-opportunity-audit/work/cr/074008993577/runs/RUN_2026-10-15_15-40-09/parameters/startup_time/run_0/startup.sch
**.subckt startup
**** begin user architecture code

* Declared stop time 0.006
** sch_path: /home/rtsang/chipalooza/sky130_ajc_ip__por/cace/response_time.sch

Ibias vbp GND 200n
XM1 ibg_200n vbp avdd_bg avdd_bg sky130_fd_pr__pfet_g5v0d10v5 L=4 W=1 nf=1 ad='int((nf+1)/2) * W/nf * 0.29'
+ as='int((nf+2)/2) * W/nf * 0.29'  pd='2*int((nf+1)/2) * (W/nf + 0.29)' ps='2*int((nf+2)/2) * (W/nf + 0.29)'
+ nrd='0.29 / W' nrs='0.29 / W' sa=0 sb=0 sd=0 mult=1 m=1
XM0 vbp vbp avdd_bg avdd_bg sky130_fd_pr__pfet_g5v0d10v5 L=4 W=1 nf=1 ad='int((nf+1)/2) * W/nf * 0.29'
+ as='int((nf+2)/2) * W/nf * 0.29'  pd='2*int((nf+1)/2) * (W/nf + 0.29)' ps='2*int((nf+2)/2) * (W/nf + 0.29)'
+ nrd='0.29 / W' nrs='0.29 / W' sa=0 sb=0 sd=0 mult=1 m=1
R1 itest GND 1e6 m=1
Vavss avss GND DC 0
Vforce_pdn force_pdn GND pwl(0 0 1u {0*1.8})
Vavdd avdd GND pwl (0 0 4m 3.3) DC 3.3
.save i(vavdd)
Vbg1v2 vbg_1v2 GND DC 1.2
Vdvss dvss GND DC 0
Vdvdd dvdd GND DC 1.8
.save i(vdvdd)
Vvotrip0 otrip[0] GND DC {0*1.8}
.save i(vvotrip0)
Vvotrip1 otrip[1] GND DC {0*1.8}
.save i(vvotrip1)
Vvotrip2 otrip[2] GND DC {1*1.8}
.save i(vvotrip2)
Vvotrip3 otrip[3] GND DC {0*1.8}
.save i(vvotrip3)
Visrc_sel isrc_sel GND DC {0*1.8}
Vavdd_bg avdd_bg GND DC 3.3
Vforce_dis_rc_osc force_dis_rc_osc GND DC {0*1.8}
Vforce_short_oneshot force_short_oneshot GND DC {0*1.8}
Vforce_ena_rc_osc force_ena_rc_osc GND DC {0*1.8}
xIpor avdd porb_h porb avss dvdd por dvss osc_ck vbg_1v2 dcomp otrip[2] otrip[1] otrip[0] itest
+ force_pdn pwup_filt vin  force_ena_rc_osc force_dis_rc_osc startup_timed_out por_timed_out
+ force_short_oneshot isrc_sel ibg_200n sky130_ajc_ip__por
C1 porb_h GND 20p m=1
C2 porb GND 20p m=1
C3 por GND 20p m=1
**** begin user architecture code

* CACE gensim simulation file response_0
* Generated by CACE gensim, Efabless Corporation (c) 2023
* Find trip voltage by ramping Vavdd, both up and down.

.lib C:/Users/QuRYous/Documents/Codex/2026-10-13/open-source-analog-verification-opportunity-audit/submission/ISSCC27/submitted_notebooks/trust_before_pass/assets/combined_source/combined_models/continuous/sky130.lib.spice tt
.include C:/Users/QuRYous/Documents/Codex/2026-10-13/open-source-analog-verification-opportunity-audit/submission/ISSCC27/submitted_notebooks/trust_before_pass/assets/fossi_hvl/sky130_fd_sc_hvl__inv_1.spice
.include C:/Users/QuRYous/Documents/Codex/2026-10-13/open-source-analog-verification-opportunity-audit/submission/ISSCC27/submitted_notebooks/trust_before_pass/assets/fossi_hvl/sky130_fd_sc_hvl__inv_16.spice
.include C:/Users/QuRYous/Documents/Codex/2026-10-13/open-source-analog-verification-opportunity-audit/submission/ISSCC27/submitted_notebooks/trust_before_pass/assets/fossi_hvl/sky130_fd_sc_hvl__inv_4.spice
.include C:/Users/QuRYous/Documents/Codex/2026-10-13/open-source-analog-verification-opportunity-audit/submission/ISSCC27/submitted_notebooks/trust_before_pass/assets/fossi_hvl/sky130_fd_sc_hvl__lsbufhv2lv_1.spice
.include C:/Users/QuRYous/Documents/Codex/2026-10-13/open-source-analog-verification-opportunity-audit/submission/ISSCC27/submitted_notebooks/trust_before_pass/assets/fossi_hvl/sky130_fd_sc_hvl__lsbuflv2hv_1.spice
.include C:/Users/QuRYous/Documents/Codex/2026-10-13/open-source-analog-verification-opportunity-audit/submission/ISSCC27/submitted_notebooks/trust_before_pass/assets/models/sc_hd/cells/inv/sky130_fd_sc_hd__inv_16.spice
.include C:/Users/QuRYous/Documents/Codex/2026-10-13/open-source-analog-verification-opportunity-audit/submission/ISSCC27/submitted_notebooks/trust_before_pass/assets/models/sc_hd/cells/inv/sky130_fd_sc_hd__inv_4.spice

.include C:/Users/QuRYous/Documents/Codex/2026-10-13/open-source-analog-verification-opportunity-audit/submission/ISSCC27/submitted_notebooks/trust_before_pass/assets/combined_source/combined_models/rescap/sky130_fd_pr__model__res.model.spice
.option reltol=1e-3
.option abstol=1e-9

.option TEMP=27.0
* Flag unsafe operating conditions (exceeds models' specified limits)
.option warn=1

.save v(xipor.xiana.dcomp3v3) v(xipor.xiana.vl) v(xipor.xiana.dcomp_filt) v(xipor.xiana.force_pdnb_avdd) v(xipor.xiana.ibias0) v(xipor.xiana.ibias1) v(xipor.xiana.xibiasgen.vp) v(xipor.xiana.xibiasgen.vp0) v(xipor.xiana.xibiasgen.vn0) v(xipor.xiana.xibiasgen.vstart) v(xipor.xiana.xicomp.vn) v(xipor.xiana.xicomp.vt) v(xipor.xiana.xicomp.vnn) v(xipor.xiana.xicomp.vpp) v(xipor.xiana.xicomp.ena_b) v(xipor.xiana.xicomp.vm) v(xipor.xiana.xicomp.n0) v(xipor.xiana.xicomp.n1)
.save v(avdd) v(dvdd) v(osc_ck) v(por) v(porb) v(porb_h) v(startup_timed_out) v(pwup_filt) v(dcomp) v(vin)

.csparam dvdd2={1.8/2}
.control
tran 1u 6m
meas tran osc_start_avg when v(osc_ck)=$&dvdd2 td=1.5m rise=3
meas tran osc_end_avg when v(osc_ck)=$&dvdd2 td=1.5m rise=9
meas tran osc_start when v(osc_ck)=$&dvdd2 td=1.5m rise=1
meas tran osc_end when v(osc_ck)=$&dvdd2 td=1.5m rise=11
meas tran por_start when v(por)=$&dvdd2 td=1.5m rise=1
let osc_ck_period = ($&osc_end_avg - $&osc_start_avg)/6
let osc_ck_freq = 1/$&osc_ck_period
let startup_time = $&por_start - $&osc_start

echo $&osc_ck_period $&osc_ck_freq
echo $&startup_time

echo $&osc_ck_period > ./response_0.data
echo $&startup_time >> ./response_0.data

set wr_singlescale
set wr_vecnames
set numdgt=15
wrdata wave.tsv v(avdd) v(osc_ck) v(por) v(startup_timed_out) v(pwup_filt)
wrdata diagnostic.tsv v(avdd) v(dvdd) v(dcomp) v(vin) v(pwup_filt)
wrdata internal.tsv v(xipor.xiana.dcomp3v3) v(xipor.xiana.vl) v(xipor.xiana.dcomp_filt) v(xipor.xiana.force_pdnb_avdd) v(xipor.xiana.ibias0) v(xipor.xiana.ibias1) v(xipor.xiana.xibiasgen.vp) v(xipor.xiana.xibiasgen.vp0) v(xipor.xiana.xibiasgen.vn0) v(xipor.xiana.xibiasgen.vstart) v(xipor.xiana.xicomp.vn) v(xipor.xiana.xicomp.vt) v(xipor.xiana.xicomp.vnn) v(xipor.xiana.xicomp.vpp) v(xipor.xiana.xicomp.ena_b) v(xipor.xiana.xicomp.vm) v(xipor.xiana.xicomp.n0) v(xipor.xiana.xicomp.n1)
rusage
unset wr_vecnames
wrdata startup_0.data v(osc_ck) v(por)
quit
.endc

**** end user architecture code
**.ends

* expanding   symbol:  xschem/sky130_ajc_ip__por.sym # of pins=22
** sym_path: /home/rtsang/chipalooza/sky130_ajc_ip__por/xschem/sky130_ajc_ip__por.sym
** sch_path: /home/rtsang/chipalooza/sky130_ajc_ip__por/xschem/sky130_ajc_ip__por.sch

.include C:/Users/QuRYous/Documents/Codex/2026-10-13/open-source-analog-verification-opportunity-audit/work/cr/074008993577/netlist/schematic/sky130_ajc_ip__por.spice
.GLOBAL GND

**** end user architecture code
**.ends
.end
